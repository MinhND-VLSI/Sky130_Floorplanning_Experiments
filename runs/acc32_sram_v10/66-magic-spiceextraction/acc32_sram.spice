* NGSPICE file created from acc32_sram.ext - technology: sky130A

* Black-box entry subcircuit for sky130_ef_sc_hd__decap_12 abstract view
.subckt sky130_ef_sc_hd__decap_12 VPWR VGND VPB VNB
.ends

* Black-box entry subcircuit for sky130_fd_sc_hd__decap_6 abstract view
.subckt sky130_fd_sc_hd__decap_6 VGND VNB VPB VPWR
.ends

* Black-box entry subcircuit for sky130_fd_sc_hd__decap_8 abstract view
.subckt sky130_fd_sc_hd__decap_8 VGND VNB VPB VPWR
.ends

* Black-box entry subcircuit for sky130_fd_sc_hd__tapvpwrvgnd_1 abstract view
.subckt sky130_fd_sc_hd__tapvpwrvgnd_1 VGND VPWR
.ends

* Black-box entry subcircuit for sky130_fd_sc_hd__fill_1 abstract view
.subckt sky130_fd_sc_hd__fill_1 VGND VNB VPB VPWR
.ends

* Black-box entry subcircuit for sky130_fd_sc_hd__conb_1 abstract view
.subckt sky130_fd_sc_hd__conb_1 VGND VNB VPB VPWR HI LO
.ends

* Black-box entry subcircuit for sky130_fd_sc_hd__fill_2 abstract view
.subckt sky130_fd_sc_hd__fill_2 VGND VNB VPB VPWR
.ends

* Black-box entry subcircuit for sky130_fd_sc_hd__decap_3 abstract view
.subckt sky130_fd_sc_hd__decap_3 VGND VNB VPB VPWR
.ends

* Black-box entry subcircuit for sky130_fd_sc_hd__o21ba_1 abstract view
.subckt sky130_fd_sc_hd__o21ba_1 A1 A2 B1_N VGND VNB VPB VPWR X
.ends

* Black-box entry subcircuit for sky130_fd_sc_hd__decap_4 abstract view
.subckt sky130_fd_sc_hd__decap_4 VGND VNB VPB VPWR
.ends

* Black-box entry subcircuit for sky130_fd_sc_hd__a21oi_1 abstract view
.subckt sky130_fd_sc_hd__a21oi_1 A1 A2 B1 VGND VNB VPB VPWR Y
.ends

* Black-box entry subcircuit for sky130_fd_sc_hd__a21o_1 abstract view
.subckt sky130_fd_sc_hd__a21o_1 A1 A2 B1 VGND VNB VPB VPWR X
.ends

* Black-box entry subcircuit for sky130_fd_sc_hd__nor2_1 abstract view
.subckt sky130_fd_sc_hd__nor2_1 A B VGND VNB VPB VPWR Y
.ends

* Black-box entry subcircuit for sky130_fd_sc_hd__buf_4 abstract view
.subckt sky130_fd_sc_hd__buf_4 A VGND VNB VPB VPWR X
.ends

* Black-box entry subcircuit for sky130_fd_sc_hd__or3b_1 abstract view
.subckt sky130_fd_sc_hd__or3b_1 A B C_N VGND VNB VPB VPWR X
.ends

* Black-box entry subcircuit for sky130_fd_sc_hd__or2_1 abstract view
.subckt sky130_fd_sc_hd__or2_1 A B VGND VNB VPB VPWR X
.ends

* Black-box entry subcircuit for sky130_fd_sc_hd__clkbuf_1 abstract view
.subckt sky130_fd_sc_hd__clkbuf_1 A VGND VNB VPB VPWR X
.ends

* Black-box entry subcircuit for sky130_fd_sc_hd__and3_1 abstract view
.subckt sky130_fd_sc_hd__and3_1 A B C VGND VNB VPB VPWR X
.ends

* Black-box entry subcircuit for sky130_fd_sc_hd__clkbuf_2 abstract view
.subckt sky130_fd_sc_hd__clkbuf_2 A VGND VNB VPB VPWR X
.ends

* Black-box entry subcircuit for sky130_fd_sc_hd__dfrtp_1 abstract view
.subckt sky130_fd_sc_hd__dfrtp_1 CLK D RESET_B VGND VNB VPB VPWR Q
.ends

* Black-box entry subcircuit for sky130_fd_sc_hd__diode_2 abstract view
.subckt sky130_fd_sc_hd__diode_2 DIODE VGND VNB VPB VPWR
.ends

* Black-box entry subcircuit for sky130_fd_sc_hd__buf_2 abstract view
.subckt sky130_fd_sc_hd__buf_2 A VGND VNB VPB VPWR X
.ends

* Black-box entry subcircuit for sky130_fd_sc_hd__inv_2 abstract view
.subckt sky130_fd_sc_hd__inv_2 A VGND VNB VPB VPWR Y
.ends

* Black-box entry subcircuit for sky130_fd_sc_hd__clkbuf_16 abstract view
.subckt sky130_fd_sc_hd__clkbuf_16 A VGND VNB VPB VPWR X
.ends

* Black-box entry subcircuit for sky130_fd_sc_hd__o21bai_1 abstract view
.subckt sky130_fd_sc_hd__o21bai_1 A1 A2 B1_N VGND VNB VPB VPWR Y
.ends

* Black-box entry subcircuit for sky130_fd_sc_hd__buf_1 abstract view
.subckt sky130_fd_sc_hd__buf_1 A VGND VNB VPB VPWR X
.ends

* Black-box entry subcircuit for sky130_fd_sc_hd__or3_1 abstract view
.subckt sky130_fd_sc_hd__or3_1 A B C VGND VNB VPB VPWR X
.ends

* Black-box entry subcircuit for sky130_fd_sc_hd__nand2_1 abstract view
.subckt sky130_fd_sc_hd__nand2_1 A B VGND VNB VPB VPWR Y
.ends

* Black-box entry subcircuit for sky130_fd_sc_hd__xor2_1 abstract view
.subckt sky130_fd_sc_hd__xor2_1 A B VGND VNB VPB VPWR X
.ends

* Black-box entry subcircuit for sky130_fd_sc_hd__and2b_1 abstract view
.subckt sky130_fd_sc_hd__and2b_1 A_N B VGND VNB VPB VPWR X
.ends

* Black-box entry subcircuit for sky130_fd_sc_hd__xnor2_1 abstract view
.subckt sky130_fd_sc_hd__xnor2_1 A B VGND VNB VPB VPWR Y
.ends

* Black-box entry subcircuit for sky130_fd_sc_hd__a2111o_1 abstract view
.subckt sky130_fd_sc_hd__a2111o_1 A1 A2 B1 C1 D1 VGND VNB VPB VPWR X
.ends

* Black-box entry subcircuit for sky130_fd_sc_hd__clkbuf_4 abstract view
.subckt sky130_fd_sc_hd__clkbuf_4 A VGND VNB VPB VPWR X
.ends

* Black-box entry subcircuit for sky130_fd_sc_hd__inv_8 abstract view
.subckt sky130_fd_sc_hd__inv_8 A VGND VNB VPB VPWR Y
.ends

* Black-box entry subcircuit for sky130_fd_sc_hd__nand3_1 abstract view
.subckt sky130_fd_sc_hd__nand3_1 A B C VGND VNB VPB VPWR Y
.ends

* Black-box entry subcircuit for sky130_fd_sc_hd__inv_6 abstract view
.subckt sky130_fd_sc_hd__inv_6 A VGND VNB VPB VPWR Y
.ends

* Black-box entry subcircuit for sky130_fd_sc_hd__clkinv_2 abstract view
.subckt sky130_fd_sc_hd__clkinv_2 A VGND VNB VPB VPWR Y
.ends

* Black-box entry subcircuit for sky130_fd_sc_hd__clkinv_4 abstract view
.subckt sky130_fd_sc_hd__clkinv_4 A VGND VNB VPB VPWR Y
.ends

* Black-box entry subcircuit for sky130_fd_sc_hd__a211o_1 abstract view
.subckt sky130_fd_sc_hd__a211o_1 A1 A2 B1 C1 VGND VNB VPB VPWR X
.ends

* Black-box entry subcircuit for sky130_fd_sc_hd__bufinv_16 abstract view
.subckt sky130_fd_sc_hd__bufinv_16 A VGND VNB VPB VPWR Y
.ends

* Black-box entry subcircuit for sky130_fd_sc_hd__o22ai_1 abstract view
.subckt sky130_fd_sc_hd__o22ai_1 A1 A2 B1 B2 VGND VNB VPB VPWR Y
.ends

* Black-box entry subcircuit for sky130_fd_sc_hd__nand2b_1 abstract view
.subckt sky130_fd_sc_hd__nand2b_1 A_N B VGND VNB VPB VPWR Y
.ends

* Black-box entry subcircuit for sky130_fd_sc_hd__o31a_1 abstract view
.subckt sky130_fd_sc_hd__o31a_1 A1 A2 A3 B1 VGND VNB VPB VPWR X
.ends

* Black-box entry subcircuit for sky130_fd_sc_hd__or4_1 abstract view
.subckt sky130_fd_sc_hd__or4_1 A B C D VGND VNB VPB VPWR X
.ends

* Black-box entry subcircuit for sky130_fd_sc_hd__o311a_1 abstract view
.subckt sky130_fd_sc_hd__o311a_1 A1 A2 A3 B1 C1 VGND VNB VPB VPWR X
.ends

* Black-box entry subcircuit for sky130_fd_sc_hd__o221a_1 abstract view
.subckt sky130_fd_sc_hd__o221a_1 A1 A2 B1 B2 C1 VGND VNB VPB VPWR X
.ends

* Black-box entry subcircuit for sky130_fd_sc_hd__mux2_1 abstract view
.subckt sky130_fd_sc_hd__mux2_1 A0 A1 S VGND VNB VPB VPWR X
.ends

* Black-box entry subcircuit for sky130_fd_sc_hd__o211a_1 abstract view
.subckt sky130_fd_sc_hd__o211a_1 A1 A2 B1 C1 VGND VNB VPB VPWR X
.ends

* Black-box entry subcircuit for sky130_fd_sc_hd__or4b_1 abstract view
.subckt sky130_fd_sc_hd__or4b_1 A B C D_N VGND VNB VPB VPWR X
.ends

* Black-box entry subcircuit for sky130_fd_sc_hd__and4_1 abstract view
.subckt sky130_fd_sc_hd__and4_1 A B C D VGND VNB VPB VPWR X
.ends

* Black-box entry subcircuit for sky130_fd_sc_hd__a21boi_1 abstract view
.subckt sky130_fd_sc_hd__a21boi_1 A1 A2 B1_N VGND VNB VPB VPWR Y
.ends

* Black-box entry subcircuit for sky130_fd_sc_hd__a211oi_1 abstract view
.subckt sky130_fd_sc_hd__a211oi_1 A1 A2 B1 C1 VGND VNB VPB VPWR Y
.ends

* Black-box entry subcircuit for sky130_fd_sc_hd__o21a_1 abstract view
.subckt sky130_fd_sc_hd__o21a_1 A1 A2 B1 VGND VNB VPB VPWR X
.ends

* Black-box entry subcircuit for sky130_fd_sc_hd__dlymetal6s2s_1 abstract view
.subckt sky130_fd_sc_hd__dlymetal6s2s_1 A VGND VNB VPB VPWR X
.ends

* Black-box entry subcircuit for sky130_fd_sc_hd__dlygate4sd3_1 abstract view
.subckt sky130_fd_sc_hd__dlygate4sd3_1 A VGND VNB VPB VPWR X
.ends

* Black-box entry subcircuit for sky130_fd_sc_hd__a21bo_1 abstract view
.subckt sky130_fd_sc_hd__a21bo_1 A1 A2 B1_N VGND VNB VPB VPWR X
.ends

* Black-box entry subcircuit for sky130_fd_sc_hd__nor3_1 abstract view
.subckt sky130_fd_sc_hd__nor3_1 A B C VGND VNB VPB VPWR Y
.ends

* Black-box entry subcircuit for sky130_fd_sc_hd__a31o_1 abstract view
.subckt sky130_fd_sc_hd__a31o_1 A1 A2 A3 B1 VGND VNB VPB VPWR X
.ends

* Black-box entry subcircuit for sky130_sram_1kbyte_1rw1r_32x256_8 abstract view
.subckt sky130_sram_1kbyte_1rw1r_32x256_8 din0[0] din0[1] din0[2] din0[3] din0[4]
+ din0[5] din0[6] din0[7] din0[8] din0[9] din0[10] din0[11] din0[12] din0[13] din0[14]
+ din0[15] din0[16] din0[17] din0[18] din0[19] din0[20] din0[21] din0[22] din0[23]
+ din0[24] din0[25] din0[26] din0[27] din0[28] din0[29] din0[30] din0[31] addr0[0]
+ addr0[1] addr0[2] addr0[3] addr0[4] addr0[5] addr0[6] addr0[7] addr1[0] addr1[1]
+ addr1[2] addr1[3] addr1[4] addr1[5] addr1[6] addr1[7] csb0 csb1 web0 clk0 clk1 wmask0[0]
+ wmask0[1] wmask0[2] wmask0[3] dout0[0] dout0[1] dout0[2] dout0[3] dout0[4] dout0[5]
+ dout0[6] dout0[7] dout0[8] dout0[9] dout0[10] dout0[11] dout0[12] dout0[13] dout0[14]
+ dout0[15] dout0[16] dout0[17] dout0[18] dout0[19] dout0[20] dout0[21] dout0[22]
+ dout0[23] dout0[24] dout0[25] dout0[26] dout0[27] dout0[28] dout0[29] dout0[30]
+ dout0[31] dout1[0] dout1[1] dout1[2] dout1[3] dout1[4] dout1[5] dout1[6] dout1[7]
+ dout1[8] dout1[9] dout1[10] dout1[11] dout1[12] dout1[13] dout1[14] dout1[15] dout1[16]
+ dout1[17] dout1[18] dout1[19] dout1[20] dout1[21] dout1[22] dout1[23] dout1[24]
+ dout1[25] dout1[26] dout1[27] dout1[28] dout1[29] dout1[30] dout1[31] vccd1 vssd1
.ends

* Black-box entry subcircuit for sky130_fd_sc_hd__a311o_1 abstract view
.subckt sky130_fd_sc_hd__a311o_1 A1 A2 A3 B1 C1 VGND VNB VPB VPWR X
.ends

.subckt acc32_sram VGND VPWR acc_out[0] acc_out[10] acc_out[11] acc_out[12] acc_out[13]
+ acc_out[14] acc_out[15] acc_out[16] acc_out[17] acc_out[18] acc_out[19] acc_out[1]
+ acc_out[20] acc_out[21] acc_out[22] acc_out[23] acc_out[24] acc_out[25] acc_out[26]
+ acc_out[27] acc_out[28] acc_out[29] acc_out[2] acc_out[30] acc_out[31] acc_out[3]
+ acc_out[4] acc_out[5] acc_out[6] acc_out[7] acc_out[8] acc_out[9] clk rst wr_addr[0]
+ wr_addr[1] wr_addr[2] wr_addr[3] wr_addr[4] wr_addr[5] wr_addr[6] wr_addr[7] wr_data[0]
+ wr_data[10] wr_data[11] wr_data[12] wr_data[13] wr_data[14] wr_data[15] wr_data[16]
+ wr_data[17] wr_data[18] wr_data[19] wr_data[1] wr_data[20] wr_data[21] wr_data[22]
+ wr_data[23] wr_data[24] wr_data[25] wr_data[26] wr_data[27] wr_data[28] wr_data[29]
+ wr_data[2] wr_data[30] wr_data[31] wr_data[3] wr_data[4] wr_data[5] wr_data[6] wr_data[7]
+ wr_data[8] wr_data[9] wr_en
XFILLER_255_610 VPWR VGND VPWR VGND sky130_ef_sc_hd__decap_12
XFILLER_210_1508 VGND VGND VPWR VPWR sky130_fd_sc_hd__decap_6
XFILLER_255_643 VGND VGND VPWR VPWR sky130_fd_sc_hd__decap_8
XFILLER_41_1249 VPWR VGND VPWR VGND sky130_ef_sc_hd__decap_12
XTAP_TAPCELL_ROW_97_2_5439 VGND VPWR sky130_fd_sc_hd__tapvpwrvgnd_1
XFILLER_254_120 VPWR VGND VPWR VGND sky130_ef_sc_hd__decap_12
XFILLER_227_345 VPWR VGND VPWR VGND sky130_ef_sc_hd__decap_12
XTAP_TAPCELL_ROW_66_2_5186 VGND VPWR sky130_fd_sc_hd__tapvpwrvgnd_1
XFILLER_132_1399 VPWR VGND VPWR VGND sky130_ef_sc_hd__decap_12
XFILLER_223_87 VPWR VGND VPWR VGND sky130_ef_sc_hd__decap_12
XFILLER_242_304 VPWR VGND VPWR VGND sky130_ef_sc_hd__decap_12
XTAP_TAPCELL_ROW_110_2_5543 VGND VPWR sky130_fd_sc_hd__tapvpwrvgnd_1
XFILLER_215_529 VPWR VGND VPWR VGND sky130_ef_sc_hd__decap_12
XFILLER_254_175 VPWR VGND VPWR VGND sky130_ef_sc_hd__decap_12
XFILLER_247_1420 VPWR VGND VPWR VGND sky130_ef_sc_hd__decap_12
XTAP_TAPCELL_ROW_109_2_5537 VGND VPWR sky130_fd_sc_hd__tapvpwrvgnd_1
XFILLER_208_581 VPWR VGND VPWR VGND sky130_ef_sc_hd__decap_12
XFILLER_242_359 VGND VGND VPWR VPWR sky130_fd_sc_hd__decap_6
XFILLER_247_1475 VPWR VGND VPWR VGND sky130_ef_sc_hd__decap_12
XFILLER_211_713 VPWR VGND VPWR VGND sky130_ef_sc_hd__decap_12
XFILLER_168_617 VGND VGND VPWR VPWR sky130_fd_sc_hd__decap_6
XFILLER_223_584 VPWR VGND VPWR VGND sky130_ef_sc_hd__decap_12
XFILLER_196_937 VPWR VGND VPWR VGND sky130_ef_sc_hd__decap_12
XFILLER_17_1421 VPWR VGND VPWR VGND sky130_ef_sc_hd__decap_12
XFILLER_211_768 VGND VGND VPWR VPWR sky130_fd_sc_hd__decap_6
XFILLER_52_1356 VPWR VGND VPWR VGND sky130_ef_sc_hd__decap_12
XFILLER_206_1183 VPWR VGND VPWR VGND sky130_ef_sc_hd__decap_12
XFILLER_17_1476 VPWR VGND VPWR VGND sky130_ef_sc_hd__decap_12
XFILLER_104_1435 VGND VGND VPWR VPWR sky130_fd_sc_hd__decap_6
XFILLER_182_108 VPWR VGND VPWR VGND sky130_ef_sc_hd__decap_12
XFILLER_202_1047 VGND VGND VPWR VPWR sky130_fd_sc_hd__decap_6
XFILLER_178_1514 VGND VGND VPWR VPWR sky130_fd_sc_hd__fill_1
XFILLER_190_163 VPWR VGND VPWR VGND sky130_ef_sc_hd__decap_12
Xsram0_678 VGND VGND VPWR VPWR sram0_678/HI net678 sky130_fd_sc_hd__conb_1
XFILLER_2_538 VGND VGND VPWR VPWR sky130_fd_sc_hd__fill_2
XFILLER_117_44 VPWR VGND VPWR VGND sky130_ef_sc_hd__decap_12
XFILLER_85_1165 VPWR VGND VPWR VGND sky130_ef_sc_hd__decap_12
XTAP_TAPCELL_ROW_170_1696 VGND VPWR sky130_fd_sc_hd__tapvpwrvgnd_1
XFILLER_77_15 VPWR VGND VPWR VGND sky130_ef_sc_hd__decap_12
XFILLER_176_1293 VPWR VGND VPWR VGND sky130_ef_sc_hd__decap_12
XPHY_EDGE_ROW_165_Right_10 VGND VGND VPWR VPWR sky130_fd_sc_hd__decap_3
XFILLER_150_1411 VPWR VGND VPWR VGND sky130_ef_sc_hd__decap_12
XFILLER_213_1143 VPWR VGND VPWR VGND sky130_ef_sc_hd__decap_12
XFILLER_4_1508 VGND VGND VPWR VPWR sky130_fd_sc_hd__decap_6
XFILLER_218_323 VPWR VGND VPWR VGND sky130_ef_sc_hd__decap_12
XFILLER_150_1466 VPWR VGND VPWR VGND sky130_ef_sc_hd__decap_12
XPHY_EDGE_ROW_36_1_Right_692 VGND VGND VPWR VPWR sky130_fd_sc_hd__decap_3
XFILLER_245_142 VPWR VGND VPWR VGND sky130_ef_sc_hd__decap_12
XFILLER_213_1198 VGND VGND VPWR VPWR sky130_fd_sc_hd__decap_6
XFILLER_206_507 VPWR VGND VPWR VGND sky130_ef_sc_hd__decap_12
XFILLER_218_378 VPWR VGND VPWR VGND sky130_ef_sc_hd__decap_12
XFILLER_172_3 VPWR VGND VPWR VGND sky130_ef_sc_hd__decap_12
X_501_ net504 net89 _107_ VGND VGND VPWR VPWR _256_ sky130_fd_sc_hd__o21ba_1
XFILLER_233_326 VPWR VGND VPWR VGND sky130_ef_sc_hd__decap_12
XFILLER_245_197 VPWR VGND VPWR VGND sky130_ef_sc_hd__decap_12
XFILLER_57_1201 VGND VGND VPWR VPWR sky130_fd_sc_hd__decap_4
X_432_ net598 dout0_q\[21\] net535 VGND VGND VPWR VPWR _221_ sky130_fd_sc_hd__a21oi_1
XFILLER_96_1294 VPWR VGND VPWR VGND sky130_ef_sc_hd__decap_12
XFILLER_198_230 VGND VGND VPWR VPWR sky130_fd_sc_hd__decap_6
XFILLER_187_904 VPWR VGND VPWR VGND sky130_ef_sc_hd__decap_12
XFILLER_214_562 VPWR VGND VPWR VGND sky130_ef_sc_hd__decap_12
XFILLER_242_882 VPWR VGND VPWR VGND sky130_ef_sc_hd__decap_12
XFILLER_199_775 VPWR VGND VPWR VGND sky130_ef_sc_hd__decap_12
XFILLER_109_1335 VPWR VGND VPWR VGND sky130_ef_sc_hd__decap_12
XFILLER_241_381 VGND VGND VPWR VPWR sky130_fd_sc_hd__decap_6
X_363_ net593 net576 net548 VGND VGND VPWR VPWR _152_ sky130_fd_sc_hd__a21o_1
XFILLER_202_746 VGND VGND VPWR VPWR sky130_fd_sc_hd__decap_6
XFILLER_187_959 VPWR VGND VPWR VGND sky130_ef_sc_hd__decap_12
XFILLER_224_1250 VPWR VGND VPWR VGND sky130_ef_sc_hd__decap_12
XFILLER_70_1423 VPWR VGND VPWR VGND sky130_ef_sc_hd__decap_12
X_294_ _084_ _087_ VGND VGND VPWR VPWR _078_ sky130_fd_sc_hd__nor2_1
XTAP_TAPCELL_ROW_154_2_5896 VGND VPWR sky130_fd_sc_hd__tapvpwrvgnd_1
XFILLER_70_1478 VGND VGND VPWR VPWR sky130_fd_sc_hd__decap_6
XFILLER_177_1002 VPWR VGND VPWR VGND sky130_ef_sc_hd__decap_12
XFILLER_181_130 VPWR VGND VPWR VGND sky130_ef_sc_hd__decap_12
XFILLER_6_866 VGND VGND VPWR VPWR sky130_fd_sc_hd__fill_2
XFILLER_6_877 VGND VGND VPWR VPWR sky130_fd_sc_hd__decap_4
XFILLER_120_1270 VPWR VGND VPWR VGND sky130_ef_sc_hd__decap_12
XFILLER_5_365 VGND VGND VPWR VPWR sky130_fd_sc_hd__fill_1
XFILLER_177_1057 VPWR VGND VPWR VGND sky130_ef_sc_hd__decap_12
XFILLER_181_185 VPWR VGND VPWR VGND sky130_ef_sc_hd__decap_12
XTAP_TAPCELL_ROW_246_4360 VGND VPWR sky130_fd_sc_hd__tapvpwrvgnd_1
XFILLER_64_1227 VPWR VGND VPWR VGND sky130_ef_sc_hd__decap_12
XFILLER_9_1408 VPWR VGND VPWR VGND sky130_ef_sc_hd__decap_12
XFILLER_218_1054 VPWR VGND VPWR VGND sky130_ef_sc_hd__decap_12
XTAP_TAPCELL_ROW_246_4371 VGND VPWR sky130_fd_sc_hd__tapvpwrvgnd_1
XFILLER_29_1347 VPWR VGND VPWR VGND sky130_ef_sc_hd__decap_12
XTAP_TAPCELL_ROW_246_4382 VGND VPWR sky130_fd_sc_hd__tapvpwrvgnd_1
XTAP_TAPCELL_ROW_242_4213 VGND VPWR sky130_fd_sc_hd__tapvpwrvgnd_1
XFILLER_116_1306 VGND VGND VPWR VPWR sky130_fd_sc_hd__decap_6
XTAP_TAPCELL_ROW_242_4224 VGND VPWR sky130_fd_sc_hd__tapvpwrvgnd_1
XTAP_TAPCELL_ROW_242_4235 VGND VPWR sky130_fd_sc_hd__tapvpwrvgnd_1
XFILLER_3_56 VPWR VGND VPWR VGND sky130_ef_sc_hd__decap_12
XTAP_TAPCELL_ROW_83_2_5325 VGND VPWR sky130_fd_sc_hd__tapvpwrvgnd_1
XFILLER_7_1143 VPWR VGND VPWR VGND sky130_ef_sc_hd__decap_12
XFILLER_236_120 VPWR VGND VPWR VGND sky130_ef_sc_hd__decap_12
XTAP_TAPCELL_ROW_8_1160 VGND VPWR sky130_fd_sc_hd__tapvpwrvgnd_1
XFILLER_209_345 VPWR VGND VPWR VGND sky130_ef_sc_hd__decap_12
XFILLER_7_1198 VGND VGND VPWR VPWR sky130_fd_sc_hd__decap_6
XTAP_TAPCELL_ROW_4_1002 VGND VPWR sky130_fd_sc_hd__tapvpwrvgnd_1
XTAP_TAPCELL_ROW_8_1171 VGND VPWR sky130_fd_sc_hd__tapvpwrvgnd_1
XTAP_TAPCELL_ROW_4_1013 VGND VPWR sky130_fd_sc_hd__tapvpwrvgnd_1
XTAP_TAPCELL_ROW_207_2986 VGND VPWR sky130_fd_sc_hd__tapvpwrvgnd_1
XTAP_TAPCELL_ROW_4_1024 VGND VPWR sky130_fd_sc_hd__tapvpwrvgnd_1
XTAP_TAPCELL_ROW_199_2710 VGND VPWR sky130_fd_sc_hd__tapvpwrvgnd_1
XFILLER_224_304 VPWR VGND VPWR VGND sky130_ef_sc_hd__decap_12
XFILLER_252_624 VPWR VGND VPWR VGND sky130_ef_sc_hd__decap_12
XFILLER_188_1164 VPWR VGND VPWR VGND sky130_ef_sc_hd__decap_12
XTAP_TAPCELL_ROW_199_2721 VGND VPWR sky130_fd_sc_hd__tapvpwrvgnd_1
XTAP_TAPCELL_ROW_207_2997 VGND VPWR sky130_fd_sc_hd__tapvpwrvgnd_1
XFILLER_236_175 VPWR VGND VPWR VGND sky130_ef_sc_hd__decap_12
XTAP_TAPCELL_ROW_199_2732 VGND VPWR sky130_fd_sc_hd__tapvpwrvgnd_1
XFILLER_40_1282 VPWR VGND VPWR VGND sky130_ef_sc_hd__decap_12
XFILLER_251_123 VGND VGND VPWR VPWR sky130_fd_sc_hd__decap_6
XTAP_TAPCELL_ROW_236_4006 VGND VPWR sky130_fd_sc_hd__tapvpwrvgnd_1
XFILLER_240_808 VPWR VGND VPWR VGND sky130_ef_sc_hd__decap_12
XFILLER_224_359 VGND VGND VPWR VPWR sky130_fd_sc_hd__decap_6
XTAP_TAPCELL_ROW_236_4017 VGND VPWR sky130_fd_sc_hd__tapvpwrvgnd_1
XFILLER_252_679 VPWR VGND VPWR VGND sky130_ef_sc_hd__decap_12
XTAP_TAPCELL_ROW_236_4028 VGND VPWR sky130_fd_sc_hd__tapvpwrvgnd_1
XFILLER_127_1402 VPWR VGND VPWR VGND sky130_ef_sc_hd__decap_12
XFILLER_225_1014 VPWR VGND VPWR VGND sky130_ef_sc_hd__decap_12
XFILLER_189_252 VGND VGND VPWR VPWR sky130_fd_sc_hd__decap_6
XFILLER_166_1484 VPWR VGND VPWR VGND sky130_ef_sc_hd__decap_12
XFILLER_199_80 VGND VGND VPWR VPWR sky130_fd_sc_hd__decap_6
XFILLER_205_584 VPWR VGND VPWR VGND sky130_ef_sc_hd__decap_12
XFILLER_75_1378 VPWR VGND VPWR VGND sky130_ef_sc_hd__decap_12
XFILLER_178_937 VPWR VGND VPWR VGND sky130_ef_sc_hd__decap_12
XFILLER_127_1457 VGND VGND VPWR VPWR sky130_fd_sc_hd__decap_6
XFILLER_162_1337 VPWR VGND VPWR VGND sky130_ef_sc_hd__decap_12
XFILLER_225_1069 VGND VGND VPWR VPWR sky130_fd_sc_hd__decap_6
XFILLER_203_1334 VPWR VGND VPWR VGND sky130_ef_sc_hd__decap_12
XFILLER_186_992 VPWR VGND VPWR VGND sky130_ef_sc_hd__decap_12
XFILLER_199_1260 VPWR VGND VPWR VGND sky130_ef_sc_hd__decap_12
XFILLER_203_1389 VPWR VGND VPWR VGND sky130_ef_sc_hd__decap_12
XFILLER_172_163 VPWR VGND VPWR VGND sky130_ef_sc_hd__decap_12
XFILLER_218_65 VPWR VGND VPWR VGND sky130_ef_sc_hd__decap_12
XFILLER_47_1414 VGND VGND VPWR VPWR sky130_fd_sc_hd__decap_6
XFILLER_236_1121 VPWR VGND VPWR VGND sky130_ef_sc_hd__decap_12
XFILLER_86_1485 VPWR VGND VPWR VGND sky130_ef_sc_hd__decap_12
XFILLER_173_1444 VPWR VGND VPWR VGND sky130_ef_sc_hd__decap_12
XFILLER_82_1349 VGND VGND VPWR VPWR sky130_fd_sc_hd__decap_6
XFILLER_236_1176 VGND VGND VPWR VPWR sky130_fd_sc_hd__decap_6
XFILLER_173_1499 VGND VGND VPWR VPWR sky130_fd_sc_hd__decap_6
XFILLER_214_1441 VPWR VGND VPWR VGND sky130_ef_sc_hd__decap_12
XFILLER_210_1305 VGND VGND VPWR VPWR sky130_fd_sc_hd__decap_6
XFILLER_214_1496 VPWR VGND VPWR VGND sky130_ef_sc_hd__decap_12
XFILLER_227_142 VPWR VGND VPWR VGND sky130_ef_sc_hd__decap_12
XFILLER_132_1196 VPWR VGND VPWR VGND sky130_ef_sc_hd__decap_12
XFILLER_255_484 VPWR VGND VPWR VGND sky130_ef_sc_hd__decap_12
XFILLER_242_101 VGND VGND VPWR VPWR sky130_fd_sc_hd__decap_6
XFILLER_215_326 VPWR VGND VPWR VGND sky130_ef_sc_hd__decap_12
XFILLER_243_646 VPWR VGND VPWR VGND sky130_ef_sc_hd__decap_12
XFILLER_227_197 VPWR VGND VPWR VGND sky130_ef_sc_hd__decap_12
XFILLER_103_68 VGND VGND VPWR VPWR sky130_fd_sc_hd__decap_3
XFILLER_167_1248 VPWR VGND VPWR VGND sky130_ef_sc_hd__decap_12
XFILLER_63_39 VGND VGND VPWR VPWR sky130_fd_sc_hd__decap_4
XFILLER_247_1272 VPWR VGND VPWR VGND sky130_ef_sc_hd__decap_12
XFILLER_93_1445 VPWR VGND VPWR VGND sky130_ef_sc_hd__decap_12
XFILLER_169_904 VPWR VGND VPWR VGND sky130_ef_sc_hd__decap_12
XFILLER_179_39 VGND VGND VPWR VPWR sky130_fd_sc_hd__decap_4
XFILLER_224_882 VPWR VGND VPWR VGND sky130_ef_sc_hd__decap_12
XFILLER_211_510 VGND VGND VPWR VPWR sky130_fd_sc_hd__decap_6
XFILLER_223_381 VGND VGND VPWR VPWR sky130_fd_sc_hd__decap_6
XTAP_TAPCELL_ROW_140_2_5782 VGND VPWR sky130_fd_sc_hd__tapvpwrvgnd_1
XFILLER_196_734 VPWR VGND VPWR VGND sky130_ef_sc_hd__decap_12
XTAP_TAPCELL_ROW_139_2_5776 VGND VPWR sky130_fd_sc_hd__tapvpwrvgnd_1
XFILLER_169_959 VPWR VGND VPWR VGND sky130_ef_sc_hd__decap_12
XFILLER_204_1109 VPWR VGND VPWR VGND sky130_ef_sc_hd__decap_12
XFILLER_221_1401 VPWR VGND VPWR VGND sky130_ef_sc_hd__decap_12
XFILLER_184_918 VGND VGND VPWR VPWR sky130_fd_sc_hd__decap_6
XFILLER_196_789 VGND VGND VPWR VPWR sky130_fd_sc_hd__decap_6
XFILLER_17_1273 VPWR VGND VPWR VGND sky130_ef_sc_hd__decap_12
XFILLER_195_27 VPWR VGND VPWR VGND sky130_ef_sc_hd__decap_12
XFILLER_221_1456 VGND VGND VPWR VPWR sky130_fd_sc_hd__decap_6
XFILLER_143_1292 VPWR VGND VPWR VGND sky130_ef_sc_hd__decap_12
XFILLER_12_65 VGND VGND VPWR VPWR sky130_fd_sc_hd__decap_6
XTAP_TAPCELL_ROW_172_1769 VGND VPWR sky130_fd_sc_hd__tapvpwrvgnd_1
XFILLER_178_1355 VPWR VGND VPWR VGND sky130_ef_sc_hd__decap_12
XFILLER_87_1249 VPWR VGND VPWR VGND sky130_ef_sc_hd__decap_12
XFILLER_3_814 VGND VGND VPWR VPWR sky130_fd_sc_hd__decap_3
XFILLER_128_65 VGND VGND VPWR VPWR sky130_fd_sc_hd__decap_6
XFILLER_139_1328 VGND VGND VPWR VPWR sky130_fd_sc_hd__decap_6
XTAP_TAPCELL_ROW_132_2_5719 VGND VPWR sky130_fd_sc_hd__tapvpwrvgnd_1
XFILLER_174_1219 VGND VGND VPWR VPWR sky130_fd_sc_hd__decap_6
XTAP_TAPCELL_ROW_101_2_5466 VGND VPWR sky130_fd_sc_hd__tapvpwrvgnd_1
XFILLER_88_58 VGND VGND VPWR VPWR sky130_fd_sc_hd__decap_6
XTAP_TAPCELL_ROW_68_2_5205 VGND VPWR sky130_fd_sc_hd__tapvpwrvgnd_1
XFILLER_176_1090 VGND VGND VPWR VPWR sky130_fd_sc_hd__decap_6
XFILLER_215_1205 VPWR VGND VPWR VGND sky130_ef_sc_hd__decap_12
XFILLER_26_1509 VGND VGND VPWR VPWR sky130_fd_sc_hd__decap_6
XFILLER_8_1441 VPWR VGND VPWR VGND sky130_ef_sc_hd__decap_12
XFILLER_28_1380 VPWR VGND VPWR VGND sky130_ef_sc_hd__decap_12
Xfanout672 net673 VGND VGND VPWR VPWR net672 sky130_fd_sc_hd__buf_4
XFILLER_4_1305 VGND VGND VPWR VPWR sky130_fd_sc_hd__decap_6
XFILLER_218_120 VPWR VGND VPWR VGND sky130_ef_sc_hd__decap_12
XFILLER_8_1496 VPWR VGND VPWR VGND sky130_ef_sc_hd__decap_12
XFILLER_150_1263 VGND VGND VPWR VPWR sky130_fd_sc_hd__decap_6
XFILLER_98_1356 VPWR VGND VPWR VGND sky130_ef_sc_hd__decap_12
XFILLER_206_304 VPWR VGND VPWR VGND sky130_ef_sc_hd__decap_12
XPHY_EDGE_ROW_37_1_Right_693 VGND VGND VPWR VPWR sky130_fd_sc_hd__decap_3
XFILLER_218_175 VPWR VGND VPWR VGND sky130_ef_sc_hd__decap_12
XFILLER_234_624 VPWR VGND VPWR VGND sky130_ef_sc_hd__decap_12
XFILLER_246_495 VPWR VGND VPWR VGND sky130_ef_sc_hd__decap_12
XFILLER_185_1315 VPWR VGND VPWR VGND sky130_ef_sc_hd__decap_12
XFILLER_248_1047 VGND VGND VPWR VPWR sky130_fd_sc_hd__decap_6
XFILLER_233_123 VGND VGND VPWR VPWR sky130_fd_sc_hd__decap_6
XFILLER_222_808 VPWR VGND VPWR VGND sky130_ef_sc_hd__decap_12
XFILLER_206_359 VGND VGND VPWR VPWR sky130_fd_sc_hd__decap_6
XFILLER_234_679 VPWR VGND VPWR VGND sky130_ef_sc_hd__decap_12
XFILLER_226_1312 VPWR VGND VPWR VGND sky130_ef_sc_hd__decap_12
XTAP_TAPCELL_ROW_254_4640 VGND VPWR sky130_fd_sc_hd__tapvpwrvgnd_1
XFILLER_187_701 VPWR VGND VPWR VGND sky130_ef_sc_hd__decap_12
XTAP_TAPCELL_ROW_254_4651 VGND VPWR sky130_fd_sc_hd__tapvpwrvgnd_1
X_415_ net133 _162_ _164_ VGND VGND VPWR VPWR _204_ sky130_fd_sc_hd__or3b_1
XFILLER_199_572 VPWR VGND VPWR VGND sky130_ef_sc_hd__decap_12
XTAP_TAPCELL_ROW_254_4662 VGND VPWR sky130_fd_sc_hd__tapvpwrvgnd_1
XTAP_TAPCELL_ROW_250_4504 VGND VPWR sky130_fd_sc_hd__tapvpwrvgnd_1
XTAP_TAPCELL_ROW_250_4515 VGND VPWR sky130_fd_sc_hd__tapvpwrvgnd_1
XFILLER_226_1367 VPWR VGND VPWR VGND sky130_ef_sc_hd__decap_12
XFILLER_109_1165 VPWR VGND VPWR VGND sky130_ef_sc_hd__decap_12
XFILLER_187_756 VPWR VGND VPWR VGND sky130_ef_sc_hd__decap_12
XFILLER_230_863 VPWR VGND VPWR VGND sky130_ef_sc_hd__decap_12
XFILLER_70_1220 VGND VGND VPWR VPWR sky130_fd_sc_hd__decap_6
X_346_ _133_ net339 VGND VGND VPWR VPWR _135_ sky130_fd_sc_hd__or2_1
XFILLER_168_992 VPWR VGND VPWR VGND sky130_ef_sc_hd__decap_12
XFILLER_179_1119 VPWR VGND VPWR VGND sky130_ef_sc_hd__decap_12
XFILLER_183_940 VGND VGND VPWR VPWR sky130_fd_sc_hd__decap_6
XFILLER_6_630 VGND VGND VPWR VPWR sky130_fd_sc_hd__fill_2
XFILLER_196_1422 VPWR VGND VPWR VGND sky130_ef_sc_hd__decap_12
XTAP_TAPCELL_ROW_248_4422 VGND VPWR sky130_fd_sc_hd__tapvpwrvgnd_1
XTAP_TAPCELL_ROW_248_4433 VGND VPWR sky130_fd_sc_hd__tapvpwrvgnd_1
XFILLER_6_663 VGND VGND VPWR VPWR sky130_fd_sc_hd__decap_3
XTAP_TAPCELL_ROW_248_4444 VGND VPWR sky130_fd_sc_hd__tapvpwrvgnd_1
XFILLER_196_1477 VGND VGND VPWR VPWR sky130_fd_sc_hd__decap_6
XFILLER_5_173 VGND VGND VPWR VPWR sky130_fd_sc_hd__decap_4
XTAP_TAPCELL_ROW_244_4308 VGND VPWR sky130_fd_sc_hd__tapvpwrvgnd_1
XFILLER_170_667 VPWR VGND VPWR VGND sky130_ef_sc_hd__decap_12
XFILLER_237_1463 VPWR VGND VPWR VGND sky130_ef_sc_hd__decap_12
XFILLER_233_1327 VGND VGND VPWR VPWR sky130_fd_sc_hd__decap_6
XFILLER_29_1177 VPWR VGND VPWR VGND sky130_ef_sc_hd__decap_12
XFILLER_2_880 VGND VGND VPWR VPWR sky130_fd_sc_hd__fill_1
XFILLER_190_1054 VPWR VGND VPWR VGND sky130_ef_sc_hd__decap_12
XFILLER_81_1371 VGND VGND VPWR VPWR sky130_fd_sc_hd__decap_6
XFILLER_204_34 VPWR VGND VPWR VGND sky130_ef_sc_hd__decap_12
XFILLER_209_142 VPWR VGND VPWR VGND sky130_ef_sc_hd__decap_12
XFILLER_42_1399 VPWR VGND VPWR VGND sky130_ef_sc_hd__decap_12
XFILLER_204_89 VPWR VGND VPWR VGND sky130_ef_sc_hd__decap_12
XFILLER_224_101 VGND VGND VPWR VPWR sky130_fd_sc_hd__decap_6
XFILLER_252_421 VPWR VGND VPWR VGND sky130_ef_sc_hd__decap_12
XTAP_TAPCELL_ROW_0_828 VGND VPWR sky130_fd_sc_hd__tapvpwrvgnd_1
XTAP_TAPCELL_ROW_0_839 VGND VPWR sky130_fd_sc_hd__tapvpwrvgnd_1
XFILLER_209_197 VPWR VGND VPWR VGND sky130_ef_sc_hd__decap_12
XFILLER_225_646 VPWR VGND VPWR VGND sky130_ef_sc_hd__decap_12
XFILLER_240_605 VPWR VGND VPWR VGND sky130_ef_sc_hd__decap_12
XFILLER_220_22 VPWR VGND VPWR VGND sky130_ef_sc_hd__decap_12
XFILLER_252_476 VPWR VGND VPWR VGND sky130_ef_sc_hd__decap_12
XTAP_TAPCELL_ROW_125_2_5662 VGND VPWR sky130_fd_sc_hd__tapvpwrvgnd_1
XFILLER_206_882 VPWR VGND VPWR VGND sky130_ef_sc_hd__decap_12
XFILLER_244_1434 VGND VGND VPWR VPWR sky130_fd_sc_hd__decap_6
XFILLER_166_1281 VPWR VGND VPWR VGND sky130_ef_sc_hd__decap_12
XFILLER_205_381 VGND VGND VPWR VPWR sky130_fd_sc_hd__decap_6
XFILLER_221_830 VPWR VGND VPWR VGND sky130_ef_sc_hd__decap_12
XFILLER_178_734 VPWR VGND VPWR VGND sky130_ef_sc_hd__decap_12
XFILLER_220_77 VPWR VGND VPWR VGND sky130_ef_sc_hd__decap_12
XFILLER_166_918 VGND VGND VPWR VPWR sky130_fd_sc_hd__decap_6
XFILLER_221_885 VPWR VGND VPWR VGND sky130_ef_sc_hd__decap_12
XFILLER_178_789 VGND VGND VPWR VPWR sky130_fd_sc_hd__decap_6
XFILLER_203_1131 VPWR VGND VPWR VGND sky130_ef_sc_hd__decap_12
XFILLER_14_1435 VGND VGND VPWR VPWR sky130_fd_sc_hd__decap_6
XFILLER_140_1454 VPWR VGND VPWR VGND sky130_ef_sc_hd__decap_12
XFILLER_203_1186 VPWR VGND VPWR VGND sky130_ef_sc_hd__decap_12
XFILLER_180_409 VPWR VGND VPWR VGND sky130_ef_sc_hd__decap_12
XFILLER_175_1506 VGND VGND VPWR VPWR sky130_fd_sc_hd__decap_8
XFILLER_238_1238 VPWR VGND VPWR VGND sky130_ef_sc_hd__decap_12
XTAP_TAPCELL_ROW_212_3190 VGND VPWR sky130_fd_sc_hd__tapvpwrvgnd_1
XTAP_TAPCELL_ROW_41_2_4989 VGND VPWR sky130_fd_sc_hd__tapvpwrvgnd_1
XFILLER_86_1282 VPWR VGND VPWR VGND sky130_ef_sc_hd__decap_12
XFILLER_216_1514 VGND VGND VPWR VPWR sky130_fd_sc_hd__fill_1
XFILLER_0_817 VGND VGND VPWR VPWR sky130_fd_sc_hd__fill_2
XFILLER_173_1241 VGND VGND VPWR VPWR sky130_fd_sc_hd__decap_6
XTAP_TAPCELL_ROW_21_2_4832 VGND VPWR sky130_fd_sc_hd__tapvpwrvgnd_1
XFILLER_60_1411 VPWR VGND VPWR VGND sky130_ef_sc_hd__decap_12
XFILLER_114_34 VPWR VGND VPWR VGND sky130_ef_sc_hd__decap_12
XFILLER_247_259 VPWR VGND VPWR VGND sky130_ef_sc_hd__decap_12
XTAP_TAPCELL_ROW_165_1540 VGND VPWR sky130_fd_sc_hd__tapvpwrvgnd_1
XFILLER_60_1466 VPWR VGND VPWR VGND sky130_ef_sc_hd__decap_12
XFILLER_214_1293 VPWR VGND VPWR VGND sky130_ef_sc_hd__decap_12
XFILLER_216_624 VPWR VGND VPWR VGND sky130_ef_sc_hd__decap_12
XFILLER_249_1334 VPWR VGND VPWR VGND sky130_ef_sc_hd__decap_12
XFILLER_95_1507 VGND VGND VPWR VPWR sky130_fd_sc_hd__decap_8
XFILLER_228_495 VPWR VGND VPWR VGND sky130_ef_sc_hd__decap_12
XFILLER_215_123 VGND VGND VPWR VPWR sky130_fd_sc_hd__decap_6
XFILLER_243_443 VPWR VGND VPWR VGND sky130_ef_sc_hd__decap_12
XFILLER_204_808 VPWR VGND VPWR VGND sky130_ef_sc_hd__decap_12
XFILLER_167_1045 VPWR VGND VPWR VGND sky130_ef_sc_hd__decap_12
XFILLER_249_1389 VPWR VGND VPWR VGND sky130_ef_sc_hd__decap_12
XFILLER_130_22 VPWR VGND VPWR VGND sky130_ef_sc_hd__decap_12
XFILLER_216_679 VPWR VGND VPWR VGND sky130_ef_sc_hd__decap_12
XFILLER_231_627 VPWR VGND VPWR VGND sky130_ef_sc_hd__decap_12
XFILLER_169_701 VPWR VGND VPWR VGND sky130_ef_sc_hd__decap_12
XFILLER_243_498 VPWR VGND VPWR VGND sky130_ef_sc_hd__decap_12
XFILLER_93_1242 VGND VGND VPWR VPWR sky130_fd_sc_hd__decap_6
XFILLER_90_15 VGND VGND VPWR VPWR sky130_fd_sc_hd__decap_6
XFILLER_19_1335 VPWR VGND VPWR VGND sky130_ef_sc_hd__decap_12
XFILLER_196_531 VGND VGND VPWR VPWR sky130_fd_sc_hd__decap_6
XFILLER_169_756 VPWR VGND VPWR VGND sky130_ef_sc_hd__decap_12
XFILLER_212_863 VPWR VGND VPWR VGND sky130_ef_sc_hd__decap_12
XFILLER_23_31 VGND VGND VPWR VPWR sky130_fd_sc_hd__fill_1
XFILLER_8_906 VPWR VGND VPWR VGND sky130_ef_sc_hd__decap_12
XFILLER_141_1218 VPWR VGND VPWR VGND sky130_ef_sc_hd__decap_12
XTAP_TAPCELL_ROW_178_1978 VGND VPWR sky130_fd_sc_hd__tapvpwrvgnd_1
XFILLER_208_1097 VPWR VGND VPWR VGND sky130_ef_sc_hd__decap_12
XFILLER_106_1349 VGND VGND VPWR VPWR sky130_fd_sc_hd__decap_6
Xwire303 net304 VGND VGND VPWR VPWR net303 sky130_fd_sc_hd__clkbuf_1
XFILLER_135_3 VPWR VGND VPWR VGND sky130_ef_sc_hd__decap_12
XTAP_TAPCELL_ROW_178_1989 VGND VPWR sky130_fd_sc_hd__tapvpwrvgnd_1
Xwire314 net315 VGND VGND VPWR VPWR net314 sky130_fd_sc_hd__clkbuf_1
Xwire325 net326 VGND VGND VPWR VPWR net325 sky130_fd_sc_hd__clkbuf_1
Xwire347 net348 VGND VGND VPWR VPWR net347 sky130_fd_sc_hd__clkbuf_1
Xwire358 net359 VGND VGND VPWR VPWR net358 sky130_fd_sc_hd__clkbuf_1
Xwire369 net370 VGND VGND VPWR VPWR net369 sky130_fd_sc_hd__clkbuf_1
XFILLER_178_1152 VPWR VGND VPWR VGND sky130_ef_sc_hd__decap_12
XFILLER_99_68 VGND VGND VPWR VPWR sky130_fd_sc_hd__decap_3
XFILLER_30_1270 VPWR VGND VPWR VGND sky130_ef_sc_hd__decap_12
XFILLER_3_633 VGND VGND VPWR VPWR sky130_fd_sc_hd__decap_4
XFILLER_2_132 VPWR VGND VPWR VGND sky130_ef_sc_hd__decap_12
XFILLER_215_1002 VPWR VGND VPWR VGND sky130_ef_sc_hd__decap_12
XFILLER_26_1306 VGND VGND VPWR VPWR sky130_fd_sc_hd__decap_6
XFILLER_2_187 VGND VGND VPWR VPWR sky130_fd_sc_hd__fill_1
XFILLER_117_1445 VPWR VGND VPWR VGND sky130_ef_sc_hd__decap_12
XFILLER_152_1325 VPWR VGND VPWR VGND sky130_ef_sc_hd__decap_12
XTAP_TAPCELL_ROW_162_2_5958 VGND VPWR sky130_fd_sc_hd__tapvpwrvgnd_1
XFILLER_215_1057 VPWR VGND VPWR VGND sky130_ef_sc_hd__decap_12
XFILLER_238_237 VPWR VGND VPWR VGND sky130_ef_sc_hd__decap_12
XTAP_TAPCELL_ROW_98_2_5444 VGND VPWR sky130_fd_sc_hd__tapvpwrvgnd_1
XPHY_EDGE_ROW_100_2_Right_191 VGND VGND VPWR VPWR sky130_fd_sc_hd__decap_3
XFILLER_8_1293 VPWR VGND VPWR VGND sky130_ef_sc_hd__decap_12
XTAP_TAPCELL_ROW_204_2901 VGND VPWR sky130_fd_sc_hd__tapvpwrvgnd_1
XTAP_TAPCELL_ROW_142_2_5801 VGND VPWR sky130_fd_sc_hd__tapvpwrvgnd_1
XTAP_TAPCELL_ROW_204_2912 VGND VPWR sky130_fd_sc_hd__tapvpwrvgnd_1
XFILLER_206_101 VGND VGND VPWR VPWR sky130_fd_sc_hd__decap_6
XFILLER_234_421 VPWR VGND VPWR VGND sky130_ef_sc_hd__decap_12
XFILLER_185_1112 VGND VGND VPWR VPWR sky130_fd_sc_hd__decap_6
XFILLER_207_646 VPWR VGND VPWR VGND sky130_ef_sc_hd__decap_12
XFILLER_246_292 VPWR VGND VPWR VGND sky130_ef_sc_hd__decap_12
XPHY_EDGE_ROW_38_1_Right_694 VGND VGND VPWR VPWR sky130_fd_sc_hd__decap_3
XFILLER_222_605 VPWR VGND VPWR VGND sky130_ef_sc_hd__decap_12
XFILLER_250_925 VPWR VGND VPWR VGND sky130_ef_sc_hd__decap_12
XFILLER_234_476 VPWR VGND VPWR VGND sky130_ef_sc_hd__decap_12
XFILLER_37_1402 VPWR VGND VPWR VGND sky130_ef_sc_hd__decap_12
XTAP_TAPCELL_ROW_67_1_1330 VGND VPWR sky130_fd_sc_hd__tapvpwrvgnd_1
XFILLER_203_830 VPWR VGND VPWR VGND sky130_ef_sc_hd__decap_12
XFILLER_163_1421 VPWR VGND VPWR VGND sky130_ef_sc_hd__decap_12
XFILLER_9_22 VPWR VGND VPWR VGND sky130_ef_sc_hd__decap_12
XFILLER_37_1457 VGND VGND VPWR VPWR sky130_fd_sc_hd__decap_6
XFILLER_72_1337 VPWR VGND VPWR VGND sky130_ef_sc_hd__decap_12
XPHY_EDGE_ROW_74_1_Left_329 VGND VGND VPWR VPWR sky130_fd_sc_hd__decap_3
XFILLER_226_1164 VPWR VGND VPWR VGND sky130_ef_sc_hd__decap_12
XTAP_TAPCELL_ROW_60_2_5145 VGND VPWR sky130_fd_sc_hd__tapvpwrvgnd_1
XFILLER_187_553 VGND VGND VPWR VPWR sky130_fd_sc_hd__decap_6
XFILLER_230_660 VGND VGND VPWR VPWR sky130_fd_sc_hd__decap_6
XFILLER_9_55 VGND VGND VPWR VPWR sky130_fd_sc_hd__decap_8
XFILLER_163_1476 VPWR VGND VPWR VGND sky130_ef_sc_hd__decap_12
XFILLER_203_885 VPWR VGND VPWR VGND sky130_ef_sc_hd__decap_12
X_329_ net595 dout0_q\[19\] net537 VGND VGND VPWR VPWR _118_ sky130_fd_sc_hd__and3_1
XFILLER_204_1484 VPWR VGND VPWR VGND sky130_ef_sc_hd__decap_12
XFILLER_239_1514 VGND VGND VPWR VPWR sky130_fd_sc_hd__fill_1
Xmax_cap603 net604 VGND VGND VPWR VPWR net603 sky130_fd_sc_hd__clkbuf_1
XTAP_TAPCELL_ROW_190_2389 VGND VPWR sky130_fd_sc_hd__tapvpwrvgnd_1
XFILLER_200_1348 VGND VGND VPWR VPWR sky130_fd_sc_hd__decap_6
XTAP_TAPCELL_ROW_26_2_4869 VGND VPWR sky130_fd_sc_hd__tapvpwrvgnd_1
XFILLER_122_1184 VPWR VGND VPWR VGND sky130_ef_sc_hd__decap_12
Xmax_cap614 rd_addr\[2\] VGND VGND VPWR VPWR net614 sky130_fd_sc_hd__clkbuf_1
XFILLER_7_983 VGND VGND VPWR VPWR sky130_fd_sc_hd__decap_6
Xmax_cap625 net42 VGND VGND VPWR VPWR net625 sky130_fd_sc_hd__clkbuf_2
XFILLER_50_3 VPWR VGND VPWR VGND sky130_ef_sc_hd__decap_12
XFILLER_182_280 VPWR VGND VPWR VGND sky130_ef_sc_hd__decap_12
XFILLER_83_1433 VPWR VGND VPWR VGND sky130_ef_sc_hd__decap_12
XFILLER_170_464 VPWR VGND VPWR VGND sky130_ef_sc_hd__decap_12
XFILLER_237_1260 VPWR VGND VPWR VGND sky130_ef_sc_hd__decap_12
XFILLER_215_44 VPWR VGND VPWR VGND sky130_ef_sc_hd__decap_12
XFILLER_83_1488 VPWR VGND VPWR VGND sky130_ef_sc_hd__decap_12
XFILLER_215_99 VPWR VGND VPWR VGND sky130_ef_sc_hd__decap_12
XFILLER_229_259 VPWR VGND VPWR VGND sky130_ef_sc_hd__decap_12
XFILLER_211_1444 VPWR VGND VPWR VGND sky130_ef_sc_hd__decap_12
XFILLER_244_218 VPWR VGND VPWR VGND sky130_ef_sc_hd__decap_12
XFILLER_42_1196 VPWR VGND VPWR VGND sky130_ef_sc_hd__decap_12
XFILLER_211_1499 VGND VGND VPWR VPWR sky130_fd_sc_hd__decap_6
XFILLER_225_443 VPWR VGND VPWR VGND sky130_ef_sc_hd__decap_12
XTAP_TAPCELL_ROW_220_3470 VGND VPWR sky130_fd_sc_hd__tapvpwrvgnd_1
XFILLER_129_1316 VPWR VGND VPWR VGND sky130_ef_sc_hd__decap_12
XFILLER_231_87 VPWR VGND VPWR VGND sky130_ef_sc_hd__decap_12
XFILLER_240_402 VGND VGND VPWR VPWR sky130_fd_sc_hd__decap_6
XFILLER_252_273 VGND VGND VPWR VPWR sky130_fd_sc_hd__decap_6
XFILLER_213_627 VPWR VGND VPWR VGND sky130_ef_sc_hd__decap_12
XFILLER_241_947 VPWR VGND VPWR VGND sky130_ef_sc_hd__decap_12
XFILLER_168_1398 VPWR VGND VPWR VGND sky130_ef_sc_hd__decap_12
XFILLER_225_498 VPWR VGND VPWR VGND sky130_ef_sc_hd__decap_12
XFILLER_178_531 VGND VGND VPWR VPWR sky130_fd_sc_hd__decap_6
XFILLER_100_58 VGND VGND VPWR VPWR sky130_fd_sc_hd__decap_6
XFILLER_221_682 VGND VGND VPWR VPWR sky130_fd_sc_hd__decap_6
XFILLER_60_18 VGND VGND VPWR VPWR sky130_fd_sc_hd__decap_3
XFILLER_205_1248 VPWR VGND VPWR VGND sky130_ef_sc_hd__decap_12
XTAP_TAPCELL_ROW_214_3230 VGND VPWR sky130_fd_sc_hd__tapvpwrvgnd_1
XTAP_TAPCELL_ROW_173_1820 VGND VPWR sky130_fd_sc_hd__tapvpwrvgnd_1
XTAP_TAPCELL_ROW_214_3241 VGND VPWR sky130_fd_sc_hd__tapvpwrvgnd_1
XFILLER_53_1292 VPWR VGND VPWR VGND sky130_ef_sc_hd__decap_12
XTAP_TAPCELL_ROW_214_3252 VGND VPWR sky130_fd_sc_hd__tapvpwrvgnd_1
XFILLER_105_1371 VGND VGND VPWR VPWR sky130_fd_sc_hd__decap_6
XFILLER_140_1251 VPWR VGND VPWR VGND sky130_ef_sc_hd__decap_12
XTAP_TAPCELL_ROW_214_3263 VGND VPWR sky130_fd_sc_hd__tapvpwrvgnd_1
XTAP_TAPCELL_ROW_210_3105 VGND VPWR sky130_fd_sc_hd__tapvpwrvgnd_1
XTAP_TAPCELL_ROW_233_3897 VGND VPWR sky130_fd_sc_hd__tapvpwrvgnd_1
XTAP_TAPCELL_ROW_210_3116 VGND VPWR sky130_fd_sc_hd__tapvpwrvgnd_1
XFILLER_180_206 VPWR VGND VPWR VGND sky130_ef_sc_hd__decap_12
XFILLER_175_1303 VPWR VGND VPWR VGND sky130_ef_sc_hd__decap_12
XFILLER_109_56 VPWR VGND VPWR VGND sky130_ef_sc_hd__decap_12
XFILLER_84_1208 VPWR VGND VPWR VGND sky130_ef_sc_hd__decap_12
XFILLER_238_1035 VPWR VGND VPWR VGND sky130_ef_sc_hd__decap_12
XFILLER_49_1328 VGND VGND VPWR VPWR sky130_fd_sc_hd__decap_6
XPHY_EDGE_ROW_139_2_Right_230 VGND VGND VPWR VPWR sky130_fd_sc_hd__decap_3
XFILLER_69_27 VPWR VGND VPWR VGND sky130_ef_sc_hd__decap_12
XFILLER_88_1399 VPWR VGND VPWR VGND sky130_ef_sc_hd__decap_12
XFILLER_175_1358 VPWR VGND VPWR VGND sky130_ef_sc_hd__decap_12
XTAP_TAPCELL_ROW_147_2_5838 VGND VPWR sky130_fd_sc_hd__tapvpwrvgnd_1
XTAP_TAPCELL_ROW_167_1602 VGND VPWR sky130_fd_sc_hd__tapvpwrvgnd_1
XTAP_TAPCELL_ROW_208_3023 VGND VPWR sky130_fd_sc_hd__tapvpwrvgnd_1
XTAP_TAPCELL_ROW_84_2_5330 VGND VPWR sky130_fd_sc_hd__tapvpwrvgnd_1
XTAP_TAPCELL_ROW_167_1613 VGND VPWR sky130_fd_sc_hd__tapvpwrvgnd_1
XTAP_TAPCELL_ROW_208_3034 VGND VPWR sky130_fd_sc_hd__tapvpwrvgnd_1
XFILLER_216_1355 VPWR VGND VPWR VGND sky130_ef_sc_hd__decap_12
XFILLER_125_44 VPWR VGND VPWR VGND sky130_ef_sc_hd__decap_12
XTAP_TAPCELL_ROW_208_3045 VGND VPWR sky130_fd_sc_hd__tapvpwrvgnd_1
XFILLER_85_15 VPWR VGND VPWR VGND sky130_ef_sc_hd__decap_12
XFILLER_212_1219 VGND VGND VPWR VPWR sky130_fd_sc_hd__decap_6
XFILLER_5_1444 VPWR VGND VPWR VGND sky130_ef_sc_hd__decap_12
XFILLER_60_1263 VGND VGND VPWR VPWR sky130_fd_sc_hd__decap_6
XFILLER_214_1090 VGND VGND VPWR VPWR sky130_fd_sc_hd__decap_6
XFILLER_249_1131 VPWR VGND VPWR VGND sky130_ef_sc_hd__decap_12
XFILLER_186_1410 VPWR VGND VPWR VGND sky130_ef_sc_hd__decap_12
XFILLER_216_421 VPWR VGND VPWR VGND sky130_ef_sc_hd__decap_12
XFILLER_95_1304 VPWR VGND VPWR VGND sky130_ef_sc_hd__decap_12
XFILLER_228_292 VPWR VGND VPWR VGND sky130_ef_sc_hd__decap_12
XFILLER_5_1499 VGND VGND VPWR VPWR sky130_fd_sc_hd__decap_6
XFILLER_243_240 VPWR VGND VPWR VGND sky130_ef_sc_hd__decap_12
XFILLER_204_605 VPWR VGND VPWR VGND sky130_ef_sc_hd__decap_12
XFILLER_186_1465 VPWR VGND VPWR VGND sky130_ef_sc_hd__decap_12
XFILLER_189_818 VPWR VGND VPWR VGND sky130_ef_sc_hd__decap_12
XFILLER_216_476 VPWR VGND VPWR VGND sky130_ef_sc_hd__decap_12
XFILLER_232_925 VPWR VGND VPWR VGND sky130_ef_sc_hd__decap_12
XFILLER_249_1186 VPWR VGND VPWR VGND sky130_ef_sc_hd__decap_12
XFILLER_244_796 VPWR VGND VPWR VGND sky130_ef_sc_hd__decap_12
XFILLER_95_1359 VPWR VGND VPWR VGND sky130_ef_sc_hd__decap_12
XFILLER_252_3 VPWR VGND VPWR VGND sky130_ef_sc_hd__decap_12
XFILLER_231_424 VGND VGND VPWR VPWR sky130_fd_sc_hd__decap_6
XFILLER_243_295 VGND VGND VPWR VPWR sky130_fd_sc_hd__decap_6
XTAP_TAPCELL_ROW_45_2_5025 VGND VPWR sky130_fd_sc_hd__tapvpwrvgnd_1
XFILLER_212_660 VGND VGND VPWR VPWR sky130_fd_sc_hd__decap_6
XFILLER_223_1315 VPWR VGND VPWR VGND sky130_ef_sc_hd__decap_12
XFILLER_19_1165 VPWR VGND VPWR VGND sky130_ef_sc_hd__decap_12
XFILLER_169_553 VGND VGND VPWR VPWR sky130_fd_sc_hd__decap_6
XFILLER_240_980 VPWR VGND VPWR VGND sky130_ef_sc_hd__decap_12
XFILLER_197_873 VPWR VGND VPWR VGND sky130_ef_sc_hd__decap_12
XFILLER_8_703 VGND VGND VPWR VPWR sky130_fd_sc_hd__decap_6
Xwire100 net101 VGND VGND VPWR VPWR net100 sky130_fd_sc_hd__clkbuf_1
XTAP_TAPCELL_ROW_12_2_4755 VGND VPWR sky130_fd_sc_hd__tapvpwrvgnd_1
Xwire111 _203_ VGND VGND VPWR VPWR net111 sky130_fd_sc_hd__clkbuf_1
XFILLER_180_1097 VPWR VGND VPWR VGND sky130_ef_sc_hd__decap_12
Xwire155 _170_ VGND VGND VPWR VPWR net155 sky130_fd_sc_hd__clkbuf_1
Xwire188 _259_ VGND VGND VPWR VPWR net188 sky130_fd_sc_hd__clkbuf_1
Xwire199 _192_ VGND VGND VPWR VPWR net199 sky130_fd_sc_hd__clkbuf_1
XFILLER_171_228 VPWR VGND VPWR VGND sky130_ef_sc_hd__decap_12
XFILLER_119_1507 VGND VGND VPWR VPWR sky130_fd_sc_hd__decap_8
XFILLER_217_1119 VPWR VGND VPWR VGND sky130_ef_sc_hd__decap_12
XFILLER_234_1422 VPWR VGND VPWR VGND sky130_ef_sc_hd__decap_12
XFILLER_117_1242 VGND VGND VPWR VPWR sky130_fd_sc_hd__decap_6
XFILLER_234_1477 VGND VGND VPWR VPWR sky130_fd_sc_hd__decap_6
XFILLER_6_1219 VGND VGND VPWR VPWR sky130_fd_sc_hd__decap_6
XFILLER_152_1177 VGND VGND VPWR VPWR sky130_fd_sc_hd__decap_6
XTAP_TAPCELL_ROW_183_2160 VGND VPWR sky130_fd_sc_hd__tapvpwrvgnd_1
XTAP_TAPCELL_ROW_183_2171 VGND VPWR sky130_fd_sc_hd__tapvpwrvgnd_1
XFILLER_8_1090 VGND VGND VPWR VPWR sky130_fd_sc_hd__decap_6
XFILLER_226_218 VPWR VGND VPWR VGND sky130_ef_sc_hd__decap_12
XFILLER_254_538 VPWR VGND VPWR VGND sky130_ef_sc_hd__decap_12
XPHY_EDGE_ROW_101_2_Right_192 VGND VGND VPWR VPWR sky130_fd_sc_hd__decap_3
XFILLER_130_1442 VPWR VGND VPWR VGND sky130_ef_sc_hd__decap_12
XFILLER_187_1229 VPWR VGND VPWR VGND sky130_ef_sc_hd__decap_12
XFILLER_207_443 VPWR VGND VPWR VGND sky130_ef_sc_hd__decap_12
XFILLER_130_1497 VPWR VGND VPWR VGND sky130_ef_sc_hd__decap_12
XFILLER_228_1226 VPWR VGND VPWR VGND sky130_ef_sc_hd__decap_12
XFILLER_222_402 VGND VGND VPWR VPWR sky130_fd_sc_hd__decap_6
XFILLER_250_722 VPWR VGND VPWR VGND sky130_ef_sc_hd__decap_12
XPHY_EDGE_ROW_39_1_Right_695 VGND VGND VPWR VPWR sky130_fd_sc_hd__decap_3
XFILLER_234_273 VGND VGND VPWR VPWR sky130_fd_sc_hd__decap_6
XFILLER_207_498 VPWR VGND VPWR VGND sky130_ef_sc_hd__decap_12
XFILLER_223_947 VPWR VGND VPWR VGND sky130_ef_sc_hd__decap_12
XFILLER_76_1270 VPWR VGND VPWR VGND sky130_ef_sc_hd__decap_12
XFILLER_201_68 VPWR VGND VPWR VGND sky130_ef_sc_hd__decap_12
XFILLER_250_777 VPWR VGND VPWR VGND sky130_ef_sc_hd__decap_12
XFILLER_98_3 VPWR VGND VPWR VGND sky130_ef_sc_hd__decap_12
XFILLER_188_851 VPWR VGND VPWR VGND sky130_ef_sc_hd__decap_12
XFILLER_163_1273 VPWR VGND VPWR VGND sky130_ef_sc_hd__decap_12
XFILLER_203_682 VGND VGND VPWR VPWR sky130_fd_sc_hd__decap_6
XFILLER_198_1336 VPWR VGND VPWR VGND sky130_ef_sc_hd__decap_12
XPHY_EDGE_ROW_7_Left_263 VGND VGND VPWR VPWR sky130_fd_sc_hd__decap_3
XFILLER_204_1281 VPWR VGND VPWR VGND sky130_ef_sc_hd__decap_12
XFILLER_50_1454 VPWR VGND VPWR VGND sky130_ef_sc_hd__decap_12
XTAP_TAPCELL_ROW_90_2_5384 VGND VPWR sky130_fd_sc_hd__tapvpwrvgnd_1
XTAP_TAPCELL_ROW_133_2_5724 VGND VPWR sky130_fd_sc_hd__tapvpwrvgnd_1
XFILLER_239_1377 VPWR VGND VPWR VGND sky130_ef_sc_hd__decap_12
XTAP_TAPCELL_ROW_69_2_5210 VGND VPWR sky130_fd_sc_hd__tapvpwrvgnd_1
XFILLER_170_261 VPWR VGND VPWR VGND sky130_ef_sc_hd__decap_12
XFILLER_83_1230 VPWR VGND VPWR VGND sky130_ef_sc_hd__decap_12
Xmax_cap499 _119_ VGND VGND VPWR VPWR net499 sky130_fd_sc_hd__clkbuf_1
XFILLER_226_65 VPWR VGND VPWR VGND sky130_ef_sc_hd__decap_12
XFILLER_174_1391 VGND VGND VPWR VPWR sky130_fd_sc_hd__decap_6
XFILLER_213_1506 VGND VGND VPWR VPWR sky130_fd_sc_hd__decap_8
XFILLER_83_1285 VGND VGND VPWR VPWR sky130_fd_sc_hd__decap_6
XFILLER_131_1206 VPWR VGND VPWR VGND sky130_ef_sc_hd__decap_12
XTAP_TAPCELL_ROW_36_2_4951 VGND VPWR sky130_fd_sc_hd__tapvpwrvgnd_1
XTAP_TAPCELL_ROW_51_2_5068 VGND VPWR sky130_fd_sc_hd__tapvpwrvgnd_1
XTAP_TAPCELL_ROW_222_3510 VGND VPWR sky130_fd_sc_hd__tapvpwrvgnd_1
XTAP_TAPCELL_ROW_222_3521 VGND VPWR sky130_fd_sc_hd__tapvpwrvgnd_1
XTAP_TAPCELL_ROW_222_3532 VGND VPWR sky130_fd_sc_hd__tapvpwrvgnd_1
XTAP_TAPCELL_ROW_1_901 VGND VPWR sky130_fd_sc_hd__tapvpwrvgnd_1
XFILLER_211_1241 VGND VGND VPWR VPWR sky130_fd_sc_hd__decap_6
XTAP_TAPCELL_ROW_222_3543 VGND VPWR sky130_fd_sc_hd__tapvpwrvgnd_1
XTAP_TAPCELL_ROW_1_912 VGND VPWR sky130_fd_sc_hd__tapvpwrvgnd_1
XTAP_TAPCELL_ROW_1_923 VGND VPWR sky130_fd_sc_hd__tapvpwrvgnd_1
XFILLER_168_1140 VPWR VGND VPWR VGND sky130_ef_sc_hd__decap_12
XFILLER_225_240 VPWR VGND VPWR VGND sky130_ef_sc_hd__decap_12
XFILLER_253_560 VPWR VGND VPWR VGND sky130_ef_sc_hd__decap_12
XFILLER_214_925 VPWR VGND VPWR VGND sky130_ef_sc_hd__decap_12
XFILLER_226_796 VPWR VGND VPWR VGND sky130_ef_sc_hd__decap_12
XFILLER_246_1348 VGND VGND VPWR VPWR sky130_fd_sc_hd__decap_6
XFILLER_213_424 VGND VGND VPWR VPWR sky130_fd_sc_hd__decap_6
XFILLER_241_744 VPWR VGND VPWR VGND sky130_ef_sc_hd__decap_12
XFILLER_168_1195 VPWR VGND VPWR VGND sky130_ef_sc_hd__decap_12
XFILLER_225_295 VGND VGND VPWR VPWR sky130_fd_sc_hd__decap_6
XFILLER_198_648 VPWR VGND VPWR VGND sky130_ef_sc_hd__decap_12
XFILLER_111_68 VGND VGND VPWR VPWR sky130_fd_sc_hd__decap_3
XFILLER_71_39 VGND VGND VPWR VPWR sky130_fd_sc_hd__decap_4
XFILLER_94_1392 VGND VGND VPWR VPWR sky130_fd_sc_hd__decap_6
XTAP_TAPCELL_ROW_216_3303 VGND VPWR sky130_fd_sc_hd__tapvpwrvgnd_1
XFILLER_241_799 VPWR VGND VPWR VGND sky130_ef_sc_hd__decap_12
XFILLER_179_873 VPWR VGND VPWR VGND sky130_ef_sc_hd__decap_12
XTAP_TAPCELL_ROW_216_3314 VGND VPWR sky130_fd_sc_hd__tapvpwrvgnd_1
XFILLER_222_980 VPWR VGND VPWR VGND sky130_ef_sc_hd__decap_12
XFILLER_107_1433 VPWR VGND VPWR VGND sky130_ef_sc_hd__decap_12
XFILLER_142_1313 VPWR VGND VPWR VGND sky130_ef_sc_hd__decap_12
XTAP_TAPCELL_ROW_216_3325 VGND VPWR sky130_fd_sc_hd__tapvpwrvgnd_1
XFILLER_51_1218 VPWR VGND VPWR VGND sky130_ef_sc_hd__decap_12
XFILLER_187_39 VGND VGND VPWR VPWR sky130_fd_sc_hd__decap_4
XFILLER_205_1045 VPWR VGND VPWR VGND sky130_ef_sc_hd__decap_12
XFILLER_194_832 VGND VGND VPWR VPWR sky130_fd_sc_hd__decap_6
XFILLER_16_1349 VGND VGND VPWR VPWR sky130_fd_sc_hd__decap_6
XFILLER_107_1488 VPWR VGND VPWR VGND sky130_ef_sc_hd__decap_12
XFILLER_142_1368 VPWR VGND VPWR VGND sky130_ef_sc_hd__decap_12
XFILLER_5_717 VPWR VGND VPWR VGND sky130_ef_sc_hd__decap_12
XFILLER_4_227 VGND VGND VPWR VPWR sky130_fd_sc_hd__decap_8
XFILLER_175_1100 VPWR VGND VPWR VGND sky130_ef_sc_hd__decap_12
XFILLER_4_249 VGND VGND VPWR VPWR sky130_fd_sc_hd__decap_4
XFILLER_179_1291 VPWR VGND VPWR VGND sky130_ef_sc_hd__decap_12
XFILLER_20_65 VGND VGND VPWR VPWR sky130_fd_sc_hd__decap_6
XFILLER_1_901 VGND VGND VPWR VPWR sky130_fd_sc_hd__fill_2
XFILLER_88_1196 VPWR VGND VPWR VGND sky130_ef_sc_hd__decap_12
XFILLER_175_1155 VGND VGND VPWR VPWR sky130_fd_sc_hd__decap_6
XFILLER_136_65 VGND VGND VPWR VPWR sky130_fd_sc_hd__decap_6
XFILLER_249_811 VGND VGND VPWR VPWR sky130_fd_sc_hd__decap_6
XFILLER_7_1506 VGND VGND VPWR VPWR sky130_fd_sc_hd__decap_8
XFILLER_62_1325 VPWR VGND VPWR VGND sky130_ef_sc_hd__decap_12
XFILLER_27_1445 VPWR VGND VPWR VGND sky130_ef_sc_hd__decap_12
XFILLER_96_58 VGND VGND VPWR VPWR sky130_fd_sc_hd__decap_6
XFILLER_216_1152 VPWR VGND VPWR VGND sky130_ef_sc_hd__decap_12
XFILLER_153_1464 VPWR VGND VPWR VGND sky130_ef_sc_hd__decap_12
XFILLER_251_1076 VPWR VGND VPWR VGND sky130_ef_sc_hd__decap_12
XFILLER_208_218 VPWR VGND VPWR VGND sky130_ef_sc_hd__decap_12
XFILLER_5_1241 VGND VGND VPWR VPWR sky130_fd_sc_hd__decap_6
XFILLER_236_538 VPWR VGND VPWR VGND sky130_ef_sc_hd__decap_12
X_663_ clknet_3_5__leaf_clk acc_core.adder.cla_blocks\[7\].block.sum\[1\] _071_ VGND
+ VGND VPWR VPWR net64 sky130_fd_sc_hd__dfrtp_1
XTAP_TAPCELL_ROW_157_2_5920 VGND VPWR sky130_fd_sc_hd__tapvpwrvgnd_1
XFILLER_99_1292 VPWR VGND VPWR VGND sky130_ef_sc_hd__decap_12
XFILLER_204_402 VGND VGND VPWR VPWR sky130_fd_sc_hd__decap_6
X_594_ clknet_3_2__leaf_clk _076_ _002_ VGND VGND VPWR VPWR rd_addr\[2\] sky130_fd_sc_hd__dfrtp_1
XFILLER_186_1262 VGND VGND VPWR VPWR sky130_fd_sc_hd__decap_6
XFILLER_232_722 VPWR VGND VPWR VGND sky130_ef_sc_hd__decap_12
XFILLER_189_615 VPWR VGND VPWR VGND sky130_ef_sc_hd__decap_12
XFILLER_205_947 VPWR VGND VPWR VGND sky130_ef_sc_hd__decap_12
XFILLER_216_273 VGND VGND VPWR VPWR sky130_fd_sc_hd__decap_6
XFILLER_244_593 VPWR VGND VPWR VGND sky130_ef_sc_hd__decap_12
XFILLER_95_1189 VPWR VGND VPWR VGND sky130_ef_sc_hd__decap_12
XFILLER_108_1208 VPWR VGND VPWR VGND sky130_ef_sc_hd__decap_12
XFILLER_220_906 VPWR VGND VPWR VGND sky130_ef_sc_hd__decap_12
XFILLER_73_1421 VPWR VGND VPWR VGND sky130_ef_sc_hd__decap_12
XFILLER_232_777 VPWR VGND VPWR VGND sky130_ef_sc_hd__decap_12
XFILLER_125_1500 VGND VGND VPWR VPWR sky130_fd_sc_hd__decap_6
XFILLER_223_1112 VGND VGND VPWR VPWR sky130_fd_sc_hd__decap_6
XFILLER_197_670 VPWR VGND VPWR VGND sky130_ef_sc_hd__decap_12
XFILLER_73_1476 VPWR VGND VPWR VGND sky130_ef_sc_hd__decap_12
XFILLER_160_1435 VGND VGND VPWR VPWR sky130_fd_sc_hd__decap_6
XFILLER_8_511 VGND VGND VPWR VPWR sky130_fd_sc_hd__decap_4
XTAP_TAPCELL_ROW_75_2_5264 VGND VPWR sky130_fd_sc_hd__tapvpwrvgnd_1
XFILLER_185_854 VGND VGND VPWR VPWR sky130_fd_sc_hd__decap_6
XTAP_TAPCELL_ROW_191_2440 VGND VPWR sky130_fd_sc_hd__tapvpwrvgnd_1
XTAP_TAPCELL_ROW_191_2451 VGND VPWR sky130_fd_sc_hd__tapvpwrvgnd_1
XTAP_TAPCELL_ROW_118_2_5604 VGND VPWR sky130_fd_sc_hd__tapvpwrvgnd_1
XFILLER_201_1432 VPWR VGND VPWR VGND sky130_ef_sc_hd__decap_12
XFILLER_6_34 VPWR VGND VPWR VGND sky130_ef_sc_hd__decap_12
XFILLER_32_1184 VPWR VGND VPWR VGND sky130_ef_sc_hd__decap_12
XANTENNA_5 dout0\[10\] VGND VGND VPWR VPWR sky130_fd_sc_hd__diode_2
XFILLER_201_1487 VPWR VGND VPWR VGND sky130_ef_sc_hd__decap_12
XTAP_TAPCELL_ROW_42_2_4994 VGND VPWR sky130_fd_sc_hd__tapvpwrvgnd_1
XFILLER_6_89 VPWR VGND VPWR VGND sky130_ef_sc_hd__decap_12
XFILLER_119_1304 VPWR VGND VPWR VGND sky130_ef_sc_hd__decap_12
XPHY_EDGE_ROW_234_Right_79 VGND VGND VPWR VPWR sky130_fd_sc_hd__decap_3
XFILLER_180_581 VPWR VGND VPWR VGND sky130_ef_sc_hd__decap_12
XTAP_TAPCELL_ROW_189_2380 VGND VPWR sky130_fd_sc_hd__tapvpwrvgnd_1
XFILLER_119_1359 VPWR VGND VPWR VGND sky130_ef_sc_hd__decap_12
XFILLER_154_1239 VPWR VGND VPWR VGND sky130_ef_sc_hd__decap_12
XTAP_TAPCELL_ROW_185_2222 VGND VPWR sky130_fd_sc_hd__tapvpwrvgnd_1
XFILLER_3_282 VGND VGND VPWR VPWR sky130_fd_sc_hd__decap_3
XTAP_TAPCELL_ROW_185_2233 VGND VPWR sky130_fd_sc_hd__tapvpwrvgnd_1
XTAP_TAPCELL_ROW_185_2244 VGND VPWR sky130_fd_sc_hd__tapvpwrvgnd_1
XTAP_TAPCELL_ROW_181_2108 VGND VPWR sky130_fd_sc_hd__tapvpwrvgnd_1
XTAP_TAPCELL_ROW_55_1_1312 VGND VPWR sky130_fd_sc_hd__tapvpwrvgnd_1
XFILLER_13_3 VPWR VGND VPWR VGND sky130_ef_sc_hd__decap_12
XFILLER_254_335 VPWR VGND VPWR VGND sky130_ef_sc_hd__decap_12
XFILLER_187_1026 VGND VGND VPWR VPWR sky130_fd_sc_hd__decap_6
XPHY_EDGE_ROW_102_2_Right_193 VGND VGND VPWR VPWR sky130_fd_sc_hd__decap_3
XFILLER_212_34 VPWR VGND VPWR VGND sky130_ef_sc_hd__decap_12
XFILLER_207_240 VPWR VGND VPWR VGND sky130_ef_sc_hd__decap_12
XFILLER_242_519 VPWR VGND VPWR VGND sky130_ef_sc_hd__decap_12
XPHY_EDGE_ROW_18_1_Left_273 VGND VGND VPWR VPWR sky130_fd_sc_hd__decap_3
XFILLER_235_560 VPWR VGND VPWR VGND sky130_ef_sc_hd__decap_12
XFILLER_130_1294 VPWR VGND VPWR VGND sky130_ef_sc_hd__decap_12
XTAP_TAPCELL_ROW_179_2004 VGND VPWR sky130_fd_sc_hd__tapvpwrvgnd_1
XPHY_EDGE_ROW_243_Right_88 VGND VGND VPWR VPWR sky130_fd_sc_hd__decap_3
XTAP_TAPCELL_ROW_179_2015 VGND VPWR sky130_fd_sc_hd__tapvpwrvgnd_1
XFILLER_39_1316 VPWR VGND VPWR VGND sky130_ef_sc_hd__decap_12
XTAP_TAPCELL_ROW_179_2026 VGND VPWR sky130_fd_sc_hd__tapvpwrvgnd_1
XFILLER_208_796 VPWR VGND VPWR VGND sky130_ef_sc_hd__decap_12
XFILLER_228_1023 VPWR VGND VPWR VGND sky130_ef_sc_hd__decap_12
XFILLER_165_1324 VPWR VGND VPWR VGND sky130_ef_sc_hd__decap_12
XTAP_TAPCELL_ROW_179_2037 VGND VPWR sky130_fd_sc_hd__tapvpwrvgnd_1
XFILLER_212_89 VPWR VGND VPWR VGND sky130_ef_sc_hd__decap_12
XFILLER_207_295 VGND VGND VPWR VPWR sky130_fd_sc_hd__decap_6
XFILLER_223_744 VPWR VGND VPWR VGND sky130_ef_sc_hd__decap_12
XFILLER_165_1357 VGND VGND VPWR VPWR sky130_fd_sc_hd__decap_8
XFILLER_228_1078 VPWR VGND VPWR VGND sky130_ef_sc_hd__decap_12
XFILLER_250_574 VGND VGND VPWR VPWR sky130_fd_sc_hd__decap_6
XFILLER_211_928 VPWR VGND VPWR VGND sky130_ef_sc_hd__decap_12
XFILLER_245_1370 VGND VGND VPWR VPWR sky130_fd_sc_hd__decap_6
XFILLER_223_799 VPWR VGND VPWR VGND sky130_ef_sc_hd__decap_12
XFILLER_204_980 VPWR VGND VPWR VGND sky130_ef_sc_hd__decap_12
XFILLER_176_832 VGND VGND VPWR VPWR sky130_fd_sc_hd__decap_6
XFILLER_202_1207 VPWR VGND VPWR VGND sky130_ef_sc_hd__decap_12
XFILLER_206_1398 VPWR VGND VPWR VGND sky130_ef_sc_hd__decap_12
XTAP_TAPCELL_ROW_230_3801 VGND VPWR sky130_fd_sc_hd__tapvpwrvgnd_1
XFILLER_198_1133 VGND VGND VPWR VPWR sky130_fd_sc_hd__decap_6
XTAP_TAPCELL_ROW_230_3812 VGND VPWR sky130_fd_sc_hd__tapvpwrvgnd_1
XTAP_TAPCELL_ROW_230_3823 VGND VPWR sky130_fd_sc_hd__tapvpwrvgnd_1
XFILLER_50_1251 VPWR VGND VPWR VGND sky130_ef_sc_hd__decap_12
XFILLER_15_1371 VGND VGND VPWR VPWR sky130_fd_sc_hd__decap_6
XFILLER_141_1390 VPWR VGND VPWR VGND sky130_ef_sc_hd__decap_12
XFILLER_190_323 VPWR VGND VPWR VGND sky130_ef_sc_hd__decap_12
XPHY_EDGE_ROW_252_Right_97 VGND VGND VPWR VPWR sky130_fd_sc_hd__decap_3
XFILLER_176_1453 VPWR VGND VPWR VGND sky130_ef_sc_hd__decap_12
XFILLER_190_378 VPWR VGND VPWR VGND sky130_ef_sc_hd__decap_12
XFILLER_239_1174 VPWR VGND VPWR VGND sky130_ef_sc_hd__decap_12
XFILLER_85_1347 VPWR VGND VPWR VGND sky130_ef_sc_hd__decap_12
XTAP_TAPCELL_ROW_228_3730 VGND VPWR sky130_fd_sc_hd__tapvpwrvgnd_1
XTAP_TAPCELL_ROW_228_3741 VGND VPWR sky130_fd_sc_hd__tapvpwrvgnd_1
XTAP_TAPCELL_ROW_228_3752 VGND VPWR sky130_fd_sc_hd__tapvpwrvgnd_1
XTAP_TAPCELL_ROW_163_2_5963 VGND VPWR sky130_fd_sc_hd__tapvpwrvgnd_1
XFILLER_213_1303 VPWR VGND VPWR VGND sky130_ef_sc_hd__decap_12
XFILLER_106_46 VPWR VGND VPWR VGND sky130_ef_sc_hd__decap_12
XTAP_TAPCELL_ROW_224_3605 VGND VPWR sky130_fd_sc_hd__tapvpwrvgnd_1
XTAP_TAPCELL_ROW_90_1_1364 VGND VPWR sky130_fd_sc_hd__tapvpwrvgnd_1
XFILLER_213_1358 VPWR VGND VPWR VGND sky130_ef_sc_hd__decap_12
XFILLER_245_302 VPWR VGND VPWR VGND sky130_ef_sc_hd__decap_12
XPHY_EDGE_ROW_151_1_Left_406 VGND VGND VPWR VPWR sky130_fd_sc_hd__decap_3
XFILLER_218_538 VPWR VGND VPWR VGND sky130_ef_sc_hd__decap_12
XFILLER_245_357 VPWR VGND VPWR VGND sky130_ef_sc_hd__decap_12
XFILLER_122_34 VPWR VGND VPWR VGND sky130_ef_sc_hd__decap_12
XFILLER_96_1454 VPWR VGND VPWR VGND sky130_ef_sc_hd__decap_12
XFILLER_214_722 VPWR VGND VPWR VGND sky130_ef_sc_hd__decap_12
XFILLER_183_1413 VGND VGND VPWR VPWR sky130_fd_sc_hd__decap_6
XFILLER_226_593 VPWR VGND VPWR VGND sky130_ef_sc_hd__decap_12
XFILLER_241_541 VPWR VGND VPWR VGND sky130_ef_sc_hd__decap_12
XFILLER_202_906 VPWR VGND VPWR VGND sky130_ef_sc_hd__decap_12
XFILLER_198_445 VGND VGND VPWR VPWR sky130_fd_sc_hd__decap_6
XFILLER_214_777 VPWR VGND VPWR VGND sky130_ef_sc_hd__decap_12
XFILLER_224_1410 VPWR VGND VPWR VGND sky130_ef_sc_hd__decap_12
XTAP_TAPCELL_ROW_61_2_5150 VGND VPWR sky130_fd_sc_hd__tapvpwrvgnd_1
XFILLER_241_596 VGND VGND VPWR VPWR sky130_fd_sc_hd__decap_6
XFILLER_179_670 VPWR VGND VPWR VGND sky130_ef_sc_hd__decap_12
XFILLER_9_319 VPWR VGND VPWR VGND sky130_ef_sc_hd__decap_12
XFILLER_107_1230 VPWR VGND VPWR VGND sky130_ef_sc_hd__decap_12
XFILLER_224_1465 VPWR VGND VPWR VGND sky130_ef_sc_hd__decap_12
XFILLER_210_961 VGND VGND VPWR VPWR sky130_fd_sc_hd__decap_6
XFILLER_167_854 VGND VGND VPWR VPWR sky130_fd_sc_hd__decap_6
XFILLER_107_1285 VGND VGND VPWR VPWR sky130_fd_sc_hd__decap_6
XFILLER_142_1165 VPWR VGND VPWR VGND sky130_ef_sc_hd__decap_12
XTAP_TAPCELL_ROW_27_2_4874 VGND VPWR sky130_fd_sc_hd__tapvpwrvgnd_1
XFILLER_215_3 VPWR VGND VPWR VGND sky130_ef_sc_hd__decap_12
XFILLER_177_1217 VPWR VGND VPWR VGND sky130_ef_sc_hd__decap_12
XFILLER_181_345 VPWR VGND VPWR VGND sky130_ef_sc_hd__decap_12
XFILLER_120_1485 VPWR VGND VPWR VGND sky130_ef_sc_hd__decap_12
XFILLER_29_1507 VGND VGND VPWR VPWR sky130_fd_sc_hd__decap_8
Xoutput53 net53 VGND VGND VPWR VPWR acc_out[19] sky130_fd_sc_hd__buf_2
Xoutput64 net64 VGND VGND VPWR VPWR acc_out[29] sky130_fd_sc_hd__buf_2
XFILLER_218_1269 VPWR VGND VPWR VGND sky130_ef_sc_hd__decap_12
XFILLER_27_1242 VGND VGND VPWR VPWR sky130_fd_sc_hd__decap_6
XFILLER_7_1303 VPWR VGND VPWR VGND sky130_ef_sc_hd__decap_12
XFILLER_1_775 VGND VGND VPWR VPWR sky130_fd_sc_hd__fill_1
XPHY_EDGE_ROW_83_1_Left_338 VGND VGND VPWR VPWR sky130_fd_sc_hd__decap_3
XFILLER_153_1261 VPWR VGND VPWR VGND sky130_ef_sc_hd__decap_12
XFILLER_1_797 VGND VGND VPWR VPWR sky130_fd_sc_hd__fill_2
XFILLER_0_274 VGND VGND VPWR VPWR sky130_fd_sc_hd__fill_1
XFILLER_118_1392 VGND VGND VPWR VPWR sky130_fd_sc_hd__decap_6
XFILLER_248_151 VPWR VGND VPWR VGND sky130_ef_sc_hd__decap_12
XTAP_TAPCELL_ROW_240_4141 VGND VPWR sky130_fd_sc_hd__tapvpwrvgnd_1
XFILLER_62_1177 VGND VGND VPWR VPWR sky130_fd_sc_hd__decap_6
XFILLER_7_1358 VPWR VGND VPWR VGND sky130_ef_sc_hd__decap_12
XTAP_TAPCELL_ROW_240_4152 VGND VPWR sky130_fd_sc_hd__tapvpwrvgnd_1
XTAP_TAPCELL_ROW_240_4163 VGND VPWR sky130_fd_sc_hd__tapvpwrvgnd_1
XFILLER_188_1324 VPWR VGND VPWR VGND sky130_ef_sc_hd__decap_12
XFILLER_97_1218 VPWR VGND VPWR VGND sky130_ef_sc_hd__decap_12
XFILLER_236_335 VPWR VGND VPWR VGND sky130_ef_sc_hd__decap_12
XFILLER_40_1442 VPWR VGND VPWR VGND sky130_ef_sc_hd__decap_12
XFILLER_224_519 VPWR VGND VPWR VGND sky130_ef_sc_hd__decap_12
XFILLER_252_839 VPWR VGND VPWR VGND sky130_ef_sc_hd__decap_12
XFILLER_188_1379 VPWR VGND VPWR VGND sky130_ef_sc_hd__decap_12
XFILLER_217_560 VPWR VGND VPWR VGND sky130_ef_sc_hd__decap_12
X_646_ clknet_3_1__leaf_clk acc_core.adder.cla_blocks\[3\].block.sum\[0\] _054_ VGND
+ VGND VPWR VPWR net46 sky130_fd_sc_hd__dfrtp_1
XFILLER_40_1497 VPWR VGND VPWR VGND sky130_ef_sc_hd__decap_12
XFILLER_251_338 VGND VGND VPWR VPWR sky130_fd_sc_hd__decap_6
XFILLER_189_412 VPWR VGND VPWR VGND sky130_ef_sc_hd__decap_12
XFILLER_244_390 VPWR VGND VPWR VGND sky130_ef_sc_hd__decap_12
XFILLER_205_744 VPWR VGND VPWR VGND sky130_ef_sc_hd__decap_12
X_577_ net668 VGND VGND VPWR VPWR _059_ sky130_fd_sc_hd__inv_2
XTAP_TAPCELL_ROW_238_4070 VGND VPWR sky130_fd_sc_hd__tapvpwrvgnd_1
XTAP_TAPCELL_ROW_197_2660 VGND VPWR sky130_fd_sc_hd__tapvpwrvgnd_1
XTAP_TAPCELL_ROW_201_2778 VGND VPWR sky130_fd_sc_hd__tapvpwrvgnd_1
XFILLER_220_703 VGND VGND VPWR VPWR sky130_fd_sc_hd__decap_6
XFILLER_225_1229 VPWR VGND VPWR VGND sky130_ef_sc_hd__decap_12
XTAP_TAPCELL_ROW_238_4081 VGND VPWR sky130_fd_sc_hd__tapvpwrvgnd_1
XFILLER_189_467 VGND VGND VPWR VPWR sky130_fd_sc_hd__decap_6
XTAP_TAPCELL_ROW_193_2502 VGND VPWR sky130_fd_sc_hd__tapvpwrvgnd_1
XTAP_TAPCELL_ROW_201_2789 VGND VPWR sky130_fd_sc_hd__tapvpwrvgnd_1
XFILLER_232_574 VGND VGND VPWR VPWR sky130_fd_sc_hd__decap_6
XTAP_TAPCELL_ROW_238_4092 VGND VPWR sky130_fd_sc_hd__tapvpwrvgnd_1
XTAP_TAPCELL_ROW_193_2513 VGND VPWR sky130_fd_sc_hd__tapvpwrvgnd_1
XFILLER_205_799 VPWR VGND VPWR VGND sky130_ef_sc_hd__decap_12
XTAP_TAPCELL_ROW_193_2524 VGND VPWR sky130_fd_sc_hd__tapvpwrvgnd_1
XFILLER_9_820 VPWR VGND VPWR VGND sky130_ef_sc_hd__decap_12
XFILLER_73_1273 VPWR VGND VPWR VGND sky130_ef_sc_hd__decap_12
XFILLER_199_1420 VPWR VGND VPWR VGND sky130_ef_sc_hd__decap_12
XFILLER_9_853 VGND VGND VPWR VPWR sky130_fd_sc_hd__decap_8
XFILLER_201_983 VGND VGND VPWR VPWR sky130_fd_sc_hd__decap_6
XPHY_EDGE_ROW_160_1_Right_816 VGND VGND VPWR VPWR sky130_fd_sc_hd__decap_3
XFILLER_121_1249 VPWR VGND VPWR VGND sky130_ef_sc_hd__decap_12
XFILLER_199_1475 VPWR VGND VPWR VGND sky130_ef_sc_hd__decap_12
XFILLER_8_385 VPWR VGND VPWR VGND sky130_ef_sc_hd__decap_12
XFILLER_172_323 VPWR VGND VPWR VGND sky130_ef_sc_hd__decap_12
XFILLER_184_194 VPWR VGND VPWR VGND sky130_ef_sc_hd__decap_12
XFILLER_201_1284 VGND VGND VPWR VPWR sky130_fd_sc_hd__decap_6
XFILLER_172_378 VPWR VGND VPWR VGND sky130_ef_sc_hd__decap_12
XTAP_TAPCELL_ROW_187_2306 VGND VPWR sky130_fd_sc_hd__tapvpwrvgnd_1
XTAP_TAPCELL_ROW_187_2317 VGND VPWR sky130_fd_sc_hd__tapvpwrvgnd_1
XFILLER_82_1509 VGND VGND VPWR VPWR sky130_fd_sc_hd__decap_6
XTAP_TAPCELL_ROW_148_2_5843 VGND VPWR sky130_fd_sc_hd__tapvpwrvgnd_1
XFILLER_236_1336 VPWR VGND VPWR VGND sky130_ef_sc_hd__decap_12
XFILLER_207_56 VPWR VGND VPWR VGND sky130_ef_sc_hd__decap_12
XFILLER_84_1380 VPWR VGND VPWR VGND sky130_ef_sc_hd__decap_12
XFILLER_119_1189 VPWR VGND VPWR VGND sky130_ef_sc_hd__decap_12
XFILLER_41_1206 VPWR VGND VPWR VGND sky130_ef_sc_hd__decap_12
XFILLER_227_302 VPWR VGND VPWR VGND sky130_ef_sc_hd__decap_12
XFILLER_255_622 VGND VGND VPWR VPWR sky130_fd_sc_hd__decap_8
XFILLER_132_1356 VPWR VGND VPWR VGND sky130_ef_sc_hd__decap_12
XFILLER_239_173 VPWR VGND VPWR VGND sky130_ef_sc_hd__decap_12
XFILLER_223_44 VPWR VGND VPWR VGND sky130_ef_sc_hd__decap_12
XFILLER_254_132 VPWR VGND VPWR VGND sky130_ef_sc_hd__decap_12
XFILLER_227_357 VPWR VGND VPWR VGND sky130_ef_sc_hd__decap_12
XTAP_TAPCELL_ROW_66_2_5187 VGND VPWR sky130_fd_sc_hd__tapvpwrvgnd_1
XFILLER_212_1391 VGND VGND VPWR VPWR sky130_fd_sc_hd__decap_6
XFILLER_223_99 VPWR VGND VPWR VGND sky130_ef_sc_hd__decap_12
XFILLER_242_316 VGND VGND VPWR VPWR sky130_fd_sc_hd__decap_6
XTAP_TAPCELL_ROW_110_2_5544 VGND VPWR sky130_fd_sc_hd__tapvpwrvgnd_1
XFILLER_199_209 VGND VGND VPWR VPWR sky130_fd_sc_hd__decap_6
XFILLER_254_187 VGND VGND VPWR VPWR sky130_fd_sc_hd__decap_6
XFILLER_247_1432 VPWR VGND VPWR VGND sky130_ef_sc_hd__decap_12
XPHY_EDGE_ROW_103_2_Right_194 VGND VGND VPWR VPWR sky130_fd_sc_hd__decap_3
XFILLER_208_593 VPWR VGND VPWR VGND sky130_ef_sc_hd__decap_12
XTAP_TAPCELL_ROW_46_2_5030 VGND VPWR sky130_fd_sc_hd__tapvpwrvgnd_1
XFILLER_78_1184 VPWR VGND VPWR VGND sky130_ef_sc_hd__decap_12
XFILLER_223_541 VPWR VGND VPWR VGND sky130_ef_sc_hd__decap_12
XFILLER_251_861 VPWR VGND VPWR VGND sky130_ef_sc_hd__decap_12
XFILLER_247_1487 VPWR VGND VPWR VGND sky130_ef_sc_hd__decap_12
XFILLER_39_1168 VPWR VGND VPWR VGND sky130_ef_sc_hd__decap_12
XFILLER_211_725 VGND VGND VPWR VPWR sky130_fd_sc_hd__decap_6
XFILLER_223_596 VGND VGND VPWR VPWR sky130_fd_sc_hd__decap_6
XFILLER_165_1198 VPWR VGND VPWR VGND sky130_ef_sc_hd__decap_12
XFILLER_196_949 VPWR VGND VPWR VGND sky130_ef_sc_hd__decap_12
XFILLER_52_1313 VPWR VGND VPWR VGND sky130_ef_sc_hd__decap_12
XFILLER_17_1433 VPWR VGND VPWR VGND sky130_ef_sc_hd__decap_12
XFILLER_189_990 VPWR VGND VPWR VGND sky130_ef_sc_hd__decap_12
XFILLER_206_1140 VPWR VGND VPWR VGND sky130_ef_sc_hd__decap_12
XFILLER_202_1004 VGND VGND VPWR VPWR sky130_fd_sc_hd__decap_6
XFILLER_52_1368 VPWR VGND VPWR VGND sky130_ef_sc_hd__decap_12
XFILLER_17_1488 VPWR VGND VPWR VGND sky130_ef_sc_hd__decap_12
XFILLER_206_1195 VPWR VGND VPWR VGND sky130_ef_sc_hd__decap_12
XFILLER_190_120 VPWR VGND VPWR VGND sky130_ef_sc_hd__decap_12
XFILLER_137_1201 VGND VGND VPWR VPWR sky130_fd_sc_hd__decap_4
XFILLER_176_1250 VPWR VGND VPWR VGND sky130_ef_sc_hd__decap_12
XFILLER_190_175 VPWR VGND VPWR VGND sky130_ef_sc_hd__decap_12
Xsram0_679 VGND VGND VPWR VPWR sram0_679/HI net679 sky130_fd_sc_hd__conb_1
XFILLER_117_56 VPWR VGND VPWR VGND sky130_ef_sc_hd__decap_12
XTAP_TAPCELL_ROW_170_1697 VGND VPWR sky130_fd_sc_hd__tapvpwrvgnd_1
XFILLER_85_1177 VPWR VGND VPWR VGND sky130_ef_sc_hd__decap_12
XFILLER_77_27 VPWR VGND VPWR VGND sky130_ef_sc_hd__decap_12
XFILLER_213_1100 VPWR VGND VPWR VGND sky130_ef_sc_hd__decap_12
XFILLER_63_1464 VPWR VGND VPWR VGND sky130_ef_sc_hd__decap_12
XFILLER_217_1291 VPWR VGND VPWR VGND sky130_ef_sc_hd__decap_12
XFILLER_150_1423 VPWR VGND VPWR VGND sky130_ef_sc_hd__decap_12
XFILLER_213_1155 VGND VGND VPWR VPWR sky130_fd_sc_hd__decap_6
XFILLER_133_44 VPWR VGND VPWR VGND sky130_ef_sc_hd__decap_12
XFILLER_218_335 VPWR VGND VPWR VGND sky130_ef_sc_hd__decap_12
XFILLER_93_15 VPWR VGND VPWR VGND sky130_ef_sc_hd__decap_12
XFILLER_150_1478 VGND VGND VPWR VPWR sky130_fd_sc_hd__decap_6
XFILLER_248_1207 VPWR VGND VPWR VGND sky130_ef_sc_hd__decap_12
XFILLER_245_154 VPWR VGND VPWR VGND sky130_ef_sc_hd__decap_12
XFILLER_6_1391 VGND VGND VPWR VPWR sky130_fd_sc_hd__decap_6
X_500_ net505 net90 VGND VGND VPWR VPWR _255_ sky130_fd_sc_hd__nor2_1
XFILLER_206_519 VPWR VGND VPWR VGND sky130_ef_sc_hd__decap_12
XFILLER_234_839 VPWR VGND VPWR VGND sky130_ef_sc_hd__decap_12
XFILLER_26_42 VGND VGND VPWR VPWR sky130_fd_sc_hd__fill_2
XFILLER_96_1251 VPWR VGND VPWR VGND sky130_ef_sc_hd__decap_12
XFILLER_233_338 VGND VGND VPWR VPWR sky130_fd_sc_hd__decap_6
XFILLER_165_3 VPWR VGND VPWR VGND sky130_ef_sc_hd__decap_12
Xclkbuf_3_6__f_clk clknet_0_clk VGND VGND VPWR VPWR clknet_3_6__leaf_clk sky130_fd_sc_hd__clkbuf_16
X_431_ net129 VGND VGND VPWR VPWR _220_ sky130_fd_sc_hd__inv_2
XFILLER_199_732 VPWR VGND VPWR VGND sky130_ef_sc_hd__decap_12
XFILLER_226_390 VPWR VGND VPWR VGND sky130_ef_sc_hd__decap_12
XFILLER_202_703 VGND VGND VPWR VPWR sky130_fd_sc_hd__decap_6
XFILLER_18_1208 VPWR VGND VPWR VGND sky130_ef_sc_hd__decap_12
XFILLER_187_916 VPWR VGND VPWR VGND sky130_ef_sc_hd__decap_12
XFILLER_214_574 VGND VGND VPWR VPWR sky130_fd_sc_hd__decap_6
XFILLER_242_894 VPWR VGND VPWR VGND sky130_ef_sc_hd__decap_12
X_362_ net593 net576 net548 VGND VGND VPWR VPWR _151_ sky130_fd_sc_hd__and3_1
XFILLER_199_787 VPWR VGND VPWR VGND sky130_ef_sc_hd__decap_12
XFILLER_35_1500 VGND VGND VPWR VPWR sky130_fd_sc_hd__decap_6
XFILLER_109_1347 VPWR VGND VPWR VGND sky130_ef_sc_hd__decap_12
XFILLER_144_1227 VPWR VGND VPWR VGND sky130_ef_sc_hd__decap_12
XFILLER_70_1435 VGND VGND VPWR VPWR sky130_fd_sc_hd__decap_6
X_293_ net612 net520 net692 VGND VGND VPWR VPWR _087_ sky130_fd_sc_hd__a21oi_1
XFILLER_9_127 VPWR VGND VPWR VGND sky130_ef_sc_hd__decap_12
XFILLER_224_1262 VGND VGND VPWR VPWR sky130_fd_sc_hd__decap_6
XTAP_TAPCELL_ROW_252_4590 VGND VPWR sky130_fd_sc_hd__tapvpwrvgnd_1
XFILLER_195_971 VPWR VGND VPWR VGND sky130_ef_sc_hd__decap_12
XTAP_TAPCELL_ROW_154_2_5897 VGND VPWR sky130_fd_sc_hd__tapvpwrvgnd_1
XFILLER_5_311 VGND VGND VPWR VPWR sky130_fd_sc_hd__decap_4
XFILLER_177_1014 VPWR VGND VPWR VGND sky130_ef_sc_hd__decap_12
XFILLER_166_194 VPWR VGND VPWR VGND sky130_ef_sc_hd__decap_12
XFILLER_181_142 VPWR VGND VPWR VGND sky130_ef_sc_hd__decap_12
XFILLER_120_1282 VPWR VGND VPWR VGND sky130_ef_sc_hd__decap_12
XFILLER_177_1069 VGND VGND VPWR VPWR sky130_fd_sc_hd__decap_6
XFILLER_29_1304 VPWR VGND VPWR VGND sky130_ef_sc_hd__decap_12
XFILLER_218_1011 VPWR VGND VPWR VGND sky130_ef_sc_hd__decap_12
XTAP_TAPCELL_ROW_246_4350 VGND VPWR sky130_fd_sc_hd__tapvpwrvgnd_1
XFILLER_181_197 VPWR VGND VPWR VGND sky130_ef_sc_hd__decap_12
XTAP_TAPCELL_ROW_246_4361 VGND VPWR sky130_fd_sc_hd__tapvpwrvgnd_1
XTAP_TAPCELL_ROW_246_4372 VGND VPWR sky130_fd_sc_hd__tapvpwrvgnd_1
XTAP_TAPCELL_ROW_242_4214 VGND VPWR sky130_fd_sc_hd__tapvpwrvgnd_1
XFILLER_64_1239 VPWR VGND VPWR VGND sky130_ef_sc_hd__decap_12
XFILLER_218_1066 VPWR VGND VPWR VGND sky130_ef_sc_hd__decap_12
XTAP_TAPCELL_ROW_246_4383 VGND VPWR sky130_fd_sc_hd__tapvpwrvgnd_1
XFILLER_29_1359 VPWR VGND VPWR VGND sky130_ef_sc_hd__decap_12
XTAP_TAPCELL_ROW_242_4225 VGND VPWR sky130_fd_sc_hd__tapvpwrvgnd_1
XTAP_TAPCELL_ROW_242_4236 VGND VPWR sky130_fd_sc_hd__tapvpwrvgnd_1
XFILLER_7_1100 VPWR VGND VPWR VGND sky130_ef_sc_hd__decap_12
XFILLER_155_1378 VPWR VGND VPWR VGND sky130_ef_sc_hd__decap_12
XFILLER_190_1269 VPWR VGND VPWR VGND sky130_ef_sc_hd__decap_12
XTAP_TAPCELL_ROW_83_2_5326 VGND VPWR sky130_fd_sc_hd__tapvpwrvgnd_1
XFILLER_3_68 VPWR VGND VPWR VGND sky130_ef_sc_hd__decap_12
XFILLER_209_302 VPWR VGND VPWR VGND sky130_ef_sc_hd__decap_12
XFILLER_7_1155 VGND VGND VPWR VPWR sky130_fd_sc_hd__decap_6
XTAP_TAPCELL_ROW_8_1150 VGND VPWR sky130_fd_sc_hd__tapvpwrvgnd_1
XTAP_TAPCELL_ROW_8_1161 VGND VPWR sky130_fd_sc_hd__tapvpwrvgnd_1
XFILLER_188_1121 VPWR VGND VPWR VGND sky130_ef_sc_hd__decap_12
XFILLER_236_132 VPWR VGND VPWR VGND sky130_ef_sc_hd__decap_12
XTAP_TAPCELL_ROW_8_1172 VGND VPWR sky130_fd_sc_hd__tapvpwrvgnd_1
XTAP_TAPCELL_ROW_4_1003 VGND VPWR sky130_fd_sc_hd__tapvpwrvgnd_1
XFILLER_209_357 VPWR VGND VPWR VGND sky130_ef_sc_hd__decap_12
XTAP_TAPCELL_ROW_4_1014 VGND VPWR sky130_fd_sc_hd__tapvpwrvgnd_1
XTAP_TAPCELL_ROW_4_1025 VGND VPWR sky130_fd_sc_hd__tapvpwrvgnd_1
XTAP_TAPCELL_ROW_207_2987 VGND VPWR sky130_fd_sc_hd__tapvpwrvgnd_1
XTAP_TAPCELL_ROW_199_2711 VGND VPWR sky130_fd_sc_hd__tapvpwrvgnd_1
XTAP_TAPCELL_ROW_207_2998 VGND VPWR sky130_fd_sc_hd__tapvpwrvgnd_1
XTAP_TAPCELL_ROW_199_2722 VGND VPWR sky130_fd_sc_hd__tapvpwrvgnd_1
XFILLER_224_316 VGND VGND VPWR VPWR sky130_fd_sc_hd__decap_6
XFILLER_252_636 VPWR VGND VPWR VGND sky130_ef_sc_hd__decap_12
XFILLER_188_1176 VGND VGND VPWR VPWR sky130_fd_sc_hd__decap_6
XTAP_TAPCELL_ROW_199_2733 VGND VPWR sky130_fd_sc_hd__tapvpwrvgnd_1
XFILLER_236_187 VGND VGND VPWR VPWR sky130_fd_sc_hd__decap_6
XFILLER_40_1294 VPWR VGND VPWR VGND sky130_ef_sc_hd__decap_12
XTAP_TAPCELL_ROW_236_4007 VGND VPWR sky130_fd_sc_hd__tapvpwrvgnd_1
XTAP_TAPCELL_ROW_236_4018 VGND VPWR sky130_fd_sc_hd__tapvpwrvgnd_1
XFILLER_205_541 VPWR VGND VPWR VGND sky130_ef_sc_hd__decap_12
X_629_ clknet_3_5__leaf_clk dout0\[27\] _037_ VGND VGND VPWR VPWR dout0_q\[27\] sky130_fd_sc_hd__dfrtp_1
XFILLER_166_1441 VPWR VGND VPWR VGND sky130_ef_sc_hd__decap_12
XFILLER_229_1162 VPWR VGND VPWR VGND sky130_ef_sc_hd__decap_12
XTAP_TAPCELL_ROW_236_4029 VGND VPWR sky130_fd_sc_hd__tapvpwrvgnd_1
XFILLER_75_1335 VPWR VGND VPWR VGND sky130_ef_sc_hd__decap_12
XFILLER_233_861 VPWR VGND VPWR VGND sky130_ef_sc_hd__decap_12
XFILLER_127_1414 VGND VGND VPWR VPWR sky130_fd_sc_hd__decap_6
XFILLER_225_1026 VGND VGND VPWR VPWR sky130_fd_sc_hd__decap_6
XFILLER_205_596 VGND VGND VPWR VPWR sky130_fd_sc_hd__decap_6
XFILLER_166_1496 VPWR VGND VPWR VGND sky130_ef_sc_hd__decap_12
XFILLER_178_949 VPWR VGND VPWR VGND sky130_ef_sc_hd__decap_12
XFILLER_162_1349 VGND VGND VPWR VPWR sky130_fd_sc_hd__decap_6
XFILLER_80_3 VPWR VGND VPWR VGND sky130_ef_sc_hd__decap_12
XFILLER_203_1346 VPWR VGND VPWR VGND sky130_ef_sc_hd__decap_12
XFILLER_9_694 VPWR VGND VPWR VGND sky130_ef_sc_hd__decap_12
XFILLER_199_1272 VPWR VGND VPWR VGND sky130_ef_sc_hd__decap_12
XFILLER_172_120 VPWR VGND VPWR VGND sky130_ef_sc_hd__decap_12
XFILLER_218_22 VPWR VGND VPWR VGND sky130_ef_sc_hd__decap_12
XFILLER_51_1390 VPWR VGND VPWR VGND sky130_ef_sc_hd__decap_12
XPHY_EDGE_ROW_161_1_Right_817 VGND VGND VPWR VPWR sky130_fd_sc_hd__decap_3
XFILLER_86_1442 VPWR VGND VPWR VGND sky130_ef_sc_hd__decap_12
XFILLER_172_175 VPWR VGND VPWR VGND sky130_ef_sc_hd__decap_12
XFILLER_218_77 VPWR VGND VPWR VGND sky130_ef_sc_hd__decap_12
XFILLER_173_1401 VPWR VGND VPWR VGND sky130_ef_sc_hd__decap_12
XFILLER_236_1133 VGND VGND VPWR VPWR sky130_fd_sc_hd__decap_6
XFILLER_82_1306 VGND VGND VPWR VPWR sky130_fd_sc_hd__decap_6
XFILLER_86_1497 VPWR VGND VPWR VGND sky130_ef_sc_hd__decap_12
XFILLER_173_1456 VGND VGND VPWR VPWR sky130_fd_sc_hd__decap_6
XFILLER_234_65 VPWR VGND VPWR VGND sky130_ef_sc_hd__decap_12
XFILLER_214_1453 VPWR VGND VPWR VGND sky130_ef_sc_hd__decap_12
XPHY_EDGE_ROW_29_2_Left_531 VGND VGND VPWR VPWR sky130_fd_sc_hd__decap_3
XFILLER_255_463 VPWR VGND VPWR VGND sky130_ef_sc_hd__decap_12
XFILLER_243_603 VPWR VGND VPWR VGND sky130_ef_sc_hd__decap_12
XFILLER_227_154 VPWR VGND VPWR VGND sky130_ef_sc_hd__decap_12
XFILLER_167_1205 VPWR VGND VPWR VGND sky130_ef_sc_hd__decap_12
XFILLER_216_839 VPWR VGND VPWR VGND sky130_ef_sc_hd__decap_12
XFILLER_255_496 VGND VGND VPWR VPWR sky130_fd_sc_hd__decap_8
XFILLER_215_338 VGND VGND VPWR VPWR sky130_fd_sc_hd__decap_6
XFILLER_243_658 VPWR VGND VPWR VGND sky130_ef_sc_hd__decap_12
XFILLER_93_1402 VPWR VGND VPWR VGND sky130_ef_sc_hd__decap_12
XFILLER_208_390 VPWR VGND VPWR VGND sky130_ef_sc_hd__decap_12
XPHY_EDGE_ROW_104_2_Right_195 VGND VGND VPWR VPWR sky130_fd_sc_hd__decap_3
XFILLER_169_916 VPWR VGND VPWR VGND sky130_ef_sc_hd__decap_12
XFILLER_247_1284 VGND VGND VPWR VPWR sky130_fd_sc_hd__decap_6
XFILLER_93_1457 VGND VGND VPWR VPWR sky130_fd_sc_hd__decap_6
XFILLER_224_894 VPWR VGND VPWR VGND sky130_ef_sc_hd__decap_12
XTAP_TAPCELL_ROW_140_2_5783 VGND VPWR sky130_fd_sc_hd__tapvpwrvgnd_1
XFILLER_106_1509 VGND VGND VPWR VPWR sky130_fd_sc_hd__decap_6
XTAP_TAPCELL_ROW_139_2_5777 VGND VPWR sky130_fd_sc_hd__tapvpwrvgnd_1
XFILLER_196_746 VGND VGND VPWR VPWR sky130_fd_sc_hd__decap_6
XFILLER_17_1230 VPWR VGND VPWR VGND sky130_ef_sc_hd__decap_12
XFILLER_221_1413 VGND VGND VPWR VPWR sky130_fd_sc_hd__decap_6
XFILLER_108_1380 VPWR VGND VPWR VGND sky130_ef_sc_hd__decap_12
XFILLER_177_971 VPWR VGND VPWR VGND sky130_ef_sc_hd__decap_12
XFILLER_52_1165 VPWR VGND VPWR VGND sky130_ef_sc_hd__decap_12
XFILLER_17_1285 VGND VGND VPWR VPWR sky130_fd_sc_hd__decap_6
XFILLER_12_11 VGND VGND VPWR VPWR sky130_fd_sc_hd__decap_3
XFILLER_6_108 VPWR VGND VPWR VGND sky130_ef_sc_hd__decap_12
XFILLER_12_22 VPWR VGND VPWR VGND sky130_ef_sc_hd__decap_12
XFILLER_195_39 VGND VGND VPWR VPWR sky130_fd_sc_hd__decap_4
XFILLER_178_1312 VPWR VGND VPWR VGND sky130_ef_sc_hd__decap_12
XFILLER_87_1206 VPWR VGND VPWR VGND sky130_ef_sc_hd__decap_12
XFILLER_128_22 VPWR VGND VPWR VGND sky130_ef_sc_hd__decap_12
XTAP_TAPCELL_ROW_172_1759 VGND VPWR sky130_fd_sc_hd__tapvpwrvgnd_1
XPHY_EDGE_ROW_248_Left_503 VGND VGND VPWR VPWR sky130_fd_sc_hd__decap_3
XFILLER_178_1367 VPWR VGND VPWR VGND sky130_ef_sc_hd__decap_12
XFILLER_88_15 VGND VGND VPWR VPWR sky130_fd_sc_hd__decap_6
XFILLER_30_1485 VPWR VGND VPWR VGND sky130_ef_sc_hd__decap_12
XTAP_TAPCELL_ROW_101_2_5467 VGND VPWR sky130_fd_sc_hd__tapvpwrvgnd_1
XTAP_TAPCELL_ROW_68_2_5206 VGND VPWR sky130_fd_sc_hd__tapvpwrvgnd_1
XFILLER_2_358 VGND VGND VPWR VPWR sky130_fd_sc_hd__fill_1
XFILLER_215_1217 VPWR VGND VPWR VGND sky130_ef_sc_hd__decap_12
XFILLER_144_65 VGND VGND VPWR VPWR sky130_fd_sc_hd__decap_6
XFILLER_63_1261 VPWR VGND VPWR VGND sky130_ef_sc_hd__decap_12
XFILLER_28_1392 VGND VGND VPWR VPWR sky130_fd_sc_hd__decap_6
XFILLER_8_1453 VPWR VGND VPWR VGND sky130_ef_sc_hd__decap_12
XFILLER_150_1220 VGND VGND VPWR VPWR sky130_fd_sc_hd__decap_6
XFILLER_98_1313 VPWR VGND VPWR VGND sky130_ef_sc_hd__decap_12
XFILLER_218_132 VPWR VGND VPWR VGND sky130_ef_sc_hd__decap_12
XFILLER_246_452 VPWR VGND VPWR VGND sky130_ef_sc_hd__decap_12
XFILLER_248_1004 VGND VGND VPWR VPWR sky130_fd_sc_hd__decap_6
XFILLER_189_1463 VPWR VGND VPWR VGND sky130_ef_sc_hd__decap_12
XFILLER_206_316 VGND VGND VPWR VPWR sky130_fd_sc_hd__decap_6
XFILLER_98_1368 VPWR VGND VPWR VGND sky130_ef_sc_hd__decap_12
XFILLER_185_1327 VGND VGND VPWR VPWR sky130_fd_sc_hd__decap_6
XFILLER_218_187 VGND VGND VPWR VPWR sky130_fd_sc_hd__decap_6
XFILLER_234_636 VPWR VGND VPWR VGND sky130_ef_sc_hd__decap_12
XTAP_TAPCELL_ROW_202_2840 VGND VPWR sky130_fd_sc_hd__tapvpwrvgnd_1
XFILLER_215_861 VPWR VGND VPWR VGND sky130_ef_sc_hd__decap_12
XTAP_TAPCELL_ROW_254_4630 VGND VPWR sky130_fd_sc_hd__tapvpwrvgnd_1
XFILLER_226_1324 VPWR VGND VPWR VGND sky130_ef_sc_hd__decap_12
XTAP_TAPCELL_ROW_254_4641 VGND VPWR sky130_fd_sc_hd__tapvpwrvgnd_1
X_414_ net218 _202_ net219 VGND VGND VPWR VPWR _203_ sky130_fd_sc_hd__o21bai_1
XTAP_TAPCELL_ROW_254_4652 VGND VPWR sky130_fd_sc_hd__tapvpwrvgnd_1
XFILLER_187_713 VPWR VGND VPWR VGND sky130_ef_sc_hd__decap_12
XFILLER_230_820 VPWR VGND VPWR VGND sky130_ef_sc_hd__decap_12
XTAP_TAPCELL_ROW_254_4663 VGND VPWR sky130_fd_sc_hd__tapvpwrvgnd_1
XFILLER_242_691 VPWR VGND VPWR VGND sky130_ef_sc_hd__decap_12
XTAP_TAPCELL_ROW_250_4505 VGND VPWR sky130_fd_sc_hd__tapvpwrvgnd_1
XFILLER_199_584 VPWR VGND VPWR VGND sky130_ef_sc_hd__decap_12
XTAP_TAPCELL_ROW_250_4516 VGND VPWR sky130_fd_sc_hd__tapvpwrvgnd_1
XFILLER_226_1379 VPWR VGND VPWR VGND sky130_ef_sc_hd__decap_12
X_345_ net593 net544 net574 VGND VGND VPWR VPWR _134_ sky130_fd_sc_hd__and3_1
XFILLER_109_1177 VPWR VGND VPWR VGND sky130_ef_sc_hd__decap_12
XFILLER_187_768 VGND VGND VPWR VPWR sky130_fd_sc_hd__decap_6
XFILLER_230_875 VGND VGND VPWR VPWR sky130_fd_sc_hd__decap_6
XFILLER_161_1371 VGND VGND VPWR VPWR sky130_fd_sc_hd__decap_6
XFILLER_200_1508 VGND VGND VPWR VPWR sky130_fd_sc_hd__decap_6
XFILLER_31_1249 VPWR VGND VPWR VGND sky130_ef_sc_hd__decap_12
XPHY_EDGE_ROW_157_2_Left_659 VGND VGND VPWR VPWR sky130_fd_sc_hd__decap_3
XFILLER_6_642 VGND VGND VPWR VPWR sky130_fd_sc_hd__fill_1
XFILLER_196_1434 VGND VGND VPWR VPWR sky130_fd_sc_hd__decap_6
XTAP_TAPCELL_ROW_248_4423 VGND VPWR sky130_fd_sc_hd__tapvpwrvgnd_1
XFILLER_5_130 VPWR VGND VPWR VGND sky130_ef_sc_hd__decap_12
XFILLER_122_1399 VPWR VGND VPWR VGND sky130_ef_sc_hd__decap_12
XTAP_TAPCELL_ROW_248_4434 VGND VPWR sky130_fd_sc_hd__tapvpwrvgnd_1
XTAP_TAPCELL_ROW_248_4445 VGND VPWR sky130_fd_sc_hd__tapvpwrvgnd_1
XFILLER_170_624 VPWR VGND VPWR VGND sky130_ef_sc_hd__decap_12
XFILLER_182_495 VPWR VGND VPWR VGND sky130_ef_sc_hd__decap_12
XFILLER_237_1420 VPWR VGND VPWR VGND sky130_ef_sc_hd__decap_12
XTAP_TAPCELL_ROW_244_4309 VGND VPWR sky130_fd_sc_hd__tapvpwrvgnd_1
XPHY_EDGE_ROW_27_1_Left_282 VGND VGND VPWR VPWR sky130_fd_sc_hd__decap_3
XFILLER_190_1011 VPWR VGND VPWR VGND sky130_ef_sc_hd__decap_12
XFILLER_170_679 VPWR VGND VPWR VGND sky130_ef_sc_hd__decap_12
XFILLER_237_1475 VPWR VGND VPWR VGND sky130_ef_sc_hd__decap_12
XFILLER_2_870 VGND VGND VPWR VPWR sky130_fd_sc_hd__fill_1
XFILLER_29_1189 VPWR VGND VPWR VGND sky130_ef_sc_hd__decap_12
XFILLER_190_1066 VPWR VGND VPWR VGND sky130_ef_sc_hd__decap_12
XFILLER_42_1356 VPWR VGND VPWR VGND sky130_ef_sc_hd__decap_12
XFILLER_204_46 VPWR VGND VPWR VGND sky130_ef_sc_hd__decap_12
XFILLER_225_603 VPWR VGND VPWR VGND sky130_ef_sc_hd__decap_12
XPHY_EDGE_ROW_184_Right_29 VGND VGND VPWR VPWR sky130_fd_sc_hd__decap_3
XFILLER_209_154 VPWR VGND VPWR VGND sky130_ef_sc_hd__decap_12
XFILLER_168_1514 VGND VGND VPWR VPWR sky130_fd_sc_hd__fill_1
XFILLER_237_474 VPWR VGND VPWR VGND sky130_ef_sc_hd__decap_12
XTAP_TAPCELL_ROW_0_829 VGND VPWR sky130_fd_sc_hd__tapvpwrvgnd_1
XFILLER_252_433 VPWR VGND VPWR VGND sky130_ef_sc_hd__decap_12
XFILLER_225_658 VPWR VGND VPWR VGND sky130_ef_sc_hd__decap_12
XTAP_TAPCELL_ROW_125_2_5663 VGND VPWR sky130_fd_sc_hd__tapvpwrvgnd_1
XFILLER_240_617 VGND VGND VPWR VPWR sky130_fd_sc_hd__decap_6
XFILLER_220_34 VPWR VGND VPWR VGND sky130_ef_sc_hd__decap_12
XFILLER_252_488 VGND VGND VPWR VPWR sky130_fd_sc_hd__decap_6
XFILLER_206_894 VPWR VGND VPWR VGND sky130_ef_sc_hd__decap_12
XFILLER_75_1165 VPWR VGND VPWR VGND sky130_ef_sc_hd__decap_12
XFILLER_166_1293 VPWR VGND VPWR VGND sky130_ef_sc_hd__decap_12
XFILLER_221_842 VPWR VGND VPWR VGND sky130_ef_sc_hd__decap_12
XFILLER_178_746 VGND VGND VPWR VPWR sky130_fd_sc_hd__decap_6
XFILLER_220_89 VPWR VGND VPWR VGND sky130_ef_sc_hd__decap_12
XFILLER_221_897 VGND VGND VPWR VPWR sky130_fd_sc_hd__decap_6
XFILLER_140_1411 VPWR VGND VPWR VGND sky130_ef_sc_hd__decap_12
XFILLER_203_1143 VPWR VGND VPWR VGND sky130_ef_sc_hd__decap_12
XFILLER_192_237 VPWR VGND VPWR VGND sky130_ef_sc_hd__decap_12
XPHY_EDGE_ROW_193_Right_38 VGND VGND VPWR VPWR sky130_fd_sc_hd__decap_3
XFILLER_140_1466 VPWR VGND VPWR VGND sky130_ef_sc_hd__decap_12
XPHY_EDGE_ROW_160_1_Left_415 VGND VGND VPWR VPWR sky130_fd_sc_hd__decap_3
XFILLER_203_1198 VGND VGND VPWR VPWR sky130_fd_sc_hd__decap_6
XFILLER_229_87 VPWR VGND VPWR VGND sky130_ef_sc_hd__decap_12
XPHY_EDGE_ROW_162_1_Right_818 VGND VGND VPWR VPWR sky130_fd_sc_hd__decap_3
XTAP_TAPCELL_ROW_212_3180 VGND VPWR sky130_fd_sc_hd__tapvpwrvgnd_1
XTAP_TAPCELL_ROW_212_3191 VGND VPWR sky130_fd_sc_hd__tapvpwrvgnd_1
XFILLER_47_1201 VGND VGND VPWR VPWR sky130_fd_sc_hd__decap_4
XFILLER_86_1294 VPWR VGND VPWR VGND sky130_ef_sc_hd__decap_12
XTAP_TAPCELL_ROW_21_2_4833 VGND VPWR sky130_fd_sc_hd__tapvpwrvgnd_1
XFILLER_247_216 VPWR VGND VPWR VGND sky130_ef_sc_hd__decap_12
XFILLER_60_1423 VPWR VGND VPWR VGND sky130_ef_sc_hd__decap_12
XFILLER_214_1250 VPWR VGND VPWR VGND sky130_ef_sc_hd__decap_12
XTAP_TAPCELL_ROW_165_1530 VGND VPWR sky130_fd_sc_hd__tapvpwrvgnd_1
XFILLER_114_46 VPWR VGND VPWR VGND sky130_ef_sc_hd__decap_12
XTAP_TAPCELL_ROW_165_1541 VGND VPWR sky130_fd_sc_hd__tapvpwrvgnd_1
XFILLER_228_452 VPWR VGND VPWR VGND sky130_ef_sc_hd__decap_12
XFILLER_60_1478 VGND VGND VPWR VPWR sky130_fd_sc_hd__decap_6
XFILLER_243_400 VPWR VGND VPWR VGND sky130_ef_sc_hd__decap_12
XFILLER_167_1002 VPWR VGND VPWR VGND sky130_ef_sc_hd__decap_12
XFILLER_216_636 VPWR VGND VPWR VGND sky130_ef_sc_hd__decap_12
XFILLER_249_1346 VPWR VGND VPWR VGND sky130_ef_sc_hd__decap_12
XFILLER_243_455 VPWR VGND VPWR VGND sky130_ef_sc_hd__decap_12
XFILLER_110_1270 VPWR VGND VPWR VGND sky130_ef_sc_hd__decap_12
XFILLER_167_1057 VPWR VGND VPWR VGND sky130_ef_sc_hd__decap_12
XFILLER_97_1390 VPWR VGND VPWR VGND sky130_ef_sc_hd__decap_12
XFILLER_130_34 VPWR VGND VPWR VGND sky130_ef_sc_hd__decap_12
XFILLER_231_639 VGND VGND VPWR VPWR sky130_fd_sc_hd__decap_6
XFILLER_169_713 VPWR VGND VPWR VGND sky130_ef_sc_hd__decap_12
XFILLER_212_820 VPWR VGND VPWR VGND sky130_ef_sc_hd__decap_12
XPHY_EDGE_ROW_105_2_Right_196 VGND VGND VPWR VPWR sky130_fd_sc_hd__decap_3
XFILLER_224_691 VPWR VGND VPWR VGND sky130_ef_sc_hd__decap_12
XFILLER_54_1227 VPWR VGND VPWR VGND sky130_ef_sc_hd__decap_12
XFILLER_19_1347 VPWR VGND VPWR VGND sky130_ef_sc_hd__decap_12
XFILLER_208_1054 VPWR VGND VPWR VGND sky130_ef_sc_hd__decap_12
XFILLER_106_1306 VGND VGND VPWR VPWR sky130_fd_sc_hd__decap_6
XFILLER_169_768 VGND VGND VPWR VPWR sky130_fd_sc_hd__decap_6
XFILLER_212_875 VGND VGND VPWR VPWR sky130_fd_sc_hd__decap_6
XTAP_TAPCELL_ROW_178_1979 VGND VPWR sky130_fd_sc_hd__tapvpwrvgnd_1
Xwire304 net305 VGND VGND VPWR VPWR net304 sky130_fd_sc_hd__clkbuf_1
XFILLER_8_918 VGND VGND VPWR VPWR sky130_fd_sc_hd__decap_6
Xwire315 net316 VGND VGND VPWR VPWR net315 sky130_fd_sc_hd__clkbuf_1
Xwire326 net327 VGND VGND VPWR VPWR net326 sky130_fd_sc_hd__clkbuf_1
XPHY_EDGE_ROW_92_1_Left_347 VGND VGND VPWR VPWR sky130_fd_sc_hd__decap_3
Xwire348 net349 VGND VGND VPWR VPWR net348 sky130_fd_sc_hd__clkbuf_1
XFILLER_128_3 VPWR VGND VPWR VGND sky130_ef_sc_hd__decap_12
Xwire359 net360 VGND VGND VPWR VPWR net359 sky130_fd_sc_hd__clkbuf_1
XTAP_TAPCELL_ROW_96_1_1373 VGND VPWR sky130_fd_sc_hd__tapvpwrvgnd_1
XFILLER_165_963 VGND VGND VPWR VPWR sky130_fd_sc_hd__decap_3
XFILLER_183_259 VPWR VGND VPWR VGND sky130_ef_sc_hd__decap_12
XFILLER_178_1164 VPWR VGND VPWR VGND sky130_ef_sc_hd__decap_12
XFILLER_30_1282 VPWR VGND VPWR VGND sky130_ef_sc_hd__decap_12
XFILLER_2_144 VGND VGND VPWR VPWR sky130_fd_sc_hd__decap_6
XFILLER_117_1402 VPWR VGND VPWR VGND sky130_ef_sc_hd__decap_12
XFILLER_215_1014 VPWR VGND VPWR VGND sky130_ef_sc_hd__decap_12
XFILLER_65_1378 VPWR VGND VPWR VGND sky130_ef_sc_hd__decap_12
XFILLER_152_1337 VPWR VGND VPWR VGND sky130_ef_sc_hd__decap_12
XFILLER_117_1457 VGND VGND VPWR VPWR sky130_fd_sc_hd__decap_6
XTAP_TAPCELL_ROW_162_2_5959 VGND VPWR sky130_fd_sc_hd__tapvpwrvgnd_1
XFILLER_215_1069 VGND VGND VPWR VPWR sky130_fd_sc_hd__decap_6
XFILLER_8_1250 VPWR VGND VPWR VGND sky130_ef_sc_hd__decap_12
XFILLER_238_249 VPWR VGND VPWR VGND sky130_ef_sc_hd__decap_12
XTAP_TAPCELL_ROW_98_2_5445 VGND VPWR sky130_fd_sc_hd__tapvpwrvgnd_1
XTAP_TAPCELL_ROW_204_2902 VGND VPWR sky130_fd_sc_hd__tapvpwrvgnd_1
XFILLER_207_603 VPWR VGND VPWR VGND sky130_ef_sc_hd__decap_12
XTAP_TAPCELL_ROW_204_2913 VGND VPWR sky130_fd_sc_hd__tapvpwrvgnd_1
XFILLER_219_474 VPWR VGND VPWR VGND sky130_ef_sc_hd__decap_12
XFILLER_189_1260 VPWR VGND VPWR VGND sky130_ef_sc_hd__decap_12
XFILLER_98_1165 VPWR VGND VPWR VGND sky130_ef_sc_hd__decap_12
XFILLER_234_433 VPWR VGND VPWR VGND sky130_ef_sc_hd__decap_12
XFILLER_207_658 VPWR VGND VPWR VGND sky130_ef_sc_hd__decap_12
XFILLER_0_69 VPWR VGND VPWR VGND sky130_ef_sc_hd__decap_12
XFILLER_222_617 VGND VGND VPWR VPWR sky130_fd_sc_hd__decap_6
XFILLER_250_937 VPWR VGND VPWR VGND sky130_ef_sc_hd__decap_12
XFILLER_234_488 VGND VGND VPWR VPWR sky130_fd_sc_hd__decap_6
XFILLER_37_1414 VGND VGND VPWR VPWR sky130_fd_sc_hd__decap_6
XFILLER_226_1121 VPWR VGND VPWR VGND sky130_ef_sc_hd__decap_12
XFILLER_187_510 VGND VGND VPWR VPWR sky130_fd_sc_hd__decap_6
XFILLER_203_842 VPWR VGND VPWR VGND sky130_ef_sc_hd__decap_12
XFILLER_76_1485 VPWR VGND VPWR VGND sky130_ef_sc_hd__decap_12
XFILLER_163_1433 VPWR VGND VPWR VGND sky130_ef_sc_hd__decap_12
XFILLER_199_381 VGND VGND VPWR VPWR sky130_fd_sc_hd__decap_6
XFILLER_9_34 VGND VGND VPWR VPWR sky130_fd_sc_hd__decap_8
XFILLER_72_1349 VGND VGND VPWR VPWR sky130_fd_sc_hd__decap_6
XFILLER_226_1176 VGND VGND VPWR VPWR sky130_fd_sc_hd__decap_6
XFILLER_203_897 VGND VGND VPWR VPWR sky130_fd_sc_hd__decap_6
XFILLER_163_1488 VPWR VGND VPWR VGND sky130_ef_sc_hd__decap_12
X_328_ _115_ net501 VGND VGND VPWR VPWR _117_ sky130_fd_sc_hd__or2_1
XFILLER_204_1441 VPWR VGND VPWR VGND sky130_ef_sc_hd__decap_12
XFILLER_174_237 VPWR VGND VPWR VGND sky130_ef_sc_hd__decap_12
XFILLER_200_1305 VGND VGND VPWR VPWR sky130_fd_sc_hd__decap_6
XFILLER_7_940 VGND VGND VPWR VPWR sky130_fd_sc_hd__decap_6
XFILLER_204_1496 VPWR VGND VPWR VGND sky130_ef_sc_hd__decap_12
Xmax_cap604 valid_d2 VGND VGND VPWR VPWR net604 sky130_fd_sc_hd__buf_1
Xmax_cap615 net616 VGND VGND VPWR VPWR net615 sky130_fd_sc_hd__clkbuf_1
XFILLER_122_1196 VPWR VGND VPWR VGND sky130_ef_sc_hd__decap_12
XFILLER_170_421 VPWR VGND VPWR VGND sky130_ef_sc_hd__decap_12
XFILLER_182_292 VPWR VGND VPWR VGND sky130_ef_sc_hd__decap_12
XFILLER_43_3 VPWR VGND VPWR VGND sky130_ef_sc_hd__decap_12
XFILLER_170_476 VPWR VGND VPWR VGND sky130_ef_sc_hd__decap_12
XFILLER_83_1445 VPWR VGND VPWR VGND sky130_ef_sc_hd__decap_12
XFILLER_237_1272 VPWR VGND VPWR VGND sky130_ef_sc_hd__decap_12
XFILLER_215_56 VPWR VGND VPWR VGND sky130_ef_sc_hd__decap_12
XFILLER_229_216 VPWR VGND VPWR VGND sky130_ef_sc_hd__decap_12
XFILLER_211_1401 VPWR VGND VPWR VGND sky130_ef_sc_hd__decap_12
XFILLER_211_1456 VGND VGND VPWR VPWR sky130_fd_sc_hd__decap_6
XFILLER_133_1292 VPWR VGND VPWR VGND sky130_ef_sc_hd__decap_12
XFILLER_225_400 VPWR VGND VPWR VGND sky130_ef_sc_hd__decap_12
XFILLER_237_271 VPWR VGND VPWR VGND sky130_ef_sc_hd__decap_12
XFILLER_231_44 VPWR VGND VPWR VGND sky130_ef_sc_hd__decap_12
XFILLER_252_230 VGND VGND VPWR VPWR sky130_fd_sc_hd__decap_6
XFILLER_246_1508 VGND VGND VPWR VPWR sky130_fd_sc_hd__decap_6
XFILLER_241_904 VPWR VGND VPWR VGND sky130_ef_sc_hd__decap_12
XFILLER_168_1355 VPWR VGND VPWR VGND sky130_ef_sc_hd__decap_12
XTAP_TAPCELL_ROW_220_3460 VGND VPWR sky130_fd_sc_hd__tapvpwrvgnd_1
XFILLER_225_455 VPWR VGND VPWR VGND sky130_ef_sc_hd__decap_12
XFILLER_253_775 VPWR VGND VPWR VGND sky130_ef_sc_hd__decap_12
XFILLER_77_1249 VPWR VGND VPWR VGND sky130_ef_sc_hd__decap_12
XFILLER_198_808 VPWR VGND VPWR VGND sky130_ef_sc_hd__decap_12
XTAP_TAPCELL_ROW_220_3471 VGND VPWR sky130_fd_sc_hd__tapvpwrvgnd_1
XFILLER_164_1208 VPWR VGND VPWR VGND sky130_ef_sc_hd__decap_12
XFILLER_129_1328 VGND VGND VPWR VPWR sky130_fd_sc_hd__decap_6
XFILLER_231_99 VPWR VGND VPWR VGND sky130_ef_sc_hd__decap_12
XFILLER_213_639 VGND VGND VPWR VPWR sky130_fd_sc_hd__decap_6
XFILLER_241_959 VPWR VGND VPWR VGND sky130_ef_sc_hd__decap_12
XFILLER_206_691 VPWR VGND VPWR VGND sky130_ef_sc_hd__decap_12
XFILLER_100_15 VGND VGND VPWR VPWR sky130_fd_sc_hd__decap_6
XFILLER_205_1205 VPWR VGND VPWR VGND sky130_ef_sc_hd__decap_12
XFILLER_166_1090 VGND VGND VPWR VPWR sky130_fd_sc_hd__decap_6
XFILLER_16_1509 VGND VGND VPWR VPWR sky130_fd_sc_hd__decap_6
XFILLER_18_1380 VPWR VGND VPWR VGND sky130_ef_sc_hd__decap_12
XTAP_TAPCELL_ROW_173_1810 VGND VPWR sky130_fd_sc_hd__tapvpwrvgnd_1
XTAP_TAPCELL_ROW_214_3231 VGND VPWR sky130_fd_sc_hd__tapvpwrvgnd_1
XTAP_TAPCELL_ROW_173_1821 VGND VPWR sky130_fd_sc_hd__tapvpwrvgnd_1
XTAP_TAPCELL_ROW_214_3242 VGND VPWR sky130_fd_sc_hd__tapvpwrvgnd_1
XTAP_TAPCELL_ROW_214_3253 VGND VPWR sky130_fd_sc_hd__tapvpwrvgnd_1
XFILLER_140_1263 VGND VGND VPWR VPWR sky130_fd_sc_hd__decap_6
XTAP_TAPCELL_ROW_210_3106 VGND VPWR sky130_fd_sc_hd__tapvpwrvgnd_1
XTAP_TAPCELL_ROW_233_3898 VGND VPWR sky130_fd_sc_hd__tapvpwrvgnd_1
XTAP_TAPCELL_ROW_210_3117 VGND VPWR sky130_fd_sc_hd__tapvpwrvgnd_1
XFILLER_180_218 VPWR VGND VPWR VGND sky130_ef_sc_hd__decap_12
XFILLER_88_1356 VPWR VGND VPWR VGND sky130_ef_sc_hd__decap_12
XFILLER_175_1315 VPWR VGND VPWR VGND sky130_ef_sc_hd__decap_12
XFILLER_109_68 VGND VGND VPWR VPWR sky130_fd_sc_hd__decap_3
XFILLER_238_1047 VGND VGND VPWR VPWR sky130_fd_sc_hd__decap_6
XFILLER_69_39 VGND VGND VPWR VPWR sky130_fd_sc_hd__decap_4
XPHY_EDGE_ROW_163_1_Right_819 VGND VGND VPWR VPWR sky130_fd_sc_hd__decap_3
XTAP_TAPCELL_ROW_147_2_5839 VGND VPWR sky130_fd_sc_hd__tapvpwrvgnd_1
XFILLER_216_1312 VPWR VGND VPWR VGND sky130_ef_sc_hd__decap_12
XTAP_TAPCELL_ROW_116_2_5586 VGND VPWR sky130_fd_sc_hd__tapvpwrvgnd_1
XTAP_TAPCELL_ROW_84_2_5331 VGND VPWR sky130_fd_sc_hd__tapvpwrvgnd_1
XTAP_TAPCELL_ROW_167_1603 VGND VPWR sky130_fd_sc_hd__tapvpwrvgnd_1
XTAP_TAPCELL_ROW_208_3024 VGND VPWR sky130_fd_sc_hd__tapvpwrvgnd_1
XTAP_TAPCELL_ROW_167_1614 VGND VPWR sky130_fd_sc_hd__tapvpwrvgnd_1
XTAP_TAPCELL_ROW_208_3035 VGND VPWR sky130_fd_sc_hd__tapvpwrvgnd_1
XTAP_TAPCELL_ROW_208_3046 VGND VPWR sky130_fd_sc_hd__tapvpwrvgnd_1
XFILLER_216_1367 VPWR VGND VPWR VGND sky130_ef_sc_hd__decap_12
XFILLER_125_56 VPWR VGND VPWR VGND sky130_ef_sc_hd__decap_12
XFILLER_60_1220 VGND VGND VPWR VPWR sky130_fd_sc_hd__decap_6
XFILLER_5_1401 VPWR VGND VPWR VGND sky130_ef_sc_hd__decap_12
XFILLER_85_27 VPWR VGND VPWR VGND sky130_ef_sc_hd__decap_12
XFILLER_5_1456 VGND VGND VPWR VPWR sky130_fd_sc_hd__decap_6
XFILLER_169_1119 VPWR VGND VPWR VGND sky130_ef_sc_hd__decap_12
XFILLER_18_65 VGND VGND VPWR VPWR sky130_fd_sc_hd__decap_6
XFILLER_186_1422 VPWR VGND VPWR VGND sky130_ef_sc_hd__decap_12
XFILLER_249_1143 VPWR VGND VPWR VGND sky130_ef_sc_hd__decap_12
XFILLER_95_1316 VPWR VGND VPWR VGND sky130_ef_sc_hd__decap_12
XFILLER_141_44 VPWR VGND VPWR VGND sky130_ef_sc_hd__decap_12
XFILLER_216_433 VPWR VGND VPWR VGND sky130_ef_sc_hd__decap_12
XFILLER_244_753 VPWR VGND VPWR VGND sky130_ef_sc_hd__decap_12
XFILLER_243_252 VGND VGND VPWR VPWR sky130_fd_sc_hd__decap_6
XFILLER_204_617 VGND VGND VPWR VPWR sky130_fd_sc_hd__decap_6
XFILLER_186_1477 VGND VGND VPWR VPWR sky130_fd_sc_hd__decap_6
XFILLER_249_1198 VGND VGND VPWR VPWR sky130_fd_sc_hd__decap_6
XFILLER_216_488 VGND VGND VPWR VPWR sky130_fd_sc_hd__decap_6
XFILLER_232_937 VPWR VGND VPWR VGND sky130_ef_sc_hd__decap_12
XFILLER_169_510 VGND VGND VPWR VPWR sky130_fd_sc_hd__decap_6
XFILLER_245_3 VPWR VGND VPWR VGND sky130_ef_sc_hd__decap_12
XFILLER_197_830 VPWR VGND VPWR VGND sky130_ef_sc_hd__decap_12
XFILLER_227_1463 VPWR VGND VPWR VGND sky130_ef_sc_hd__decap_12
XPHY_EDGE_ROW_106_2_Right_197 VGND VGND VPWR VPWR sky130_fd_sc_hd__decap_3
XFILLER_223_1327 VGND VGND VPWR VPWR sky130_fd_sc_hd__decap_6
XFILLER_240_992 VPWR VGND VPWR VGND sky130_ef_sc_hd__decap_12
XFILLER_19_1177 VPWR VGND VPWR VGND sky130_ef_sc_hd__decap_12
XFILLER_180_1054 VPWR VGND VPWR VGND sky130_ef_sc_hd__decap_12
XFILLER_197_885 VPWR VGND VPWR VGND sky130_ef_sc_hd__decap_12
XTAP_TAPCELL_ROW_12_2_4756 VGND VPWR sky130_fd_sc_hd__tapvpwrvgnd_1
XFILLER_71_1371 VGND VGND VPWR VPWR sky130_fd_sc_hd__decap_6
Xwire123 _198_ VGND VGND VPWR VPWR net123 sky130_fd_sc_hd__clkbuf_1
Xwire134 _157_ VGND VGND VPWR VPWR net134 sky130_fd_sc_hd__clkbuf_1
XPHY_EDGE_ROW_199_Left_454 VGND VGND VPWR VPWR sky130_fd_sc_hd__decap_3
Xwire167 _139_ VGND VGND VPWR VPWR net167 sky130_fd_sc_hd__clkbuf_1
XFILLER_32_1399 VPWR VGND VPWR VGND sky130_ef_sc_hd__decap_12
XFILLER_180_796 VPWR VGND VPWR VGND sky130_ef_sc_hd__decap_12
XFILLER_156_1270 VPWR VGND VPWR VGND sky130_ef_sc_hd__decap_12
XFILLER_234_1434 VGND VGND VPWR VPWR sky130_fd_sc_hd__decap_6
XTAP_TAPCELL_ROW_183_2150 VGND VPWR sky130_fd_sc_hd__tapvpwrvgnd_1
XTAP_TAPCELL_ROW_183_2161 VGND VPWR sky130_fd_sc_hd__tapvpwrvgnd_1
XTAP_TAPCELL_ROW_183_2172 VGND VPWR sky130_fd_sc_hd__tapvpwrvgnd_1
XFILLER_207_400 VPWR VGND VPWR VGND sky130_ef_sc_hd__decap_12
XFILLER_219_271 VPWR VGND VPWR VGND sky130_ef_sc_hd__decap_12
XFILLER_130_1454 VPWR VGND VPWR VGND sky130_ef_sc_hd__decap_12
XFILLER_223_904 VPWR VGND VPWR VGND sky130_ef_sc_hd__decap_12
XFILLER_234_230 VGND VGND VPWR VPWR sky130_fd_sc_hd__decap_6
XFILLER_207_455 VPWR VGND VPWR VGND sky130_ef_sc_hd__decap_12
XFILLER_235_775 VPWR VGND VPWR VGND sky130_ef_sc_hd__decap_12
XFILLER_228_1238 VPWR VGND VPWR VGND sky130_ef_sc_hd__decap_12
XFILLER_250_734 VPWR VGND VPWR VGND sky130_ef_sc_hd__decap_12
XFILLER_223_959 VPWR VGND VPWR VGND sky130_ef_sc_hd__decap_12
XFILLER_76_1282 VPWR VGND VPWR VGND sky130_ef_sc_hd__decap_12
XFILLER_163_1230 VPWR VGND VPWR VGND sky130_ef_sc_hd__decap_12
XFILLER_206_1514 VGND VGND VPWR VPWR sky130_fd_sc_hd__fill_1
XFILLER_250_789 VGND VGND VPWR VPWR sky130_fd_sc_hd__decap_6
XFILLER_188_863 VPWR VGND VPWR VGND sky130_ef_sc_hd__decap_12
XTAP_TAPCELL_ROW_196_2599 VGND VPWR sky130_fd_sc_hd__tapvpwrvgnd_1
XFILLER_163_1285 VGND VGND VPWR VPWR sky130_fd_sc_hd__decap_6
XFILLER_50_1411 VPWR VGND VPWR VGND sky130_ef_sc_hd__decap_12
XFILLER_198_1348 VGND VGND VPWR VPWR sky130_fd_sc_hd__decap_6
XFILLER_50_1466 VPWR VGND VPWR VGND sky130_ef_sc_hd__decap_12
XPHY_EDGE_ROW_38_2_Left_540 VGND VGND VPWR VPWR sky130_fd_sc_hd__decap_3
XFILLER_204_1293 VPWR VGND VPWR VGND sky130_ef_sc_hd__decap_12
XTAP_TAPCELL_ROW_90_2_5385 VGND VPWR sky130_fd_sc_hd__tapvpwrvgnd_1
XFILLER_239_1334 VPWR VGND VPWR VGND sky130_ef_sc_hd__decap_12
XFILLER_85_1507 VGND VGND VPWR VPWR sky130_fd_sc_hd__decap_8
XFILLER_190_538 VPWR VGND VPWR VGND sky130_ef_sc_hd__decap_12
XTAP_TAPCELL_ROW_133_2_5725 VGND VPWR sky130_fd_sc_hd__tapvpwrvgnd_1
XFILLER_6_280 VGND VGND VPWR VPWR sky130_fd_sc_hd__decap_4
XFILLER_226_22 VPWR VGND VPWR VGND sky130_ef_sc_hd__decap_12
XFILLER_239_1389 VPWR VGND VPWR VGND sky130_ef_sc_hd__decap_12
XTAP_TAPCELL_ROW_69_2_5211 VGND VPWR sky130_fd_sc_hd__tapvpwrvgnd_1
XPHY_EDGE_ROW_203_Left_458 VGND VGND VPWR VPWR sky130_fd_sc_hd__decap_3
XFILLER_170_273 VGND VGND VPWR VPWR sky130_fd_sc_hd__decap_6
XFILLER_83_1242 VGND VGND VPWR VPWR sky130_fd_sc_hd__decap_6
XTAP_TAPCELL_ROW_154_1_1460 VGND VPWR sky130_fd_sc_hd__tapvpwrvgnd_1
XFILLER_226_77 VPWR VGND VPWR VGND sky130_ef_sc_hd__decap_12
XFILLER_131_1218 VPWR VGND VPWR VGND sky130_ef_sc_hd__decap_12
XTAP_TAPCELL_ROW_36_2_4952 VGND VPWR sky130_fd_sc_hd__tapvpwrvgnd_1
XTAP_TAPCELL_ROW_51_2_5069 VGND VPWR sky130_fd_sc_hd__tapvpwrvgnd_1
XTAP_TAPCELL_ROW_222_3511 VGND VPWR sky130_fd_sc_hd__tapvpwrvgnd_1
XTAP_TAPCELL_ROW_226_3680 VGND VPWR sky130_fd_sc_hd__tapvpwrvgnd_1
XFILLER_245_517 VPWR VGND VPWR VGND sky130_ef_sc_hd__decap_12
XTAP_TAPCELL_ROW_222_3522 VGND VPWR sky130_fd_sc_hd__tapvpwrvgnd_1
XTAP_TAPCELL_ROW_222_3533 VGND VPWR sky130_fd_sc_hd__tapvpwrvgnd_1
XFILLER_242_65 VPWR VGND VPWR VGND sky130_ef_sc_hd__decap_12
XTAP_TAPCELL_ROW_1_902 VGND VPWR sky130_fd_sc_hd__tapvpwrvgnd_1
XTAP_TAPCELL_ROW_1_913 VGND VPWR sky130_fd_sc_hd__tapvpwrvgnd_1
XTAP_TAPCELL_ROW_1_924 VGND VPWR sky130_fd_sc_hd__tapvpwrvgnd_1
XFILLER_226_753 VPWR VGND VPWR VGND sky130_ef_sc_hd__decap_12
XFILLER_246_1305 VGND VGND VPWR VPWR sky130_fd_sc_hd__decap_6
XFILLER_241_701 VPWR VGND VPWR VGND sky130_ef_sc_hd__decap_12
XFILLER_225_252 VGND VGND VPWR VPWR sky130_fd_sc_hd__decap_6
XFILLER_168_1152 VPWR VGND VPWR VGND sky130_ef_sc_hd__decap_12
XFILLER_253_572 VPWR VGND VPWR VGND sky130_ef_sc_hd__decap_12
XFILLER_198_605 VPWR VGND VPWR VGND sky130_ef_sc_hd__decap_12
XPHY_EDGE_ROW_212_Left_467 VGND VGND VPWR VPWR sky130_fd_sc_hd__decap_3
XFILLER_214_937 VPWR VGND VPWR VGND sky130_ef_sc_hd__decap_12
XFILLER_20_1270 VPWR VGND VPWR VGND sky130_ef_sc_hd__decap_12
XFILLER_241_756 VPWR VGND VPWR VGND sky130_ef_sc_hd__decap_12
XFILLER_179_830 VPWR VGND VPWR VGND sky130_ef_sc_hd__decap_12
XTAP_TAPCELL_ROW_49_1_1303 VGND VPWR sky130_fd_sc_hd__tapvpwrvgnd_1
XFILLER_205_1002 VPWR VGND VPWR VGND sky130_ef_sc_hd__decap_12
XTAP_TAPCELL_ROW_216_3304 VGND VPWR sky130_fd_sc_hd__tapvpwrvgnd_1
XFILLER_16_1306 VGND VGND VPWR VPWR sky130_fd_sc_hd__decap_6
XFILLER_200_108 VPWR VGND VPWR VGND sky130_ef_sc_hd__decap_12
XTAP_TAPCELL_ROW_216_3315 VGND VPWR sky130_fd_sc_hd__tapvpwrvgnd_1
XFILLER_179_885 VPWR VGND VPWR VGND sky130_ef_sc_hd__decap_12
XTAP_TAPCELL_ROW_216_3326 VGND VPWR sky130_fd_sc_hd__tapvpwrvgnd_1
XFILLER_222_992 VPWR VGND VPWR VGND sky130_ef_sc_hd__decap_12
XFILLER_107_1445 VPWR VGND VPWR VGND sky130_ef_sc_hd__decap_12
XFILLER_142_1325 VPWR VGND VPWR VGND sky130_ef_sc_hd__decap_12
XFILLER_205_1057 VPWR VGND VPWR VGND sky130_ef_sc_hd__decap_12
XFILLER_5_729 VGND VGND VPWR VPWR sky130_fd_sc_hd__fill_2
XFILLER_20_22 VPWR VGND VPWR VGND sky130_ef_sc_hd__decap_12
XFILLER_175_1112 VGND VGND VPWR VPWR sky130_fd_sc_hd__decap_6
XPHY_EDGE_ROW_221_Left_476 VGND VGND VPWR VPWR sky130_fd_sc_hd__decap_3
XFILLER_136_22 VPWR VGND VPWR VGND sky130_ef_sc_hd__decap_12
XFILLER_27_1402 VPWR VGND VPWR VGND sky130_ef_sc_hd__decap_12
XFILLER_96_15 VGND VGND VPWR VPWR sky130_fd_sc_hd__decap_6
XFILLER_153_1421 VPWR VGND VPWR VGND sky130_ef_sc_hd__decap_12
XFILLER_251_1033 VPWR VGND VPWR VGND sky130_ef_sc_hd__decap_12
XFILLER_216_1164 VPWR VGND VPWR VGND sky130_ef_sc_hd__decap_12
XFILLER_62_1337 VPWR VGND VPWR VGND sky130_ef_sc_hd__decap_12
XFILLER_27_1457 VGND VGND VPWR VPWR sky130_fd_sc_hd__decap_6
XFILLER_29_42 VGND VGND VPWR VPWR sky130_fd_sc_hd__fill_1
XFILLER_153_1476 VPWR VGND VPWR VGND sky130_ef_sc_hd__decap_12
XFILLER_195_3 VPWR VGND VPWR VGND sky130_ef_sc_hd__decap_12
XFILLER_251_1088 VPWR VGND VPWR VGND sky130_ef_sc_hd__decap_12
XFILLER_248_366 VPWR VGND VPWR VGND sky130_ef_sc_hd__decap_12
XFILLER_29_64 VGND VGND VPWR VPWR sky130_fd_sc_hd__decap_6
XFILLER_152_65 VGND VGND VPWR VPWR sky130_fd_sc_hd__decap_6
X_662_ clknet_3_5__leaf_clk acc_core.adder.cla_blocks\[7\].block.sum\[0\] _070_ VGND
+ VGND VPWR VPWR net63 sky130_fd_sc_hd__dfrtp_1
XFILLER_216_230 VGND VGND VPWR VPWR sky130_fd_sc_hd__decap_6
XPHY_EDGE_ROW_230_Left_485 VGND VGND VPWR VPWR sky130_fd_sc_hd__decap_3
XFILLER_205_904 VPWR VGND VPWR VGND sky130_ef_sc_hd__decap_12
XFILLER_229_1514 VGND VGND VPWR VPWR sky130_fd_sc_hd__fill_1
XFILLER_244_550 VPWR VGND VPWR VGND sky130_ef_sc_hd__decap_12
XFILLER_112_1184 VPWR VGND VPWR VGND sky130_ef_sc_hd__decap_12
XTAP_TAPCELL_ROW_157_2_5921 VGND VPWR sky130_fd_sc_hd__tapvpwrvgnd_1
XFILLER_217_775 VPWR VGND VPWR VGND sky130_ef_sc_hd__decap_12
X_593_ clknet_3_2__leaf_clk _075_ _001_ VGND VGND VPWR VPWR rd_addr\[1\] sky130_fd_sc_hd__dfrtp_1
XFILLER_45_52 VGND VGND VPWR VPWR sky130_fd_sc_hd__decap_3
XFILLER_232_734 VPWR VGND VPWR VGND sky130_ef_sc_hd__decap_12
XFILLER_189_627 VPWR VGND VPWR VGND sky130_ef_sc_hd__decap_12
XFILLER_205_959 VPWR VGND VPWR VGND sky130_ef_sc_hd__decap_12
XTAP_TAPCELL_ROW_84_1_1355 VGND VPWR sky130_fd_sc_hd__tapvpwrvgnd_1
XPHY_EDGE_ROW_36_1_Left_291 VGND VGND VPWR VPWR sky130_fd_sc_hd__decap_3
XFILLER_220_918 VGND VGND VPWR VPWR sky130_fd_sc_hd__decap_6
XFILLER_73_1433 VPWR VGND VPWR VGND sky130_ef_sc_hd__decap_12
XFILLER_227_1260 VPWR VGND VPWR VGND sky130_ef_sc_hd__decap_12
XFILLER_232_789 VGND VGND VPWR VPWR sky130_fd_sc_hd__decap_6
XFILLER_185_811 VGND VGND VPWR VPWR sky130_fd_sc_hd__decap_6
XFILLER_8_501 VGND VGND VPWR VPWR sky130_fd_sc_hd__decap_6
XFILLER_197_682 VGND VGND VPWR VPWR sky130_fd_sc_hd__decap_6
XFILLER_73_1488 VPWR VGND VPWR VGND sky130_ef_sc_hd__decap_12
XPHY_EDGE_ROW_107_2_Right_198 VGND VGND VPWR VPWR sky130_fd_sc_hd__decap_3
XTAP_TAPCELL_ROW_191_2430 VGND VPWR sky130_fd_sc_hd__tapvpwrvgnd_1
XTAP_TAPCELL_ROW_160_1_1470 VGND VPWR sky130_fd_sc_hd__tapvpwrvgnd_1
XTAP_TAPCELL_ROW_191_2441 VGND VPWR sky130_fd_sc_hd__tapvpwrvgnd_1
XTAP_TAPCELL_ROW_75_2_5265 VGND VPWR sky130_fd_sc_hd__tapvpwrvgnd_1
XTAP_TAPCELL_ROW_191_2452 VGND VPWR sky130_fd_sc_hd__tapvpwrvgnd_1
XTAP_TAPCELL_ROW_118_2_5605 VGND VPWR sky130_fd_sc_hd__tapvpwrvgnd_1
XFILLER_8_578 VGND VGND VPWR VPWR sky130_fd_sc_hd__fill_2
XFILLER_201_1444 VPWR VGND VPWR VGND sky130_ef_sc_hd__decap_12
XFILLER_172_538 VPWR VGND VPWR VGND sky130_ef_sc_hd__decap_12
XANTENNA_6 dout0\[11\] VGND VGND VPWR VPWR sky130_fd_sc_hd__diode_2
XFILLER_6_46 VPWR VGND VPWR VGND sky130_ef_sc_hd__decap_12
XFILLER_32_1196 VPWR VGND VPWR VGND sky130_ef_sc_hd__decap_12
XFILLER_197_1370 VGND VGND VPWR VPWR sky130_fd_sc_hd__decap_6
XFILLER_201_1499 VGND VGND VPWR VPWR sky130_fd_sc_hd__decap_6
XTAP_TAPCELL_ROW_42_2_4995 VGND VPWR sky130_fd_sc_hd__tapvpwrvgnd_1
XFILLER_119_1316 VPWR VGND VPWR VGND sky130_ef_sc_hd__decap_12
XTAP_TAPCELL_ROW_189_2370 VGND VPWR sky130_fd_sc_hd__tapvpwrvgnd_1
XFILLER_180_593 VPWR VGND VPWR VGND sky130_ef_sc_hd__decap_12
XTAP_TAPCELL_ROW_189_2381 VGND VPWR sky130_fd_sc_hd__tapvpwrvgnd_1
XTAP_TAPCELL_ROW_185_2223 VGND VPWR sky130_fd_sc_hd__tapvpwrvgnd_1
XTAP_TAPCELL_ROW_185_2234 VGND VPWR sky130_fd_sc_hd__tapvpwrvgnd_1
XTAP_TAPCELL_ROW_185_2245 VGND VPWR sky130_fd_sc_hd__tapvpwrvgnd_1
XFILLER_227_517 VPWR VGND VPWR VGND sky130_ef_sc_hd__decap_12
XFILLER_239_388 VPWR VGND VPWR VGND sky130_ef_sc_hd__decap_12
XFILLER_43_1292 VPWR VGND VPWR VGND sky130_ef_sc_hd__decap_12
XFILLER_254_347 VPWR VGND VPWR VGND sky130_ef_sc_hd__decap_12
XFILLER_130_1251 VPWR VGND VPWR VGND sky130_ef_sc_hd__decap_12
XFILLER_208_753 VPWR VGND VPWR VGND sky130_ef_sc_hd__decap_12
XFILLER_212_46 VPWR VGND VPWR VGND sky130_ef_sc_hd__decap_12
XTAP_TAPCELL_ROW_179_2005 VGND VPWR sky130_fd_sc_hd__tapvpwrvgnd_1
XFILLER_207_252 VGND VGND VPWR VPWR sky130_fd_sc_hd__decap_6
XFILLER_223_701 VPWR VGND VPWR VGND sky130_ef_sc_hd__decap_12
XFILLER_165_1303 VPWR VGND VPWR VGND sky130_ef_sc_hd__decap_12
XFILLER_235_572 VPWR VGND VPWR VGND sky130_ef_sc_hd__decap_12
XTAP_TAPCELL_ROW_179_2016 VGND VPWR sky130_fd_sc_hd__tapvpwrvgnd_1
XTAP_TAPCELL_ROW_179_2027 VGND VPWR sky130_fd_sc_hd__tapvpwrvgnd_1
XPHY_EDGE_ROW_69_2_Right_160 VGND VGND VPWR VPWR sky130_fd_sc_hd__decap_3
XFILLER_39_1328 VGND VGND VPWR VPWR sky130_fd_sc_hd__decap_6
XFILLER_74_1208 VPWR VGND VPWR VGND sky130_ef_sc_hd__decap_12
XTAP_TAPCELL_ROW_179_2038 VGND VPWR sky130_fd_sc_hd__tapvpwrvgnd_1
XFILLER_228_1035 VPWR VGND VPWR VGND sky130_ef_sc_hd__decap_12
XFILLER_250_531 VGND VGND VPWR VPWR sky130_fd_sc_hd__decap_6
XFILLER_165_1336 VGND VGND VPWR VPWR sky130_fd_sc_hd__decap_8
XFILLER_78_1399 VPWR VGND VPWR VGND sky130_ef_sc_hd__decap_12
XFILLER_91_1500 VGND VGND VPWR VPWR sky130_fd_sc_hd__decap_6
XFILLER_223_756 VPWR VGND VPWR VGND sky130_ef_sc_hd__decap_12
XFILLER_188_660 VGND VGND VPWR VPWR sky130_fd_sc_hd__decap_6
XFILLER_204_992 VPWR VGND VPWR VGND sky130_ef_sc_hd__decap_12
XFILLER_206_1355 VPWR VGND VPWR VGND sky130_ef_sc_hd__decap_12
XFILLER_202_1219 VGND VGND VPWR VPWR sky130_fd_sc_hd__decap_6
XTAP_TAPCELL_ROW_234_3960 VGND VPWR sky130_fd_sc_hd__tapvpwrvgnd_1
XTAP_TAPCELL_ROW_230_3802 VGND VPWR sky130_fd_sc_hd__tapvpwrvgnd_1
XTAP_TAPCELL_ROW_230_3813 VGND VPWR sky130_fd_sc_hd__tapvpwrvgnd_1
XPHY_EDGE_ROW_6_Right_6 VGND VGND VPWR VPWR sky130_fd_sc_hd__decap_3
XFILLER_50_1263 VGND VGND VPWR VPWR sky130_fd_sc_hd__decap_6
XFILLER_204_1090 VGND VGND VPWR VPWR sky130_fd_sc_hd__decap_6
XTAP_TAPCELL_ROW_10_1_4736 VGND VPWR sky130_fd_sc_hd__tapvpwrvgnd_1
XFILLER_176_1410 VPWR VGND VPWR VGND sky130_ef_sc_hd__decap_12
XFILLER_190_335 VPWR VGND VPWR VGND sky130_ef_sc_hd__decap_12
XFILLER_239_1131 VPWR VGND VPWR VGND sky130_ef_sc_hd__decap_12
XFILLER_85_1304 VPWR VGND VPWR VGND sky130_ef_sc_hd__decap_12
XFILLER_237_87 VPWR VGND VPWR VGND sky130_ef_sc_hd__decap_12
XFILLER_171_560 VPWR VGND VPWR VGND sky130_ef_sc_hd__decap_12
XFILLER_176_1465 VPWR VGND VPWR VGND sky130_ef_sc_hd__decap_12
XFILLER_239_1186 VPWR VGND VPWR VGND sky130_ef_sc_hd__decap_12
XFILLER_85_1359 VPWR VGND VPWR VGND sky130_ef_sc_hd__decap_12
XTAP_TAPCELL_ROW_228_3720 VGND VPWR sky130_fd_sc_hd__tapvpwrvgnd_1
XTAP_TAPCELL_ROW_228_3731 VGND VPWR sky130_fd_sc_hd__tapvpwrvgnd_1
XTAP_TAPCELL_ROW_228_3742 VGND VPWR sky130_fd_sc_hd__tapvpwrvgnd_1
XTAP_TAPCELL_ROW_228_3753 VGND VPWR sky130_fd_sc_hd__tapvpwrvgnd_1
XTAP_TAPCELL_ROW_163_2_5964 VGND VPWR sky130_fd_sc_hd__tapvpwrvgnd_1
XTAP_TAPCELL_ROW_224_3606 VGND VPWR sky130_fd_sc_hd__tapvpwrvgnd_1
XFILLER_213_1315 VPWR VGND VPWR VGND sky130_ef_sc_hd__decap_12
XFILLER_106_58 VGND VGND VPWR VPWR sky130_fd_sc_hd__decap_6
XFILLER_66_18 VGND VGND VPWR VPWR sky130_fd_sc_hd__decap_3
XTAP_TAPCELL_ROW_90_1_1365 VGND VPWR sky130_fd_sc_hd__tapvpwrvgnd_1
XTAP_TAPCELL_ROW_99_2_5450 VGND VPWR sky130_fd_sc_hd__tapvpwrvgnd_1
XFILLER_245_314 VPWR VGND VPWR VGND sky130_ef_sc_hd__decap_12
XFILLER_170_1097 VPWR VGND VPWR VGND sky130_ef_sc_hd__decap_12
XFILLER_96_1411 VPWR VGND VPWR VGND sky130_ef_sc_hd__decap_12
XFILLER_245_369 VPWR VGND VPWR VGND sky130_ef_sc_hd__decap_12
XFILLER_122_46 VPWR VGND VPWR VGND sky130_ef_sc_hd__decap_12
XFILLER_226_550 VPWR VGND VPWR VGND sky130_ef_sc_hd__decap_12
XFILLER_96_1466 VPWR VGND VPWR VGND sky130_ef_sc_hd__decap_12
XFILLER_198_402 VGND VGND VPWR VPWR sky130_fd_sc_hd__decap_6
XFILLER_214_734 VPWR VGND VPWR VGND sky130_ef_sc_hd__decap_12
XFILLER_199_947 VPWR VGND VPWR VGND sky130_ef_sc_hd__decap_12
XFILLER_109_1507 VGND VGND VPWR VPWR sky130_fd_sc_hd__decap_8
XFILLER_241_553 VGND VGND VPWR VPWR sky130_fd_sc_hd__decap_6
XFILLER_202_918 VGND VGND VPWR VPWR sky130_fd_sc_hd__decap_6
XFILLER_207_1119 VPWR VGND VPWR VGND sky130_ef_sc_hd__decap_12
XFILLER_15_44 VPWR VGND VPWR VGND sky130_ef_sc_hd__decap_12
XFILLER_214_789 VGND VGND VPWR VPWR sky130_fd_sc_hd__decap_6
XTAP_TAPCELL_ROW_61_2_5151 VGND VPWR sky130_fd_sc_hd__tapvpwrvgnd_1
XFILLER_224_1422 VPWR VGND VPWR VGND sky130_ef_sc_hd__decap_12
XFILLER_9_309 VGND VGND VPWR VPWR sky130_fd_sc_hd__decap_6
XFILLER_167_811 VGND VGND VPWR VPWR sky130_fd_sc_hd__decap_6
XFILLER_179_682 VGND VGND VPWR VPWR sky130_fd_sc_hd__decap_6
XFILLER_107_1242 VGND VGND VPWR VPWR sky130_fd_sc_hd__decap_6
XFILLER_224_1477 VGND VGND VPWR VPWR sky130_fd_sc_hd__decap_6
XFILLER_142_1177 VGND VGND VPWR VPWR sky130_fd_sc_hd__decap_6
XFILLER_181_302 VPWR VGND VPWR VGND sky130_ef_sc_hd__decap_12
XTAP_TAPCELL_ROW_27_2_4875 VGND VPWR sky130_fd_sc_hd__tapvpwrvgnd_1
XFILLER_193_173 VPWR VGND VPWR VGND sky130_ef_sc_hd__decap_12
XFILLER_120_1442 VPWR VGND VPWR VGND sky130_ef_sc_hd__decap_12
XFILLER_110_3 VPWR VGND VPWR VGND sky130_ef_sc_hd__decap_12
XFILLER_177_1229 VPWR VGND VPWR VGND sky130_ef_sc_hd__decap_12
XFILLER_208_3 VPWR VGND VPWR VGND sky130_ef_sc_hd__decap_12
XFILLER_181_357 VPWR VGND VPWR VGND sky130_ef_sc_hd__decap_12
XFILLER_120_1497 VPWR VGND VPWR VGND sky130_ef_sc_hd__decap_12
XFILLER_218_1226 VPWR VGND VPWR VGND sky130_ef_sc_hd__decap_12
Xoutput43 net570 VGND VGND VPWR VPWR acc_out[0] sky130_fd_sc_hd__buf_2
XFILLER_1_732 VGND VGND VPWR VPWR sky130_fd_sc_hd__fill_2
Xoutput54 net567 VGND VGND VPWR VPWR acc_out[1] sky130_fd_sc_hd__buf_2
Xoutput65 net564 VGND VGND VPWR VPWR acc_out[2] sky130_fd_sc_hd__buf_2
XFILLER_66_1270 VPWR VGND VPWR VGND sky130_ef_sc_hd__decap_12
XFILLER_7_1315 VPWR VGND VPWR VGND sky130_ef_sc_hd__decap_12
XTAP_TAPCELL_ROW_20_2_4818 VGND VPWR sky130_fd_sc_hd__tapvpwrvgnd_1
XFILLER_0_253 VPWR VGND VPWR VGND sky130_ef_sc_hd__decap_12
XFILLER_153_1273 VPWR VGND VPWR VGND sky130_ef_sc_hd__decap_12
XFILLER_209_517 VPWR VGND VPWR VGND sky130_ef_sc_hd__decap_12
XTAP_TAPCELL_ROW_240_4142 VGND VPWR sky130_fd_sc_hd__tapvpwrvgnd_1
XFILLER_248_163 VPWR VGND VPWR VGND sky130_ef_sc_hd__decap_12
XTAP_TAPCELL_ROW_240_4153 VGND VPWR sky130_fd_sc_hd__tapvpwrvgnd_1
XTAP_TAPCELL_ROW_240_4164 VGND VPWR sky130_fd_sc_hd__tapvpwrvgnd_1
XFILLER_188_1336 VPWR VGND VPWR VGND sky130_ef_sc_hd__decap_12
XFILLER_236_347 VPWR VGND VPWR VGND sky130_ef_sc_hd__decap_12
XFILLER_40_1454 VPWR VGND VPWR VGND sky130_ef_sc_hd__decap_12
X_645_ clknet_3_1__leaf_clk acc_core.adder.cla_blocks\[2\].block.sum\[3\] _053_ VGND
+ VGND VPWR VPWR net45 sky130_fd_sc_hd__dfrtp_1
XFILLER_205_701 VPWR VGND VPWR VGND sky130_ef_sc_hd__decap_12
XFILLER_217_572 VPWR VGND VPWR VGND sky130_ef_sc_hd__decap_12
XFILLER_189_424 VGND VGND VPWR VPWR sky130_fd_sc_hd__decap_6
XFILLER_232_531 VGND VGND VPWR VPWR sky130_fd_sc_hd__decap_6
X_576_ net668 VGND VGND VPWR VPWR _058_ sky130_fd_sc_hd__inv_2
XFILLER_205_756 VPWR VGND VPWR VGND sky130_ef_sc_hd__decap_12
XTAP_TAPCELL_ROW_197_2650 VGND VPWR sky130_fd_sc_hd__tapvpwrvgnd_1
XFILLER_229_1377 VPWR VGND VPWR VGND sky130_ef_sc_hd__decap_12
XTAP_TAPCELL_ROW_238_4071 VGND VPWR sky130_fd_sc_hd__tapvpwrvgnd_1
XFILLER_162_1509 VGND VGND VPWR VPWR sky130_fd_sc_hd__decap_6
XTAP_TAPCELL_ROW_197_2661 VGND VPWR sky130_fd_sc_hd__tapvpwrvgnd_1
XTAP_TAPCELL_ROW_238_4082 VGND VPWR sky130_fd_sc_hd__tapvpwrvgnd_1
XTAP_TAPCELL_ROW_193_2503 VGND VPWR sky130_fd_sc_hd__tapvpwrvgnd_1
XTAP_TAPCELL_ROW_201_2779 VGND VPWR sky130_fd_sc_hd__tapvpwrvgnd_1
XFILLER_73_1230 VPWR VGND VPWR VGND sky130_ef_sc_hd__decap_12
XTAP_TAPCELL_ROW_238_4093 VGND VPWR sky130_fd_sc_hd__tapvpwrvgnd_1
XTAP_TAPCELL_ROW_193_2514 VGND VPWR sky130_fd_sc_hd__tapvpwrvgnd_1
XTAP_TAPCELL_ROW_193_2525 VGND VPWR sky130_fd_sc_hd__tapvpwrvgnd_1
XFILLER_198_980 VPWR VGND VPWR VGND sky130_ef_sc_hd__decap_12
XFILLER_164_1380 VPWR VGND VPWR VGND sky130_ef_sc_hd__decap_12
XFILLER_201_940 VGND VGND VPWR VPWR sky130_fd_sc_hd__decap_6
XFILLER_203_1506 VGND VGND VPWR VPWR sky130_fd_sc_hd__decap_8
XFILLER_73_1285 VGND VGND VPWR VPWR sky130_fd_sc_hd__decap_6
XFILLER_9_832 VGND VGND VPWR VPWR sky130_fd_sc_hd__decap_8
XFILLER_121_1206 VPWR VGND VPWR VGND sky130_ef_sc_hd__decap_12
XFILLER_199_1432 VPWR VGND VPWR VGND sky130_ef_sc_hd__decap_12
XPHY_EDGE_ROW_108_2_Right_199 VGND VGND VPWR VPWR sky130_fd_sc_hd__decap_3
XFILLER_184_151 VPWR VGND VPWR VGND sky130_ef_sc_hd__decap_12
XFILLER_201_1241 VGND VGND VPWR VPWR sky130_fd_sc_hd__decap_6
XFILLER_199_1487 VPWR VGND VPWR VGND sky130_ef_sc_hd__decap_12
XFILLER_8_397 VGND VGND VPWR VPWR sky130_fd_sc_hd__decap_3
XFILLER_172_335 VPWR VGND VPWR VGND sky130_ef_sc_hd__decap_12
XTAP_TAPCELL_ROW_187_2307 VGND VPWR sky130_fd_sc_hd__tapvpwrvgnd_1
XTAP_TAPCELL_ROW_187_2318 VGND VPWR sky130_fd_sc_hd__tapvpwrvgnd_1
XTAP_TAPCELL_ROW_148_2_5844 VGND VPWR sky130_fd_sc_hd__tapvpwrvgnd_1
XFILLER_158_1184 VPWR VGND VPWR VGND sky130_ef_sc_hd__decap_12
XFILLER_236_1348 VGND VGND VPWR VPWR sky130_fd_sc_hd__decap_6
XFILLER_180_390 VPWR VGND VPWR VGND sky130_ef_sc_hd__decap_12
XFILLER_207_68 VPWR VGND VPWR VGND sky130_ef_sc_hd__decap_12
XFILLER_84_1392 VGND VGND VPWR VPWR sky130_fd_sc_hd__decap_6
XFILLER_239_130 VPWR VGND VPWR VGND sky130_ef_sc_hd__decap_12
XFILLER_132_1313 VPWR VGND VPWR VGND sky130_ef_sc_hd__decap_12
XFILLER_255_601 VGND VGND VPWR VPWR sky130_fd_sc_hd__decap_8
XFILLER_41_1218 VPWR VGND VPWR VGND sky130_ef_sc_hd__decap_12
XFILLER_227_314 VPWR VGND VPWR VGND sky130_ef_sc_hd__decap_12
XFILLER_132_1368 VPWR VGND VPWR VGND sky130_ef_sc_hd__decap_12
XFILLER_223_56 VPWR VGND VPWR VGND sky130_ef_sc_hd__decap_12
XFILLER_239_185 VPWR VGND VPWR VGND sky130_ef_sc_hd__decap_12
XFILLER_254_144 VGND VGND VPWR VPWR sky130_fd_sc_hd__decap_6
XTAP_TAPCELL_ROW_66_2_5188 VGND VPWR sky130_fd_sc_hd__tapvpwrvgnd_1
XFILLER_243_818 VPWR VGND VPWR VGND sky130_ef_sc_hd__decap_12
XFILLER_227_369 VPWR VGND VPWR VGND sky130_ef_sc_hd__decap_12
XFILLER_208_550 VPWR VGND VPWR VGND sky130_ef_sc_hd__decap_12
XTAP_TAPCELL_ROW_110_2_5545 VGND VPWR sky130_fd_sc_hd__tapvpwrvgnd_1
XFILLER_247_1444 VPWR VGND VPWR VGND sky130_ef_sc_hd__decap_12
XTAP_TAPCELL_ROW_46_2_5031 VGND VPWR sky130_fd_sc_hd__tapvpwrvgnd_1
XFILLER_169_1291 VPWR VGND VPWR VGND sky130_ef_sc_hd__decap_12
XFILLER_223_553 VGND VGND VPWR VPWR sky130_fd_sc_hd__decap_6
XFILLER_78_1196 VPWR VGND VPWR VGND sky130_ef_sc_hd__decap_12
XFILLER_251_873 VPWR VGND VPWR VGND sky130_ef_sc_hd__decap_12
XFILLER_196_906 VPWR VGND VPWR VGND sky130_ef_sc_hd__decap_12
XFILLER_247_1499 VGND VGND VPWR VPWR sky130_fd_sc_hd__decap_6
XFILLER_165_1177 VPWR VGND VPWR VGND sky130_ef_sc_hd__decap_12
XFILLER_52_1325 VPWR VGND VPWR VGND sky130_ef_sc_hd__decap_12
XFILLER_17_1445 VPWR VGND VPWR VGND sky130_ef_sc_hd__decap_12
XFILLER_206_1152 VPWR VGND VPWR VGND sky130_ef_sc_hd__decap_12
XFILLER_143_1464 VPWR VGND VPWR VGND sky130_ef_sc_hd__decap_12
XFILLER_241_1076 VPWR VGND VPWR VGND sky130_ef_sc_hd__decap_12
XTAP_TAPCELL_ROW_142_1_1442 VGND VPWR sky130_fd_sc_hd__tapvpwrvgnd_1
XFILLER_175_173 VPWR VGND VPWR VGND sky130_ef_sc_hd__decap_12
XFILLER_190_132 VPWR VGND VPWR VGND sky130_ef_sc_hd__decap_12
XFILLER_89_1292 VPWR VGND VPWR VGND sky130_ef_sc_hd__decap_12
XFILLER_176_1262 VGND VGND VPWR VPWR sky130_fd_sc_hd__decap_6
XFILLER_190_187 VGND VGND VPWR VPWR sky130_fd_sc_hd__decap_6
XTAP_TAPCELL_ROW_170_1698 VGND VPWR sky130_fd_sc_hd__tapvpwrvgnd_1
XFILLER_117_68 VGND VGND VPWR VPWR sky130_fd_sc_hd__decap_3
XFILLER_85_1189 VPWR VGND VPWR VGND sky130_ef_sc_hd__decap_12
XFILLER_63_1421 VPWR VGND VPWR VGND sky130_ef_sc_hd__decap_12
XFILLER_77_39 VGND VGND VPWR VPWR sky130_fd_sc_hd__decap_4
XFILLER_115_1500 VGND VGND VPWR VPWR sky130_fd_sc_hd__decap_6
XFILLER_213_1112 VGND VGND VPWR VPWR sky130_fd_sc_hd__decap_6
XFILLER_252_1183 VPWR VGND VPWR VGND sky130_ef_sc_hd__decap_12
XFILLER_63_1476 VPWR VGND VPWR VGND sky130_ef_sc_hd__decap_12
XFILLER_150_1435 VGND VGND VPWR VPWR sky130_fd_sc_hd__decap_6
XFILLER_245_111 VPWR VGND VPWR VGND sky130_ef_sc_hd__decap_12
XFILLER_133_56 VPWR VGND VPWR VGND sky130_ef_sc_hd__decap_12
XFILLER_218_347 VPWR VGND VPWR VGND sky130_ef_sc_hd__decap_12
XFILLER_246_667 VPWR VGND VPWR VGND sky130_ef_sc_hd__decap_12
XFILLER_93_27 VPWR VGND VPWR VGND sky130_ef_sc_hd__decap_12
XFILLER_248_1219 VGND VGND VPWR VPWR sky130_fd_sc_hd__decap_6
XFILLER_245_166 VGND VGND VPWR VPWR sky130_fd_sc_hd__decap_6
XFILLER_22_1184 VPWR VGND VPWR VGND sky130_ef_sc_hd__decap_12
X_430_ _215_ _216_ net193 VGND VGND VPWR VPWR _219_ sky130_fd_sc_hd__or3_1
XFILLER_96_1263 VGND VGND VPWR VPWR sky130_fd_sc_hd__decap_6
XFILLER_214_531 VGND VGND VPWR VPWR sky130_fd_sc_hd__decap_6
XFILLER_26_65 VGND VGND VPWR VPWR sky130_fd_sc_hd__fill_2
XFILLER_242_851 VPWR VGND VPWR VGND sky130_ef_sc_hd__decap_12
XFILLER_199_744 VPWR VGND VPWR VGND sky130_ef_sc_hd__decap_12
XFILLER_109_1304 VPWR VGND VPWR VGND sky130_ef_sc_hd__decap_12
XFILLER_158_3 VPWR VGND VPWR VGND sky130_ef_sc_hd__decap_12
X_361_ net330 _149_ VGND VGND VPWR VPWR _150_ sky130_fd_sc_hd__nand2_1
XFILLER_187_928 VPWR VGND VPWR VGND sky130_ef_sc_hd__decap_12
XFILLER_144_1239 VPWR VGND VPWR VGND sky130_ef_sc_hd__decap_12
XFILLER_199_799 VPWR VGND VPWR VGND sky130_ef_sc_hd__decap_12
XFILLER_109_1359 VPWR VGND VPWR VGND sky130_ef_sc_hd__decap_12
XFILLER_9_106 VPWR VGND VPWR VGND sky130_ef_sc_hd__decap_12
X_292_ net691 net183 VGND VGND VPWR VPWR _079_ sky130_fd_sc_hd__xor2_1
XTAP_TAPCELL_ROW_252_4580 VGND VPWR sky130_fd_sc_hd__tapvpwrvgnd_1
XFILLER_9_139 VGND VGND VPWR VPWR sky130_fd_sc_hd__decap_8
XTAP_TAPCELL_ROW_252_4591 VGND VPWR sky130_fd_sc_hd__tapvpwrvgnd_1
XFILLER_195_983 VGND VGND VPWR VPWR sky130_fd_sc_hd__decap_6
XFILLER_166_151 VPWR VGND VPWR VGND sky130_ef_sc_hd__decap_12
XTAP_TAPCELL_ROW_91_2_5390 VGND VPWR sky130_fd_sc_hd__tapvpwrvgnd_1
XTAP_TAPCELL_ROW_134_2_5730 VGND VPWR sky130_fd_sc_hd__tapvpwrvgnd_1
XFILLER_177_1026 VGND VGND VPWR VPWR sky130_fd_sc_hd__decap_6
XFILLER_6_857 VGND VGND VPWR VPWR sky130_fd_sc_hd__fill_2
XFILLER_5_345 VGND VGND VPWR VPWR sky130_fd_sc_hd__fill_2
XFILLER_181_154 VPWR VGND VPWR VGND sky130_ef_sc_hd__decap_12
XFILLER_170_839 VPWR VGND VPWR VGND sky130_ef_sc_hd__decap_12
XFILLER_120_1294 VPWR VGND VPWR VGND sky130_ef_sc_hd__decap_12
XFILLER_29_1316 VPWR VGND VPWR VGND sky130_ef_sc_hd__decap_12
XFILLER_218_1023 VPWR VGND VPWR VGND sky130_ef_sc_hd__decap_12
XTAP_TAPCELL_ROW_246_4351 VGND VPWR sky130_fd_sc_hd__tapvpwrvgnd_1
XTAP_TAPCELL_ROW_246_4362 VGND VPWR sky130_fd_sc_hd__tapvpwrvgnd_1
XFILLER_155_1335 VPWR VGND VPWR VGND sky130_ef_sc_hd__decap_12
XTAP_TAPCELL_ROW_246_4373 VGND VPWR sky130_fd_sc_hd__tapvpwrvgnd_1
XFILLER_190_1226 VPWR VGND VPWR VGND sky130_ef_sc_hd__decap_12
XTAP_TAPCELL_ROW_242_4215 VGND VPWR sky130_fd_sc_hd__tapvpwrvgnd_1
XTAP_TAPCELL_ROW_242_4226 VGND VPWR sky130_fd_sc_hd__tapvpwrvgnd_1
XFILLER_218_1078 VPWR VGND VPWR VGND sky130_ef_sc_hd__decap_12
XTAP_TAPCELL_ROW_242_4237 VGND VPWR sky130_fd_sc_hd__tapvpwrvgnd_1
XFILLER_235_1370 VGND VGND VPWR VPWR sky130_fd_sc_hd__decap_6
XFILLER_7_1112 VGND VGND VPWR VPWR sky130_fd_sc_hd__decap_6
XTAP_TAPCELL_ROW_83_2_5327 VGND VPWR sky130_fd_sc_hd__tapvpwrvgnd_1
XTAP_TAPCELL_ROW_52_2_5074 VGND VPWR sky130_fd_sc_hd__tapvpwrvgnd_1
XTAP_TAPCELL_ROW_72_1_1337 VGND VPWR sky130_fd_sc_hd__tapvpwrvgnd_1
XFILLER_209_314 VPWR VGND VPWR VGND sky130_ef_sc_hd__decap_12
XTAP_TAPCELL_ROW_8_1140 VGND VPWR sky130_fd_sc_hd__tapvpwrvgnd_1
XTAP_TAPCELL_ROW_8_1151 VGND VPWR sky130_fd_sc_hd__tapvpwrvgnd_1
XTAP_TAPCELL_ROW_8_1162 VGND VPWR sky130_fd_sc_hd__tapvpwrvgnd_1
XTAP_TAPCELL_ROW_8_1173 VGND VPWR sky130_fd_sc_hd__tapvpwrvgnd_1
XTAP_TAPCELL_ROW_4_1004 VGND VPWR sky130_fd_sc_hd__tapvpwrvgnd_1
XFILLER_188_1133 VGND VGND VPWR VPWR sky130_fd_sc_hd__decap_6
XFILLER_236_144 VGND VGND VPWR VPWR sky130_fd_sc_hd__decap_6
XFILLER_40_1251 VPWR VGND VPWR VGND sky130_ef_sc_hd__decap_12
XTAP_TAPCELL_ROW_4_1015 VGND VPWR sky130_fd_sc_hd__tapvpwrvgnd_1
XFILLER_209_369 VPWR VGND VPWR VGND sky130_ef_sc_hd__decap_12
XFILLER_225_818 VPWR VGND VPWR VGND sky130_ef_sc_hd__decap_12
XTAP_TAPCELL_ROW_4_1026 VGND VPWR sky130_fd_sc_hd__tapvpwrvgnd_1
XTAP_TAPCELL_ROW_199_2712 VGND VPWR sky130_fd_sc_hd__tapvpwrvgnd_1
XTAP_TAPCELL_ROW_207_2988 VGND VPWR sky130_fd_sc_hd__tapvpwrvgnd_1
XFILLER_237_689 VPWR VGND VPWR VGND sky130_ef_sc_hd__decap_12
XTAP_TAPCELL_ROW_199_2723 VGND VPWR sky130_fd_sc_hd__tapvpwrvgnd_1
XTAP_TAPCELL_ROW_207_2999 VGND VPWR sky130_fd_sc_hd__tapvpwrvgnd_1
XFILLER_131_1390 VPWR VGND VPWR VGND sky130_ef_sc_hd__decap_12
XTAP_TAPCELL_ROW_199_2734 VGND VPWR sky130_fd_sc_hd__tapvpwrvgnd_1
XFILLER_252_648 VPWR VGND VPWR VGND sky130_ef_sc_hd__decap_12
XTAP_TAPCELL_ROW_236_4008 VGND VPWR sky130_fd_sc_hd__tapvpwrvgnd_1
X_628_ clknet_3_5__leaf_clk dout0\[26\] _036_ VGND VGND VPWR VPWR dout0_q\[26\] sky130_fd_sc_hd__dfrtp_1
XTAP_TAPCELL_ROW_236_4019 VGND VPWR sky130_fd_sc_hd__tapvpwrvgnd_1
XTAP_TAPCELL_ROW_30_2_4900 VGND VPWR sky130_fd_sc_hd__tapvpwrvgnd_1
XFILLER_166_1453 VPWR VGND VPWR VGND sky130_ef_sc_hd__decap_12
XFILLER_205_553 VGND VGND VPWR VPWR sky130_fd_sc_hd__decap_6
XFILLER_75_1347 VPWR VGND VPWR VGND sky130_ef_sc_hd__decap_12
XFILLER_178_906 VPWR VGND VPWR VGND sky130_ef_sc_hd__decap_12
XFILLER_229_1174 VPWR VGND VPWR VGND sky130_ef_sc_hd__decap_12
XFILLER_233_873 VPWR VGND VPWR VGND sky130_ef_sc_hd__decap_12
XFILLER_162_1306 VGND VGND VPWR VPWR sky130_fd_sc_hd__decap_6
X_559_ net671 VGND VGND VPWR VPWR _041_ sky130_fd_sc_hd__inv_2
XFILLER_203_1303 VPWR VGND VPWR VGND sky130_ef_sc_hd__decap_12
XFILLER_186_961 VGND VGND VPWR VPWR sky130_fd_sc_hd__decap_6
XFILLER_73_3 VPWR VGND VPWR VGND sky130_ef_sc_hd__decap_12
XFILLER_9_673 VPWR VGND VPWR VGND sky130_ef_sc_hd__decap_12
XFILLER_203_1358 VPWR VGND VPWR VGND sky130_ef_sc_hd__decap_12
XFILLER_200_280 VPWR VGND VPWR VGND sky130_ef_sc_hd__decap_12
XFILLER_199_1284 VGND VGND VPWR VPWR sky130_fd_sc_hd__decap_6
XFILLER_8_194 VGND VGND VPWR VPWR sky130_fd_sc_hd__decap_8
XFILLER_172_132 VPWR VGND VPWR VGND sky130_ef_sc_hd__decap_12
XFILLER_218_34 VPWR VGND VPWR VGND sky130_ef_sc_hd__decap_12
XFILLER_86_1454 VPWR VGND VPWR VGND sky130_ef_sc_hd__decap_12
XFILLER_172_187 VGND VGND VPWR VPWR sky130_fd_sc_hd__decap_6
XFILLER_218_89 VPWR VGND VPWR VGND sky130_ef_sc_hd__decap_12
XFILLER_173_1413 VGND VGND VPWR VPWR sky130_fd_sc_hd__decap_6
XFILLER_234_22 VPWR VGND VPWR VGND sky130_ef_sc_hd__decap_12
XFILLER_214_1410 VPWR VGND VPWR VGND sky130_ef_sc_hd__decap_12
XFILLER_234_77 VPWR VGND VPWR VGND sky130_ef_sc_hd__decap_12
XFILLER_214_1465 VPWR VGND VPWR VGND sky130_ef_sc_hd__decap_12
XFILLER_227_111 VPWR VGND VPWR VGND sky130_ef_sc_hd__decap_12
XFILLER_255_442 VPWR VGND VPWR VGND sky130_ef_sc_hd__decap_12
XFILLER_249_1506 VGND VGND VPWR VPWR sky130_fd_sc_hd__decap_8
XFILLER_132_1165 VPWR VGND VPWR VGND sky130_ef_sc_hd__decap_12
XFILLER_228_667 VPWR VGND VPWR VGND sky130_ef_sc_hd__decap_12
XFILLER_103_15 VPWR VGND VPWR VGND sky130_ef_sc_hd__decap_12
XFILLER_255_475 VGND VGND VPWR VPWR sky130_fd_sc_hd__decap_8
XFILLER_243_615 VPWR VGND VPWR VGND sky130_ef_sc_hd__decap_12
XFILLER_227_166 VGND VGND VPWR VPWR sky130_fd_sc_hd__decap_6
XFILLER_167_1217 VPWR VGND VPWR VGND sky130_ef_sc_hd__decap_12
XFILLER_250_65 VPWR VGND VPWR VGND sky130_ef_sc_hd__decap_12
XFILLER_247_1241 VGND VGND VPWR VPWR sky130_fd_sc_hd__decap_6
XFILLER_93_1414 VGND VGND VPWR VPWR sky130_fd_sc_hd__decap_6
XFILLER_224_851 VPWR VGND VPWR VGND sky130_ef_sc_hd__decap_12
XFILLER_110_1485 VPWR VGND VPWR VGND sky130_ef_sc_hd__decap_12
XFILLER_19_1507 VGND VGND VPWR VPWR sky130_fd_sc_hd__decap_8
XFILLER_251_670 VPWR VGND VPWR VGND sky130_ef_sc_hd__decap_12
XFILLER_196_703 VGND VGND VPWR VPWR sky130_fd_sc_hd__decap_6
XFILLER_169_928 VPWR VGND VPWR VGND sky130_ef_sc_hd__decap_12
XTAP_TAPCELL_ROW_140_2_5784 VGND VPWR sky130_fd_sc_hd__tapvpwrvgnd_1
XFILLER_208_1269 VPWR VGND VPWR VGND sky130_ef_sc_hd__decap_12
XFILLER_17_1242 VGND VGND VPWR VPWR sky130_fd_sc_hd__decap_6
XTAP_TAPCELL_ROW_76_2_5270 VGND VPWR sky130_fd_sc_hd__tapvpwrvgnd_1
Xwire519 _089_ VGND VGND VPWR VPWR net519 sky130_fd_sc_hd__buf_1
XFILLER_143_1261 VPWR VGND VPWR VGND sky130_ef_sc_hd__decap_12
XFILLER_108_1392 VGND VGND VPWR VPWR sky130_fd_sc_hd__decap_6
XTAP_TAPCELL_ROW_119_2_5610 VGND VPWR sky130_fd_sc_hd__tapvpwrvgnd_1
XFILLER_177_983 VGND VGND VPWR VPWR sky130_fd_sc_hd__decap_6
XFILLER_52_1177 VGND VGND VPWR VPWR sky130_fd_sc_hd__decap_6
XFILLER_12_34 VPWR VGND VPWR VGND sky130_ef_sc_hd__decap_12
XFILLER_178_1324 VPWR VGND VPWR VGND sky130_ef_sc_hd__decap_12
XFILLER_30_1442 VPWR VGND VPWR VGND sky130_ef_sc_hd__decap_12
XFILLER_87_1218 VPWR VGND VPWR VGND sky130_ef_sc_hd__decap_12
XFILLER_128_34 VPWR VGND VPWR VGND sky130_ef_sc_hd__decap_12
XFILLER_191_474 VPWR VGND VPWR VGND sky130_ef_sc_hd__decap_12
XFILLER_178_1379 VPWR VGND VPWR VGND sky130_ef_sc_hd__decap_12
XFILLER_30_1497 VPWR VGND VPWR VGND sky130_ef_sc_hd__decap_12
XFILLER_2_304 VPWR VGND VPWR VGND sky130_ef_sc_hd__decap_12
XTAP_TAPCELL_ROW_101_2_5468 VGND VPWR sky130_fd_sc_hd__tapvpwrvgnd_1
XFILLER_5_6 VPWR VGND VPWR VGND sky130_ef_sc_hd__decap_12
XTAP_TAPCELL_ROW_68_2_5207 VGND VPWR sky130_fd_sc_hd__tapvpwrvgnd_1
XFILLER_250_1109 VPWR VGND VPWR VGND sky130_ef_sc_hd__decap_12
XFILLER_144_22 VPWR VGND VPWR VGND sky130_ef_sc_hd__decap_12
XFILLER_8_1410 VPWR VGND VPWR VGND sky130_ef_sc_hd__decap_12
XFILLER_215_1229 VPWR VGND VPWR VGND sky130_ef_sc_hd__decap_12
XFILLER_238_409 VPWR VGND VPWR VGND sky130_ef_sc_hd__decap_12
XFILLER_63_1273 VPWR VGND VPWR VGND sky130_ef_sc_hd__decap_12
XFILLER_8_1465 VPWR VGND VPWR VGND sky130_ef_sc_hd__decap_12
XPHY_EDGE_ROW_171_Left_426 VGND VGND VPWR VPWR sky130_fd_sc_hd__decap_3
XFILLER_189_1420 VPWR VGND VPWR VGND sky130_ef_sc_hd__decap_12
XFILLER_98_1325 VPWR VGND VPWR VGND sky130_ef_sc_hd__decap_12
XFILLER_207_818 VPWR VGND VPWR VGND sky130_ef_sc_hd__decap_12
XFILLER_218_144 VGND VGND VPWR VPWR sky130_fd_sc_hd__decap_6
XFILLER_246_464 VPWR VGND VPWR VGND sky130_ef_sc_hd__decap_12
XPHY_EDGE_ROW_90_1_Right_746 VGND VGND VPWR VPWR sky130_fd_sc_hd__decap_3
XFILLER_111_1249 VPWR VGND VPWR VGND sky130_ef_sc_hd__decap_12
XFILLER_219_689 VPWR VGND VPWR VGND sky130_ef_sc_hd__decap_12
XFILLER_189_1475 VPWR VGND VPWR VGND sky130_ef_sc_hd__decap_12
XFILLER_234_648 VPWR VGND VPWR VGND sky130_ef_sc_hd__decap_12
XFILLER_160_65 VGND VGND VPWR VPWR sky130_fd_sc_hd__decap_6
XTAP_TAPCELL_ROW_202_2830 VGND VPWR sky130_fd_sc_hd__tapvpwrvgnd_1
XTAP_TAPCELL_ROW_202_2841 VGND VPWR sky130_fd_sc_hd__tapvpwrvgnd_1
XFILLER_199_541 VPWR VGND VPWR VGND sky130_ef_sc_hd__decap_12
XTAP_TAPCELL_ROW_254_4631 VGND VPWR sky130_fd_sc_hd__tapvpwrvgnd_1
XFILLER_2_1097 VPWR VGND VPWR VGND sky130_ef_sc_hd__decap_12
XFILLER_215_873 VPWR VGND VPWR VGND sky130_ef_sc_hd__decap_12
XTAP_TAPCELL_ROW_254_4642 VGND VPWR sky130_fd_sc_hd__tapvpwrvgnd_1
XPHY_EDGE_ROW_64_1_Left_319 VGND VGND VPWR VPWR sky130_fd_sc_hd__decap_3
X_413_ net126 _200_ _201_ VGND VGND VPWR VPWR _202_ sky130_fd_sc_hd__and3_1
XFILLER_72_1509 VGND VGND VPWR VPWR sky130_fd_sc_hd__decap_6
XFILLER_226_1336 VPWR VGND VPWR VGND sky130_ef_sc_hd__decap_12
XTAP_TAPCELL_ROW_254_4653 VGND VPWR sky130_fd_sc_hd__tapvpwrvgnd_1
XFILLER_187_725 VGND VGND VPWR VPWR sky130_fd_sc_hd__decap_6
XFILLER_230_832 VGND VGND VPWR VPWR sky130_fd_sc_hd__decap_6
XTAP_TAPCELL_ROW_250_4506 VGND VPWR sky130_fd_sc_hd__tapvpwrvgnd_1
XTAP_TAPCELL_ROW_250_4517 VGND VPWR sky130_fd_sc_hd__tapvpwrvgnd_1
XFILLER_199_596 VGND VGND VPWR VPWR sky130_fd_sc_hd__decap_6
X_344_ net593 net574 net545 VGND VGND VPWR VPWR _133_ sky130_fd_sc_hd__a21oi_1
XFILLER_74_1380 VPWR VGND VPWR VGND sky130_ef_sc_hd__decap_12
XFILLER_109_1189 VPWR VGND VPWR VGND sky130_ef_sc_hd__decap_12
XFILLER_168_961 VGND VGND VPWR VPWR sky130_fd_sc_hd__decap_6
XPHY_EDGE_ROW_180_Left_435 VGND VGND VPWR VPWR sky130_fd_sc_hd__decap_3
XFILLER_31_1206 VPWR VGND VPWR VGND sky130_ef_sc_hd__decap_12
XFILLER_6_621 VGND VGND VPWR VPWR sky130_fd_sc_hd__fill_2
XFILLER_122_1356 VPWR VGND VPWR VGND sky130_ef_sc_hd__decap_12
XTAP_TAPCELL_ROW_248_4424 VGND VPWR sky130_fd_sc_hd__tapvpwrvgnd_1
XFILLER_182_452 VPWR VGND VPWR VGND sky130_ef_sc_hd__decap_12
XTAP_TAPCELL_ROW_248_4435 VGND VPWR sky130_fd_sc_hd__tapvpwrvgnd_1
XFILLER_202_1391 VGND VGND VPWR VPWR sky130_fd_sc_hd__decap_6
XFILLER_255_1009 VPWR VGND VPWR VGND sky130_ef_sc_hd__decap_12
XTAP_TAPCELL_ROW_248_4446 VGND VPWR sky130_fd_sc_hd__tapvpwrvgnd_1
XFILLER_5_142 VPWR VGND VPWR VGND sky130_ef_sc_hd__decap_12
XFILLER_170_636 VPWR VGND VPWR VGND sky130_ef_sc_hd__decap_12
XFILLER_237_1432 VPWR VGND VPWR VGND sky130_ef_sc_hd__decap_12
XFILLER_68_1184 VPWR VGND VPWR VGND sky130_ef_sc_hd__decap_12
XFILLER_190_1023 VPWR VGND VPWR VGND sky130_ef_sc_hd__decap_12
XFILLER_237_1487 VPWR VGND VPWR VGND sky130_ef_sc_hd__decap_12
XFILLER_2_882 VPWR VGND VPWR VGND sky130_ef_sc_hd__decap_12
XFILLER_190_1078 VPWR VGND VPWR VGND sky130_ef_sc_hd__decap_12
XFILLER_42_1313 VPWR VGND VPWR VGND sky130_ef_sc_hd__decap_12
XFILLER_209_111 VPWR VGND VPWR VGND sky130_ef_sc_hd__decap_12
XFILLER_237_431 VPWR VGND VPWR VGND sky130_ef_sc_hd__decap_12
XFILLER_42_1368 VPWR VGND VPWR VGND sky130_ef_sc_hd__decap_12
XFILLER_204_58 VGND VGND VPWR VPWR sky130_fd_sc_hd__decap_6
XFILLER_209_166 VGND VGND VPWR VPWR sky130_fd_sc_hd__decap_6
XFILLER_225_615 VPWR VGND VPWR VGND sky130_ef_sc_hd__decap_12
XFILLER_237_486 VPWR VGND VPWR VGND sky130_ef_sc_hd__decap_12
XFILLER_252_445 VGND VGND VPWR VPWR sky130_fd_sc_hd__decap_6
XTAP_TAPCELL_ROW_156_2_5906 VGND VPWR sky130_fd_sc_hd__tapvpwrvgnd_1
XFILLER_206_851 VPWR VGND VPWR VGND sky130_ef_sc_hd__decap_12
XTAP_TAPCELL_ROW_125_2_5664 VGND VPWR sky130_fd_sc_hd__tapvpwrvgnd_1
XFILLER_127_1201 VGND VGND VPWR VPWR sky130_fd_sc_hd__decap_4
XFILLER_166_1250 VPWR VGND VPWR VGND sky130_ef_sc_hd__decap_12
XFILLER_220_46 VPWR VGND VPWR VGND sky130_ef_sc_hd__decap_12
XFILLER_178_703 VGND VGND VPWR VPWR sky130_fd_sc_hd__decap_6
XFILLER_233_670 VPWR VGND VPWR VGND sky130_ef_sc_hd__decap_12
XFILLER_75_1177 VPWR VGND VPWR VGND sky130_ef_sc_hd__decap_12
XFILLER_221_854 VGND VGND VPWR VPWR sky130_fd_sc_hd__decap_6
XFILLER_203_1100 VPWR VGND VPWR VGND sky130_ef_sc_hd__decap_12
XFILLER_53_1464 VPWR VGND VPWR VGND sky130_ef_sc_hd__decap_12
XFILLER_207_1291 VPWR VGND VPWR VGND sky130_ef_sc_hd__decap_12
XFILLER_140_1423 VPWR VGND VPWR VGND sky130_ef_sc_hd__decap_12
XFILLER_203_1155 VGND VGND VPWR VPWR sky130_fd_sc_hd__decap_6
XFILLER_229_44 VPWR VGND VPWR VGND sky130_ef_sc_hd__decap_12
XFILLER_192_249 VPWR VGND VPWR VGND sky130_ef_sc_hd__decap_12
XFILLER_140_1478 VGND VGND VPWR VPWR sky130_fd_sc_hd__decap_6
XFILLER_238_1207 VPWR VGND VPWR VGND sky130_ef_sc_hd__decap_12
XFILLER_229_99 VPWR VGND VPWR VGND sky130_ef_sc_hd__decap_12
XFILLER_173_474 VPWR VGND VPWR VGND sky130_ef_sc_hd__decap_12
XTAP_TAPCELL_ROW_212_3170 VGND VPWR sky130_fd_sc_hd__tapvpwrvgnd_1
XTAP_TAPCELL_ROW_212_3181 VGND VPWR sky130_fd_sc_hd__tapvpwrvgnd_1
XTAP_TAPCELL_ROW_212_3192 VGND VPWR sky130_fd_sc_hd__tapvpwrvgnd_1
XFILLER_86_1251 VPWR VGND VPWR VGND sky130_ef_sc_hd__decap_12
XFILLER_245_87 VPWR VGND VPWR VGND sky130_ef_sc_hd__decap_12
XFILLER_25_1500 VGND VGND VPWR VPWR sky130_fd_sc_hd__decap_6
XFILLER_134_1227 VPWR VGND VPWR VGND sky130_ef_sc_hd__decap_12
XFILLER_247_228 VPWR VGND VPWR VGND sky130_ef_sc_hd__decap_12
XFILLER_60_1435 VGND VGND VPWR VPWR sky130_fd_sc_hd__decap_6
XTAP_TAPCELL_ROW_165_1520 VGND VPWR sky130_fd_sc_hd__tapvpwrvgnd_1
XFILLER_214_1262 VGND VGND VPWR VPWR sky130_fd_sc_hd__decap_6
XTAP_TAPCELL_ROW_42_1_1292 VGND VPWR sky130_fd_sc_hd__tapvpwrvgnd_1
XTAP_TAPCELL_ROW_165_1531 VGND VPWR sky130_fd_sc_hd__tapvpwrvgnd_1
XTAP_TAPCELL_ROW_165_1542 VGND VPWR sky130_fd_sc_hd__tapvpwrvgnd_1
XFILLER_114_58 VGND VGND VPWR VPWR sky130_fd_sc_hd__decap_6
XFILLER_249_1303 VPWR VGND VPWR VGND sky130_ef_sc_hd__decap_12
XFILLER_228_464 VPWR VGND VPWR VGND sky130_ef_sc_hd__decap_12
XFILLER_243_412 VPWR VGND VPWR VGND sky130_ef_sc_hd__decap_12
XFILLER_167_1014 VPWR VGND VPWR VGND sky130_ef_sc_hd__decap_12
XFILLER_216_648 VPWR VGND VPWR VGND sky130_ef_sc_hd__decap_12
XFILLER_249_1358 VPWR VGND VPWR VGND sky130_ef_sc_hd__decap_12
XFILLER_244_968 VPWR VGND VPWR VGND sky130_ef_sc_hd__decap_12
XFILLER_243_467 VGND VGND VPWR VPWR sky130_fd_sc_hd__decap_6
XFILLER_110_1282 VPWR VGND VPWR VGND sky130_ef_sc_hd__decap_12
XTAP_TAPCELL_ROW_130_1_1424 VGND VPWR sky130_fd_sc_hd__tapvpwrvgnd_1
XFILLER_167_1069 VGND VGND VPWR VPWR sky130_fd_sc_hd__decap_6
XFILLER_208_1011 VPWR VGND VPWR VGND sky130_ef_sc_hd__decap_12
XFILLER_19_1304 VPWR VGND VPWR VGND sky130_ef_sc_hd__decap_12
XFILLER_130_46 VPWR VGND VPWR VGND sky130_ef_sc_hd__decap_12
XFILLER_212_832 VGND VGND VPWR VPWR sky130_fd_sc_hd__decap_6
XFILLER_169_725 VGND VGND VPWR VPWR sky130_fd_sc_hd__decap_6
XFILLER_208_1066 VPWR VGND VPWR VGND sky130_ef_sc_hd__decap_12
XFILLER_54_1239 VPWR VGND VPWR VGND sky130_ef_sc_hd__decap_12
XFILLER_19_1359 VPWR VGND VPWR VGND sky130_ef_sc_hd__decap_12
XFILLER_145_1378 VPWR VGND VPWR VGND sky130_ef_sc_hd__decap_12
XTAP_TAPCELL_ROW_178_1969 VGND VPWR sky130_fd_sc_hd__tapvpwrvgnd_1
XFILLER_180_1269 VPWR VGND VPWR VGND sky130_ef_sc_hd__decap_12
XFILLER_23_44 VPWR VGND VPWR VGND sky130_ef_sc_hd__decap_12
Xwire305 net306 VGND VGND VPWR VPWR net305 sky130_fd_sc_hd__clkbuf_1
Xwire316 net317 VGND VGND VPWR VPWR net316 sky130_fd_sc_hd__clkbuf_1
Xwire327 net328 VGND VGND VPWR VPWR net327 sky130_fd_sc_hd__clkbuf_1
XFILLER_183_216 VPWR VGND VPWR VGND sky130_ef_sc_hd__decap_12
XFILLER_139_44 VPWR VGND VPWR VGND sky130_ef_sc_hd__decap_12
Xwire349 net350 VGND VGND VPWR VPWR net349 sky130_fd_sc_hd__clkbuf_1
XFILLER_99_15 VPWR VGND VPWR VGND sky130_ef_sc_hd__decap_12
XTAP_TAPCELL_ROW_96_1_1374 VGND VPWR sky130_fd_sc_hd__tapvpwrvgnd_1
XFILLER_178_1121 VPWR VGND VPWR VGND sky130_ef_sc_hd__decap_12
XFILLER_178_1176 VGND VGND VPWR VPWR sky130_fd_sc_hd__decap_6
XFILLER_191_271 VPWR VGND VPWR VGND sky130_ef_sc_hd__decap_12
XFILLER_2_101 VGND VGND VPWR VPWR sky130_fd_sc_hd__decap_6
XFILLER_30_1294 VPWR VGND VPWR VGND sky130_ef_sc_hd__decap_12
XFILLER_3_3 VPWR VGND VPWR VGND sky130_ef_sc_hd__decap_12
XFILLER_65_1335 VPWR VGND VPWR VGND sky130_ef_sc_hd__decap_12
XFILLER_219_1162 VPWR VGND VPWR VGND sky130_ef_sc_hd__decap_12
XFILLER_117_1414 VGND VGND VPWR VPWR sky130_fd_sc_hd__decap_6
XFILLER_215_1026 VGND VGND VPWR VPWR sky130_fd_sc_hd__decap_6
XFILLER_156_1485 VPWR VGND VPWR VGND sky130_ef_sc_hd__decap_12
XFILLER_254_1097 VPWR VGND VPWR VGND sky130_ef_sc_hd__decap_12
XFILLER_238_206 VPWR VGND VPWR VGND sky130_ef_sc_hd__decap_12
XFILLER_152_1349 VGND VGND VPWR VPWR sky130_fd_sc_hd__decap_6
XFILLER_8_1262 VGND VGND VPWR VPWR sky130_fd_sc_hd__decap_6
XFILLER_219_431 VPWR VGND VPWR VGND sky130_ef_sc_hd__decap_12
XTAP_TAPCELL_ROW_98_2_5446 VGND VPWR sky130_fd_sc_hd__tapvpwrvgnd_1
XFILLER_253_209 VGND VGND VPWR VPWR sky130_fd_sc_hd__decap_6
XTAP_TAPCELL_ROW_204_2903 VGND VPWR sky130_fd_sc_hd__tapvpwrvgnd_1
XFILLER_246_261 VPWR VGND VPWR VGND sky130_ef_sc_hd__decap_12
XFILLER_0_15 VGND VGND VPWR VPWR sky130_fd_sc_hd__decap_6
XFILLER_207_615 VPWR VGND VPWR VGND sky130_ef_sc_hd__decap_12
XFILLER_219_486 VPWR VGND VPWR VGND sky130_ef_sc_hd__decap_12
XTAP_TAPCELL_ROW_111_2_5550 VGND VPWR sky130_fd_sc_hd__tapvpwrvgnd_1
XFILLER_189_1272 VPWR VGND VPWR VGND sky130_ef_sc_hd__decap_12
XFILLER_41_1390 VPWR VGND VPWR VGND sky130_ef_sc_hd__decap_12
XPHY_EDGE_ROW_91_1_Right_747 VGND VGND VPWR VPWR sky130_fd_sc_hd__decap_3
XFILLER_98_1177 VGND VGND VPWR VPWR sky130_fd_sc_hd__decap_6
XFILLER_234_445 VGND VGND VPWR VPWR sky130_fd_sc_hd__decap_6
XFILLER_76_1442 VPWR VGND VPWR VGND sky130_ef_sc_hd__decap_12
XFILLER_215_670 VPWR VGND VPWR VGND sky130_ef_sc_hd__decap_12
XFILLER_250_949 VPWR VGND VPWR VGND sky130_ef_sc_hd__decap_12
XFILLER_243_990 VPWR VGND VPWR VGND sky130_ef_sc_hd__decap_12
XFILLER_72_1306 VGND VGND VPWR VPWR sky130_fd_sc_hd__decap_6
XFILLER_226_1133 VGND VGND VPWR VPWR sky130_fd_sc_hd__decap_6
XFILLER_76_1497 VPWR VGND VPWR VGND sky130_ef_sc_hd__decap_12
XFILLER_163_1445 VPWR VGND VPWR VGND sky130_ef_sc_hd__decap_12
XFILLER_203_854 VGND VGND VPWR VPWR sky130_fd_sc_hd__decap_6
X_327_ net595 net539 dout0_q\[17\] VGND VGND VPWR VPWR _116_ sky130_fd_sc_hd__and3_1
XFILLER_198_1508 VGND VGND VPWR VPWR sky130_fd_sc_hd__decap_6
XFILLER_204_1453 VPWR VGND VPWR VGND sky130_ef_sc_hd__decap_12
XFILLER_174_249 VPWR VGND VPWR VGND sky130_ef_sc_hd__decap_12
Xmax_cap605 net606 VGND VGND VPWR VPWR net605 sky130_fd_sc_hd__clkbuf_1
Xmax_cap616 rd_addr\[1\] VGND VGND VPWR VPWR net616 sky130_fd_sc_hd__clkbuf_1
XTAP_TAPCELL_ROW_60_1_1319 VGND VPWR sky130_fd_sc_hd__tapvpwrvgnd_1
XFILLER_6_495 VGND VGND VPWR VPWR sky130_fd_sc_hd__fill_1
XFILLER_170_433 VPWR VGND VPWR VGND sky130_ef_sc_hd__decap_12
XFILLER_83_1402 VPWR VGND VPWR VGND sky130_ef_sc_hd__decap_12
XFILLER_157_1249 VPWR VGND VPWR VGND sky130_ef_sc_hd__decap_12
XFILLER_170_488 VGND VGND VPWR VPWR sky130_fd_sc_hd__decap_6
XFILLER_83_1457 VGND VGND VPWR VPWR sky130_fd_sc_hd__decap_6
XFILLER_237_1284 VGND VGND VPWR VPWR sky130_fd_sc_hd__decap_6
XFILLER_36_3 VPWR VGND VPWR VGND sky130_ef_sc_hd__decap_12
XFILLER_229_228 VPWR VGND VPWR VGND sky130_ef_sc_hd__decap_12
XFILLER_215_68 VPWR VGND VPWR VGND sky130_ef_sc_hd__decap_12
XFILLER_211_1413 VGND VGND VPWR VPWR sky130_fd_sc_hd__decap_6
XFILLER_250_1484 VPWR VGND VPWR VGND sky130_ef_sc_hd__decap_12
XFILLER_168_1312 VPWR VGND VPWR VGND sky130_ef_sc_hd__decap_12
XFILLER_225_412 VPWR VGND VPWR VGND sky130_ef_sc_hd__decap_12
XFILLER_253_732 VPWR VGND VPWR VGND sky130_ef_sc_hd__decap_12
XFILLER_77_1206 VPWR VGND VPWR VGND sky130_ef_sc_hd__decap_12
XFILLER_237_283 VPWR VGND VPWR VGND sky130_ef_sc_hd__decap_12
XFILLER_0_1513 VGND VGND VPWR VPWR sky130_fd_sc_hd__fill_2
XTAP_TAPCELL_ROW_220_3450 VGND VPWR sky130_fd_sc_hd__tapvpwrvgnd_1
XFILLER_226_968 VPWR VGND VPWR VGND sky130_ef_sc_hd__decap_12
XTAP_TAPCELL_ROW_220_3461 VGND VPWR sky130_fd_sc_hd__tapvpwrvgnd_1
XFILLER_231_56 VPWR VGND VPWR VGND sky130_ef_sc_hd__decap_12
XFILLER_241_916 VPWR VGND VPWR VGND sky130_ef_sc_hd__decap_12
XFILLER_168_1367 VPWR VGND VPWR VGND sky130_ef_sc_hd__decap_12
XTAP_TAPCELL_ROW_220_3472 VGND VPWR sky130_fd_sc_hd__tapvpwrvgnd_1
XFILLER_225_467 VGND VGND VPWR VPWR sky130_fd_sc_hd__decap_6
XFILLER_253_787 VPWR VGND VPWR VGND sky130_ef_sc_hd__decap_12
XFILLER_20_1485 VPWR VGND VPWR VGND sky130_ef_sc_hd__decap_12
XFILLER_248_1391 VGND VGND VPWR VPWR sky130_fd_sc_hd__decap_6
XFILLER_205_1217 VPWR VGND VPWR VGND sky130_ef_sc_hd__decap_12
XFILLER_53_1261 VPWR VGND VPWR VGND sky130_ef_sc_hd__decap_12
XTAP_TAPCELL_ROW_173_1800 VGND VPWR sky130_fd_sc_hd__tapvpwrvgnd_1
XTAP_TAPCELL_ROW_218_3390 VGND VPWR sky130_fd_sc_hd__tapvpwrvgnd_1
XFILLER_18_1392 VGND VGND VPWR VPWR sky130_fd_sc_hd__decap_6
XFILLER_140_1220 VGND VGND VPWR VPWR sky130_fd_sc_hd__decap_6
XTAP_TAPCELL_ROW_173_1811 VGND VPWR sky130_fd_sc_hd__tapvpwrvgnd_1
XTAP_TAPCELL_ROW_214_3232 VGND VPWR sky130_fd_sc_hd__tapvpwrvgnd_1
XFILLER_220_194 VPWR VGND VPWR VGND sky130_ef_sc_hd__decap_12
XTAP_TAPCELL_ROW_173_1822 VGND VPWR sky130_fd_sc_hd__tapvpwrvgnd_1
XTAP_TAPCELL_ROW_214_3243 VGND VPWR sky130_fd_sc_hd__tapvpwrvgnd_1
XTAP_TAPCELL_ROW_214_3254 VGND VPWR sky130_fd_sc_hd__tapvpwrvgnd_1
XFILLER_88_1313 VPWR VGND VPWR VGND sky130_ef_sc_hd__decap_12
XTAP_TAPCELL_ROW_210_3107 VGND VPWR sky130_fd_sc_hd__tapvpwrvgnd_1
XTAP_TAPCELL_ROW_210_3118 VGND VPWR sky130_fd_sc_hd__tapvpwrvgnd_1
XTAP_TAPCELL_ROW_233_3899 VGND VPWR sky130_fd_sc_hd__tapvpwrvgnd_1
XFILLER_179_1463 VPWR VGND VPWR VGND sky130_ef_sc_hd__decap_12
XFILLER_238_1004 VGND VGND VPWR VPWR sky130_fd_sc_hd__decap_6
XFILLER_173_271 VPWR VGND VPWR VGND sky130_ef_sc_hd__decap_12
XFILLER_88_1368 VPWR VGND VPWR VGND sky130_ef_sc_hd__decap_12
XFILLER_175_1327 VGND VGND VPWR VPWR sky130_fd_sc_hd__decap_6
XFILLER_216_1324 VPWR VGND VPWR VGND sky130_ef_sc_hd__decap_12
XTAP_TAPCELL_ROW_116_2_5587 VGND VPWR sky130_fd_sc_hd__tapvpwrvgnd_1
XTAP_TAPCELL_ROW_167_1604 VGND VPWR sky130_fd_sc_hd__tapvpwrvgnd_1
XTAP_TAPCELL_ROW_208_3025 VGND VPWR sky130_fd_sc_hd__tapvpwrvgnd_1
XTAP_TAPCELL_ROW_84_2_5332 VGND VPWR sky130_fd_sc_hd__tapvpwrvgnd_1
XFILLER_251_1248 VPWR VGND VPWR VGND sky130_ef_sc_hd__decap_12
XTAP_TAPCELL_ROW_167_1615 VGND VPWR sky130_fd_sc_hd__tapvpwrvgnd_1
XTAP_TAPCELL_ROW_208_3036 VGND VPWR sky130_fd_sc_hd__tapvpwrvgnd_1
XTAP_TAPCELL_ROW_208_3047 VGND VPWR sky130_fd_sc_hd__tapvpwrvgnd_1
XFILLER_125_68 VGND VGND VPWR VPWR sky130_fd_sc_hd__decap_3
XFILLER_216_1379 VPWR VGND VPWR VGND sky130_ef_sc_hd__decap_12
XFILLER_5_1413 VGND VGND VPWR VPWR sky130_fd_sc_hd__decap_6
XFILLER_85_39 VGND VGND VPWR VPWR sky130_fd_sc_hd__decap_4
XFILLER_18_22 VPWR VGND VPWR VGND sky130_ef_sc_hd__decap_12
XFILLER_151_1371 VGND VGND VPWR VPWR sky130_fd_sc_hd__decap_6
XFILLER_235_209 VGND VGND VPWR VPWR sky130_fd_sc_hd__decap_6
XFILLER_249_1100 VPWR VGND VPWR VGND sky130_ef_sc_hd__decap_12
XFILLER_244_710 VPWR VGND VPWR VGND sky130_ef_sc_hd__decap_12
XFILLER_228_261 VPWR VGND VPWR VGND sky130_ef_sc_hd__decap_12
XFILLER_21_1249 VPWR VGND VPWR VGND sky130_ef_sc_hd__decap_12
XTAP_TAPCELL_ROW_4_999 VGND VPWR sky130_fd_sc_hd__tapvpwrvgnd_1
XFILLER_99_1464 VPWR VGND VPWR VGND sky130_ef_sc_hd__decap_12
XFILLER_186_1434 VGND VGND VPWR VPWR sky130_fd_sc_hd__decap_6
XFILLER_249_1155 VGND VGND VPWR VPWR sky130_fd_sc_hd__decap_6
XFILLER_95_1328 VGND VGND VPWR VPWR sky130_fd_sc_hd__decap_6
XFILLER_141_56 VPWR VGND VPWR VGND sky130_ef_sc_hd__decap_12
XTAP_TAPCELL_ROW_148_1_1451 VGND VPWR sky130_fd_sc_hd__tapvpwrvgnd_1
XFILLER_216_445 VGND VGND VPWR VPWR sky130_fd_sc_hd__decap_6
XFILLER_244_765 VPWR VGND VPWR VGND sky130_ef_sc_hd__decap_12
XFILLER_112_1399 VPWR VGND VPWR VGND sky130_ef_sc_hd__decap_12
XFILLER_227_1420 VPWR VGND VPWR VGND sky130_ef_sc_hd__decap_12
XFILLER_225_990 VPWR VGND VPWR VGND sky130_ef_sc_hd__decap_12
XFILLER_232_949 VPWR VGND VPWR VGND sky130_ef_sc_hd__decap_12
XFILLER_180_1011 VPWR VGND VPWR VGND sky130_ef_sc_hd__decap_12
XFILLER_197_842 VPWR VGND VPWR VGND sky130_ef_sc_hd__decap_12
XFILLER_227_1475 VPWR VGND VPWR VGND sky130_ef_sc_hd__decap_12
XFILLER_34_65 VGND VGND VPWR VPWR sky130_fd_sc_hd__decap_6
XFILLER_140_3 VPWR VGND VPWR VGND sky130_ef_sc_hd__decap_12
XFILLER_238_3 VPWR VGND VPWR VGND sky130_ef_sc_hd__decap_12
XFILLER_19_1189 VPWR VGND VPWR VGND sky130_ef_sc_hd__decap_12
XFILLER_180_1066 VPWR VGND VPWR VGND sky130_ef_sc_hd__decap_12
Xwire102 _210_ VGND VGND VPWR VPWR net102 sky130_fd_sc_hd__clkbuf_1
XFILLER_197_897 VGND VGND VPWR VPWR sky130_fd_sc_hd__decap_6
XTAP_TAPCELL_ROW_12_2_4757 VGND VPWR sky130_fd_sc_hd__tapvpwrvgnd_1
Xwire146 _215_ VGND VGND VPWR VPWR net146 sky130_fd_sc_hd__clkbuf_1
XFILLER_50_42 VGND VGND VPWR VPWR sky130_fd_sc_hd__fill_2
XFILLER_32_1356 VPWR VGND VPWR VGND sky130_ef_sc_hd__decap_12
Xwire157 _166_ VGND VGND VPWR VPWR net157 sky130_fd_sc_hd__clkbuf_1
XFILLER_7_259 VGND VGND VPWR VPWR sky130_fd_sc_hd__fill_1
Xwire168 _135_ VGND VGND VPWR VPWR net168 sky130_fd_sc_hd__clkbuf_1
Xwire179 _099_ VGND VGND VPWR VPWR net179 sky130_fd_sc_hd__clkbuf_1
XFILLER_180_753 VPWR VGND VPWR VGND sky130_ef_sc_hd__decap_12
XFILLER_65_1165 VPWR VGND VPWR VGND sky130_ef_sc_hd__decap_12
XFILLER_156_1282 VPWR VGND VPWR VGND sky130_ef_sc_hd__decap_12
XFILLER_191_1162 VPWR VGND VPWR VGND sky130_ef_sc_hd__decap_12
XTAP_TAPCELL_ROW_183_2151 VGND VPWR sky130_fd_sc_hd__tapvpwrvgnd_1
XTAP_TAPCELL_ROW_183_2162 VGND VPWR sky130_fd_sc_hd__tapvpwrvgnd_1
XFILLER_254_507 VPWR VGND VPWR VGND sky130_ef_sc_hd__decap_12
XFILLER_130_1411 VPWR VGND VPWR VGND sky130_ef_sc_hd__decap_12
XTAP_TAPCELL_ROW_183_2173 VGND VPWR sky130_fd_sc_hd__tapvpwrvgnd_1
XFILLER_207_412 VPWR VGND VPWR VGND sky130_ef_sc_hd__decap_12
XFILLER_219_283 VPWR VGND VPWR VGND sky130_ef_sc_hd__decap_12
XFILLER_235_732 VPWR VGND VPWR VGND sky130_ef_sc_hd__decap_12
XFILLER_130_1466 VPWR VGND VPWR VGND sky130_ef_sc_hd__decap_12
XFILLER_208_968 VPWR VGND VPWR VGND sky130_ef_sc_hd__decap_12
XFILLER_207_467 VGND VGND VPWR VPWR sky130_fd_sc_hd__decap_6
XFILLER_223_916 VPWR VGND VPWR VGND sky130_ef_sc_hd__decap_12
XPHY_EDGE_ROW_92_1_Right_748 VGND VGND VPWR VPWR sky130_fd_sc_hd__decap_3
XFILLER_201_15 VPWR VGND VPWR VGND sky130_ef_sc_hd__decap_12
XFILLER_235_787 VPWR VGND VPWR VGND sky130_ef_sc_hd__decap_12
XFILLER_250_746 VGND VGND VPWR VPWR sky130_fd_sc_hd__decap_6
XFILLER_37_1201 VGND VGND VPWR VPWR sky130_fd_sc_hd__decap_4
XFILLER_188_820 VPWR VGND VPWR VGND sky130_ef_sc_hd__decap_12
XFILLER_76_1294 VPWR VGND VPWR VGND sky130_ef_sc_hd__decap_12
XFILLER_163_1242 VGND VGND VPWR VPWR sky130_fd_sc_hd__decap_6
XFILLER_231_971 VPWR VGND VPWR VGND sky130_ef_sc_hd__decap_12
XFILLER_188_875 VGND VGND VPWR VPWR sky130_fd_sc_hd__decap_6
XFILLER_198_1305 VGND VGND VPWR VPWR sky130_fd_sc_hd__decap_6
XFILLER_202_194 VPWR VGND VPWR VGND sky130_ef_sc_hd__decap_12
XFILLER_50_1423 VPWR VGND VPWR VGND sky130_ef_sc_hd__decap_12
XFILLER_204_1250 VPWR VGND VPWR VGND sky130_ef_sc_hd__decap_12
XFILLER_50_1478 VGND VGND VPWR VPWR sky130_fd_sc_hd__decap_6
XTAP_TAPCELL_ROW_78_1_1346 VGND VPWR sky130_fd_sc_hd__tapvpwrvgnd_1
XFILLER_239_1346 VPWR VGND VPWR VGND sky130_ef_sc_hd__decap_12
XTAP_TAPCELL_ROW_133_2_5726 VGND VPWR sky130_fd_sc_hd__tapvpwrvgnd_1
XFILLER_170_230 VGND VGND VPWR VPWR sky130_fd_sc_hd__decap_6
XFILLER_226_34 VPWR VGND VPWR VGND sky130_ef_sc_hd__decap_12
XTAP_TAPCELL_ROW_69_2_5212 VGND VPWR sky130_fd_sc_hd__tapvpwrvgnd_1
XFILLER_100_1270 VPWR VGND VPWR VGND sky130_ef_sc_hd__decap_12
XFILLER_171_775 VPWR VGND VPWR VGND sky130_ef_sc_hd__decap_12
XFILLER_87_1390 VPWR VGND VPWR VGND sky130_ef_sc_hd__decap_12
XTAP_TAPCELL_ROW_154_1_1461 VGND VPWR sky130_fd_sc_hd__tapvpwrvgnd_1
XFILLER_226_89 VPWR VGND VPWR VGND sky130_ef_sc_hd__decap_12
XFILLER_44_1227 VPWR VGND VPWR VGND sky130_ef_sc_hd__decap_12
XFILLER_242_22 VPWR VGND VPWR VGND sky130_ef_sc_hd__decap_12
XTAP_TAPCELL_ROW_226_3670 VGND VPWR sky130_fd_sc_hd__tapvpwrvgnd_1
XTAP_TAPCELL_ROW_36_2_4953 VGND VPWR sky130_fd_sc_hd__tapvpwrvgnd_1
XTAP_TAPCELL_ROW_222_3512 VGND VPWR sky130_fd_sc_hd__tapvpwrvgnd_1
XTAP_TAPCELL_ROW_226_3681 VGND VPWR sky130_fd_sc_hd__tapvpwrvgnd_1
XTAP_TAPCELL_ROW_222_3523 VGND VPWR sky130_fd_sc_hd__tapvpwrvgnd_1
XFILLER_250_1281 VPWR VGND VPWR VGND sky130_ef_sc_hd__decap_12
XFILLER_217_209 VGND VGND VPWR VPWR sky130_fd_sc_hd__decap_6
XFILLER_245_529 VPWR VGND VPWR VGND sky130_ef_sc_hd__decap_12
XTAP_TAPCELL_ROW_222_3534 VGND VPWR sky130_fd_sc_hd__tapvpwrvgnd_1
XFILLER_226_710 VPWR VGND VPWR VGND sky130_ef_sc_hd__decap_12
XTAP_TAPCELL_ROW_1_903 VGND VPWR sky130_fd_sc_hd__tapvpwrvgnd_1
XFILLER_242_77 VPWR VGND VPWR VGND sky130_ef_sc_hd__decap_12
XTAP_TAPCELL_ROW_1_914 VGND VPWR sky130_fd_sc_hd__tapvpwrvgnd_1
XFILLER_238_581 VPWR VGND VPWR VGND sky130_ef_sc_hd__decap_12
XTAP_TAPCELL_ROW_1_925 VGND VPWR sky130_fd_sc_hd__tapvpwrvgnd_1
XFILLER_1_80 VGND VGND VPWR VPWR sky130_fd_sc_hd__decap_6
XFILLER_226_765 VPWR VGND VPWR VGND sky130_ef_sc_hd__decap_12
XFILLER_241_713 VPWR VGND VPWR VGND sky130_ef_sc_hd__decap_12
XFILLER_111_15 VPWR VGND VPWR VGND sky130_ef_sc_hd__decap_12
XFILLER_168_1164 VPWR VGND VPWR VGND sky130_ef_sc_hd__decap_12
XFILLER_253_584 VPWR VGND VPWR VGND sky130_ef_sc_hd__decap_12
XFILLER_20_1282 VPWR VGND VPWR VGND sky130_ef_sc_hd__decap_12
XFILLER_198_617 VGND VGND VPWR VPWR sky130_fd_sc_hd__decap_6
XFILLER_214_949 VPWR VGND VPWR VGND sky130_ef_sc_hd__decap_12
XFILLER_207_990 VPWR VGND VPWR VGND sky130_ef_sc_hd__decap_12
XFILLER_241_768 VGND VGND VPWR VPWR sky130_fd_sc_hd__decap_6
XFILLER_0_1387 VPWR VGND VPWR VGND sky130_ef_sc_hd__decap_12
XFILLER_179_842 VPWR VGND VPWR VGND sky130_ef_sc_hd__decap_12
XFILLER_107_1402 VPWR VGND VPWR VGND sky130_ef_sc_hd__decap_12
XTAP_TAPCELL_ROW_216_3305 VGND VPWR sky130_fd_sc_hd__tapvpwrvgnd_1
XFILLER_205_1014 VPWR VGND VPWR VGND sky130_ef_sc_hd__decap_12
XTAP_TAPCELL_ROW_216_3316 VGND VPWR sky130_fd_sc_hd__tapvpwrvgnd_1
XTAP_TAPCELL_ROW_216_3327 VGND VPWR sky130_fd_sc_hd__tapvpwrvgnd_1
XFILLER_55_1378 VPWR VGND VPWR VGND sky130_ef_sc_hd__decap_12
XFILLER_179_897 VGND VGND VPWR VPWR sky130_fd_sc_hd__decap_6
XFILLER_107_1457 VGND VGND VPWR VPWR sky130_fd_sc_hd__decap_6
XFILLER_142_1337 VPWR VGND VPWR VGND sky130_ef_sc_hd__decap_12
XFILLER_205_1069 VGND VGND VPWR VPWR sky130_fd_sc_hd__decap_6
XFILLER_181_517 VPWR VGND VPWR VGND sky130_ef_sc_hd__decap_12
XPHY_EDGE_ROW_54_1_Right_710 VGND VGND VPWR VPWR sky130_fd_sc_hd__decap_3
XFILLER_193_388 VPWR VGND VPWR VGND sky130_ef_sc_hd__decap_12
XFILLER_179_1260 VPWR VGND VPWR VGND sky130_ef_sc_hd__decap_12
XFILLER_20_34 VPWR VGND VPWR VGND sky130_ef_sc_hd__decap_12
XFILLER_88_1165 VPWR VGND VPWR VGND sky130_ef_sc_hd__decap_12
XTAP_TAPCELL_ROW_30_1_1274 VGND VPWR sky130_fd_sc_hd__tapvpwrvgnd_1
XFILLER_136_34 VPWR VGND VPWR VGND sky130_ef_sc_hd__decap_12
XFILLER_27_1414 VGND VGND VPWR VPWR sky130_fd_sc_hd__decap_6
XFILLER_0_413 VGND VGND VPWR VPWR sky130_fd_sc_hd__fill_2
XFILLER_216_1121 VPWR VGND VPWR VGND sky130_ef_sc_hd__decap_12
XFILLER_1_947 VPWR VGND VPWR VGND sky130_ef_sc_hd__decap_12
XPHY_EDGE_ROW_73_1_Left_328 VGND VGND VPWR VPWR sky130_fd_sc_hd__decap_3
XFILLER_66_1485 VPWR VGND VPWR VGND sky130_ef_sc_hd__decap_12
XFILLER_153_1433 VPWR VGND VPWR VGND sky130_ef_sc_hd__decap_12
XFILLER_251_1045 VPWR VGND VPWR VGND sky130_ef_sc_hd__decap_12
XFILLER_248_323 VPWR VGND VPWR VGND sky130_ef_sc_hd__decap_12
XFILLER_62_1349 VGND VGND VPWR VPWR sky130_fd_sc_hd__decap_6
XFILLER_216_1176 VGND VGND VPWR VPWR sky130_fd_sc_hd__decap_6
XFILLER_152_22 VPWR VGND VPWR VGND sky130_ef_sc_hd__decap_12
XFILLER_153_1488 VPWR VGND VPWR VGND sky130_ef_sc_hd__decap_12
XFILLER_236_507 VPWR VGND VPWR VGND sky130_ef_sc_hd__decap_12
XFILLER_248_378 VPWR VGND VPWR VGND sky130_ef_sc_hd__decap_12
XFILLER_188_3 VPWR VGND VPWR VGND sky130_ef_sc_hd__decap_12
X_661_ clknet_3_5__leaf_clk acc_core.adder.cla_blocks\[6\].block.sum\[3\] _069_ VGND
+ VGND VPWR VPWR net62 sky130_fd_sc_hd__dfrtp_1
XFILLER_217_732 VPWR VGND VPWR VGND sky130_ef_sc_hd__decap_12
XFILLER_99_1261 VPWR VGND VPWR VGND sky130_ef_sc_hd__decap_12
XFILLER_244_562 VPWR VGND VPWR VGND sky130_ef_sc_hd__decap_12
X_592_ clknet_3_2__leaf_clk _074_ _000_ VGND VGND VPWR VPWR rd_addr\[0\] sky130_fd_sc_hd__dfrtp_1
XFILLER_205_916 VPWR VGND VPWR VGND sky130_ef_sc_hd__decap_12
XFILLER_112_1196 VPWR VGND VPWR VGND sky130_ef_sc_hd__decap_12
XFILLER_217_787 VPWR VGND VPWR VGND sky130_ef_sc_hd__decap_12
XFILLER_189_639 VGND VGND VPWR VPWR sky130_fd_sc_hd__decap_6
XFILLER_232_746 VGND VGND VPWR VPWR sky130_fd_sc_hd__decap_6
XTAP_TAPCELL_ROW_84_1_1356 VGND VPWR sky130_fd_sc_hd__tapvpwrvgnd_1
XFILLER_227_1272 VPWR VGND VPWR VGND sky130_ef_sc_hd__decap_12
XFILLER_73_1445 VPWR VGND VPWR VGND sky130_ef_sc_hd__decap_12
XFILLER_213_971 VPWR VGND VPWR VGND sky130_ef_sc_hd__decap_12
XTAP_TAPCELL_ROW_191_2431 VGND VPWR sky130_fd_sc_hd__tapvpwrvgnd_1
XTAP_TAPCELL_ROW_191_2442 VGND VPWR sky130_fd_sc_hd__tapvpwrvgnd_1
XTAP_TAPCELL_ROW_191_2453 VGND VPWR sky130_fd_sc_hd__tapvpwrvgnd_1
XFILLER_201_1401 VPWR VGND VPWR VGND sky130_ef_sc_hd__decap_12
XTAP_TAPCELL_ROW_118_2_5606 VGND VPWR sky130_fd_sc_hd__tapvpwrvgnd_1
XFILLER_184_366 VPWR VGND VPWR VGND sky130_ef_sc_hd__decap_12
XFILLER_123_1292 VPWR VGND VPWR VGND sky130_ef_sc_hd__decap_12
XFILLER_201_1456 VGND VGND VPWR VPWR sky130_fd_sc_hd__decap_6
XANTENNA_7 dout0\[9\] VGND VGND VPWR VPWR sky130_fd_sc_hd__diode_2
XFILLER_165_580 VGND VGND VPWR VPWR sky130_fd_sc_hd__decap_8
XFILLER_6_58 VGND VGND VPWR VPWR sky130_fd_sc_hd__decap_6
XTAP_TAPCELL_ROW_42_2_4996 VGND VPWR sky130_fd_sc_hd__tapvpwrvgnd_1
XFILLER_236_1508 VGND VGND VPWR VPWR sky130_fd_sc_hd__decap_6
XFILLER_180_550 VPWR VGND VPWR VGND sky130_ef_sc_hd__decap_12
XFILLER_67_1249 VPWR VGND VPWR VGND sky130_ef_sc_hd__decap_12
XFILLER_119_1328 VGND VGND VPWR VPWR sky130_fd_sc_hd__decap_6
XFILLER_154_1208 VPWR VGND VPWR VGND sky130_ef_sc_hd__decap_12
XTAP_TAPCELL_ROW_189_2360 VGND VPWR sky130_fd_sc_hd__tapvpwrvgnd_1
XTAP_TAPCELL_ROW_189_2371 VGND VPWR sky130_fd_sc_hd__tapvpwrvgnd_1
XFILLER_158_1399 VPWR VGND VPWR VGND sky130_ef_sc_hd__decap_12
XTAP_TAPCELL_ROW_189_2382 VGND VPWR sky130_fd_sc_hd__tapvpwrvgnd_1
XTAP_TAPCELL_ROW_185_2224 VGND VPWR sky130_fd_sc_hd__tapvpwrvgnd_1
XTAP_TAPCELL_ROW_185_2235 VGND VPWR sky130_fd_sc_hd__tapvpwrvgnd_1
XTAP_TAPCELL_ROW_185_2246 VGND VPWR sky130_fd_sc_hd__tapvpwrvgnd_1
XFILLER_239_345 VPWR VGND VPWR VGND sky130_ef_sc_hd__decap_12
XFILLER_254_304 VPWR VGND VPWR VGND sky130_ef_sc_hd__decap_12
XFILLER_227_529 VPWR VGND VPWR VGND sky130_ef_sc_hd__decap_12
XFILLER_208_710 VPWR VGND VPWR VGND sky130_ef_sc_hd__decap_12
XFILLER_254_359 VGND VGND VPWR VPWR sky130_fd_sc_hd__decap_6
XFILLER_130_1263 VGND VGND VPWR VPWR sky130_fd_sc_hd__decap_6
XFILLER_208_765 VPWR VGND VPWR VGND sky130_ef_sc_hd__decap_12
XTAP_TAPCELL_ROW_179_2006 VGND VPWR sky130_fd_sc_hd__tapvpwrvgnd_1
XFILLER_212_58 VGND VGND VPWR VPWR sky130_fd_sc_hd__decap_6
XFILLER_78_1356 VPWR VGND VPWR VGND sky130_ef_sc_hd__decap_12
XTAP_TAPCELL_ROW_179_2017 VGND VPWR sky130_fd_sc_hd__tapvpwrvgnd_1
XFILLER_223_713 VPWR VGND VPWR VGND sky130_ef_sc_hd__decap_12
XFILLER_165_1315 VGND VGND VPWR VPWR sky130_fd_sc_hd__decap_8
XTAP_TAPCELL_ROW_179_2028 VGND VPWR sky130_fd_sc_hd__tapvpwrvgnd_1
XFILLER_235_584 VPWR VGND VPWR VGND sky130_ef_sc_hd__decap_12
XFILLER_228_1047 VGND VGND VPWR VPWR sky130_fd_sc_hd__decap_6
XPHY_EDGE_ROW_93_1_Right_749 VGND VGND VPWR VPWR sky130_fd_sc_hd__decap_3
XFILLER_223_768 VGND VGND VPWR VPWR sky130_fd_sc_hd__decap_6
XFILLER_206_1312 VPWR VGND VPWR VGND sky130_ef_sc_hd__decap_12
XFILLER_194_108 VPWR VGND VPWR VGND sky130_ef_sc_hd__decap_12
XFILLER_206_1367 VPWR VGND VPWR VGND sky130_ef_sc_hd__decap_12
XTAP_TAPCELL_ROW_234_3950 VGND VPWR sky130_fd_sc_hd__tapvpwrvgnd_1
XTAP_TAPCELL_ROW_234_3961 VGND VPWR sky130_fd_sc_hd__tapvpwrvgnd_1
XFILLER_50_1220 VGND VGND VPWR VPWR sky130_fd_sc_hd__decap_6
XTAP_TAPCELL_ROW_230_3803 VGND VPWR sky130_fd_sc_hd__tapvpwrvgnd_1
XTAP_TAPCELL_ROW_230_3814 VGND VPWR sky130_fd_sc_hd__tapvpwrvgnd_1
XFILLER_175_388 VPWR VGND VPWR VGND sky130_ef_sc_hd__decap_12
XTAP_TAPCELL_ROW_10_1_4737 VGND VPWR sky130_fd_sc_hd__tapvpwrvgnd_1
Xmax_cap210 _176_ VGND VGND VPWR VPWR net210 sky130_fd_sc_hd__clkbuf_1
XFILLER_237_44 VPWR VGND VPWR VGND sky130_ef_sc_hd__decap_12
XFILLER_176_1422 VPWR VGND VPWR VGND sky130_ef_sc_hd__decap_12
XFILLER_190_347 VPWR VGND VPWR VGND sky130_ef_sc_hd__decap_12
XFILLER_239_1143 VPWR VGND VPWR VGND sky130_ef_sc_hd__decap_12
XFILLER_85_1316 VPWR VGND VPWR VGND sky130_ef_sc_hd__decap_12
XFILLER_171_572 VPWR VGND VPWR VGND sky130_ef_sc_hd__decap_12
XFILLER_237_99 VPWR VGND VPWR VGND sky130_ef_sc_hd__decap_12
XFILLER_176_1477 VGND VGND VPWR VPWR sky130_fd_sc_hd__decap_6
XFILLER_239_1198 VGND VGND VPWR VPWR sky130_fd_sc_hd__decap_6
XTAP_TAPCELL_ROW_228_3721 VGND VPWR sky130_fd_sc_hd__tapvpwrvgnd_1
XTAP_TAPCELL_ROW_228_3732 VGND VPWR sky130_fd_sc_hd__tapvpwrvgnd_1
XTAP_TAPCELL_ROW_228_3743 VGND VPWR sky130_fd_sc_hd__tapvpwrvgnd_1
XFILLER_106_15 VGND VGND VPWR VPWR sky130_fd_sc_hd__decap_6
XFILLER_217_1463 VPWR VGND VPWR VGND sky130_ef_sc_hd__decap_12
XTAP_TAPCELL_ROW_163_2_5965 VGND VPWR sky130_fd_sc_hd__tapvpwrvgnd_1
XTAP_TAPCELL_ROW_224_3607 VGND VPWR sky130_fd_sc_hd__tapvpwrvgnd_1
XFILLER_213_1327 VGND VGND VPWR VPWR sky130_fd_sc_hd__decap_6
XFILLER_170_1054 VPWR VGND VPWR VGND sky130_ef_sc_hd__decap_12
XFILLER_253_87 VPWR VGND VPWR VGND sky130_ef_sc_hd__decap_12
XFILLER_252_1398 VPWR VGND VPWR VGND sky130_ef_sc_hd__decap_12
XTAP_TAPCELL_ROW_99_2_5451 VGND VPWR sky130_fd_sc_hd__tapvpwrvgnd_1
XFILLER_218_507 VPWR VGND VPWR VGND sky130_ef_sc_hd__decap_12
XFILLER_245_326 VPWR VGND VPWR VGND sky130_ef_sc_hd__decap_12
XFILLER_61_1371 VGND VGND VPWR VPWR sky130_fd_sc_hd__decap_6
XFILLER_96_1423 VPWR VGND VPWR VGND sky130_ef_sc_hd__decap_12
XFILLER_122_58 VGND VGND VPWR VPWR sky130_fd_sc_hd__decap_6
XFILLER_199_904 VPWR VGND VPWR VGND sky130_ef_sc_hd__decap_12
XFILLER_226_562 VPWR VGND VPWR VGND sky130_ef_sc_hd__decap_12
XFILLER_254_882 VPWR VGND VPWR VGND sky130_ef_sc_hd__decap_12
XFILLER_22_1399 VPWR VGND VPWR VGND sky130_ef_sc_hd__decap_12
XFILLER_241_510 VGND VGND VPWR VPWR sky130_fd_sc_hd__decap_6
XFILLER_253_381 VGND VGND VPWR VPWR sky130_fd_sc_hd__decap_6
XFILLER_96_1478 VGND VGND VPWR VPWR sky130_fd_sc_hd__decap_6
XFILLER_214_746 VGND VGND VPWR VPWR sky130_fd_sc_hd__decap_6
XFILLER_199_959 VPWR VGND VPWR VGND sky130_ef_sc_hd__decap_12
XTAP_TAPCELL_ROW_61_2_5152 VGND VPWR sky130_fd_sc_hd__tapvpwrvgnd_1
XFILLER_15_56 VPWR VGND VPWR VGND sky130_ef_sc_hd__decap_12
XFILLER_224_1434 VGND VGND VPWR VPWR sky130_fd_sc_hd__decap_6
XFILLER_146_1270 VPWR VGND VPWR VGND sky130_ef_sc_hd__decap_12
XFILLER_193_130 VPWR VGND VPWR VGND sky130_ef_sc_hd__decap_12
XFILLER_166_366 VPWR VGND VPWR VGND sky130_ef_sc_hd__decap_12
XFILLER_31_44 VGND VGND VPWR VPWR sky130_fd_sc_hd__decap_6
XTAP_TAPCELL_ROW_27_2_4876 VGND VPWR sky130_fd_sc_hd__tapvpwrvgnd_1
XFILLER_181_314 VPWR VGND VPWR VGND sky130_ef_sc_hd__decap_12
XFILLER_193_185 VPWR VGND VPWR VGND sky130_ef_sc_hd__decap_12
XFILLER_120_1454 VPWR VGND VPWR VGND sky130_ef_sc_hd__decap_12
XFILLER_147_44 VPWR VGND VPWR VGND sky130_ef_sc_hd__decap_12
XPHY_EDGE_ROW_55_1_Right_711 VGND VGND VPWR VPWR sky130_fd_sc_hd__decap_3
XFILLER_181_369 VPWR VGND VPWR VGND sky130_ef_sc_hd__decap_12
XFILLER_103_3 VPWR VGND VPWR VGND sky130_ef_sc_hd__decap_12
XFILLER_218_1238 VPWR VGND VPWR VGND sky130_ef_sc_hd__decap_12
Xoutput44 net549 VGND VGND VPWR VPWR acc_out[10] sky130_fd_sc_hd__buf_2
Xoutput55 net55 VGND VGND VPWR VPWR acc_out[20] sky130_fd_sc_hd__buf_2
Xoutput66 net66 VGND VGND VPWR VPWR acc_out[30] sky130_fd_sc_hd__buf_2
XFILLER_66_1282 VPWR VGND VPWR VGND sky130_ef_sc_hd__decap_12
XFILLER_0_232 VPWR VGND VPWR VGND sky130_ef_sc_hd__decap_12
XTAP_TAPCELL_ROW_136_1_1433 VGND VPWR sky130_fd_sc_hd__tapvpwrvgnd_1
XFILLER_153_1230 VPWR VGND VPWR VGND sky130_ef_sc_hd__decap_12
XTAP_TAPCELL_ROW_20_2_4819 VGND VPWR sky130_fd_sc_hd__tapvpwrvgnd_1
XFILLER_248_120 VPWR VGND VPWR VGND sky130_ef_sc_hd__decap_12
XFILLER_7_1327 VGND VGND VPWR VPWR sky130_fd_sc_hd__decap_6
XTAP_TAPCELL_ROW_244_4290 VGND VPWR sky130_fd_sc_hd__tapvpwrvgnd_1
XFILLER_1_788 VGND VGND VPWR VPWR sky130_fd_sc_hd__decap_3
XFILLER_0_265 VGND VGND VPWR VPWR sky130_fd_sc_hd__decap_8
XFILLER_153_1285 VGND VGND VPWR VPWR sky130_fd_sc_hd__decap_6
XTAP_TAPCELL_ROW_240_4143 VGND VPWR sky130_fd_sc_hd__tapvpwrvgnd_1
XFILLER_236_304 VPWR VGND VPWR VGND sky130_ef_sc_hd__decap_12
XFILLER_209_529 VPWR VGND VPWR VGND sky130_ef_sc_hd__decap_12
XTAP_TAPCELL_ROW_240_4154 VGND VPWR sky130_fd_sc_hd__tapvpwrvgnd_1
XFILLER_248_175 VPWR VGND VPWR VGND sky130_ef_sc_hd__decap_12
XTAP_TAPCELL_ROW_240_4165 VGND VPWR sky130_fd_sc_hd__tapvpwrvgnd_1
XFILLER_40_1411 VPWR VGND VPWR VGND sky130_ef_sc_hd__decap_12
XFILLER_252_808 VPWR VGND VPWR VGND sky130_ef_sc_hd__decap_12
XFILLER_188_1348 VGND VGND VPWR VPWR sky130_fd_sc_hd__decap_6
XFILLER_236_359 VGND VGND VPWR VPWR sky130_fd_sc_hd__decap_6
XFILLER_40_1466 VPWR VGND VPWR VGND sky130_ef_sc_hd__decap_12
X_644_ clknet_3_1__leaf_clk acc_core.adder.cla_blocks\[2\].block.sum\[2\] _052_ VGND
+ VGND VPWR VPWR net44 sky130_fd_sc_hd__dfrtp_1
XFILLER_205_713 VPWR VGND VPWR VGND sky130_ef_sc_hd__decap_12
XTAP_TAPCELL_ROW_6_1090 VGND VPWR sky130_fd_sc_hd__tapvpwrvgnd_1
XFILLER_75_1507 VGND VGND VPWR VPWR sky130_fd_sc_hd__decap_8
XFILLER_217_584 VPWR VGND VPWR VGND sky130_ef_sc_hd__decap_12
XFILLER_229_1334 VPWR VGND VPWR VGND sky130_ef_sc_hd__decap_12
X_575_ net668 VGND VGND VPWR VPWR _057_ sky130_fd_sc_hd__inv_2
XTAP_TAPCELL_ROW_197_2640 VGND VPWR sky130_fd_sc_hd__tapvpwrvgnd_1
XFILLER_205_768 VGND VGND VPWR VPWR sky130_fd_sc_hd__decap_6
XTAP_TAPCELL_ROW_197_2651 VGND VPWR sky130_fd_sc_hd__tapvpwrvgnd_1
XTAP_TAPCELL_ROW_238_4072 VGND VPWR sky130_fd_sc_hd__tapvpwrvgnd_1
XTAP_TAPCELL_ROW_197_2662 VGND VPWR sky130_fd_sc_hd__tapvpwrvgnd_1
XFILLER_229_1389 VPWR VGND VPWR VGND sky130_ef_sc_hd__decap_12
XTAP_TAPCELL_ROW_238_4083 VGND VPWR sky130_fd_sc_hd__tapvpwrvgnd_1
XTAP_TAPCELL_ROW_193_2504 VGND VPWR sky130_fd_sc_hd__tapvpwrvgnd_1
XTAP_TAPCELL_ROW_238_4094 VGND VPWR sky130_fd_sc_hd__tapvpwrvgnd_1
XTAP_TAPCELL_ROW_193_2515 VGND VPWR sky130_fd_sc_hd__tapvpwrvgnd_1
XFILLER_73_1242 VGND VGND VPWR VPWR sky130_fd_sc_hd__decap_6
XTAP_TAPCELL_ROW_193_2526 VGND VPWR sky130_fd_sc_hd__tapvpwrvgnd_1
XFILLER_176_108 VPWR VGND VPWR VGND sky130_ef_sc_hd__decap_12
XFILLER_9_811 VGND VGND VPWR VPWR sky130_fd_sc_hd__decap_8
XFILLER_198_992 VPWR VGND VPWR VGND sky130_ef_sc_hd__decap_12
XFILLER_164_1392 VGND VGND VPWR VPWR sky130_fd_sc_hd__decap_6
XFILLER_121_1218 VPWR VGND VPWR VGND sky130_ef_sc_hd__decap_12
XFILLER_199_1444 VPWR VGND VPWR VGND sky130_ef_sc_hd__decap_12
XFILLER_184_163 VPWR VGND VPWR VGND sky130_ef_sc_hd__decap_12
XFILLER_200_495 VPWR VGND VPWR VGND sky130_ef_sc_hd__decap_12
XFILLER_199_1499 VGND VGND VPWR VPWR sky130_fd_sc_hd__decap_6
XFILLER_172_347 VPWR VGND VPWR VGND sky130_ef_sc_hd__decap_12
XFILLER_236_1305 VGND VGND VPWR VPWR sky130_fd_sc_hd__decap_6
XTAP_TAPCELL_ROW_187_2308 VGND VPWR sky130_fd_sc_hd__tapvpwrvgnd_1
XFILLER_10_1270 VPWR VGND VPWR VGND sky130_ef_sc_hd__decap_12
XTAP_TAPCELL_ROW_148_2_5845 VGND VPWR sky130_fd_sc_hd__tapvpwrvgnd_1
XFILLER_158_1196 VPWR VGND VPWR VGND sky130_ef_sc_hd__decap_12
XFILLER_193_1076 VPWR VGND VPWR VGND sky130_ef_sc_hd__decap_12
XPHY_EDGE_ROW_19_2_Left_521 VGND VGND VPWR VPWR sky130_fd_sc_hd__decap_3
XFILLER_239_142 VPWR VGND VPWR VGND sky130_ef_sc_hd__decap_12
XFILLER_132_1325 VPWR VGND VPWR VGND sky130_ef_sc_hd__decap_12
XFILLER_254_101 VGND VGND VPWR VPWR sky130_fd_sc_hd__decap_6
XFILLER_227_326 VPWR VGND VPWR VGND sky130_ef_sc_hd__decap_12
XFILLER_239_197 VPWR VGND VPWR VGND sky130_ef_sc_hd__decap_12
XFILLER_223_68 VPWR VGND VPWR VGND sky130_ef_sc_hd__decap_12
XTAP_TAPCELL_ROW_66_2_5189 VGND VPWR sky130_fd_sc_hd__tapvpwrvgnd_1
XFILLER_247_1401 VPWR VGND VPWR VGND sky130_ef_sc_hd__decap_12
XFILLER_208_562 VPWR VGND VPWR VGND sky130_ef_sc_hd__decap_12
XFILLER_236_882 VPWR VGND VPWR VGND sky130_ef_sc_hd__decap_12
XFILLER_223_510 VGND VGND VPWR VPWR sky130_fd_sc_hd__decap_6
XFILLER_251_830 VPWR VGND VPWR VGND sky130_ef_sc_hd__decap_12
XFILLER_235_381 VGND VGND VPWR VPWR sky130_fd_sc_hd__decap_6
XFILLER_247_1456 VGND VGND VPWR VPWR sky130_fd_sc_hd__decap_6
XTAP_TAPCELL_ROW_46_2_5032 VGND VPWR sky130_fd_sc_hd__tapvpwrvgnd_1
XFILLER_165_1156 VPWR VGND VPWR VGND sky130_ef_sc_hd__decap_12
XFILLER_251_885 VPWR VGND VPWR VGND sky130_ef_sc_hd__decap_12
XFILLER_196_918 VGND VGND VPWR VPWR sky130_fd_sc_hd__decap_6
XTAP_TAPCELL_ROW_66_1_1328 VGND VPWR sky130_fd_sc_hd__tapvpwrvgnd_1
XFILLER_17_1402 VPWR VGND VPWR VGND sky130_ef_sc_hd__decap_12
XFILLER_165_1189 VGND VGND VPWR VPWR sky130_fd_sc_hd__decap_8
XFILLER_143_1421 VPWR VGND VPWR VGND sky130_ef_sc_hd__decap_12
XFILLER_241_1033 VPWR VGND VPWR VGND sky130_ef_sc_hd__decap_12
XFILLER_210_237 VPWR VGND VPWR VGND sky130_ef_sc_hd__decap_12
XFILLER_52_1337 VPWR VGND VPWR VGND sky130_ef_sc_hd__decap_12
XFILLER_17_1457 VGND VGND VPWR VPWR sky130_fd_sc_hd__decap_6
XTAP_TAPCELL_ROW_13_2_4762 VGND VPWR sky130_fd_sc_hd__tapvpwrvgnd_1
XFILLER_206_1164 VPWR VGND VPWR VGND sky130_ef_sc_hd__decap_12
XFILLER_143_1476 VPWR VGND VPWR VGND sky130_ef_sc_hd__decap_12
XFILLER_175_130 VPWR VGND VPWR VGND sky130_ef_sc_hd__decap_12
XFILLER_241_1088 VPWR VGND VPWR VGND sky130_ef_sc_hd__decap_12
XTAP_TAPCELL_ROW_142_1_1443 VGND VPWR sky130_fd_sc_hd__tapvpwrvgnd_1
XFILLER_248_65 VPWR VGND VPWR VGND sky130_ef_sc_hd__decap_12
XFILLER_175_185 VPWR VGND VPWR VGND sky130_ef_sc_hd__decap_12
XFILLER_190_144 VGND VGND VPWR VPWR sky130_fd_sc_hd__decap_6
XFILLER_219_1514 VGND VGND VPWR VPWR sky130_fd_sc_hd__fill_1
XFILLER_102_1184 VPWR VGND VPWR VGND sky130_ef_sc_hd__decap_12
XFILLER_191_689 VPWR VGND VPWR VGND sky130_ef_sc_hd__decap_12
XTAP_TAPCELL_ROW_170_1699 VGND VPWR sky130_fd_sc_hd__tapvpwrvgnd_1
XFILLER_252_1140 VPWR VGND VPWR VGND sky130_ef_sc_hd__decap_12
XFILLER_63_1433 VPWR VGND VPWR VGND sky130_ef_sc_hd__decap_12
XFILLER_217_1260 VPWR VGND VPWR VGND sky130_ef_sc_hd__decap_12
XFILLER_252_1195 VPWR VGND VPWR VGND sky130_ef_sc_hd__decap_12
XFILLER_63_1488 VPWR VGND VPWR VGND sky130_ef_sc_hd__decap_12
XFILLER_218_304 VPWR VGND VPWR VGND sky130_ef_sc_hd__decap_12
XFILLER_246_624 VPWR VGND VPWR VGND sky130_ef_sc_hd__decap_12
XFILLER_245_123 VGND VGND VPWR VPWR sky130_fd_sc_hd__decap_6
XFILLER_133_68 VGND VGND VPWR VPWR sky130_fd_sc_hd__decap_3
XFILLER_218_359 VGND VGND VPWR VPWR sky130_fd_sc_hd__decap_6
XFILLER_234_808 VPWR VGND VPWR VGND sky130_ef_sc_hd__decap_12
XFILLER_246_679 VPWR VGND VPWR VGND sky130_ef_sc_hd__decap_12
XFILLER_93_39 VGND VGND VPWR VPWR sky130_fd_sc_hd__decap_4
XFILLER_96_1220 VGND VGND VPWR VPWR sky130_fd_sc_hd__decap_6
XFILLER_26_22 VPWR VGND VPWR VGND sky130_ef_sc_hd__decap_12
XFILLER_199_701 VPWR VGND VPWR VGND sky130_ef_sc_hd__decap_12
XFILLER_22_1196 VPWR VGND VPWR VGND sky130_ef_sc_hd__decap_12
XFILLER_187_1370 VGND VGND VPWR VPWR sky130_fd_sc_hd__decap_6
XFILLER_242_863 VPWR VGND VPWR VGND sky130_ef_sc_hd__decap_12
XFILLER_109_1316 VPWR VGND VPWR VGND sky130_ef_sc_hd__decap_12
XFILLER_199_756 VPWR VGND VPWR VGND sky130_ef_sc_hd__decap_12
X_360_ net594 net575 net547 VGND VGND VPWR VPWR _149_ sky130_fd_sc_hd__a21o_1
X_291_ _085_ _086_ VGND VGND VPWR VPWR _080_ sky130_fd_sc_hd__and2b_1
XFILLER_9_118 VGND VGND VPWR VPWR sky130_fd_sc_hd__decap_8
XTAP_TAPCELL_ROW_252_4570 VGND VPWR sky130_fd_sc_hd__tapvpwrvgnd_1
XFILLER_195_940 VGND VGND VPWR VPWR sky130_fd_sc_hd__decap_6
XFILLER_201_259 VPWR VGND VPWR VGND sky130_ef_sc_hd__decap_12
XTAP_TAPCELL_ROW_252_4581 VGND VPWR sky130_fd_sc_hd__tapvpwrvgnd_1
XTAP_TAPCELL_ROW_252_4592 VGND VPWR sky130_fd_sc_hd__tapvpwrvgnd_1
XPHY_EDGE_ROW_147_2_Left_649 VGND VGND VPWR VPWR sky130_fd_sc_hd__decap_3
XFILLER_220_3 VPWR VGND VPWR VGND sky130_ef_sc_hd__decap_12
XFILLER_166_163 VPWR VGND VPWR VGND sky130_ef_sc_hd__decap_12
XFILLER_158_65 VGND VGND VPWR VPWR sky130_fd_sc_hd__decap_6
XFILLER_5_302 VGND VGND VPWR VPWR sky130_fd_sc_hd__decap_6
XTAP_TAPCELL_ROW_91_2_5391 VGND VPWR sky130_fd_sc_hd__tapvpwrvgnd_1
XFILLER_6_836 VGND VGND VPWR VPWR sky130_fd_sc_hd__fill_2
XFILLER_181_111 VPWR VGND VPWR VGND sky130_ef_sc_hd__decap_12
XFILLER_33_1292 VPWR VGND VPWR VGND sky130_ef_sc_hd__decap_12
XFILLER_6_847 VGND VGND VPWR VPWR sky130_fd_sc_hd__fill_2
XTAP_TAPCELL_ROW_134_2_5731 VGND VPWR sky130_fd_sc_hd__tapvpwrvgnd_1
XPHY_EDGE_ROW_17_1_Left_272 VGND VGND VPWR VPWR sky130_fd_sc_hd__decap_3
XFILLER_120_1251 VPWR VGND VPWR VGND sky130_ef_sc_hd__decap_12
XFILLER_182_667 VPWR VGND VPWR VGND sky130_ef_sc_hd__decap_12
XFILLER_181_166 VGND VGND VPWR VPWR sky130_fd_sc_hd__decap_6
XPHY_EDGE_ROW_56_1_Right_712 VGND VGND VPWR VPWR sky130_fd_sc_hd__decap_3
XTAP_TAPCELL_ROW_246_4352 VGND VPWR sky130_fd_sc_hd__tapvpwrvgnd_1
XFILLER_64_1208 VPWR VGND VPWR VGND sky130_ef_sc_hd__decap_12
XFILLER_29_1328 VGND VGND VPWR VPWR sky130_fd_sc_hd__decap_6
XFILLER_218_1035 VPWR VGND VPWR VGND sky130_ef_sc_hd__decap_12
XTAP_TAPCELL_ROW_246_4363 VGND VPWR sky130_fd_sc_hd__tapvpwrvgnd_1
XFILLER_81_1500 VGND VGND VPWR VPWR sky130_fd_sc_hd__decap_6
XTAP_TAPCELL_ROW_246_4374 VGND VPWR sky130_fd_sc_hd__tapvpwrvgnd_1
XFILLER_68_1399 VPWR VGND VPWR VGND sky130_ef_sc_hd__decap_12
XFILLER_3_15 VPWR VGND VPWR VGND sky130_ef_sc_hd__decap_12
XFILLER_155_1347 VPWR VGND VPWR VGND sky130_ef_sc_hd__decap_12
XTAP_TAPCELL_ROW_242_4216 VGND VPWR sky130_fd_sc_hd__tapvpwrvgnd_1
XFILLER_190_1238 VPWR VGND VPWR VGND sky130_ef_sc_hd__decap_12
XTAP_TAPCELL_ROW_242_4227 VGND VPWR sky130_fd_sc_hd__tapvpwrvgnd_1
XTAP_TAPCELL_ROW_242_4238 VGND VPWR sky130_fd_sc_hd__tapvpwrvgnd_1
XTAP_TAPCELL_ROW_83_2_5328 VGND VPWR sky130_fd_sc_hd__tapvpwrvgnd_1
XTAP_TAPCELL_ROW_52_2_5075 VGND VPWR sky130_fd_sc_hd__tapvpwrvgnd_1
XTAP_TAPCELL_ROW_72_1_1338 VGND VPWR sky130_fd_sc_hd__tapvpwrvgnd_1
XFILLER_236_101 VGND VGND VPWR VPWR sky130_fd_sc_hd__decap_6
XTAP_TAPCELL_ROW_8_1141 VGND VPWR sky130_fd_sc_hd__tapvpwrvgnd_1
XFILLER_209_326 VPWR VGND VPWR VGND sky130_ef_sc_hd__decap_12
XTAP_TAPCELL_ROW_8_1152 VGND VPWR sky130_fd_sc_hd__tapvpwrvgnd_1
XFILLER_237_646 VPWR VGND VPWR VGND sky130_ef_sc_hd__decap_12
XTAP_TAPCELL_ROW_8_1163 VGND VPWR sky130_fd_sc_hd__tapvpwrvgnd_1
XTAP_TAPCELL_ROW_4_1005 VGND VPWR sky130_fd_sc_hd__tapvpwrvgnd_1
XTAP_TAPCELL_ROW_4_1016 VGND VPWR sky130_fd_sc_hd__tapvpwrvgnd_1
XFILLER_252_605 VPWR VGND VPWR VGND sky130_ef_sc_hd__decap_12
XTAP_TAPCELL_ROW_207_2989 VGND VPWR sky130_fd_sc_hd__tapvpwrvgnd_1
XFILLER_40_1263 VGND VGND VPWR VPWR sky130_fd_sc_hd__decap_6
XTAP_TAPCELL_ROW_4_1027 VGND VPWR sky130_fd_sc_hd__tapvpwrvgnd_1
XTAP_TAPCELL_ROW_199_2713 VGND VPWR sky130_fd_sc_hd__tapvpwrvgnd_1
XTAP_TAPCELL_ROW_199_2724 VGND VPWR sky130_fd_sc_hd__tapvpwrvgnd_1
XFILLER_218_882 VPWR VGND VPWR VGND sky130_ef_sc_hd__decap_12
XTAP_TAPCELL_ROW_199_2735 VGND VPWR sky130_fd_sc_hd__tapvpwrvgnd_1
XFILLER_166_1410 VPWR VGND VPWR VGND sky130_ef_sc_hd__decap_12
XFILLER_205_510 VGND VGND VPWR VPWR sky130_fd_sc_hd__decap_6
X_627_ clknet_3_5__leaf_clk dout0\[25\] _035_ VGND VGND VPWR VPWR dout0_q\[25\] sky130_fd_sc_hd__dfrtp_1
XFILLER_75_1304 VPWR VGND VPWR VGND sky130_ef_sc_hd__decap_12
XFILLER_217_381 VGND VGND VPWR VPWR sky130_fd_sc_hd__decap_6
XFILLER_229_1131 VPWR VGND VPWR VGND sky130_ef_sc_hd__decap_12
XFILLER_233_830 VPWR VGND VPWR VGND sky130_ef_sc_hd__decap_12
XTAP_TAPCELL_ROW_236_4009 VGND VPWR sky130_fd_sc_hd__tapvpwrvgnd_1
XTAP_TAPCELL_ROW_30_2_4901 VGND VPWR sky130_fd_sc_hd__tapvpwrvgnd_1
XFILLER_166_1465 VPWR VGND VPWR VGND sky130_ef_sc_hd__decap_12
X_558_ net671 VGND VGND VPWR VPWR _040_ sky130_fd_sc_hd__inv_2
XFILLER_75_1359 VPWR VGND VPWR VGND sky130_ef_sc_hd__decap_12
XFILLER_178_918 VGND VGND VPWR VPWR sky130_fd_sc_hd__decap_6
XFILLER_229_1186 VPWR VGND VPWR VGND sky130_ef_sc_hd__decap_12
XFILLER_233_885 VPWR VGND VPWR VGND sky130_ef_sc_hd__decap_12
X_489_ net172 net86 VGND VGND VPWR VPWR acc_core.adder.cla_blocks\[4\].block.sum\[2\]
+ sky130_fd_sc_hd__xnor2_1
XFILLER_203_1315 VPWR VGND VPWR VGND sky130_ef_sc_hd__decap_12
XFILLER_9_652 VPWR VGND VPWR VGND sky130_ef_sc_hd__decap_12
XFILLER_192_409 VPWR VGND VPWR VGND sky130_ef_sc_hd__decap_12
XPHY_EDGE_ROW_150_1_Left_405 VGND VGND VPWR VPWR sky130_fd_sc_hd__decap_3
XFILLER_199_1241 VGND VGND VPWR VPWR sky130_fd_sc_hd__decap_6
XFILLER_8_151 VPWR VGND VPWR VGND sky130_ef_sc_hd__decap_12
XFILLER_9_685 VGND VGND VPWR VPWR sky130_fd_sc_hd__decap_8
XFILLER_200_292 VPWR VGND VPWR VGND sky130_ef_sc_hd__decap_12
XFILLER_86_1411 VPWR VGND VPWR VGND sky130_ef_sc_hd__decap_12
XFILLER_172_144 VGND VGND VPWR VPWR sky130_fd_sc_hd__decap_6
XFILLER_218_46 VPWR VGND VPWR VGND sky130_ef_sc_hd__decap_12
XFILLER_173_689 VPWR VGND VPWR VGND sky130_ef_sc_hd__decap_12
XFILLER_86_1466 VPWR VGND VPWR VGND sky130_ef_sc_hd__decap_12
XFILLER_234_34 VPWR VGND VPWR VGND sky130_ef_sc_hd__decap_12
XFILLER_214_1422 VPWR VGND VPWR VGND sky130_ef_sc_hd__decap_12
XFILLER_228_624 VPWR VGND VPWR VGND sky130_ef_sc_hd__decap_12
XFILLER_234_89 VPWR VGND VPWR VGND sky130_ef_sc_hd__decap_12
XFILLER_255_421 VPWR VGND VPWR VGND sky130_ef_sc_hd__decap_12
XFILLER_214_1477 VGND VGND VPWR VPWR sky130_fd_sc_hd__decap_6
XFILLER_227_123 VGND VGND VPWR VPWR sky130_fd_sc_hd__decap_6
XFILLER_216_808 VPWR VGND VPWR VGND sky130_ef_sc_hd__decap_12
XFILLER_255_454 VGND VGND VPWR VPWR sky130_fd_sc_hd__decap_8
XFILLER_132_1177 VGND VGND VPWR VPWR sky130_fd_sc_hd__decap_6
XFILLER_250_22 VPWR VGND VPWR VGND sky130_ef_sc_hd__decap_12
XFILLER_228_679 VPWR VGND VPWR VGND sky130_ef_sc_hd__decap_12
XFILLER_103_27 VPWR VGND VPWR VGND sky130_ef_sc_hd__decap_12
XFILLER_243_627 VPWR VGND VPWR VGND sky130_ef_sc_hd__decap_12
XFILLER_110_1442 VPWR VGND VPWR VGND sky130_ef_sc_hd__decap_12
XFILLER_167_1229 VPWR VGND VPWR VGND sky130_ef_sc_hd__decap_12
XFILLER_250_77 VPWR VGND VPWR VGND sky130_ef_sc_hd__decap_12
XFILLER_110_1497 VPWR VGND VPWR VGND sky130_ef_sc_hd__decap_12
XFILLER_224_863 VPWR VGND VPWR VGND sky130_ef_sc_hd__decap_12
XFILLER_208_1226 VPWR VGND VPWR VGND sky130_ef_sc_hd__decap_12
XFILLER_251_682 VGND VGND VPWR VPWR sky130_fd_sc_hd__decap_6
XTAP_TAPCELL_ROW_140_2_5785 VGND VPWR sky130_fd_sc_hd__tapvpwrvgnd_1
XPHY_EDGE_ROW_249_Right_94 VGND VGND VPWR VPWR sky130_fd_sc_hd__decap_3
XFILLER_56_1270 VPWR VGND VPWR VGND sky130_ef_sc_hd__decap_12
XPHY_EDGE_ROW_82_1_Left_337 VGND VGND VPWR VPWR sky130_fd_sc_hd__decap_3
XFILLER_177_940 VGND VGND VPWR VPWR sky130_fd_sc_hd__decap_6
XTAP_TAPCELL_ROW_76_2_5271 VGND VPWR sky130_fd_sc_hd__tapvpwrvgnd_1
XFILLER_143_1273 VPWR VGND VPWR VGND sky130_ef_sc_hd__decap_12
XTAP_TAPCELL_ROW_119_2_5611 VGND VPWR sky130_fd_sc_hd__tapvpwrvgnd_1
XFILLER_12_46 VPWR VGND VPWR VGND sky130_ef_sc_hd__decap_12
XFILLER_178_1336 VPWR VGND VPWR VGND sky130_ef_sc_hd__decap_12
XFILLER_191_431 VPWR VGND VPWR VGND sky130_ef_sc_hd__decap_12
XFILLER_30_1454 VPWR VGND VPWR VGND sky130_ef_sc_hd__decap_12
XFILLER_128_46 VPWR VGND VPWR VGND sky130_ef_sc_hd__decap_12
XFILLER_3_806 VGND VGND VPWR VPWR sky130_fd_sc_hd__decap_8
XFILLER_191_486 VPWR VGND VPWR VGND sky130_ef_sc_hd__decap_12
XFILLER_2_316 VGND VGND VPWR VPWR sky130_fd_sc_hd__decap_6
XTAP_TAPCELL_ROW_101_2_5469 VGND VPWR sky130_fd_sc_hd__tapvpwrvgnd_1
XFILLER_191_1514 VGND VGND VPWR VPWR sky130_fd_sc_hd__fill_1
XTAP_TAPCELL_ROW_68_2_5208 VGND VPWR sky130_fd_sc_hd__tapvpwrvgnd_1
XFILLER_219_1377 VPWR VGND VPWR VGND sky130_ef_sc_hd__decap_12
XFILLER_152_1509 VGND VGND VPWR VPWR sky130_fd_sc_hd__decap_6
XFILLER_144_34 VPWR VGND VPWR VGND sky130_ef_sc_hd__decap_12
XFILLER_63_1230 VPWR VGND VPWR VGND sky130_ef_sc_hd__decap_12
XFILLER_8_1422 VPWR VGND VPWR VGND sky130_ef_sc_hd__decap_12
XFILLER_154_1380 VPWR VGND VPWR VGND sky130_ef_sc_hd__decap_12
Xfanout664 net672 VGND VGND VPWR VPWR net664 sky130_fd_sc_hd__buf_4
XFILLER_218_101 VGND VGND VPWR VPWR sky130_fd_sc_hd__decap_6
XFILLER_63_1285 VGND VGND VPWR VPWR sky130_fd_sc_hd__decap_6
XFILLER_8_1477 VGND VGND VPWR VPWR sky130_fd_sc_hd__decap_6
XFILLER_246_421 VPWR VGND VPWR VGND sky130_ef_sc_hd__decap_12
XTAP_TAPCELL_ROW_35_2_4938 VGND VPWR sky130_fd_sc_hd__tapvpwrvgnd_1
XFILLER_219_646 VPWR VGND VPWR VGND sky130_ef_sc_hd__decap_12
XFILLER_111_1206 VPWR VGND VPWR VGND sky130_ef_sc_hd__decap_12
XFILLER_189_1432 VPWR VGND VPWR VGND sky130_ef_sc_hd__decap_12
XFILLER_98_1337 VPWR VGND VPWR VGND sky130_ef_sc_hd__decap_12
XFILLER_234_605 VPWR VGND VPWR VGND sky130_ef_sc_hd__decap_12
XFILLER_160_22 VPWR VGND VPWR VGND sky130_ef_sc_hd__decap_12
XFILLER_246_476 VPWR VGND VPWR VGND sky130_ef_sc_hd__decap_12
XFILLER_170_3 VPWR VGND VPWR VGND sky130_ef_sc_hd__decap_12
XFILLER_189_1487 VPWR VGND VPWR VGND sky130_ef_sc_hd__decap_12
XTAP_TAPCELL_ROW_202_2820 VGND VPWR sky130_fd_sc_hd__tapvpwrvgnd_1
XFILLER_2_1054 VPWR VGND VPWR VGND sky130_ef_sc_hd__decap_12
XFILLER_215_830 VPWR VGND VPWR VGND sky130_ef_sc_hd__decap_12
XTAP_TAPCELL_ROW_202_2831 VGND VPWR sky130_fd_sc_hd__tapvpwrvgnd_1
XTAP_TAPCELL_ROW_202_2842 VGND VPWR sky130_fd_sc_hd__tapvpwrvgnd_1
X_412_ net202 net131 _182_ _185_ net204 VGND VGND VPWR VPWR _201_ sky130_fd_sc_hd__a2111o_1
XTAP_TAPCELL_ROW_254_4632 VGND VPWR sky130_fd_sc_hd__tapvpwrvgnd_1
XFILLER_242_660 VGND VGND VPWR VPWR sky130_fd_sc_hd__decap_6
XFILLER_199_553 VGND VGND VPWR VPWR sky130_fd_sc_hd__decap_6
XTAP_TAPCELL_ROW_254_4643 VGND VPWR sky130_fd_sc_hd__tapvpwrvgnd_1
XFILLER_215_885 VPWR VGND VPWR VGND sky130_ef_sc_hd__decap_12
XTAP_TAPCELL_ROW_254_4654 VGND VPWR sky130_fd_sc_hd__tapvpwrvgnd_1
XFILLER_148_1184 VPWR VGND VPWR VGND sky130_ef_sc_hd__decap_12
XFILLER_226_1348 VGND VGND VPWR VPWR sky130_fd_sc_hd__decap_6
XTAP_TAPCELL_ROW_250_4507 VGND VPWR sky130_fd_sc_hd__tapvpwrvgnd_1
XFILLER_53_53 VGND VGND VPWR VPWR sky130_fd_sc_hd__fill_1
XTAP_TAPCELL_ROW_36_1_1283 VGND VPWR sky130_fd_sc_hd__tapvpwrvgnd_1
X_343_ _130_ _131_ VGND VGND VPWR VPWR _132_ sky130_fd_sc_hd__nand2_1
XTAP_TAPCELL_ROW_250_4518 VGND VPWR sky130_fd_sc_hd__tapvpwrvgnd_1
XFILLER_74_1392 VGND VGND VPWR VPWR sky130_fd_sc_hd__decap_6
XFILLER_174_409 VPWR VGND VPWR VGND sky130_ef_sc_hd__decap_12
XFILLER_122_1313 VPWR VGND VPWR VGND sky130_ef_sc_hd__decap_12
XFILLER_31_1218 VPWR VGND VPWR VGND sky130_ef_sc_hd__decap_12
XTAP_TAPCELL_ROW_124_1_1415 VGND VPWR sky130_fd_sc_hd__tapvpwrvgnd_1
XFILLER_194_280 VPWR VGND VPWR VGND sky130_ef_sc_hd__decap_12
XFILLER_122_1368 VPWR VGND VPWR VGND sky130_ef_sc_hd__decap_12
XTAP_TAPCELL_ROW_248_4425 VGND VPWR sky130_fd_sc_hd__tapvpwrvgnd_1
XTAP_TAPCELL_ROW_248_4436 VGND VPWR sky130_fd_sc_hd__tapvpwrvgnd_1
XFILLER_182_464 VPWR VGND VPWR VGND sky130_ef_sc_hd__decap_12
XTAP_TAPCELL_ROW_248_4447 VGND VPWR sky130_fd_sc_hd__tapvpwrvgnd_1
XFILLER_5_154 VGND VGND VPWR VPWR sky130_fd_sc_hd__decap_4
XFILLER_170_648 VPWR VGND VPWR VGND sky130_ef_sc_hd__decap_12
XFILLER_237_1444 VPWR VGND VPWR VGND sky130_ef_sc_hd__decap_12
XPHY_EDGE_ROW_57_1_Right_713 VGND VGND VPWR VPWR sky130_fd_sc_hd__decap_3
XFILLER_68_1196 VPWR VGND VPWR VGND sky130_ef_sc_hd__decap_12
XFILLER_9_1219 VPWR VGND VPWR VGND sky130_ef_sc_hd__decap_12
XFILLER_190_1035 VPWR VGND VPWR VGND sky130_ef_sc_hd__decap_12
XTAP_TAPCELL_ROW_164_2_5970 VGND VPWR sky130_fd_sc_hd__tapvpwrvgnd_1
XFILLER_237_1499 VGND VGND VPWR VPWR sky130_fd_sc_hd__decap_6
XFILLER_2_894 VPWR VGND VPWR VGND sky130_ef_sc_hd__decap_12
XFILLER_42_1325 VPWR VGND VPWR VGND sky130_ef_sc_hd__decap_12
XFILLER_204_15 VGND VGND VPWR VPWR sky130_fd_sc_hd__decap_6
XFILLER_133_1464 VPWR VGND VPWR VGND sky130_ef_sc_hd__decap_12
XFILLER_209_123 VGND VGND VPWR VPWR sky130_fd_sc_hd__decap_6
XFILLER_237_443 VPWR VGND VPWR VGND sky130_ef_sc_hd__decap_12
XFILLER_231_1076 VPWR VGND VPWR VGND sky130_ef_sc_hd__decap_12
XFILLER_252_402 VGND VGND VPWR VPWR sky130_fd_sc_hd__decap_6
XFILLER_225_627 VPWR VGND VPWR VGND sky130_ef_sc_hd__decap_12
XFILLER_253_947 VPWR VGND VPWR VGND sky130_ef_sc_hd__decap_12
XFILLER_237_498 VPWR VGND VPWR VGND sky130_ef_sc_hd__decap_12
XTAP_TAPCELL_ROW_156_2_5907 VGND VPWR sky130_fd_sc_hd__tapvpwrvgnd_1
XFILLER_79_1292 VPWR VGND VPWR VGND sky130_ef_sc_hd__decap_12
XFILLER_206_863 VPWR VGND VPWR VGND sky130_ef_sc_hd__decap_12
XTAP_TAPCELL_ROW_125_2_5665 VGND VPWR sky130_fd_sc_hd__tapvpwrvgnd_1
XFILLER_221_811 VGND VGND VPWR VPWR sky130_fd_sc_hd__decap_6
XFILLER_166_1262 VGND VGND VPWR VPWR sky130_fd_sc_hd__decap_6
XFILLER_220_58 VGND VGND VPWR VPWR sky130_fd_sc_hd__decap_6
XFILLER_233_682 VGND VGND VPWR VPWR sky130_fd_sc_hd__decap_6
XFILLER_75_1189 VPWR VGND VPWR VGND sky130_ef_sc_hd__decap_12
XFILLER_53_1421 VPWR VGND VPWR VGND sky130_ef_sc_hd__decap_12
XFILLER_105_1500 VGND VGND VPWR VPWR sky130_fd_sc_hd__decap_6
XFILLER_203_1112 VGND VGND VPWR VPWR sky130_fd_sc_hd__decap_6
XFILLER_242_1183 VPWR VGND VPWR VGND sky130_ef_sc_hd__decap_12
XFILLER_192_206 VPWR VGND VPWR VGND sky130_ef_sc_hd__decap_12
XFILLER_53_1476 VPWR VGND VPWR VGND sky130_ef_sc_hd__decap_12
XFILLER_140_1435 VGND VGND VPWR VPWR sky130_fd_sc_hd__decap_6
XFILLER_229_56 VPWR VGND VPWR VGND sky130_ef_sc_hd__decap_12
XFILLER_9_493 VGND VGND VPWR VPWR sky130_fd_sc_hd__decap_8
XFILLER_173_431 VPWR VGND VPWR VGND sky130_ef_sc_hd__decap_12
XTAP_TAPCELL_ROW_212_3160 VGND VPWR sky130_fd_sc_hd__tapvpwrvgnd_1
XFILLER_238_1219 VGND VGND VPWR VPWR sky130_fd_sc_hd__decap_6
XTAP_TAPCELL_ROW_171_1750 VGND VPWR sky130_fd_sc_hd__tapvpwrvgnd_1
XTAP_TAPCELL_ROW_212_3171 VGND VPWR sky130_fd_sc_hd__tapvpwrvgnd_1
XTAP_TAPCELL_ROW_212_3182 VGND VPWR sky130_fd_sc_hd__tapvpwrvgnd_1
XFILLER_12_1184 VPWR VGND VPWR VGND sky130_ef_sc_hd__decap_12
XFILLER_173_486 VPWR VGND VPWR VGND sky130_ef_sc_hd__decap_12
XTAP_TAPCELL_ROW_212_3193 VGND VPWR sky130_fd_sc_hd__tapvpwrvgnd_1
XFILLER_86_1263 VGND VGND VPWR VPWR sky130_fd_sc_hd__decap_6
XFILLER_245_44 VPWR VGND VPWR VGND sky130_ef_sc_hd__decap_12
XFILLER_245_99 VPWR VGND VPWR VGND sky130_ef_sc_hd__decap_12
XFILLER_134_1239 VPWR VGND VPWR VGND sky130_ef_sc_hd__decap_12
XFILLER_114_15 VGND VGND VPWR VPWR sky130_fd_sc_hd__decap_6
XTAP_TAPCELL_ROW_165_1510 VGND VPWR sky130_fd_sc_hd__tapvpwrvgnd_1
XFILLER_228_421 VPWR VGND VPWR VGND sky130_ef_sc_hd__decap_12
XTAP_TAPCELL_ROW_42_1_1293 VGND VPWR sky130_fd_sc_hd__tapvpwrvgnd_1
XTAP_TAPCELL_ROW_165_1521 VGND VPWR sky130_fd_sc_hd__tapvpwrvgnd_1
XTAP_TAPCELL_ROW_165_1532 VGND VPWR sky130_fd_sc_hd__tapvpwrvgnd_1
XTAP_TAPCELL_ROW_165_1543 VGND VPWR sky130_fd_sc_hd__tapvpwrvgnd_1
XFILLER_249_1315 VPWR VGND VPWR VGND sky130_ef_sc_hd__decap_12
XFILLER_216_605 VPWR VGND VPWR VGND sky130_ef_sc_hd__decap_12
XFILLER_244_925 VPWR VGND VPWR VGND sky130_ef_sc_hd__decap_12
XFILLER_228_476 VPWR VGND VPWR VGND sky130_ef_sc_hd__decap_12
XFILLER_243_424 VGND VGND VPWR VPWR sky130_fd_sc_hd__decap_6
XFILLER_255_295 VPWR VGND VPWR VGND sky130_ef_sc_hd__decap_12
XFILLER_167_1026 VGND VGND VPWR VPWR sky130_fd_sc_hd__decap_6
XFILLER_93_1201 VGND VGND VPWR VPWR sky130_fd_sc_hd__decap_4
XTAP_TAPCELL_ROW_130_1_1425 VGND VPWR sky130_fd_sc_hd__tapvpwrvgnd_1
XFILLER_110_1294 VPWR VGND VPWR VGND sky130_ef_sc_hd__decap_12
XFILLER_224_660 VGND VGND VPWR VPWR sky130_fd_sc_hd__decap_6
XFILLER_252_980 VPWR VGND VPWR VGND sky130_ef_sc_hd__decap_12
XFILLER_208_1023 VPWR VGND VPWR VGND sky130_ef_sc_hd__decap_12
XFILLER_19_1316 VPWR VGND VPWR VGND sky130_ef_sc_hd__decap_12
XFILLER_130_58 VGND VGND VPWR VPWR sky130_fd_sc_hd__decap_6
XFILLER_145_1335 VPWR VGND VPWR VGND sky130_ef_sc_hd__decap_12
XFILLER_180_1226 VPWR VGND VPWR VGND sky130_ef_sc_hd__decap_12
XFILLER_208_1078 VPWR VGND VPWR VGND sky130_ef_sc_hd__decap_12
XFILLER_225_1370 VGND VGND VPWR VPWR sky130_fd_sc_hd__decap_6
Xwire306 net307 VGND VGND VPWR VPWR net306 sky130_fd_sc_hd__clkbuf_1
XFILLER_23_56 VGND VGND VPWR VPWR sky130_fd_sc_hd__decap_3
Xwire317 net318 VGND VGND VPWR VPWR net317 sky130_fd_sc_hd__clkbuf_1
Xwire328 net329 VGND VGND VPWR VPWR net328 sky130_fd_sc_hd__clkbuf_1
XFILLER_183_228 VPWR VGND VPWR VGND sky130_ef_sc_hd__decap_12
XFILLER_139_56 VPWR VGND VPWR VGND sky130_ef_sc_hd__decap_12
XFILLER_176_280 VPWR VGND VPWR VGND sky130_ef_sc_hd__decap_12
XFILLER_99_27 VPWR VGND VPWR VGND sky130_ef_sc_hd__decap_12
XFILLER_178_1133 VGND VGND VPWR VPWR sky130_fd_sc_hd__decap_6
XFILLER_30_1251 VPWR VGND VPWR VGND sky130_ef_sc_hd__decap_12
XFILLER_3_614 VGND VGND VPWR VPWR sky130_fd_sc_hd__fill_1
XFILLER_121_1390 VPWR VGND VPWR VGND sky130_ef_sc_hd__decap_12
XTAP_TAPCELL_ROW_149_2_5850 VGND VPWR sky130_fd_sc_hd__tapvpwrvgnd_1
XFILLER_191_283 VPWR VGND VPWR VGND sky130_ef_sc_hd__decap_12
XFILLER_180_968 VPWR VGND VPWR VGND sky130_ef_sc_hd__decap_12
XFILLER_155_44 VPWR VGND VPWR VGND sky130_ef_sc_hd__decap_12
XFILLER_3_658 VGND VGND VPWR VPWR sky130_fd_sc_hd__fill_1
XFILLER_156_1442 VPWR VGND VPWR VGND sky130_ef_sc_hd__decap_12
XFILLER_254_1054 VPWR VGND VPWR VGND sky130_ef_sc_hd__decap_12
XFILLER_65_1347 VPWR VGND VPWR VGND sky130_ef_sc_hd__decap_12
XFILLER_219_1174 VPWR VGND VPWR VGND sky130_ef_sc_hd__decap_12
XFILLER_152_1306 VGND VGND VPWR VPWR sky130_fd_sc_hd__decap_6
XFILLER_191_1377 VPWR VGND VPWR VGND sky130_ef_sc_hd__decap_12
XFILLER_156_1497 VPWR VGND VPWR VGND sky130_ef_sc_hd__decap_12
XFILLER_238_218 VPWR VGND VPWR VGND sky130_ef_sc_hd__decap_12
XFILLER_48_53 VGND VGND VPWR VPWR sky130_fd_sc_hd__decap_3
XTAP_TAPCELL_ROW_98_2_5447 VGND VPWR sky130_fd_sc_hd__tapvpwrvgnd_1
XFILLER_219_443 VPWR VGND VPWR VGND sky130_ef_sc_hd__decap_12
XTAP_TAPCELL_ROW_67_2_5194 VGND VPWR sky130_fd_sc_hd__tapvpwrvgnd_1
XTAP_TAPCELL_ROW_204_2904 VGND VPWR sky130_fd_sc_hd__tapvpwrvgnd_1
XFILLER_171_87 VPWR VGND VPWR VGND sky130_ef_sc_hd__decap_12
XFILLER_234_402 VGND VGND VPWR VPWR sky130_fd_sc_hd__decap_6
XFILLER_246_273 VGND VGND VPWR VPWR sky130_fd_sc_hd__decap_6
XTAP_TAPCELL_ROW_111_2_5551 VGND VPWR sky130_fd_sc_hd__tapvpwrvgnd_1
XFILLER_207_627 VPWR VGND VPWR VGND sky130_ef_sc_hd__decap_12
XFILLER_219_498 VPWR VGND VPWR VGND sky130_ef_sc_hd__decap_12
XFILLER_235_947 VPWR VGND VPWR VGND sky130_ef_sc_hd__decap_12
XTAP_TAPCELL_ROW_181_2090 VGND VPWR sky130_fd_sc_hd__tapvpwrvgnd_1
XFILLER_189_1284 VGND VGND VPWR VPWR sky130_fd_sc_hd__decap_6
XFILLER_250_906 VPWR VGND VPWR VGND sky130_ef_sc_hd__decap_12
XFILLER_64_63 VGND VGND VPWR VPWR sky130_fd_sc_hd__fill_1
XFILLER_76_1454 VPWR VGND VPWR VGND sky130_ef_sc_hd__decap_12
XFILLER_163_1402 VPWR VGND VPWR VGND sky130_ef_sc_hd__decap_12
XFILLER_203_811 VGND VGND VPWR VPWR sky130_fd_sc_hd__decap_6
XFILLER_215_682 VGND VGND VPWR VPWR sky130_fd_sc_hd__decap_6
XFILLER_163_1457 VGND VGND VPWR VPWR sky130_fd_sc_hd__decap_6
XFILLER_204_1410 VPWR VGND VPWR VGND sky130_ef_sc_hd__decap_12
X_326_ net595 dout0_q\[17\] net51 VGND VGND VPWR VPWR _115_ sky130_fd_sc_hd__a21oi_1
XFILLER_174_206 VPWR VGND VPWR VGND sky130_ef_sc_hd__decap_12
XPHY_EDGE_ROW_28_2_Left_530 VGND VGND VPWR VPWR sky130_fd_sc_hd__decap_3
XFILLER_204_1465 VPWR VGND VPWR VGND sky130_ef_sc_hd__decap_12
XFILLER_239_1506 VGND VGND VPWR VPWR sky130_fd_sc_hd__decap_8
XFILLER_122_1165 VPWR VGND VPWR VGND sky130_ef_sc_hd__decap_12
XFILLER_6_441 VGND VGND VPWR VPWR sky130_fd_sc_hd__fill_1
Xmax_cap617 net618 VGND VGND VPWR VPWR net617 sky130_fd_sc_hd__clkbuf_1
XFILLER_6_452 VGND VGND VPWR VPWR sky130_fd_sc_hd__fill_1
XFILLER_157_1206 VPWR VGND VPWR VGND sky130_ef_sc_hd__decap_12
XFILLER_182_261 VPWR VGND VPWR VGND sky130_ef_sc_hd__decap_12
XPHY_EDGE_ROW_120_2_Right_211 VGND VGND VPWR VPWR sky130_fd_sc_hd__decap_3
XFILLER_170_445 VGND VGND VPWR VPWR sky130_fd_sc_hd__decap_6
XFILLER_83_1414 VGND VGND VPWR VPWR sky130_fd_sc_hd__decap_6
XFILLER_237_1241 VGND VGND VPWR VPWR sky130_fd_sc_hd__decap_6
XFILLER_100_1485 VPWR VGND VPWR VGND sky130_ef_sc_hd__decap_12
XPHY_EDGE_ROW_58_1_Right_714 VGND VGND VPWR VPWR sky130_fd_sc_hd__decap_3
XFILLER_250_1441 VPWR VGND VPWR VGND sky130_ef_sc_hd__decap_12
XFILLER_29_3 VPWR VGND VPWR VGND sky130_ef_sc_hd__decap_12
XFILLER_133_1261 VPWR VGND VPWR VGND sky130_ef_sc_hd__decap_12
XFILLER_250_1496 VPWR VGND VPWR VGND sky130_ef_sc_hd__decap_12
XFILLER_237_240 VPWR VGND VPWR VGND sky130_ef_sc_hd__decap_12
XFILLER_226_925 VPWR VGND VPWR VGND sky130_ef_sc_hd__decap_12
XFILLER_238_796 VPWR VGND VPWR VGND sky130_ef_sc_hd__decap_12
XFILLER_168_1324 VPWR VGND VPWR VGND sky130_ef_sc_hd__decap_12
XTAP_TAPCELL_ROW_220_3440 VGND VPWR sky130_fd_sc_hd__tapvpwrvgnd_1
XFILLER_225_424 VGND VGND VPWR VPWR sky130_fd_sc_hd__decap_6
XFILLER_253_744 VPWR VGND VPWR VGND sky130_ef_sc_hd__decap_12
XFILLER_77_1218 VPWR VGND VPWR VGND sky130_ef_sc_hd__decap_12
XFILLER_237_295 VGND VGND VPWR VPWR sky130_fd_sc_hd__decap_6
XFILLER_20_1442 VPWR VGND VPWR VGND sky130_ef_sc_hd__decap_12
XTAP_TAPCELL_ROW_220_3451 VGND VPWR sky130_fd_sc_hd__tapvpwrvgnd_1
XTAP_TAPCELL_ROW_220_3462 VGND VPWR sky130_fd_sc_hd__tapvpwrvgnd_1
XFILLER_231_68 VPWR VGND VPWR VGND sky130_ef_sc_hd__decap_12
XTAP_TAPCELL_ROW_220_3473 VGND VPWR sky130_fd_sc_hd__tapvpwrvgnd_1
XFILLER_241_928 VPWR VGND VPWR VGND sky130_ef_sc_hd__decap_12
XFILLER_168_1379 VPWR VGND VPWR VGND sky130_ef_sc_hd__decap_12
XFILLER_206_660 VGND VGND VPWR VPWR sky130_fd_sc_hd__decap_6
XFILLER_253_799 VPWR VGND VPWR VGND sky130_ef_sc_hd__decap_12
XFILLER_234_980 VPWR VGND VPWR VGND sky130_ef_sc_hd__decap_12
XFILLER_20_1497 VPWR VGND VPWR VGND sky130_ef_sc_hd__decap_12
XFILLER_240_1109 VPWR VGND VPWR VGND sky130_ef_sc_hd__decap_12
XFILLER_205_1229 VPWR VGND VPWR VGND sky130_ef_sc_hd__decap_12
XFILLER_220_151 VPWR VGND VPWR VGND sky130_ef_sc_hd__decap_12
XTAP_TAPCELL_ROW_218_3380 VGND VPWR sky130_fd_sc_hd__tapvpwrvgnd_1
XTAP_TAPCELL_ROW_173_1801 VGND VPWR sky130_fd_sc_hd__tapvpwrvgnd_1
XTAP_TAPCELL_ROW_218_3391 VGND VPWR sky130_fd_sc_hd__tapvpwrvgnd_1
XFILLER_53_1273 VPWR VGND VPWR VGND sky130_ef_sc_hd__decap_12
XTAP_TAPCELL_ROW_173_1812 VGND VPWR sky130_fd_sc_hd__tapvpwrvgnd_1
XTAP_TAPCELL_ROW_214_3233 VGND VPWR sky130_fd_sc_hd__tapvpwrvgnd_1
XTAP_TAPCELL_ROW_173_1823 VGND VPWR sky130_fd_sc_hd__tapvpwrvgnd_1
XTAP_TAPCELL_ROW_214_3244 VGND VPWR sky130_fd_sc_hd__tapvpwrvgnd_1
XFILLER_179_1420 VPWR VGND VPWR VGND sky130_ef_sc_hd__decap_12
XTAP_TAPCELL_ROW_214_3255 VGND VPWR sky130_fd_sc_hd__tapvpwrvgnd_1
XFILLER_9_290 VGND VGND VPWR VPWR sky130_fd_sc_hd__fill_1
XFILLER_88_1325 VPWR VGND VPWR VGND sky130_ef_sc_hd__decap_12
XFILLER_109_15 VPWR VGND VPWR VGND sky130_ef_sc_hd__decap_12
XTAP_TAPCELL_ROW_210_3108 VGND VPWR sky130_fd_sc_hd__tapvpwrvgnd_1
XTAP_TAPCELL_ROW_210_3119 VGND VPWR sky130_fd_sc_hd__tapvpwrvgnd_1
XFILLER_101_1249 VPWR VGND VPWR VGND sky130_ef_sc_hd__decap_12
XFILLER_179_1475 VPWR VGND VPWR VGND sky130_ef_sc_hd__decap_12
XFILLER_173_283 VPWR VGND VPWR VGND sky130_ef_sc_hd__decap_12
XFILLER_251_1205 VPWR VGND VPWR VGND sky130_ef_sc_hd__decap_12
XFILLER_216_1336 VPWR VGND VPWR VGND sky130_ef_sc_hd__decap_12
XFILLER_62_1509 VGND VGND VPWR VPWR sky130_fd_sc_hd__decap_6
XTAP_TAPCELL_ROW_116_2_5588 VGND VPWR sky130_fd_sc_hd__tapvpwrvgnd_1
XTAP_TAPCELL_ROW_84_2_5333 VGND VPWR sky130_fd_sc_hd__tapvpwrvgnd_1
XTAP_TAPCELL_ROW_167_1605 VGND VPWR sky130_fd_sc_hd__tapvpwrvgnd_1
XTAP_TAPCELL_ROW_208_3026 VGND VPWR sky130_fd_sc_hd__tapvpwrvgnd_1
XTAP_TAPCELL_ROW_167_1616 VGND VPWR sky130_fd_sc_hd__tapvpwrvgnd_1
XTAP_TAPCELL_ROW_208_3037 VGND VPWR sky130_fd_sc_hd__tapvpwrvgnd_1
XTAP_TAPCELL_ROW_208_3048 VGND VPWR sky130_fd_sc_hd__tapvpwrvgnd_1
XFILLER_248_538 VPWR VGND VPWR VGND sky130_ef_sc_hd__decap_12
XFILLER_64_1380 VPWR VGND VPWR VGND sky130_ef_sc_hd__decap_12
XFILLER_21_1206 VPWR VGND VPWR VGND sky130_ef_sc_hd__decap_12
XFILLER_99_1421 VPWR VGND VPWR VGND sky130_ef_sc_hd__decap_12
XFILLER_205_80 VGND VGND VPWR VPWR sky130_fd_sc_hd__decap_6
XFILLER_18_34 VPWR VGND VPWR VGND sky130_ef_sc_hd__decap_12
XFILLER_216_402 VGND VGND VPWR VPWR sky130_fd_sc_hd__decap_6
XFILLER_249_1112 VGND VGND VPWR VPWR sky130_fd_sc_hd__decap_6
XPHY_EDGE_ROW_156_2_Left_658 VGND VGND VPWR VPWR sky130_fd_sc_hd__decap_3
XFILLER_244_722 VPWR VGND VPWR VGND sky130_ef_sc_hd__decap_12
XFILLER_112_1356 VPWR VGND VPWR VGND sky130_ef_sc_hd__decap_12
XFILLER_217_947 VPWR VGND VPWR VGND sky130_ef_sc_hd__decap_12
XFILLER_228_273 VGND VGND VPWR VPWR sky130_fd_sc_hd__decap_6
XFILLER_99_1476 VPWR VGND VPWR VGND sky130_ef_sc_hd__decap_12
XTAP_TAPCELL_ROW_148_1_1452 VGND VPWR sky130_fd_sc_hd__tapvpwrvgnd_1
XFILLER_232_906 VPWR VGND VPWR VGND sky130_ef_sc_hd__decap_12
XFILLER_141_68 VGND VGND VPWR VPWR sky130_fd_sc_hd__decap_3
XFILLER_244_777 VPWR VGND VPWR VGND sky130_ef_sc_hd__decap_12
XPHY_EDGE_ROW_26_1_Left_281 VGND VGND VPWR VPWR sky130_fd_sc_hd__decap_3
XPHY_EDGE_ROW_20_1_Right_676 VGND VGND VPWR VPWR sky130_fd_sc_hd__decap_3
XFILLER_34_22 VPWR VGND VPWR VGND sky130_ef_sc_hd__decap_12
XFILLER_227_1432 VPWR VGND VPWR VGND sky130_ef_sc_hd__decap_12
XFILLER_58_1184 VPWR VGND VPWR VGND sky130_ef_sc_hd__decap_12
XFILLER_240_961 VGND VGND VPWR VPWR sky130_fd_sc_hd__decap_6
XFILLER_180_1023 VPWR VGND VPWR VGND sky130_ef_sc_hd__decap_12
XFILLER_197_854 VGND VGND VPWR VPWR sky130_fd_sc_hd__decap_6
XFILLER_227_1487 VPWR VGND VPWR VGND sky130_ef_sc_hd__decap_12
XFILLER_145_1165 VPWR VGND VPWR VGND sky130_ef_sc_hd__decap_12
XFILLER_211_173 VPWR VGND VPWR VGND sky130_ef_sc_hd__decap_12
Xwire103 _209_ VGND VGND VPWR VPWR net103 sky130_fd_sc_hd__clkbuf_1
XFILLER_133_3 VPWR VGND VPWR VGND sky130_ef_sc_hd__decap_12
XFILLER_180_1078 VPWR VGND VPWR VGND sky130_ef_sc_hd__decap_12
XFILLER_32_1313 VPWR VGND VPWR VGND sky130_ef_sc_hd__decap_12
XTAP_TAPCELL_ROW_12_2_4758 VGND VPWR sky130_fd_sc_hd__tapvpwrvgnd_1
Xwire114 _205_ VGND VGND VPWR VPWR net114 sky130_fd_sc_hd__clkbuf_1
XFILLER_8_739 VPWR VGND VPWR VGND sky130_ef_sc_hd__decap_12
XFILLER_32_1368 VPWR VGND VPWR VGND sky130_ef_sc_hd__decap_12
XFILLER_50_65 VGND VGND VPWR VPWR sky130_fd_sc_hd__decap_6
XFILLER_171_209 VGND VGND VPWR VPWR sky130_fd_sc_hd__decap_6
XFILLER_180_710 VPWR VGND VPWR VGND sky130_ef_sc_hd__decap_12
XFILLER_192_581 VPWR VGND VPWR VGND sky130_ef_sc_hd__decap_12
XFILLER_166_65 VPWR VGND VPWR VGND sky130_ef_sc_hd__decap_12
XFILLER_180_765 VPWR VGND VPWR VGND sky130_ef_sc_hd__decap_12
XFILLER_117_1201 VGND VGND VPWR VPWR sky130_fd_sc_hd__decap_4
XFILLER_65_1177 VPWR VGND VPWR VGND sky130_ef_sc_hd__decap_12
XFILLER_156_1294 VPWR VGND VPWR VGND sky130_ef_sc_hd__decap_12
XFILLER_191_1174 VPWR VGND VPWR VGND sky130_ef_sc_hd__decap_12
XTAP_TAPCELL_ROW_183_2152 VGND VPWR sky130_fd_sc_hd__tapvpwrvgnd_1
XTAP_TAPCELL_ROW_183_2163 VGND VPWR sky130_fd_sc_hd__tapvpwrvgnd_1
XFILLER_43_1464 VPWR VGND VPWR VGND sky130_ef_sc_hd__decap_12
XTAP_TAPCELL_ROW_183_2174 VGND VPWR sky130_fd_sc_hd__tapvpwrvgnd_1
XFILLER_219_240 VPWR VGND VPWR VGND sky130_ef_sc_hd__decap_12
XFILLER_254_519 VPWR VGND VPWR VGND sky130_ef_sc_hd__decap_12
XFILLER_130_1423 VPWR VGND VPWR VGND sky130_ef_sc_hd__decap_12
XFILLER_247_560 VPWR VGND VPWR VGND sky130_ef_sc_hd__decap_12
XTAP_TAPCELL_ROW_24_1_1265 VGND VPWR sky130_fd_sc_hd__tapvpwrvgnd_1
XFILLER_208_925 VPWR VGND VPWR VGND sky130_ef_sc_hd__decap_12
XFILLER_207_424 VGND VGND VPWR VPWR sky130_fd_sc_hd__decap_6
XFILLER_235_744 VPWR VGND VPWR VGND sky130_ef_sc_hd__decap_12
XFILLER_130_1478 VGND VGND VPWR VPWR sky130_fd_sc_hd__decap_6
XFILLER_219_295 VGND VGND VPWR VPWR sky130_fd_sc_hd__decap_6
XFILLER_228_1207 VPWR VGND VPWR VGND sky130_ef_sc_hd__decap_12
XFILLER_250_703 VGND VGND VPWR VPWR sky130_fd_sc_hd__decap_6
XFILLER_223_928 VPWR VGND VPWR VGND sky130_ef_sc_hd__decap_12
XFILLER_235_799 VPWR VGND VPWR VGND sky130_ef_sc_hd__decap_12
XTAP_TAPCELL_ROW_100_1_1380 VGND VPWR sky130_fd_sc_hd__tapvpwrvgnd_1
XFILLER_201_27 VPWR VGND VPWR VGND sky130_ef_sc_hd__decap_12
XFILLER_216_980 VPWR VGND VPWR VGND sky130_ef_sc_hd__decap_12
XFILLER_76_1251 VPWR VGND VPWR VGND sky130_ef_sc_hd__decap_12
XFILLER_188_832 VGND VGND VPWR VPWR sky130_fd_sc_hd__decap_6
XTAP_TAPCELL_ROW_141_2_5790 VGND VPWR sky130_fd_sc_hd__tapvpwrvgnd_1
XFILLER_202_151 VPWR VGND VPWR VGND sky130_ef_sc_hd__decap_12
XFILLER_231_983 VGND VGND VPWR VPWR sky130_fd_sc_hd__decap_6
XFILLER_15_1500 VGND VGND VPWR VPWR sky130_fd_sc_hd__decap_6
XFILLER_124_1227 VPWR VGND VPWR VGND sky130_ef_sc_hd__decap_12
X_309_ net596 dout0_q\[25\] net531 VGND VGND VPWR VPWR _098_ sky130_fd_sc_hd__a21oi_1
XFILLER_50_1435 VGND VGND VPWR VPWR sky130_fd_sc_hd__decap_6
XFILLER_204_1262 VGND VGND VPWR VPWR sky130_fd_sc_hd__decap_6
XFILLER_190_507 VPWR VGND VPWR VGND sky130_ef_sc_hd__decap_12
XFILLER_239_1303 VPWR VGND VPWR VGND sky130_ef_sc_hd__decap_12
XFILLER_7_750 VGND VGND VPWR VPWR sky130_fd_sc_hd__fill_1
XTAP_TAPCELL_ROW_78_1_1347 VGND VPWR sky130_fd_sc_hd__tapvpwrvgnd_1
XTAP_TAPCELL_ROW_133_2_5727 VGND VPWR sky130_fd_sc_hd__tapvpwrvgnd_1
XFILLER_171_732 VPWR VGND VPWR VGND sky130_ef_sc_hd__decap_12
XFILLER_239_1358 VPWR VGND VPWR VGND sky130_ef_sc_hd__decap_12
XTAP_TAPCELL_ROW_102_2_5474 VGND VPWR sky130_fd_sc_hd__tapvpwrvgnd_1
XPHY_EDGE_ROW_121_2_Right_212 VGND VGND VPWR VPWR sky130_fd_sc_hd__decap_3
XTAP_TAPCELL_ROW_69_2_5213 VGND VPWR sky130_fd_sc_hd__tapvpwrvgnd_1
XFILLER_226_46 VPWR VGND VPWR VGND sky130_ef_sc_hd__decap_12
XFILLER_100_1282 VPWR VGND VPWR VGND sky130_ef_sc_hd__decap_12
XFILLER_171_787 VPWR VGND VPWR VGND sky130_ef_sc_hd__decap_12
XFILLER_252_1514 VGND VGND VPWR VPWR sky130_fd_sc_hd__fill_1
XPHY_EDGE_ROW_59_1_Right_715 VGND VGND VPWR VPWR sky130_fd_sc_hd__decap_3
XFILLER_44_1239 VPWR VGND VPWR VGND sky130_ef_sc_hd__decap_12
XFILLER_135_1378 VPWR VGND VPWR VGND sky130_ef_sc_hd__decap_12
XTAP_TAPCELL_ROW_226_3660 VGND VPWR sky130_fd_sc_hd__tapvpwrvgnd_1
XFILLER_170_1269 VPWR VGND VPWR VGND sky130_ef_sc_hd__decap_12
XTAP_TAPCELL_ROW_226_3671 VGND VPWR sky130_fd_sc_hd__tapvpwrvgnd_1
XFILLER_242_34 VPWR VGND VPWR VGND sky130_ef_sc_hd__decap_12
XPHY_EDGE_ROW_91_1_Left_346 VGND VGND VPWR VPWR sky130_fd_sc_hd__decap_3
XTAP_TAPCELL_ROW_222_3513 VGND VPWR sky130_fd_sc_hd__tapvpwrvgnd_1
XTAP_TAPCELL_ROW_226_3682 VGND VPWR sky130_fd_sc_hd__tapvpwrvgnd_1
XTAP_TAPCELL_ROW_222_3524 VGND VPWR sky130_fd_sc_hd__tapvpwrvgnd_1
XTAP_TAPCELL_ROW_222_3535 VGND VPWR sky130_fd_sc_hd__tapvpwrvgnd_1
XFILLER_250_1293 VPWR VGND VPWR VGND sky130_ef_sc_hd__decap_12
XTAP_TAPCELL_ROW_1_904 VGND VPWR sky130_fd_sc_hd__tapvpwrvgnd_1
XTAP_TAPCELL_ROW_1_915 VGND VPWR sky130_fd_sc_hd__tapvpwrvgnd_1
XFILLER_226_722 VPWR VGND VPWR VGND sky130_ef_sc_hd__decap_12
XFILLER_242_89 VPWR VGND VPWR VGND sky130_ef_sc_hd__decap_12
XTAP_TAPCELL_ROW_1_926 VGND VPWR sky130_fd_sc_hd__tapvpwrvgnd_1
XFILLER_238_593 VPWR VGND VPWR VGND sky130_ef_sc_hd__decap_12
XFILLER_168_1121 VPWR VGND VPWR VGND sky130_ef_sc_hd__decap_12
XFILLER_253_541 VPWR VGND VPWR VGND sky130_ef_sc_hd__decap_12
XFILLER_214_906 VPWR VGND VPWR VGND sky130_ef_sc_hd__decap_12
XFILLER_226_777 VPWR VGND VPWR VGND sky130_ef_sc_hd__decap_12
XFILLER_241_725 VGND VGND VPWR VPWR sky130_fd_sc_hd__decap_6
XFILLER_111_27 VPWR VGND VPWR VGND sky130_ef_sc_hd__decap_12
XFILLER_168_1176 VGND VGND VPWR VPWR sky130_fd_sc_hd__decap_6
XFILLER_253_596 VGND VGND VPWR VPWR sky130_fd_sc_hd__decap_6
XFILLER_20_1294 VPWR VGND VPWR VGND sky130_ef_sc_hd__decap_12
XFILLER_0_1366 VPWR VGND VPWR VGND sky130_ef_sc_hd__decap_12
XFILLER_55_1335 VPWR VGND VPWR VGND sky130_ef_sc_hd__decap_12
XFILLER_0_1399 VGND VGND VPWR VPWR sky130_fd_sc_hd__decap_8
XFILLER_209_1162 VPWR VGND VPWR VGND sky130_ef_sc_hd__decap_12
XFILLER_179_854 VGND VGND VPWR VPWR sky130_fd_sc_hd__decap_6
XTAP_TAPCELL_ROW_216_3306 VGND VPWR sky130_fd_sc_hd__tapvpwrvgnd_1
XFILLER_222_961 VGND VGND VPWR VPWR sky130_fd_sc_hd__decap_6
XFILLER_107_1414 VGND VGND VPWR VPWR sky130_fd_sc_hd__decap_6
XFILLER_205_1026 VGND VGND VPWR VPWR sky130_fd_sc_hd__decap_6
XTAP_TAPCELL_ROW_216_3317 VGND VPWR sky130_fd_sc_hd__tapvpwrvgnd_1
XFILLER_146_1485 VPWR VGND VPWR VGND sky130_ef_sc_hd__decap_12
XTAP_TAPCELL_ROW_216_3328 VGND VPWR sky130_fd_sc_hd__tapvpwrvgnd_1
XFILLER_244_1097 VPWR VGND VPWR VGND sky130_ef_sc_hd__decap_12
XFILLER_142_1349 VGND VGND VPWR VPWR sky130_fd_sc_hd__decap_6
XFILLER_193_345 VPWR VGND VPWR VGND sky130_ef_sc_hd__decap_12
XFILLER_181_529 VPWR VGND VPWR VGND sky130_ef_sc_hd__decap_12
XFILLER_4_219 VGND VGND VPWR VPWR sky130_fd_sc_hd__fill_1
XFILLER_174_581 VPWR VGND VPWR VGND sky130_ef_sc_hd__decap_12
XFILLER_179_1272 VPWR VGND VPWR VGND sky130_ef_sc_hd__decap_12
XFILLER_31_1390 VPWR VGND VPWR VGND sky130_ef_sc_hd__decap_12
XTAP_TAPCELL_ROW_30_1_1275 VGND VPWR sky130_fd_sc_hd__tapvpwrvgnd_1
XFILLER_20_46 VPWR VGND VPWR VGND sky130_ef_sc_hd__decap_12
XFILLER_88_1177 VGND VGND VPWR VPWR sky130_fd_sc_hd__decap_6
XPHY_EDGE_ROW_199_Right_44 VGND VGND VPWR VPWR sky130_fd_sc_hd__decap_3
XFILLER_1_904 VPWR VGND VPWR VGND sky130_ef_sc_hd__decap_12
XFILLER_136_46 VPWR VGND VPWR VGND sky130_ef_sc_hd__decap_12
XFILLER_66_1442 VPWR VGND VPWR VGND sky130_ef_sc_hd__decap_12
XFILLER_251_1002 VPWR VGND VPWR VGND sky130_ef_sc_hd__decap_12
XFILLER_62_1306 VGND VGND VPWR VPWR sky130_fd_sc_hd__decap_6
XFILLER_216_1133 VGND VGND VPWR VPWR sky130_fd_sc_hd__decap_6
XFILLER_1_959 VPWR VGND VPWR VGND sky130_ef_sc_hd__decap_12
XFILLER_66_1497 VPWR VGND VPWR VGND sky130_ef_sc_hd__decap_12
XFILLER_153_1445 VPWR VGND VPWR VGND sky130_ef_sc_hd__decap_12
XFILLER_251_1057 VPWR VGND VPWR VGND sky130_ef_sc_hd__decap_12
XFILLER_248_335 VPWR VGND VPWR VGND sky130_ef_sc_hd__decap_12
XFILLER_0_469 VGND VGND VPWR VPWR sky130_fd_sc_hd__fill_1
XFILLER_29_44 VPWR VGND VPWR VGND sky130_ef_sc_hd__decap_12
XFILLER_152_34 VPWR VGND VPWR VGND sky130_ef_sc_hd__decap_12
XFILLER_188_1508 VGND VGND VPWR VPWR sky130_fd_sc_hd__decap_6
XFILLER_229_560 VPWR VGND VPWR VGND sky130_ef_sc_hd__decap_12
XFILLER_236_519 VPWR VGND VPWR VGND sky130_ef_sc_hd__decap_12
X_660_ clknet_3_5__leaf_clk acc_core.adder.cla_blocks\[6\].block.sum\[2\] _068_ VGND
+ VGND VPWR VPWR net61 sky130_fd_sc_hd__dfrtp_1
XFILLER_217_744 VPWR VGND VPWR VGND sky130_ef_sc_hd__decap_12
XFILLER_1_1119 VPWR VGND VPWR VGND sky130_ef_sc_hd__decap_12
XFILLER_99_1273 VPWR VGND VPWR VGND sky130_ef_sc_hd__decap_12
X_591_ net671 VGND VGND VPWR VPWR _073_ sky130_fd_sc_hd__inv_2
XFILLER_232_703 VGND VGND VPWR VPWR sky130_fd_sc_hd__decap_6
XFILLER_244_574 VGND VGND VPWR VPWR sky130_fd_sc_hd__decap_6
XFILLER_205_928 VPWR VGND VPWR VGND sky130_ef_sc_hd__decap_12
XTAP_TAPCELL_ROW_126_2_5670 VGND VPWR sky130_fd_sc_hd__tapvpwrvgnd_1
XFILLER_217_799 VPWR VGND VPWR VGND sky130_ef_sc_hd__decap_12
XFILLER_250_3 VPWR VGND VPWR VGND sky130_ef_sc_hd__decap_12
XFILLER_73_1402 VPWR VGND VPWR VGND sky130_ef_sc_hd__decap_12
XPHY_EDGE_ROW_21_1_Right_677 VGND VGND VPWR VPWR sky130_fd_sc_hd__decap_3
XFILLER_147_1249 VPWR VGND VPWR VGND sky130_ef_sc_hd__decap_12
XFILLER_73_1457 VGND VGND VPWR VPWR sky130_fd_sc_hd__decap_6
XFILLER_213_983 VGND VGND VPWR VPWR sky130_fd_sc_hd__decap_6
XFILLER_227_1284 VGND VGND VPWR VPWR sky130_fd_sc_hd__decap_6
XTAP_TAPCELL_ROW_195_2590 VGND VPWR sky130_fd_sc_hd__tapvpwrvgnd_1
XTAP_TAPCELL_ROW_191_2432 VGND VPWR sky130_fd_sc_hd__tapvpwrvgnd_1
XFILLER_184_323 VPWR VGND VPWR VGND sky130_ef_sc_hd__decap_12
XTAP_TAPCELL_ROW_191_2443 VGND VPWR sky130_fd_sc_hd__tapvpwrvgnd_1
XFILLER_196_194 VPWR VGND VPWR VGND sky130_ef_sc_hd__decap_12
XTAP_TAPCELL_ROW_191_2454 VGND VPWR sky130_fd_sc_hd__tapvpwrvgnd_1
XFILLER_201_1413 VGND VGND VPWR VPWR sky130_fd_sc_hd__decap_6
XTAP_TAPCELL_ROW_118_2_5607 VGND VPWR sky130_fd_sc_hd__tapvpwrvgnd_1
XFILLER_240_1484 VPWR VGND VPWR VGND sky130_ef_sc_hd__decap_12
XFILLER_172_507 VPWR VGND VPWR VGND sky130_ef_sc_hd__decap_12
XFILLER_32_1165 VPWR VGND VPWR VGND sky130_ef_sc_hd__decap_12
XFILLER_184_378 VPWR VGND VPWR VGND sky130_ef_sc_hd__decap_12
XFILLER_67_1206 VPWR VGND VPWR VGND sky130_ef_sc_hd__decap_12
XTAP_TAPCELL_ROW_42_2_4997 VGND VPWR sky130_fd_sc_hd__tapvpwrvgnd_1
XFILLER_4_753 VGND VGND VPWR VPWR sky130_fd_sc_hd__fill_2
XFILLER_158_1356 VPWR VGND VPWR VGND sky130_ef_sc_hd__decap_12
XFILLER_180_562 VPWR VGND VPWR VGND sky130_ef_sc_hd__decap_12
XFILLER_10_1485 VPWR VGND VPWR VGND sky130_ef_sc_hd__decap_12
XTAP_TAPCELL_ROW_189_2361 VGND VPWR sky130_fd_sc_hd__tapvpwrvgnd_1
XFILLER_4_786 VGND VGND VPWR VPWR sky130_fd_sc_hd__decap_6
XTAP_TAPCELL_ROW_189_2372 VGND VPWR sky130_fd_sc_hd__tapvpwrvgnd_1
XTAP_TAPCELL_ROW_185_2214 VGND VPWR sky130_fd_sc_hd__tapvpwrvgnd_1
XTAP_TAPCELL_ROW_189_2383 VGND VPWR sky130_fd_sc_hd__tapvpwrvgnd_1
XTAP_TAPCELL_ROW_185_2225 VGND VPWR sky130_fd_sc_hd__tapvpwrvgnd_1
XFILLER_238_1391 VGND VGND VPWR VPWR sky130_fd_sc_hd__decap_6
XTAP_TAPCELL_ROW_22_2_4840 VGND VPWR sky130_fd_sc_hd__tapvpwrvgnd_1
XTAP_TAPCELL_ROW_185_2236 VGND VPWR sky130_fd_sc_hd__tapvpwrvgnd_1
XFILLER_239_302 VPWR VGND VPWR VGND sky130_ef_sc_hd__decap_12
XTAP_TAPCELL_ROW_185_2247 VGND VPWR sky130_fd_sc_hd__tapvpwrvgnd_1
XPHY_EDGE_ROW_203_Right_48 VGND VGND VPWR VPWR sky130_fd_sc_hd__decap_3
XFILLER_239_357 VPWR VGND VPWR VGND sky130_ef_sc_hd__decap_12
XFILLER_254_316 VGND VGND VPWR VPWR sky130_fd_sc_hd__decap_6
XFILLER_43_1261 VPWR VGND VPWR VGND sky130_ef_sc_hd__decap_12
XFILLER_130_1220 VGND VGND VPWR VPWR sky130_fd_sc_hd__decap_6
XFILLER_208_722 VPWR VGND VPWR VGND sky130_ef_sc_hd__decap_12
XFILLER_212_15 VGND VGND VPWR VPWR sky130_fd_sc_hd__decap_6
XFILLER_78_1313 VPWR VGND VPWR VGND sky130_ef_sc_hd__decap_12
XFILLER_235_541 VPWR VGND VPWR VGND sky130_ef_sc_hd__decap_12
XFILLER_208_777 VPWR VGND VPWR VGND sky130_ef_sc_hd__decap_12
XFILLER_228_1004 VGND VGND VPWR VPWR sky130_fd_sc_hd__decap_6
XFILLER_169_1463 VPWR VGND VPWR VGND sky130_ef_sc_hd__decap_12
XTAP_TAPCELL_ROW_179_2007 VGND VPWR sky130_fd_sc_hd__tapvpwrvgnd_1
XTAP_TAPCELL_ROW_179_2018 VGND VPWR sky130_fd_sc_hd__tapvpwrvgnd_1
XFILLER_78_1368 VPWR VGND VPWR VGND sky130_ef_sc_hd__decap_12
XTAP_TAPCELL_ROW_179_2029 VGND VPWR sky130_fd_sc_hd__tapvpwrvgnd_1
XFILLER_223_725 VGND VGND VPWR VPWR sky130_fd_sc_hd__decap_6
XFILLER_235_596 VGND VGND VPWR VPWR sky130_fd_sc_hd__decap_6
XFILLER_204_961 VGND VGND VPWR VPWR sky130_fd_sc_hd__decap_6
XFILLER_96_3 VPWR VGND VPWR VGND sky130_ef_sc_hd__decap_12
XFILLER_206_1324 VPWR VGND VPWR VGND sky130_ef_sc_hd__decap_12
XPHY_EDGE_ROW_212_Right_57 VGND VGND VPWR VPWR sky130_fd_sc_hd__decap_3
XFILLER_241_1248 VPWR VGND VPWR VGND sky130_ef_sc_hd__decap_12
XTAP_TAPCELL_ROW_234_3940 VGND VPWR sky130_fd_sc_hd__tapvpwrvgnd_1
XFILLER_206_1379 VPWR VGND VPWR VGND sky130_ef_sc_hd__decap_12
XTAP_TAPCELL_ROW_234_3951 VGND VPWR sky130_fd_sc_hd__tapvpwrvgnd_1
XTAP_TAPCELL_ROW_234_3962 VGND VPWR sky130_fd_sc_hd__tapvpwrvgnd_1
XTAP_TAPCELL_ROW_230_3804 VGND VPWR sky130_fd_sc_hd__tapvpwrvgnd_1
XFILLER_175_345 VPWR VGND VPWR VGND sky130_ef_sc_hd__decap_12
XTAP_TAPCELL_ROW_230_3815 VGND VPWR sky130_fd_sc_hd__tapvpwrvgnd_1
XFILLER_141_1371 VGND VGND VPWR VPWR sky130_fd_sc_hd__decap_6
XFILLER_239_1100 VPWR VGND VPWR VGND sky130_ef_sc_hd__decap_12
XFILLER_190_304 VPWR VGND VPWR VGND sky130_ef_sc_hd__decap_12
Xmax_cap200 _192_ VGND VGND VPWR VPWR net200 sky130_fd_sc_hd__clkbuf_1
Xmax_cap211 net212 VGND VGND VPWR VPWR net211 sky130_fd_sc_hd__clkbuf_1
XFILLER_89_1464 VPWR VGND VPWR VGND sky130_ef_sc_hd__decap_12
XFILLER_11_1249 VPWR VGND VPWR VGND sky130_ef_sc_hd__decap_12
XFILLER_237_56 VPWR VGND VPWR VGND sky130_ef_sc_hd__decap_12
XFILLER_239_1155 VGND VGND VPWR VPWR sky130_fd_sc_hd__decap_6
XFILLER_176_1434 VGND VGND VPWR VPWR sky130_fd_sc_hd__decap_6
XFILLER_190_359 VGND VGND VPWR VPWR sky130_fd_sc_hd__decap_6
XFILLER_85_1328 VGND VGND VPWR VPWR sky130_fd_sc_hd__decap_6
XFILLER_102_1399 VPWR VGND VPWR VGND sky130_ef_sc_hd__decap_12
XFILLER_171_584 VPWR VGND VPWR VGND sky130_ef_sc_hd__decap_12
XFILLER_217_1420 VPWR VGND VPWR VGND sky130_ef_sc_hd__decap_12
XPHY_EDGE_ROW_122_2_Right_213 VGND VGND VPWR VPWR sky130_fd_sc_hd__decap_3
XTAP_TAPCELL_ROW_228_3722 VGND VPWR sky130_fd_sc_hd__tapvpwrvgnd_1
XTAP_TAPCELL_ROW_228_3733 VGND VPWR sky130_fd_sc_hd__tapvpwrvgnd_1
XTAP_TAPCELL_ROW_228_3744 VGND VPWR sky130_fd_sc_hd__tapvpwrvgnd_1
XPHY_EDGE_ROW_221_Right_66 VGND VGND VPWR VPWR sky130_fd_sc_hd__decap_3
XFILLER_170_1011 VPWR VGND VPWR VGND sky130_ef_sc_hd__decap_12
XFILLER_253_44 VPWR VGND VPWR VGND sky130_ef_sc_hd__decap_12
XFILLER_252_1355 VPWR VGND VPWR VGND sky130_ef_sc_hd__decap_12
XTAP_TAPCELL_ROW_163_2_5966 VGND VPWR sky130_fd_sc_hd__tapvpwrvgnd_1
XFILLER_217_1475 VPWR VGND VPWR VGND sky130_ef_sc_hd__decap_12
XTAP_TAPCELL_ROW_224_3608 VGND VPWR sky130_fd_sc_hd__tapvpwrvgnd_1
XTAP_TAPCELL_ROW_99_2_5452 VGND VPWR sky130_fd_sc_hd__tapvpwrvgnd_1
XFILLER_170_1066 VPWR VGND VPWR VGND sky130_ef_sc_hd__decap_12
XFILLER_253_99 VPWR VGND VPWR VGND sky130_ef_sc_hd__decap_12
XFILLER_218_519 VPWR VGND VPWR VGND sky130_ef_sc_hd__decap_12
XFILLER_246_839 VPWR VGND VPWR VGND sky130_ef_sc_hd__decap_12
XFILLER_250_1090 VGND VGND VPWR VPWR sky130_fd_sc_hd__decap_6
XFILLER_245_338 VGND VGND VPWR VPWR sky130_fd_sc_hd__decap_6
XFILLER_122_15 VGND VGND VPWR VPWR sky130_fd_sc_hd__decap_6
XFILLER_22_1356 VPWR VGND VPWR VGND sky130_ef_sc_hd__decap_12
XFILLER_238_390 VPWR VGND VPWR VGND sky130_ef_sc_hd__decap_12
XFILLER_96_1435 VGND VGND VPWR VPWR sky130_fd_sc_hd__decap_6
XFILLER_214_703 VGND VGND VPWR VPWR sky130_fd_sc_hd__decap_6
XFILLER_199_916 VPWR VGND VPWR VGND sky130_ef_sc_hd__decap_12
XFILLER_226_574 VGND VGND VPWR VPWR sky130_fd_sc_hd__decap_6
XFILLER_254_894 VPWR VGND VPWR VGND sky130_ef_sc_hd__decap_12
XPHY_EDGE_ROW_230_Right_75 VGND VGND VPWR VPWR sky130_fd_sc_hd__decap_3
XTAP_TAPCELL_ROW_61_2_5153 VGND VPWR sky130_fd_sc_hd__tapvpwrvgnd_1
XFILLER_15_68 VGND VGND VPWR VPWR sky130_fd_sc_hd__decap_3
XFILLER_55_1165 VPWR VGND VPWR VGND sky130_ef_sc_hd__decap_12
XFILLER_181_1162 VPWR VGND VPWR VGND sky130_ef_sc_hd__decap_12
XFILLER_146_1282 VPWR VGND VPWR VGND sky130_ef_sc_hd__decap_12
XFILLER_166_323 VPWR VGND VPWR VGND sky130_ef_sc_hd__decap_12
XFILLER_178_194 VPWR VGND VPWR VGND sky130_ef_sc_hd__decap_12
XFILLER_193_142 VPWR VGND VPWR VGND sky130_ef_sc_hd__decap_12
XFILLER_120_1411 VPWR VGND VPWR VGND sky130_ef_sc_hd__decap_12
XFILLER_166_378 VPWR VGND VPWR VGND sky130_ef_sc_hd__decap_12
XTAP_TAPCELL_ROW_27_2_4877 VGND VPWR sky130_fd_sc_hd__tapvpwrvgnd_1
XFILLER_181_326 VPWR VGND VPWR VGND sky130_ef_sc_hd__decap_12
XFILLER_193_197 VPWR VGND VPWR VGND sky130_ef_sc_hd__decap_12
XFILLER_120_1466 VPWR VGND VPWR VGND sky130_ef_sc_hd__decap_12
XFILLER_147_56 VPWR VGND VPWR VGND sky130_ef_sc_hd__decap_12
XFILLER_155_1507 VGND VGND VPWR VPWR sky130_fd_sc_hd__decap_8
XFILLER_190_882 VPWR VGND VPWR VGND sky130_ef_sc_hd__decap_12
XFILLER_253_1119 VPWR VGND VPWR VGND sky130_ef_sc_hd__decap_12
XFILLER_27_1201 VGND VGND VPWR VPWR sky130_fd_sc_hd__decap_4
Xoutput45 net45 VGND VGND VPWR VPWR acc_out[11] sky130_fd_sc_hd__buf_2
Xoutput56 net56 VGND VGND VPWR VPWR acc_out[21] sky130_fd_sc_hd__buf_2
XFILLER_0_211 VPWR VGND VPWR VGND sky130_ef_sc_hd__decap_12
Xoutput67 net67 VGND VGND VPWR VPWR acc_out[31] sky130_fd_sc_hd__buf_2
XTAP_TAPCELL_ROW_136_1_1434 VGND VPWR sky130_fd_sc_hd__tapvpwrvgnd_1
XFILLER_163_44 VPWR VGND VPWR VGND sky130_ef_sc_hd__decap_12
XFILLER_66_1294 VPWR VGND VPWR VGND sky130_ef_sc_hd__decap_12
XFILLER_0_244 VGND VGND VPWR VPWR sky130_fd_sc_hd__decap_8
XFILLER_153_1242 VGND VGND VPWR VPWR sky130_fd_sc_hd__decap_6
XFILLER_248_132 VPWR VGND VPWR VGND sky130_ef_sc_hd__decap_12
XTAP_TAPCELL_ROW_244_4280 VGND VPWR sky130_fd_sc_hd__tapvpwrvgnd_1
XTAP_TAPCELL_ROW_244_4291 VGND VPWR sky130_fd_sc_hd__tapvpwrvgnd_1
XTAP_TAPCELL_ROW_240_4144 VGND VPWR sky130_fd_sc_hd__tapvpwrvgnd_1
XTAP_TAPCELL_ROW_240_4155 VGND VPWR sky130_fd_sc_hd__tapvpwrvgnd_1
XTAP_TAPCELL_ROW_240_4166 VGND VPWR sky130_fd_sc_hd__tapvpwrvgnd_1
XFILLER_188_1305 VGND VGND VPWR VPWR sky130_fd_sc_hd__decap_6
XFILLER_236_316 VGND VGND VPWR VPWR sky130_fd_sc_hd__decap_6
XFILLER_248_187 VGND VGND VPWR VPWR sky130_fd_sc_hd__decap_6
XFILLER_40_1423 VPWR VGND VPWR VGND sky130_ef_sc_hd__decap_12
X_643_ clknet_3_0__leaf_clk acc_core.adder.cla_blocks\[2\].block.sum\[1\] _051_ VGND
+ VGND VPWR VPWR net74 sky130_fd_sc_hd__dfrtp_1
XFILLER_217_541 VPWR VGND VPWR VGND sky130_ef_sc_hd__decap_12
XFILLER_245_861 VPWR VGND VPWR VGND sky130_ef_sc_hd__decap_12
XFILLER_40_1478 VGND VGND VPWR VPWR sky130_fd_sc_hd__decap_6
XTAP_TAPCELL_ROW_6_1080 VGND VPWR sky130_fd_sc_hd__tapvpwrvgnd_1
XFILLER_205_725 VGND VGND VPWR VPWR sky130_fd_sc_hd__decap_6
XTAP_TAPCELL_ROW_6_1091 VGND VPWR sky130_fd_sc_hd__tapvpwrvgnd_1
XFILLER_229_1346 VPWR VGND VPWR VGND sky130_ef_sc_hd__decap_12
X_574_ net667 VGND VGND VPWR VPWR _056_ sky130_fd_sc_hd__inv_2
XFILLER_217_596 VGND VGND VPWR VPWR sky130_fd_sc_hd__decap_6
XTAP_TAPCELL_ROW_197_2641 VGND VPWR sky130_fd_sc_hd__tapvpwrvgnd_1
XTAP_TAPCELL_ROW_197_2652 VGND VPWR sky130_fd_sc_hd__tapvpwrvgnd_1
XTAP_TAPCELL_ROW_238_4073 VGND VPWR sky130_fd_sc_hd__tapvpwrvgnd_1
XTAP_TAPCELL_ROW_197_2663 VGND VPWR sky130_fd_sc_hd__tapvpwrvgnd_1
XTAP_TAPCELL_ROW_238_4084 VGND VPWR sky130_fd_sc_hd__tapvpwrvgnd_1
XPHY_EDGE_ROW_22_1_Right_678 VGND VGND VPWR VPWR sky130_fd_sc_hd__decap_3
XFILLER_77_1390 VPWR VGND VPWR VGND sky130_ef_sc_hd__decap_12
XTAP_TAPCELL_ROW_193_2505 VGND VPWR sky130_fd_sc_hd__tapvpwrvgnd_1
XTAP_TAPCELL_ROW_238_4095 VGND VPWR sky130_fd_sc_hd__tapvpwrvgnd_1
XTAP_TAPCELL_ROW_193_2516 VGND VPWR sky130_fd_sc_hd__tapvpwrvgnd_1
XTAP_TAPCELL_ROW_193_2527 VGND VPWR sky130_fd_sc_hd__tapvpwrvgnd_1
XFILLER_34_1227 VPWR VGND VPWR VGND sky130_ef_sc_hd__decap_12
XFILLER_199_1401 VPWR VGND VPWR VGND sky130_ef_sc_hd__decap_12
XFILLER_8_311 VGND VGND VPWR VPWR sky130_fd_sc_hd__decap_8
XFILLER_184_120 VPWR VGND VPWR VGND sky130_ef_sc_hd__decap_12
XFILLER_200_452 VPWR VGND VPWR VGND sky130_ef_sc_hd__decap_12
XFILLER_199_1456 VGND VGND VPWR VPWR sky130_fd_sc_hd__decap_6
XFILLER_240_1281 VPWR VGND VPWR VGND sky130_ef_sc_hd__decap_12
XFILLER_8_366 VGND VGND VPWR VPWR sky130_fd_sc_hd__fill_1
XFILLER_172_304 VPWR VGND VPWR VGND sky130_ef_sc_hd__decap_12
XFILLER_184_175 VPWR VGND VPWR VGND sky130_ef_sc_hd__decap_12
XFILLER_172_359 VGND VGND VPWR VPWR sky130_fd_sc_hd__decap_6
XTAP_TAPCELL_ROW_187_2309 VGND VPWR sky130_fd_sc_hd__tapvpwrvgnd_1
XFILLER_193_1033 VPWR VGND VPWR VGND sky130_ef_sc_hd__decap_12
XFILLER_207_15 VPWR VGND VPWR VGND sky130_ef_sc_hd__decap_12
XTAP_TAPCELL_ROW_12_1_1247 VGND VPWR sky130_fd_sc_hd__tapvpwrvgnd_1
XTAP_TAPCELL_ROW_148_2_5846 VGND VPWR sky130_fd_sc_hd__tapvpwrvgnd_1
XFILLER_10_1282 VPWR VGND VPWR VGND sky130_ef_sc_hd__decap_12
XFILLER_193_1088 VPWR VGND VPWR VGND sky130_ef_sc_hd__decap_12
XFILLER_45_1378 VPWR VGND VPWR VGND sky130_ef_sc_hd__decap_12
XFILLER_239_154 VPWR VGND VPWR VGND sky130_ef_sc_hd__decap_12
XFILLER_132_1337 VPWR VGND VPWR VGND sky130_ef_sc_hd__decap_12
XFILLER_228_839 VPWR VGND VPWR VGND sky130_ef_sc_hd__decap_12
XFILLER_11_3 VPWR VGND VPWR VGND sky130_ef_sc_hd__decap_12
XFILLER_227_338 VGND VGND VPWR VPWR sky130_fd_sc_hd__decap_6
XFILLER_247_1413 VGND VGND VPWR VPWR sky130_fd_sc_hd__decap_6
XFILLER_208_574 VGND VGND VPWR VPWR sky130_fd_sc_hd__decap_6
XFILLER_169_1260 VPWR VGND VPWR VGND sky130_ef_sc_hd__decap_12
XFILLER_236_894 VPWR VGND VPWR VGND sky130_ef_sc_hd__decap_12
XFILLER_78_1165 VPWR VGND VPWR VGND sky130_ef_sc_hd__decap_12
XFILLER_251_842 VPWR VGND VPWR VGND sky130_ef_sc_hd__decap_12
XTAP_TAPCELL_ROW_46_2_5033 VGND VPWR sky130_fd_sc_hd__tapvpwrvgnd_1
XFILLER_165_1135 VPWR VGND VPWR VGND sky130_ef_sc_hd__decap_12
XFILLER_165_1168 VGND VGND VPWR VPWR sky130_fd_sc_hd__decap_8
XFILLER_251_897 VGND VGND VPWR VPWR sky130_fd_sc_hd__decap_6
XTAP_TAPCELL_ROW_66_1_1329 VGND VPWR sky130_fd_sc_hd__tapvpwrvgnd_1
XFILLER_189_971 VPWR VGND VPWR VGND sky130_ef_sc_hd__decap_12
XFILLER_206_1121 VPWR VGND VPWR VGND sky130_ef_sc_hd__decap_12
XFILLER_17_1414 VGND VGND VPWR VPWR sky130_fd_sc_hd__decap_6
XFILLER_56_1485 VPWR VGND VPWR VGND sky130_ef_sc_hd__decap_12
XFILLER_143_1433 VPWR VGND VPWR VGND sky130_ef_sc_hd__decap_12
XFILLER_210_249 VPWR VGND VPWR VGND sky130_ef_sc_hd__decap_12
XFILLER_241_1045 VPWR VGND VPWR VGND sky130_ef_sc_hd__decap_12
XTAP_TAPCELL_ROW_13_2_4763 VGND VPWR sky130_fd_sc_hd__tapvpwrvgnd_1
XFILLER_248_22 VPWR VGND VPWR VGND sky130_ef_sc_hd__decap_12
XFILLER_52_1349 VGND VGND VPWR VPWR sky130_fd_sc_hd__decap_6
XFILLER_206_1176 VGND VGND VPWR VPWR sky130_fd_sc_hd__decap_6
XFILLER_143_1488 VPWR VGND VPWR VGND sky130_ef_sc_hd__decap_12
XFILLER_175_142 VPWR VGND VPWR VGND sky130_ef_sc_hd__decap_12
XFILLER_248_77 VPWR VGND VPWR VGND sky130_ef_sc_hd__decap_12
XFILLER_190_101 VGND VGND VPWR VPWR sky130_fd_sc_hd__decap_6
XFILLER_175_197 VPWR VGND VPWR VGND sky130_ef_sc_hd__decap_12
XFILLER_191_646 VPWR VGND VPWR VGND sky130_ef_sc_hd__decap_12
XFILLER_7_80 VGND VGND VPWR VPWR sky130_fd_sc_hd__decap_6
XFILLER_89_1261 VPWR VGND VPWR VGND sky130_ef_sc_hd__decap_12
XFILLER_117_15 VPWR VGND VPWR VGND sky130_ef_sc_hd__decap_12
XFILLER_102_1196 VPWR VGND VPWR VGND sky130_ef_sc_hd__decap_12
XFILLER_172_882 VPWR VGND VPWR VGND sky130_ef_sc_hd__decap_12
XTAP_TAPCELL_ROW_170_1689 VGND VPWR sky130_fd_sc_hd__tapvpwrvgnd_1
XPHY_EDGE_ROW_35_1_Left_290 VGND VGND VPWR VPWR sky130_fd_sc_hd__decap_3
XFILLER_171_381 VGND VGND VPWR VPWR sky130_fd_sc_hd__decap_6
XPHY_EDGE_ROW_123_2_Right_214 VGND VGND VPWR VPWR sky130_fd_sc_hd__decap_3
XFILLER_252_1152 VPWR VGND VPWR VGND sky130_ef_sc_hd__decap_12
XFILLER_63_1445 VPWR VGND VPWR VGND sky130_ef_sc_hd__decap_12
XFILLER_217_1272 VPWR VGND VPWR VGND sky130_ef_sc_hd__decap_12
XPHY_EDGE_ROW_209_Left_464 VGND VGND VPWR VPWR sky130_fd_sc_hd__decap_3
XFILLER_218_316 VGND VGND VPWR VPWR sky130_fd_sc_hd__decap_6
XFILLER_246_636 VPWR VGND VPWR VGND sky130_ef_sc_hd__decap_12
XFILLER_227_861 VPWR VGND VPWR VGND sky130_ef_sc_hd__decap_12
XFILLER_113_1292 VPWR VGND VPWR VGND sky130_ef_sc_hd__decap_12
XFILLER_213_80 VGND VGND VPWR VPWR sky130_fd_sc_hd__decap_6
XFILLER_242_820 VPWR VGND VPWR VGND sky130_ef_sc_hd__decap_12
XFILLER_26_34 VGND VGND VPWR VPWR sky130_fd_sc_hd__decap_8
XFILLER_199_713 VPWR VGND VPWR VGND sky130_ef_sc_hd__decap_12
XPHY_EDGE_ROW_54_1_Left_309 VGND VGND VPWR VPWR sky130_fd_sc_hd__decap_3
XFILLER_2_1269 VPWR VGND VPWR VGND sky130_ef_sc_hd__decap_12
XFILLER_254_691 VPWR VGND VPWR VGND sky130_ef_sc_hd__decap_12
XFILLER_226_1508 VGND VGND VPWR VPWR sky130_fd_sc_hd__decap_6
XFILLER_242_875 VGND VGND VPWR VPWR sky130_fd_sc_hd__decap_6
XFILLER_57_1249 VPWR VGND VPWR VGND sky130_ef_sc_hd__decap_12
XFILLER_109_1328 VGND VGND VPWR VPWR sky130_fd_sc_hd__decap_6
XFILLER_144_1208 VPWR VGND VPWR VGND sky130_ef_sc_hd__decap_12
XFILLER_199_768 VGND VGND VPWR VPWR sky130_fd_sc_hd__decap_6
XFILLER_161_1500 VGND VGND VPWR VPWR sky130_fd_sc_hd__decap_6
XFILLER_148_1399 VPWR VGND VPWR VGND sky130_ef_sc_hd__decap_12
XFILLER_201_216 VPWR VGND VPWR VGND sky130_ef_sc_hd__decap_12
XTAP_TAPCELL_ROW_200_2770 VGND VPWR sky130_fd_sc_hd__tapvpwrvgnd_1
X_290_ net609 net182 net693 VGND VGND VPWR VPWR _086_ sky130_fd_sc_hd__a21o_1
XTAP_TAPCELL_ROW_252_4560 VGND VPWR sky130_fd_sc_hd__tapvpwrvgnd_1
XFILLER_42_22 VPWR VGND VPWR VGND sky130_ef_sc_hd__decap_12
XPHY_EDGE_ROW_218_Left_473 VGND VGND VPWR VPWR sky130_fd_sc_hd__decap_3
XTAP_TAPCELL_ROW_252_4571 VGND VPWR sky130_fd_sc_hd__tapvpwrvgnd_1
XTAP_TAPCELL_ROW_252_4582 VGND VPWR sky130_fd_sc_hd__tapvpwrvgnd_1
XFILLER_158_22 VPWR VGND VPWR VGND sky130_ef_sc_hd__decap_12
XFILLER_166_120 VPWR VGND VPWR VGND sky130_ef_sc_hd__decap_12
XTAP_TAPCELL_ROW_252_4593 VGND VPWR sky130_fd_sc_hd__tapvpwrvgnd_1
XPHY_EDGE_ROW_97_2_Left_599 VGND VGND VPWR VPWR sky130_fd_sc_hd__decap_3
XTAP_TAPCELL_ROW_91_2_5392 VGND VPWR sky130_fd_sc_hd__tapvpwrvgnd_1
XFILLER_166_175 VPWR VGND VPWR VGND sky130_ef_sc_hd__decap_12
XFILLER_182_624 VPWR VGND VPWR VGND sky130_ef_sc_hd__decap_12
XFILLER_213_3 VPWR VGND VPWR VGND sky130_ef_sc_hd__decap_12
XFILLER_194_495 VPWR VGND VPWR VGND sky130_ef_sc_hd__decap_12
XTAP_TAPCELL_ROW_134_2_5732 VGND VPWR sky130_fd_sc_hd__tapvpwrvgnd_1
XFILLER_181_123 VGND VGND VPWR VPWR sky130_fd_sc_hd__decap_6
XFILLER_120_1263 VGND VGND VPWR VPWR sky130_fd_sc_hd__decap_6
XFILLER_170_808 VPWR VGND VPWR VGND sky130_ef_sc_hd__decap_12
XFILLER_182_679 VPWR VGND VPWR VGND sky130_ef_sc_hd__decap_12
XFILLER_68_1356 VPWR VGND VPWR VGND sky130_ef_sc_hd__decap_12
XFILLER_155_1304 VPWR VGND VPWR VGND sky130_ef_sc_hd__decap_12
XTAP_TAPCELL_ROW_246_4353 VGND VPWR sky130_fd_sc_hd__tapvpwrvgnd_1
XTAP_TAPCELL_ROW_246_4364 VGND VPWR sky130_fd_sc_hd__tapvpwrvgnd_1
XFILLER_174_65 VPWR VGND VPWR VGND sky130_ef_sc_hd__decap_12
XFILLER_218_1047 VGND VGND VPWR VPWR sky130_fd_sc_hd__decap_6
XTAP_TAPCELL_ROW_246_4375 VGND VPWR sky130_fd_sc_hd__tapvpwrvgnd_1
XTAP_TAPCELL_ROW_242_4217 VGND VPWR sky130_fd_sc_hd__tapvpwrvgnd_1
XFILLER_155_1359 VPWR VGND VPWR VGND sky130_ef_sc_hd__decap_12
XFILLER_3_27 VPWR VGND VPWR VGND sky130_ef_sc_hd__decap_12
XTAP_TAPCELL_ROW_242_4228 VGND VPWR sky130_fd_sc_hd__tapvpwrvgnd_1
XPHY_EDGE_ROW_227_Left_482 VGND VGND VPWR VPWR sky130_fd_sc_hd__decap_3
XTAP_TAPCELL_ROW_242_4239 VGND VPWR sky130_fd_sc_hd__tapvpwrvgnd_1
XTAP_TAPCELL_ROW_83_2_5329 VGND VPWR sky130_fd_sc_hd__tapvpwrvgnd_1
XTAP_TAPCELL_ROW_52_2_5076 VGND VPWR sky130_fd_sc_hd__tapvpwrvgnd_1
XFILLER_237_603 VPWR VGND VPWR VGND sky130_ef_sc_hd__decap_12
XFILLER_249_474 VPWR VGND VPWR VGND sky130_ef_sc_hd__decap_12
XTAP_TAPCELL_ROW_8_1142 VGND VPWR sky130_fd_sc_hd__tapvpwrvgnd_1
XFILLER_209_338 VGND VGND VPWR VPWR sky130_fd_sc_hd__decap_6
XFILLER_40_1220 VGND VGND VPWR VPWR sky130_fd_sc_hd__decap_6
XTAP_TAPCELL_ROW_8_1153 VGND VPWR sky130_fd_sc_hd__tapvpwrvgnd_1
XTAP_TAPCELL_ROW_8_1164 VGND VPWR sky130_fd_sc_hd__tapvpwrvgnd_1
XFILLER_237_658 VPWR VGND VPWR VGND sky130_ef_sc_hd__decap_12
XTAP_TAPCELL_ROW_4_1006 VGND VPWR sky130_fd_sc_hd__tapvpwrvgnd_1
XTAP_TAPCELL_ROW_4_1017 VGND VPWR sky130_fd_sc_hd__tapvpwrvgnd_1
XFILLER_252_617 VGND VGND VPWR VPWR sky130_fd_sc_hd__decap_6
XTAP_TAPCELL_ROW_4_1028 VGND VPWR sky130_fd_sc_hd__tapvpwrvgnd_1
XTAP_TAPCELL_ROW_199_2714 VGND VPWR sky130_fd_sc_hd__tapvpwrvgnd_1
XTAP_TAPCELL_ROW_199_2725 VGND VPWR sky130_fd_sc_hd__tapvpwrvgnd_1
XTAP_TAPCELL_ROW_199_2736 VGND VPWR sky130_fd_sc_hd__tapvpwrvgnd_1
XFILLER_218_894 VPWR VGND VPWR VGND sky130_ef_sc_hd__decap_12
X_626_ clknet_3_5__leaf_clk dout0\[24\] _034_ VGND VGND VPWR VPWR dout0_q\[24\] sky130_fd_sc_hd__dfrtp_1
XFILLER_166_1422 VPWR VGND VPWR VGND sky130_ef_sc_hd__decap_12
XFILLER_75_1316 VPWR VGND VPWR VGND sky130_ef_sc_hd__decap_12
XFILLER_229_1143 VPWR VGND VPWR VGND sky130_ef_sc_hd__decap_12
XFILLER_233_842 VPWR VGND VPWR VGND sky130_ef_sc_hd__decap_12
XTAP_TAPCELL_ROW_30_2_4902 VGND VPWR sky130_fd_sc_hd__tapvpwrvgnd_1
X_557_ net671 VGND VGND VPWR VPWR _039_ sky130_fd_sc_hd__inv_2
XFILLER_166_1477 VGND VGND VPWR VPWR sky130_fd_sc_hd__decap_6
XFILLER_229_1198 VGND VGND VPWR VPWR sky130_fd_sc_hd__decap_6
XFILLER_233_897 VGND VGND VPWR VPWR sky130_fd_sc_hd__decap_6
XPHY_EDGE_ROW_236_Left_491 VGND VGND VPWR VPWR sky130_fd_sc_hd__decap_3
XPHY_EDGE_ROW_23_1_Right_679 VGND VGND VPWR VPWR sky130_fd_sc_hd__decap_3
X_488_ net173 _250_ VGND VGND VPWR VPWR acc_core.adder.cla_blocks\[4\].block.sum\[3\]
+ sky130_fd_sc_hd__xnor2_1
XFILLER_207_1463 VPWR VGND VPWR VGND sky130_ef_sc_hd__decap_12
XFILLER_9_631 VPWR VGND VPWR VGND sky130_ef_sc_hd__decap_12
XFILLER_203_1327 VGND VGND VPWR VPWR sky130_fd_sc_hd__decap_6
XFILLER_242_1398 VPWR VGND VPWR VGND sky130_ef_sc_hd__decap_12
XFILLER_9_664 VGND VGND VPWR VPWR sky130_fd_sc_hd__decap_8
XFILLER_51_1371 VGND VGND VPWR VPWR sky130_fd_sc_hd__decap_6
XFILLER_8_163 VPWR VGND VPWR VGND sky130_ef_sc_hd__decap_12
XFILLER_172_101 VGND VGND VPWR VPWR sky130_fd_sc_hd__decap_6
XFILLER_173_646 VPWR VGND VPWR VGND sky130_ef_sc_hd__decap_12
XFILLER_86_1423 VPWR VGND VPWR VGND sky130_ef_sc_hd__decap_12
XFILLER_218_58 VGND VGND VPWR VPWR sky130_fd_sc_hd__decap_6
XFILLER_59_3 VPWR VGND VPWR VGND sky130_ef_sc_hd__decap_12
XFILLER_12_1399 VPWR VGND VPWR VGND sky130_ef_sc_hd__decap_12
XFILLER_86_1478 VGND VGND VPWR VPWR sky130_fd_sc_hd__decap_6
XFILLER_234_46 VPWR VGND VPWR VGND sky130_ef_sc_hd__decap_12
XTAP_TAPCELL_ROW_118_1_1406 VGND VPWR sky130_fd_sc_hd__tapvpwrvgnd_1
XFILLER_136_1270 VPWR VGND VPWR VGND sky130_ef_sc_hd__decap_12
XFILLER_214_1434 VGND VGND VPWR VPWR sky130_fd_sc_hd__decap_6
XFILLER_255_400 VPWR VGND VPWR VGND sky130_ef_sc_hd__decap_12
XFILLER_228_636 VPWR VGND VPWR VGND sky130_ef_sc_hd__decap_12
XFILLER_255_433 VGND VGND VPWR VPWR sky130_fd_sc_hd__decap_8
XFILLER_209_861 VPWR VGND VPWR VGND sky130_ef_sc_hd__decap_12
XFILLER_250_34 VPWR VGND VPWR VGND sky130_ef_sc_hd__decap_12
XFILLER_103_39 VGND VGND VPWR VPWR sky130_fd_sc_hd__decap_4
XFILLER_243_639 VGND VGND VPWR VPWR sky130_fd_sc_hd__decap_6
XFILLER_110_1454 VPWR VGND VPWR VGND sky130_ef_sc_hd__decap_12
XFILLER_224_820 VPWR VGND VPWR VGND sky130_ef_sc_hd__decap_12
XFILLER_236_691 VPWR VGND VPWR VGND sky130_ef_sc_hd__decap_12
XFILLER_250_89 VPWR VGND VPWR VGND sky130_ef_sc_hd__decap_12
XFILLER_224_875 VGND VGND VPWR VPWR sky130_fd_sc_hd__decap_6
XFILLER_1_1291 VPWR VGND VPWR VGND sky130_ef_sc_hd__decap_12
XFILLER_208_1238 VPWR VGND VPWR VGND sky130_ef_sc_hd__decap_12
XFILLER_56_1282 VPWR VGND VPWR VGND sky130_ef_sc_hd__decap_12
XFILLER_143_1230 VPWR VGND VPWR VGND sky130_ef_sc_hd__decap_12
XTAP_TAPCELL_ROW_76_2_5272 VGND VPWR sky130_fd_sc_hd__tapvpwrvgnd_1
XFILLER_195_259 VPWR VGND VPWR VGND sky130_ef_sc_hd__decap_12
XTAP_TAPCELL_ROW_119_2_5612 VGND VPWR sky130_fd_sc_hd__tapvpwrvgnd_1
XFILLER_143_1285 VGND VGND VPWR VPWR sky130_fd_sc_hd__decap_6
XFILLER_30_1411 VPWR VGND VPWR VGND sky130_ef_sc_hd__decap_12
XFILLER_176_495 VPWR VGND VPWR VGND sky130_ef_sc_hd__decap_12
XFILLER_12_58 VGND VGND VPWR VPWR sky130_fd_sc_hd__decap_6
XFILLER_178_1348 VGND VGND VPWR VPWR sky130_fd_sc_hd__decap_6
XFILLER_191_443 VPWR VGND VPWR VGND sky130_ef_sc_hd__decap_12
XFILLER_30_1466 VPWR VGND VPWR VGND sky130_ef_sc_hd__decap_12
XFILLER_128_58 VGND VGND VPWR VPWR sky130_fd_sc_hd__decap_6
XFILLER_3_818 VPWR VGND VPWR VGND sky130_ef_sc_hd__decap_12
XFILLER_65_1507 VGND VGND VPWR VPWR sky130_fd_sc_hd__decap_8
XFILLER_191_498 VPWR VGND VPWR VGND sky130_ef_sc_hd__decap_12
XFILLER_219_1334 VPWR VGND VPWR VGND sky130_ef_sc_hd__decap_12
XTAP_TAPCELL_ROW_68_2_5209 VGND VPWR sky130_fd_sc_hd__tapvpwrvgnd_1
XFILLER_254_1269 VPWR VGND VPWR VGND sky130_ef_sc_hd__decap_12
XFILLER_219_1389 VPWR VGND VPWR VGND sky130_ef_sc_hd__decap_12
XFILLER_63_1242 VGND VGND VPWR VPWR sky130_fd_sc_hd__decap_6
XFILLER_144_46 VPWR VGND VPWR VGND sky130_ef_sc_hd__decap_12
XFILLER_8_1434 VGND VGND VPWR VPWR sky130_fd_sc_hd__decap_6
XPHY_EDGE_ROW_124_2_Right_215 VGND VGND VPWR VPWR sky130_fd_sc_hd__decap_3
XFILLER_219_603 VPWR VGND VPWR VGND sky130_ef_sc_hd__decap_12
Xfanout665 net672 VGND VGND VPWR VPWR net665 sky130_fd_sc_hd__clkbuf_4
XFILLER_154_1392 VGND VGND VPWR VPWR sky130_fd_sc_hd__decap_6
XTAP_TAPCELL_ROW_35_2_4939 VGND VPWR sky130_fd_sc_hd__tapvpwrvgnd_1
XFILLER_246_433 VPWR VGND VPWR VGND sky130_ef_sc_hd__decap_12
XFILLER_219_658 VPWR VGND VPWR VGND sky130_ef_sc_hd__decap_12
XFILLER_111_1218 VPWR VGND VPWR VGND sky130_ef_sc_hd__decap_12
XFILLER_189_1444 VPWR VGND VPWR VGND sky130_ef_sc_hd__decap_12
XFILLER_37_44 VGND VGND VPWR VPWR sky130_fd_sc_hd__decap_6
XFILLER_2_1011 VPWR VGND VPWR VGND sky130_ef_sc_hd__decap_12
XFILLER_98_1349 VGND VGND VPWR VPWR sky130_fd_sc_hd__decap_6
XFILLER_160_34 VPWR VGND VPWR VGND sky130_ef_sc_hd__decap_12
XFILLER_234_617 VGND VGND VPWR VPWR sky130_fd_sc_hd__decap_6
XFILLER_246_488 VGND VGND VPWR VPWR sky130_fd_sc_hd__decap_6
XTAP_TAPCELL_ROW_202_2810 VGND VPWR sky130_fd_sc_hd__tapvpwrvgnd_1
XFILLER_189_1499 VGND VGND VPWR VPWR sky130_fd_sc_hd__decap_6
XTAP_TAPCELL_ROW_202_2821 VGND VPWR sky130_fd_sc_hd__tapvpwrvgnd_1
XFILLER_199_510 VGND VGND VPWR VPWR sky130_fd_sc_hd__decap_6
XTAP_TAPCELL_ROW_202_2832 VGND VPWR sky130_fd_sc_hd__tapvpwrvgnd_1
XFILLER_2_1066 VPWR VGND VPWR VGND sky130_ef_sc_hd__decap_12
XFILLER_163_3 VPWR VGND VPWR VGND sky130_ef_sc_hd__decap_12
XTAP_TAPCELL_ROW_202_2843 VGND VPWR sky130_fd_sc_hd__tapvpwrvgnd_1
XFILLER_215_842 VPWR VGND VPWR VGND sky130_ef_sc_hd__decap_12
X_411_ _175_ net151 net206 VGND VGND VPWR VPWR _200_ sky130_fd_sc_hd__or3b_1
XFILLER_226_1305 VGND VGND VPWR VPWR sky130_fd_sc_hd__decap_6
XTAP_TAPCELL_ROW_254_4633 VGND VPWR sky130_fd_sc_hd__tapvpwrvgnd_1
XTAP_TAPCELL_ROW_254_4644 VGND VPWR sky130_fd_sc_hd__tapvpwrvgnd_1
XTAP_TAPCELL_ROW_254_4655 VGND VPWR sky130_fd_sc_hd__tapvpwrvgnd_1
XFILLER_215_897 VGND VGND VPWR VPWR sky130_fd_sc_hd__decap_6
XTAP_TAPCELL_ROW_250_4508 VGND VPWR sky130_fd_sc_hd__tapvpwrvgnd_1
XTAP_TAPCELL_ROW_36_1_1284 VGND VPWR sky130_fd_sc_hd__tapvpwrvgnd_1
X_342_ net595 net572 net540 VGND VGND VPWR VPWR _131_ sky130_fd_sc_hd__a21o_1
XFILLER_148_1196 VPWR VGND VPWR VGND sky130_ef_sc_hd__decap_12
XFILLER_183_1076 VPWR VGND VPWR VGND sky130_ef_sc_hd__decap_12
XTAP_TAPCELL_ROW_250_4519 VGND VPWR sky130_fd_sc_hd__tapvpwrvgnd_1
XFILLER_186_237 VPWR VGND VPWR VGND sky130_ef_sc_hd__decap_12
XFILLER_169_87 VPWR VGND VPWR VGND sky130_ef_sc_hd__decap_12
XFILLER_122_1325 VPWR VGND VPWR VGND sky130_ef_sc_hd__decap_12
XTAP_TAPCELL_ROW_124_1_1416 VGND VPWR sky130_fd_sc_hd__tapvpwrvgnd_1
XFILLER_182_421 VPWR VGND VPWR VGND sky130_ef_sc_hd__decap_12
XFILLER_5_111 VPWR VGND VPWR VGND sky130_ef_sc_hd__decap_12
XFILLER_194_292 VPWR VGND VPWR VGND sky130_ef_sc_hd__decap_12
XTAP_TAPCELL_ROW_248_4426 VGND VPWR sky130_fd_sc_hd__tapvpwrvgnd_1
XTAP_TAPCELL_ROW_248_4437 VGND VPWR sky130_fd_sc_hd__tapvpwrvgnd_1
XFILLER_170_605 VPWR VGND VPWR VGND sky130_ef_sc_hd__decap_12
XFILLER_6_667 VGND VGND VPWR VPWR sky130_fd_sc_hd__fill_1
XFILLER_237_1401 VPWR VGND VPWR VGND sky130_ef_sc_hd__decap_12
XTAP_TAPCELL_ROW_248_4448 VGND VPWR sky130_fd_sc_hd__tapvpwrvgnd_1
XFILLER_182_476 VPWR VGND VPWR VGND sky130_ef_sc_hd__decap_12
XFILLER_5_177 VGND VGND VPWR VPWR sky130_fd_sc_hd__fill_1
XFILLER_159_1292 VPWR VGND VPWR VGND sky130_ef_sc_hd__decap_12
XFILLER_237_1456 VGND VGND VPWR VPWR sky130_fd_sc_hd__decap_6
XFILLER_194_1183 VPWR VGND VPWR VGND sky130_ef_sc_hd__decap_12
XFILLER_2_851 VGND VGND VPWR VPWR sky130_fd_sc_hd__fill_1
XFILLER_2_862 VGND VGND VPWR VPWR sky130_fd_sc_hd__decap_8
XTAP_TAPCELL_ROW_164_2_5971 VGND VPWR sky130_fd_sc_hd__tapvpwrvgnd_1
XFILLER_190_1047 VGND VGND VPWR VPWR sky130_fd_sc_hd__decap_6
XFILLER_133_1421 VPWR VGND VPWR VGND sky130_ef_sc_hd__decap_12
XFILLER_237_400 VPWR VGND VPWR VGND sky130_ef_sc_hd__decap_12
XFILLER_231_1033 VPWR VGND VPWR VGND sky130_ef_sc_hd__decap_12
XFILLER_249_271 VPWR VGND VPWR VGND sky130_ef_sc_hd__decap_12
XFILLER_42_1337 VPWR VGND VPWR VGND sky130_ef_sc_hd__decap_12
XFILLER_133_1476 VPWR VGND VPWR VGND sky130_ef_sc_hd__decap_12
XFILLER_253_904 VPWR VGND VPWR VGND sky130_ef_sc_hd__decap_12
XFILLER_237_455 VPWR VGND VPWR VGND sky130_ef_sc_hd__decap_12
XFILLER_231_1088 VPWR VGND VPWR VGND sky130_ef_sc_hd__decap_12
XFILLER_206_820 VPWR VGND VPWR VGND sky130_ef_sc_hd__decap_12
XFILLER_225_639 VGND VGND VPWR VPWR sky130_fd_sc_hd__decap_6
XFILLER_253_959 VPWR VGND VPWR VGND sky130_ef_sc_hd__decap_12
XTAP_TAPCELL_ROW_156_2_5908 VGND VPWR sky130_fd_sc_hd__tapvpwrvgnd_1
XFILLER_218_691 VPWR VGND VPWR VGND sky130_ef_sc_hd__decap_12
XFILLER_220_15 VGND VGND VPWR VPWR sky130_fd_sc_hd__decap_6
XFILLER_209_1514 VGND VGND VPWR VPWR sky130_fd_sc_hd__fill_1
X_609_ clknet_3_1__leaf_clk dout0\[7\] _017_ VGND VGND VPWR VPWR dout0_q\[7\] sky130_fd_sc_hd__dfrtp_1
XFILLER_206_875 VGND VGND VPWR VPWR sky130_fd_sc_hd__decap_6
XFILLER_242_1140 VPWR VGND VPWR VGND sky130_ef_sc_hd__decap_12
XFILLER_53_1433 VPWR VGND VPWR VGND sky130_ef_sc_hd__decap_12
XFILLER_207_1260 VPWR VGND VPWR VGND sky130_ef_sc_hd__decap_12
XFILLER_177_259 VPWR VGND VPWR VGND sky130_ef_sc_hd__decap_12
XFILLER_220_366 VPWR VGND VPWR VGND sky130_ef_sc_hd__decap_12
XFILLER_242_1195 VPWR VGND VPWR VGND sky130_ef_sc_hd__decap_12
XFILLER_53_1488 VPWR VGND VPWR VGND sky130_ef_sc_hd__decap_12
XFILLER_192_218 VPWR VGND VPWR VGND sky130_ef_sc_hd__decap_12
XTAP_TAPCELL_ROW_28_2_4882 VGND VPWR sky130_fd_sc_hd__tapvpwrvgnd_1
XFILLER_229_68 VPWR VGND VPWR VGND sky130_ef_sc_hd__decap_12
XFILLER_173_443 VPWR VGND VPWR VGND sky130_ef_sc_hd__decap_12
XTAP_TAPCELL_ROW_171_1740 VGND VPWR sky130_fd_sc_hd__tapvpwrvgnd_1
XTAP_TAPCELL_ROW_212_3161 VGND VPWR sky130_fd_sc_hd__tapvpwrvgnd_1
XFILLER_86_1220 VGND VGND VPWR VPWR sky130_fd_sc_hd__decap_6
XTAP_TAPCELL_ROW_171_1751 VGND VPWR sky130_fd_sc_hd__tapvpwrvgnd_1
XTAP_TAPCELL_ROW_212_3172 VGND VPWR sky130_fd_sc_hd__tapvpwrvgnd_1
XTAP_TAPCELL_ROW_212_3183 VGND VPWR sky130_fd_sc_hd__tapvpwrvgnd_1
XFILLER_173_498 VPWR VGND VPWR VGND sky130_ef_sc_hd__decap_12
XFILLER_12_1196 VPWR VGND VPWR VGND sky130_ef_sc_hd__decap_12
XFILLER_177_1370 VGND VGND VPWR VPWR sky130_fd_sc_hd__decap_6
XFILLER_245_56 VPWR VGND VPWR VGND sky130_ef_sc_hd__decap_12
XFILLER_4_92 VGND VGND VPWR VPWR sky130_fd_sc_hd__decap_4
XFILLER_253_1291 VPWR VGND VPWR VGND sky130_ef_sc_hd__decap_12
XTAP_TAPCELL_ROW_165_1500 VGND VPWR sky130_fd_sc_hd__tapvpwrvgnd_1
XTAP_TAPCELL_ROW_165_1511 VGND VPWR sky130_fd_sc_hd__tapvpwrvgnd_1
XTAP_TAPCELL_ROW_169_1680 VGND VPWR sky130_fd_sc_hd__tapvpwrvgnd_1
XTAP_TAPCELL_ROW_165_1522 VGND VPWR sky130_fd_sc_hd__tapvpwrvgnd_1
XTAP_TAPCELL_ROW_165_1533 VGND VPWR sky130_fd_sc_hd__tapvpwrvgnd_1
XFILLER_228_433 VPWR VGND VPWR VGND sky130_ef_sc_hd__decap_12
XTAP_TAPCELL_ROW_165_1544 VGND VPWR sky130_fd_sc_hd__tapvpwrvgnd_1
XFILLER_249_1327 VGND VGND VPWR VPWR sky130_fd_sc_hd__decap_6
XFILLER_216_617 VGND VGND VPWR VPWR sky130_fd_sc_hd__decap_6
XFILLER_255_274 VPWR VGND VPWR VGND sky130_ef_sc_hd__decap_12
XFILLER_244_937 VPWR VGND VPWR VGND sky130_ef_sc_hd__decap_12
XFILLER_228_488 VGND VGND VPWR VPWR sky130_fd_sc_hd__decap_6
XFILLER_23_1292 VPWR VGND VPWR VGND sky130_ef_sc_hd__decap_12
XFILLER_110_1251 VPWR VGND VPWR VGND sky130_ef_sc_hd__decap_12
XFILLER_97_1371 VGND VGND VPWR VPWR sky130_fd_sc_hd__decap_6
XFILLER_130_15 VGND VGND VPWR VPWR sky130_fd_sc_hd__decap_6
XPHY_EDGE_ROW_171_Right_16 VGND VGND VPWR VPWR sky130_fd_sc_hd__decap_3
XFILLER_230_108 VPWR VGND VPWR VGND sky130_ef_sc_hd__decap_12
XFILLER_252_992 VPWR VGND VPWR VGND sky130_ef_sc_hd__decap_12
XFILLER_54_1208 VPWR VGND VPWR VGND sky130_ef_sc_hd__decap_12
XFILLER_19_1328 VGND VGND VPWR VPWR sky130_fd_sc_hd__decap_6
XFILLER_208_1035 VPWR VGND VPWR VGND sky130_ef_sc_hd__decap_12
XFILLER_71_1500 VGND VGND VPWR VPWR sky130_fd_sc_hd__decap_6
XFILLER_58_1399 VPWR VGND VPWR VGND sky130_ef_sc_hd__decap_12
XFILLER_145_1347 VPWR VGND VPWR VGND sky130_ef_sc_hd__decap_12
XFILLER_180_1238 VPWR VGND VPWR VGND sky130_ef_sc_hd__decap_12
XFILLER_168_237 VPWR VGND VPWR VGND sky130_ef_sc_hd__decap_12
XFILLER_23_35 VGND VGND VPWR VPWR sky130_fd_sc_hd__decap_8
Xwire307 net308 VGND VGND VPWR VPWR net307 sky130_fd_sc_hd__clkbuf_1
Xwire318 net319 VGND VGND VPWR VPWR net318 sky130_fd_sc_hd__clkbuf_1
XFILLER_211_388 VPWR VGND VPWR VGND sky130_ef_sc_hd__decap_12
Xwire329 _148_ VGND VGND VPWR VPWR net329 sky130_fd_sc_hd__clkbuf_1
XFILLER_139_68 VGND VGND VPWR VPWR sky130_fd_sc_hd__decap_3
XFILLER_176_292 VPWR VGND VPWR VGND sky130_ef_sc_hd__decap_12
XFILLER_99_39 VGND VGND VPWR VPWR sky130_fd_sc_hd__decap_4
XFILLER_191_240 VPWR VGND VPWR VGND sky130_ef_sc_hd__decap_12
XFILLER_165_988 VPWR VGND VPWR VGND sky130_ef_sc_hd__decap_12
XFILLER_180_925 VPWR VGND VPWR VGND sky130_ef_sc_hd__decap_12
XPHY_EDGE_ROW_180_Right_25 VGND VGND VPWR VPWR sky130_fd_sc_hd__decap_3
XFILLER_30_1263 VGND VGND VPWR VPWR sky130_fd_sc_hd__decap_6
XFILLER_192_796 VPWR VGND VPWR VGND sky130_ef_sc_hd__decap_12
XFILLER_254_1011 VPWR VGND VPWR VGND sky130_ef_sc_hd__decap_12
XFILLER_65_1304 VPWR VGND VPWR VGND sky130_ef_sc_hd__decap_12
XTAP_TAPCELL_ROW_149_2_5851 VGND VPWR sky130_fd_sc_hd__tapvpwrvgnd_1
XFILLER_191_295 VGND VGND VPWR VPWR sky130_fd_sc_hd__decap_6
XFILLER_219_1131 VPWR VGND VPWR VGND sky130_ef_sc_hd__decap_12
XFILLER_155_56 VPWR VGND VPWR VGND sky130_ef_sc_hd__decap_12
XFILLER_156_1454 VPWR VGND VPWR VGND sky130_ef_sc_hd__decap_12
XFILLER_191_1334 VPWR VGND VPWR VGND sky130_ef_sc_hd__decap_12
XFILLER_254_1066 VPWR VGND VPWR VGND sky130_ef_sc_hd__decap_12
XFILLER_219_1186 VPWR VGND VPWR VGND sky130_ef_sc_hd__decap_12
XFILLER_65_1359 VPWR VGND VPWR VGND sky130_ef_sc_hd__decap_12
XFILLER_191_1389 VPWR VGND VPWR VGND sky130_ef_sc_hd__decap_12
XFILLER_219_400 VPWR VGND VPWR VGND sky130_ef_sc_hd__decap_12
XFILLER_48_65 VGND VGND VPWR VPWR sky130_fd_sc_hd__decap_6
XPHY_EDGE_ROW_125_2_Right_216 VGND VGND VPWR VPWR sky130_fd_sc_hd__decap_3
XTAP_TAPCELL_ROW_98_2_5448 VGND VPWR sky130_fd_sc_hd__tapvpwrvgnd_1
XFILLER_171_44 VPWR VGND VPWR VGND sky130_ef_sc_hd__decap_12
XFILLER_246_230 VGND VGND VPWR VPWR sky130_fd_sc_hd__decap_6
XTAP_TAPCELL_ROW_204_2905 VGND VPWR sky130_fd_sc_hd__tapvpwrvgnd_1
XFILLER_219_455 VPWR VGND VPWR VGND sky130_ef_sc_hd__decap_12
XFILLER_235_904 VPWR VGND VPWR VGND sky130_ef_sc_hd__decap_12
XFILLER_247_775 VPWR VGND VPWR VGND sky130_ef_sc_hd__decap_12
XTAP_TAPCELL_ROW_67_2_5195 VGND VPWR sky130_fd_sc_hd__tapvpwrvgnd_1
XFILLER_189_1241 VGND VGND VPWR VPWR sky130_fd_sc_hd__decap_6
XTAP_TAPCELL_ROW_111_2_5552 VGND VPWR sky130_fd_sc_hd__tapvpwrvgnd_1
XFILLER_171_99 VPWR VGND VPWR VGND sky130_ef_sc_hd__decap_12
XTAP_TAPCELL_ROW_181_2080 VGND VPWR sky130_fd_sc_hd__tapvpwrvgnd_1
XFILLER_207_639 VGND VGND VPWR VPWR sky130_fd_sc_hd__decap_6
XTAP_TAPCELL_ROW_181_2091 VGND VPWR sky130_fd_sc_hd__tapvpwrvgnd_1
XFILLER_235_959 VPWR VGND VPWR VGND sky130_ef_sc_hd__decap_12
XFILLER_76_1411 VPWR VGND VPWR VGND sky130_ef_sc_hd__decap_12
XFILLER_250_918 VGND VGND VPWR VPWR sky130_fd_sc_hd__decap_6
XFILLER_76_1466 VPWR VGND VPWR VGND sky130_ef_sc_hd__decap_12
XFILLER_163_1414 VGND VGND VPWR VPWR sky130_fd_sc_hd__decap_6
XTAP_TAPCELL_ROW_60_2_5138 VGND VPWR sky130_fd_sc_hd__tapvpwrvgnd_1
X_325_ _112_ _113_ VGND VGND VPWR VPWR _114_ sky130_fd_sc_hd__or2_1
XFILLER_202_366 VPWR VGND VPWR VGND sky130_ef_sc_hd__decap_12
XFILLER_204_1422 VPWR VGND VPWR VGND sky130_ef_sc_hd__decap_12
XFILLER_174_218 VPWR VGND VPWR VGND sky130_ef_sc_hd__decap_12
XFILLER_204_1477 VGND VGND VPWR VPWR sky130_fd_sc_hd__decap_6
XFILLER_122_1177 VGND VGND VPWR VPWR sky130_fd_sc_hd__decap_6
Xmax_cap607 rd_addr\[6\] VGND VGND VPWR VPWR net607 sky130_fd_sc_hd__clkbuf_1
Xmax_cap618 net619 VGND VGND VPWR VPWR net618 sky130_fd_sc_hd__clkbuf_1
XFILLER_170_402 VGND VGND VPWR VPWR sky130_fd_sc_hd__decap_6
XFILLER_157_1218 VPWR VGND VPWR VGND sky130_ef_sc_hd__decap_12
XFILLER_182_273 VGND VGND VPWR VPWR sky130_fd_sc_hd__decap_6
XFILLER_100_1442 VPWR VGND VPWR VGND sky130_ef_sc_hd__decap_12
XFILLER_171_947 VPWR VGND VPWR VGND sky130_ef_sc_hd__decap_12
XFILLER_192_1109 VPWR VGND VPWR VGND sky130_ef_sc_hd__decap_12
XFILLER_100_1497 VPWR VGND VPWR VGND sky130_ef_sc_hd__decap_12
XFILLER_215_15 VPWR VGND VPWR VGND sky130_ef_sc_hd__decap_12
XFILLER_46_1270 VPWR VGND VPWR VGND sky130_ef_sc_hd__decap_12
XFILLER_250_1453 VPWR VGND VPWR VGND sky130_ef_sc_hd__decap_12
XFILLER_238_753 VPWR VGND VPWR VGND sky130_ef_sc_hd__decap_12
XFILLER_133_1273 VPWR VGND VPWR VGND sky130_ef_sc_hd__decap_12
XFILLER_253_701 VPWR VGND VPWR VGND sky130_ef_sc_hd__decap_12
XFILLER_237_252 VGND VGND VPWR VPWR sky130_fd_sc_hd__decap_6
XFILLER_226_937 VPWR VGND VPWR VGND sky130_ef_sc_hd__decap_12
XFILLER_0_1504 VGND VGND VPWR VPWR sky130_fd_sc_hd__decap_8
XTAP_TAPCELL_ROW_220_3441 VGND VPWR sky130_fd_sc_hd__tapvpwrvgnd_1
XFILLER_168_1336 VPWR VGND VPWR VGND sky130_ef_sc_hd__decap_12
XTAP_TAPCELL_ROW_220_3452 VGND VPWR sky130_fd_sc_hd__tapvpwrvgnd_1
XFILLER_253_756 VPWR VGND VPWR VGND sky130_ef_sc_hd__decap_12
XFILLER_20_1454 VPWR VGND VPWR VGND sky130_ef_sc_hd__decap_12
XTAP_TAPCELL_ROW_220_3463 VGND VPWR sky130_fd_sc_hd__tapvpwrvgnd_1
XFILLER_212_108 VPWR VGND VPWR VGND sky130_ef_sc_hd__decap_12
XFILLER_234_992 VPWR VGND VPWR VGND sky130_ef_sc_hd__decap_12
XFILLER_181_1514 VGND VGND VPWR VPWR sky130_fd_sc_hd__fill_1
XFILLER_209_1377 VPWR VGND VPWR VGND sky130_ef_sc_hd__decap_12
XFILLER_142_1509 VGND VGND VPWR VPWR sky130_fd_sc_hd__decap_6
XTAP_TAPCELL_ROW_18_1_1256 VGND VPWR sky130_fd_sc_hd__tapvpwrvgnd_1
XFILLER_53_1230 VPWR VGND VPWR VGND sky130_ef_sc_hd__decap_12
XTAP_TAPCELL_ROW_218_3370 VGND VPWR sky130_fd_sc_hd__tapvpwrvgnd_1
XFILLER_220_163 VPWR VGND VPWR VGND sky130_ef_sc_hd__decap_12
XTAP_TAPCELL_ROW_177_1960 VGND VPWR sky130_fd_sc_hd__tapvpwrvgnd_1
XTAP_TAPCELL_ROW_218_3381 VGND VPWR sky130_fd_sc_hd__tapvpwrvgnd_1
XFILLER_144_1380 VPWR VGND VPWR VGND sky130_ef_sc_hd__decap_12
XTAP_TAPCELL_ROW_173_1802 VGND VPWR sky130_fd_sc_hd__tapvpwrvgnd_1
XTAP_TAPCELL_ROW_218_3392 VGND VPWR sky130_fd_sc_hd__tapvpwrvgnd_1
XTAP_TAPCELL_ROW_173_1813 VGND VPWR sky130_fd_sc_hd__tapvpwrvgnd_1
XTAP_TAPCELL_ROW_214_3234 VGND VPWR sky130_fd_sc_hd__tapvpwrvgnd_1
XFILLER_53_1285 VGND VGND VPWR VPWR sky130_fd_sc_hd__decap_6
XTAP_TAPCELL_ROW_173_1824 VGND VPWR sky130_fd_sc_hd__tapvpwrvgnd_1
XTAP_TAPCELL_ROW_214_3245 VGND VPWR sky130_fd_sc_hd__tapvpwrvgnd_1
XTAP_TAPCELL_ROW_214_3256 VGND VPWR sky130_fd_sc_hd__tapvpwrvgnd_1
XFILLER_101_1206 VPWR VGND VPWR VGND sky130_ef_sc_hd__decap_12
XFILLER_179_1432 VPWR VGND VPWR VGND sky130_ef_sc_hd__decap_12
XTAP_TAPCELL_ROW_210_3109 VGND VPWR sky130_fd_sc_hd__tapvpwrvgnd_1
XFILLER_88_1337 VPWR VGND VPWR VGND sky130_ef_sc_hd__decap_12
XFILLER_109_27 VPWR VGND VPWR VGND sky130_ef_sc_hd__decap_12
XFILLER_173_240 VPWR VGND VPWR VGND sky130_ef_sc_hd__decap_12
XFILLER_174_796 VPWR VGND VPWR VGND sky130_ef_sc_hd__decap_12
XFILLER_179_1487 VPWR VGND VPWR VGND sky130_ef_sc_hd__decap_12
XFILLER_173_295 VGND VGND VPWR VPWR sky130_fd_sc_hd__decap_6
XPHY_EDGE_ROW_63_1_Left_318 VGND VGND VPWR VPWR sky130_fd_sc_hd__decap_3
XFILLER_170_980 VPWR VGND VPWR VGND sky130_ef_sc_hd__decap_12
XFILLER_251_1217 VPWR VGND VPWR VGND sky130_ef_sc_hd__decap_12
XFILLER_125_15 VPWR VGND VPWR VGND sky130_ef_sc_hd__decap_12
XTAP_TAPCELL_ROW_116_2_5589 VGND VPWR sky130_fd_sc_hd__tapvpwrvgnd_1
XFILLER_216_1348 VGND VGND VPWR VPWR sky130_fd_sc_hd__decap_6
XTAP_TAPCELL_ROW_84_2_5334 VGND VPWR sky130_fd_sc_hd__tapvpwrvgnd_1
XFILLER_138_1184 VPWR VGND VPWR VGND sky130_ef_sc_hd__decap_12
XTAP_TAPCELL_ROW_167_1606 VGND VPWR sky130_fd_sc_hd__tapvpwrvgnd_1
XTAP_TAPCELL_ROW_208_3027 VGND VPWR sky130_fd_sc_hd__tapvpwrvgnd_1
XTAP_TAPCELL_ROW_167_1617 VGND VPWR sky130_fd_sc_hd__tapvpwrvgnd_1
XTAP_TAPCELL_ROW_208_3038 VGND VPWR sky130_fd_sc_hd__tapvpwrvgnd_1
XTAP_TAPCELL_ROW_208_3049 VGND VPWR sky130_fd_sc_hd__tapvpwrvgnd_1
XFILLER_64_1392 VGND VGND VPWR VPWR sky130_fd_sc_hd__decap_6
XFILLER_112_1313 VPWR VGND VPWR VGND sky130_ef_sc_hd__decap_12
XFILLER_217_904 VPWR VGND VPWR VGND sky130_ef_sc_hd__decap_12
XFILLER_228_230 VGND VGND VPWR VPWR sky130_fd_sc_hd__decap_6
XFILLER_99_1433 VPWR VGND VPWR VGND sky130_ef_sc_hd__decap_12
XFILLER_21_1218 VPWR VGND VPWR VGND sky130_ef_sc_hd__decap_12
XFILLER_229_775 VPWR VGND VPWR VGND sky130_ef_sc_hd__decap_12
XFILLER_18_46 VPWR VGND VPWR VGND sky130_ef_sc_hd__decap_12
XFILLER_244_734 VPWR VGND VPWR VGND sky130_ef_sc_hd__decap_12
XFILLER_112_1368 VPWR VGND VPWR VGND sky130_ef_sc_hd__decap_12
XFILLER_217_959 VPWR VGND VPWR VGND sky130_ef_sc_hd__decap_12
XFILLER_99_1488 VPWR VGND VPWR VGND sky130_ef_sc_hd__decap_12
XFILLER_232_918 VGND VGND VPWR VPWR sky130_fd_sc_hd__decap_6
XFILLER_244_789 VGND VGND VPWR VPWR sky130_fd_sc_hd__decap_6
XTAP_TAPCELL_ROW_45_2_5018 VGND VPWR sky130_fd_sc_hd__tapvpwrvgnd_1
XFILLER_197_811 VGND VGND VPWR VPWR sky130_fd_sc_hd__decap_6
XFILLER_221_80 VGND VGND VPWR VPWR sky130_fd_sc_hd__decap_6
XFILLER_34_34 VPWR VGND VPWR VGND sky130_ef_sc_hd__decap_12
XFILLER_227_1444 VPWR VGND VPWR VGND sky130_ef_sc_hd__decap_12
XFILLER_58_1196 VPWR VGND VPWR VGND sky130_ef_sc_hd__decap_12
XFILLER_180_1035 VPWR VGND VPWR VGND sky130_ef_sc_hd__decap_12
XFILLER_211_130 VPWR VGND VPWR VGND sky130_ef_sc_hd__decap_12
XFILLER_227_1499 VGND VGND VPWR VPWR sky130_fd_sc_hd__decap_6
XFILLER_145_1177 VPWR VGND VPWR VGND sky130_ef_sc_hd__decap_12
XFILLER_8_718 VGND VGND VPWR VPWR sky130_fd_sc_hd__fill_1
XFILLER_211_185 VPWR VGND VPWR VGND sky130_ef_sc_hd__decap_12
XTAP_TAPCELL_ROW_12_2_4759 VGND VPWR sky130_fd_sc_hd__tapvpwrvgnd_1
Xclkload0 clknet_3_0__leaf_clk VGND VGND VPWR VPWR clkload0/Y sky130_fd_sc_hd__inv_8
XFILLER_184_538 VPWR VGND VPWR VGND sky130_ef_sc_hd__decap_12
XFILLER_32_1325 VPWR VGND VPWR VGND sky130_ef_sc_hd__decap_12
Xwire126 _178_ VGND VGND VPWR VPWR net126 sky130_fd_sc_hd__clkbuf_1
XFILLER_50_22 VPWR VGND VPWR VGND sky130_ef_sc_hd__decap_12
Xwire148 _190_ VGND VGND VPWR VPWR net148 sky130_fd_sc_hd__clkbuf_1
XFILLER_123_1464 VPWR VGND VPWR VGND sky130_ef_sc_hd__decap_12
XFILLER_126_3 VPWR VGND VPWR VGND sky130_ef_sc_hd__decap_12
XFILLER_166_22 VPWR VGND VPWR VGND sky130_ef_sc_hd__decap_12
XFILLER_221_1076 VPWR VGND VPWR VGND sky130_ef_sc_hd__decap_12
XFILLER_180_722 VPWR VGND VPWR VGND sky130_ef_sc_hd__decap_12
XFILLER_192_593 VPWR VGND VPWR VGND sky130_ef_sc_hd__decap_12
XFILLER_166_77 VPWR VGND VPWR VGND sky130_ef_sc_hd__decap_12
XFILLER_4_968 VPWR VGND VPWR VGND sky130_ef_sc_hd__decap_12
XPHY_EDGE_ROW_168_Left_423 VGND VGND VPWR VPWR sky130_fd_sc_hd__decap_3
XFILLER_180_777 VPWR VGND VPWR VGND sky130_ef_sc_hd__decap_12
XFILLER_69_1292 VPWR VGND VPWR VGND sky130_ef_sc_hd__decap_12
XFILLER_156_1251 VPWR VGND VPWR VGND sky130_ef_sc_hd__decap_12
XFILLER_191_1131 VPWR VGND VPWR VGND sky130_ef_sc_hd__decap_12
XFILLER_239_517 VPWR VGND VPWR VGND sky130_ef_sc_hd__decap_12
XFILLER_65_1189 VPWR VGND VPWR VGND sky130_ef_sc_hd__decap_12
XFILLER_182_65 VPWR VGND VPWR VGND sky130_ef_sc_hd__decap_12
XFILLER_191_1186 VPWR VGND VPWR VGND sky130_ef_sc_hd__decap_12
XFILLER_43_1421 VPWR VGND VPWR VGND sky130_ef_sc_hd__decap_12
XTAP_TAPCELL_ROW_183_2153 VGND VPWR sky130_fd_sc_hd__tapvpwrvgnd_1
XTAP_TAPCELL_ROW_183_2164 VGND VPWR sky130_fd_sc_hd__tapvpwrvgnd_1
XTAP_TAPCELL_ROW_183_2175 VGND VPWR sky130_fd_sc_hd__tapvpwrvgnd_1
XFILLER_43_1476 VPWR VGND VPWR VGND sky130_ef_sc_hd__decap_12
XFILLER_219_252 VGND VGND VPWR VPWR sky130_fd_sc_hd__decap_6
XFILLER_232_1183 VPWR VGND VPWR VGND sky130_ef_sc_hd__decap_12
XFILLER_235_701 VPWR VGND VPWR VGND sky130_ef_sc_hd__decap_12
XTAP_TAPCELL_ROW_24_1_1266 VGND VPWR sky130_fd_sc_hd__tapvpwrvgnd_1
XPHY_EDGE_ROW_126_2_Right_217 VGND VGND VPWR VPWR sky130_fd_sc_hd__decap_3
XFILLER_130_1435 VGND VGND VPWR VPWR sky130_fd_sc_hd__decap_6
XFILLER_247_572 VPWR VGND VPWR VGND sky130_ef_sc_hd__decap_12
XFILLER_208_937 VPWR VGND VPWR VGND sky130_ef_sc_hd__decap_12
XFILLER_235_756 VPWR VGND VPWR VGND sky130_ef_sc_hd__decap_12
XTAP_TAPCELL_ROW_3_990 VGND VPWR sky130_fd_sc_hd__tapvpwrvgnd_1
XFILLER_228_1219 VGND VGND VPWR VPWR sky130_fd_sc_hd__decap_6
XPHY_EDGE_ROW_177_Left_432 VGND VGND VPWR VPWR sky130_fd_sc_hd__decap_3
XFILLER_201_39 VGND VGND VPWR VPWR sky130_fd_sc_hd__decap_4
XFILLER_216_992 VPWR VGND VPWR VGND sky130_ef_sc_hd__decap_12
XFILLER_76_1263 VGND VGND VPWR VPWR sky130_fd_sc_hd__decap_6
XFILLER_231_940 VGND VGND VPWR VPWR sky130_fd_sc_hd__decap_6
XTAP_TAPCELL_ROW_141_2_5791 VGND VPWR sky130_fd_sc_hd__tapvpwrvgnd_1
XFILLER_202_163 VPWR VGND VPWR VGND sky130_ef_sc_hd__decap_12
XFILLER_124_1239 VPWR VGND VPWR VGND sky130_ef_sc_hd__decap_12
X_308_ net510 VGND VGND VPWR VPWR _097_ sky130_fd_sc_hd__inv_2
Xwire660 net13 VGND VGND VPWR VPWR net660 sky130_fd_sc_hd__buf_1
XFILLER_190_519 VPWR VGND VPWR VGND sky130_ef_sc_hd__decap_12
XFILLER_239_1315 VPWR VGND VPWR VGND sky130_ef_sc_hd__decap_12
XFILLER_183_560 VPWR VGND VPWR VGND sky130_ef_sc_hd__decap_12
XTAP_TAPCELL_ROW_232_3890 VGND VPWR sky130_fd_sc_hd__tapvpwrvgnd_1
XFILLER_6_261 VGND VGND VPWR VPWR sky130_fd_sc_hd__fill_1
XTAP_TAPCELL_ROW_133_2_5728 VGND VPWR sky130_fd_sc_hd__tapvpwrvgnd_1
XPHY_EDGE_ROW_186_Left_441 VGND VGND VPWR VPWR sky130_fd_sc_hd__decap_3
XFILLER_171_744 VPWR VGND VPWR VGND sky130_ef_sc_hd__decap_12
XTAP_TAPCELL_ROW_102_2_5475 VGND VPWR sky130_fd_sc_hd__tapvpwrvgnd_1
XTAP_TAPCELL_ROW_70_2_5220 VGND VPWR sky130_fd_sc_hd__tapvpwrvgnd_1
XFILLER_83_1201 VGND VGND VPWR VPWR sky130_fd_sc_hd__decap_4
XFILLER_196_1097 VPWR VGND VPWR VGND sky130_ef_sc_hd__decap_12
XTAP_TAPCELL_ROW_69_2_5214 VGND VPWR sky130_fd_sc_hd__tapvpwrvgnd_1
XFILLER_41_3 VPWR VGND VPWR VGND sky130_ef_sc_hd__decap_12
XFILLER_100_1294 VPWR VGND VPWR VGND sky130_ef_sc_hd__decap_12
XFILLER_171_799 VPWR VGND VPWR VGND sky130_ef_sc_hd__decap_12
XFILLER_226_58 VGND VGND VPWR VPWR sky130_fd_sc_hd__decap_6
XFILLER_3_990 VPWR VGND VPWR VGND sky130_ef_sc_hd__decap_12
XFILLER_135_1335 VPWR VGND VPWR VGND sky130_ef_sc_hd__decap_12
XFILLER_170_1226 VPWR VGND VPWR VGND sky130_ef_sc_hd__decap_12
XTAP_TAPCELL_ROW_226_3650 VGND VPWR sky130_fd_sc_hd__tapvpwrvgnd_1
XTAP_TAPCELL_ROW_226_3661 VGND VPWR sky130_fd_sc_hd__tapvpwrvgnd_1
XFILLER_250_1250 VPWR VGND VPWR VGND sky130_ef_sc_hd__decap_12
XFILLER_215_1370 VGND VGND VPWR VPWR sky130_fd_sc_hd__decap_6
XTAP_TAPCELL_ROW_226_3672 VGND VPWR sky130_fd_sc_hd__tapvpwrvgnd_1
XTAP_TAPCELL_ROW_222_3514 VGND VPWR sky130_fd_sc_hd__tapvpwrvgnd_1
XTAP_TAPCELL_ROW_226_3683 VGND VPWR sky130_fd_sc_hd__tapvpwrvgnd_1
XFILLER_238_550 VPWR VGND VPWR VGND sky130_ef_sc_hd__decap_12
XFILLER_242_46 VPWR VGND VPWR VGND sky130_ef_sc_hd__decap_12
XTAP_TAPCELL_ROW_222_3525 VGND VPWR sky130_fd_sc_hd__tapvpwrvgnd_1
XTAP_TAPCELL_ROW_222_3536 VGND VPWR sky130_fd_sc_hd__tapvpwrvgnd_1
XTAP_TAPCELL_ROW_1_905 VGND VPWR sky130_fd_sc_hd__tapvpwrvgnd_1
XTAP_TAPCELL_ROW_1_916 VGND VPWR sky130_fd_sc_hd__tapvpwrvgnd_1
XTAP_TAPCELL_ROW_1_927 VGND VPWR sky130_fd_sc_hd__tapvpwrvgnd_1
XFILLER_226_734 VPWR VGND VPWR VGND sky130_ef_sc_hd__decap_12
XPHY_EDGE_ROW_195_Left_450 VGND VGND VPWR VPWR sky130_fd_sc_hd__decap_3
XFILLER_168_1133 VGND VGND VPWR VPWR sky130_fd_sc_hd__decap_6
XFILLER_253_553 VGND VGND VPWR VPWR sky130_fd_sc_hd__decap_6
XFILLER_20_1251 VPWR VGND VPWR VGND sky130_ef_sc_hd__decap_12
XFILLER_214_918 VGND VGND VPWR VPWR sky130_fd_sc_hd__decap_6
XFILLER_226_789 VGND VGND VPWR VPWR sky130_fd_sc_hd__decap_6
XFILLER_0_1345 VPWR VGND VPWR VGND sky130_ef_sc_hd__decap_12
XFILLER_111_1390 VPWR VGND VPWR VGND sky130_ef_sc_hd__decap_12
XFILLER_111_39 VGND VGND VPWR VPWR sky130_fd_sc_hd__decap_4
XFILLER_179_811 VGND VGND VPWR VPWR sky130_fd_sc_hd__decap_6
XFILLER_0_1378 VGND VGND VPWR VPWR sky130_fd_sc_hd__decap_8
XFILLER_146_1442 VPWR VGND VPWR VGND sky130_ef_sc_hd__decap_12
XFILLER_244_1054 VPWR VGND VPWR VGND sky130_ef_sc_hd__decap_12
XFILLER_55_1347 VPWR VGND VPWR VGND sky130_ef_sc_hd__decap_12
XFILLER_90_1227 VPWR VGND VPWR VGND sky130_ef_sc_hd__decap_12
XFILLER_209_1174 VPWR VGND VPWR VGND sky130_ef_sc_hd__decap_12
XTAP_TAPCELL_ROW_216_3307 VGND VPWR sky130_fd_sc_hd__tapvpwrvgnd_1
XFILLER_142_1306 VGND VGND VPWR VPWR sky130_fd_sc_hd__decap_6
XTAP_TAPCELL_ROW_216_3318 VGND VPWR sky130_fd_sc_hd__tapvpwrvgnd_1
XTAP_TAPCELL_ROW_216_3329 VGND VPWR sky130_fd_sc_hd__tapvpwrvgnd_1
XFILLER_146_1497 VPWR VGND VPWR VGND sky130_ef_sc_hd__decap_12
XFILLER_181_1377 VPWR VGND VPWR VGND sky130_ef_sc_hd__decap_12
XFILLER_193_302 VPWR VGND VPWR VGND sky130_ef_sc_hd__decap_12
XFILLER_166_538 VPWR VGND VPWR VGND sky130_ef_sc_hd__decap_12
XFILLER_193_357 VPWR VGND VPWR VGND sky130_ef_sc_hd__decap_12
XFILLER_174_593 VPWR VGND VPWR VGND sky130_ef_sc_hd__decap_12
XFILLER_179_1284 VGND VGND VPWR VPWR sky130_fd_sc_hd__decap_6
XFILLER_20_58 VGND VGND VPWR VPWR sky130_fd_sc_hd__decap_6
XFILLER_1_916 VPWR VGND VPWR VGND sky130_ef_sc_hd__decap_12
XFILLER_136_58 VGND VGND VPWR VPWR sky130_fd_sc_hd__decap_6
XFILLER_66_1454 VPWR VGND VPWR VGND sky130_ef_sc_hd__decap_12
XFILLER_153_1402 VPWR VGND VPWR VGND sky130_ef_sc_hd__decap_12
XFILLER_251_1014 VPWR VGND VPWR VGND sky130_ef_sc_hd__decap_12
XPHY_EDGE_ROW_114_1_Right_770 VGND VGND VPWR VPWR sky130_fd_sc_hd__decap_3
XFILLER_192_1484 VPWR VGND VPWR VGND sky130_ef_sc_hd__decap_12
XFILLER_153_1457 VGND VGND VPWR VPWR sky130_fd_sc_hd__decap_6
XFILLER_251_1069 VGND VGND VPWR VPWR sky130_fd_sc_hd__decap_6
XFILLER_248_347 VPWR VGND VPWR VGND sky130_ef_sc_hd__decap_12
XFILLER_29_56 VGND VGND VPWR VPWR sky130_fd_sc_hd__fill_1
XFILLER_152_46 VPWR VGND VPWR VGND sky130_ef_sc_hd__decap_12
XFILLER_217_701 VPWR VGND VPWR VGND sky130_ef_sc_hd__decap_12
XFILLER_99_1230 VPWR VGND VPWR VGND sky130_ef_sc_hd__decap_12
XFILLER_229_572 VPWR VGND VPWR VGND sky130_ef_sc_hd__decap_12
XFILLER_244_531 VGND VGND VPWR VPWR sky130_fd_sc_hd__decap_6
XFILLER_112_1165 VPWR VGND VPWR VGND sky130_ef_sc_hd__decap_12
X_590_ net671 VGND VGND VPWR VPWR _072_ sky130_fd_sc_hd__inv_2
XFILLER_217_756 VPWR VGND VPWR VGND sky130_ef_sc_hd__decap_12
XFILLER_229_1506 VGND VGND VPWR VPWR sky130_fd_sc_hd__decap_8
XFILLER_99_1285 VGND VGND VPWR VPWR sky130_fd_sc_hd__decap_6
XFILLER_45_44 VGND VGND VPWR VPWR sky130_fd_sc_hd__decap_8
XFILLER_147_1206 VPWR VGND VPWR VGND sky130_ef_sc_hd__decap_12
XPHY_EDGE_ROW_50_2_Right_141 VGND VGND VPWR VPWR sky130_fd_sc_hd__decap_3
XTAP_TAPCELL_ROW_126_2_5671 VGND VPWR sky130_fd_sc_hd__tapvpwrvgnd_1
XFILLER_73_1414 VGND VGND VPWR VPWR sky130_fd_sc_hd__decap_6
XFILLER_213_940 VGND VGND VPWR VPWR sky130_fd_sc_hd__decap_6
XFILLER_227_1241 VGND VGND VPWR VPWR sky130_fd_sc_hd__decap_6
XFILLER_243_3 VPWR VGND VPWR VGND sky130_ef_sc_hd__decap_12
XFILLER_196_151 VPWR VGND VPWR VGND sky130_ef_sc_hd__decap_12
XTAP_TAPCELL_ROW_195_2580 VGND VPWR sky130_fd_sc_hd__tapvpwrvgnd_1
XTAP_TAPCELL_ROW_195_2591 VGND VPWR sky130_fd_sc_hd__tapvpwrvgnd_1
XTAP_TAPCELL_ROW_191_2433 VGND VPWR sky130_fd_sc_hd__tapvpwrvgnd_1
XFILLER_240_1441 VPWR VGND VPWR VGND sky130_ef_sc_hd__decap_12
XTAP_TAPCELL_ROW_191_2444 VGND VPWR sky130_fd_sc_hd__tapvpwrvgnd_1
XFILLER_184_335 VPWR VGND VPWR VGND sky130_ef_sc_hd__decap_12
XTAP_TAPCELL_ROW_191_2455 VGND VPWR sky130_fd_sc_hd__tapvpwrvgnd_1
XFILLER_200_667 VPWR VGND VPWR VGND sky130_ef_sc_hd__decap_12
XTAP_TAPCELL_ROW_118_2_5608 VGND VPWR sky130_fd_sc_hd__tapvpwrvgnd_1
XFILLER_123_1261 VPWR VGND VPWR VGND sky130_ef_sc_hd__decap_12
XFILLER_240_1496 VPWR VGND VPWR VGND sky130_ef_sc_hd__decap_12
XFILLER_172_519 VPWR VGND VPWR VGND sky130_ef_sc_hd__decap_12
XFILLER_177_87 VPWR VGND VPWR VGND sky130_ef_sc_hd__decap_12
XFILLER_32_1177 VGND VGND VPWR VPWR sky130_fd_sc_hd__decap_6
XTAP_TAPCELL_ROW_55_2_5100 VGND VPWR sky130_fd_sc_hd__tapvpwrvgnd_1
XFILLER_158_1313 VPWR VGND VPWR VGND sky130_ef_sc_hd__decap_12
XFILLER_67_1218 VPWR VGND VPWR VGND sky130_ef_sc_hd__decap_12
XFILLER_10_1442 VPWR VGND VPWR VGND sky130_ef_sc_hd__decap_12
XFILLER_192_390 VPWR VGND VPWR VGND sky130_ef_sc_hd__decap_12
XTAP_TAPCELL_ROW_42_2_4998 VGND VPWR sky130_fd_sc_hd__tapvpwrvgnd_1
XFILLER_158_1368 VPWR VGND VPWR VGND sky130_ef_sc_hd__decap_12
XFILLER_193_1248 VPWR VGND VPWR VGND sky130_ef_sc_hd__decap_12
XFILLER_180_574 VGND VGND VPWR VPWR sky130_fd_sc_hd__decap_6
XTAP_TAPCELL_ROW_189_2362 VGND VPWR sky130_fd_sc_hd__tapvpwrvgnd_1
XTAP_TAPCELL_ROW_189_2373 VGND VPWR sky130_fd_sc_hd__tapvpwrvgnd_1
XFILLER_10_1497 VPWR VGND VPWR VGND sky130_ef_sc_hd__decap_12
XTAP_TAPCELL_ROW_185_2215 VGND VPWR sky130_fd_sc_hd__tapvpwrvgnd_1
XTAP_TAPCELL_ROW_189_2384 VGND VPWR sky130_fd_sc_hd__tapvpwrvgnd_1
XTAP_TAPCELL_ROW_185_2226 VGND VPWR sky130_fd_sc_hd__tapvpwrvgnd_1
XTAP_TAPCELL_ROW_22_2_4841 VGND VPWR sky130_fd_sc_hd__tapvpwrvgnd_1
XTAP_TAPCELL_ROW_185_2237 VGND VPWR sky130_fd_sc_hd__tapvpwrvgnd_1
XTAP_TAPCELL_ROW_185_2248 VGND VPWR sky130_fd_sc_hd__tapvpwrvgnd_1
XFILLER_239_314 VPWR VGND VPWR VGND sky130_ef_sc_hd__decap_12
XFILLER_230_1109 VPWR VGND VPWR VGND sky130_ef_sc_hd__decap_12
XFILLER_239_369 VPWR VGND VPWR VGND sky130_ef_sc_hd__decap_12
XFILLER_43_1273 VPWR VGND VPWR VGND sky130_ef_sc_hd__decap_12
XFILLER_169_1420 VPWR VGND VPWR VGND sky130_ef_sc_hd__decap_12
XFILLER_208_734 VPWR VGND VPWR VGND sky130_ef_sc_hd__decap_12
XPHY_EDGE_ROW_127_2_Right_218 VGND VGND VPWR VPWR sky130_fd_sc_hd__decap_3
XFILLER_78_1325 VPWR VGND VPWR VGND sky130_ef_sc_hd__decap_12
XFILLER_235_553 VGND VGND VPWR VPWR sky130_fd_sc_hd__decap_6
XTAP_TAPCELL_ROW_179_2008 VGND VPWR sky130_fd_sc_hd__tapvpwrvgnd_1
XFILLER_169_1475 VPWR VGND VPWR VGND sky130_ef_sc_hd__decap_12
XTAP_TAPCELL_ROW_179_2019 VGND VPWR sky130_fd_sc_hd__tapvpwrvgnd_1
XFILLER_208_789 VGND VGND VPWR VPWR sky130_fd_sc_hd__decap_6
XFILLER_241_1205 VPWR VGND VPWR VGND sky130_ef_sc_hd__decap_12
XFILLER_210_409 VPWR VGND VPWR VGND sky130_ef_sc_hd__decap_12
XFILLER_52_1509 VGND VGND VPWR VPWR sky130_fd_sc_hd__decap_6
XFILLER_206_1336 VPWR VGND VPWR VGND sky130_ef_sc_hd__decap_12
XTAP_TAPCELL_ROW_234_3930 VGND VPWR sky130_fd_sc_hd__tapvpwrvgnd_1
XFILLER_175_302 VPWR VGND VPWR VGND sky130_ef_sc_hd__decap_12
XFILLER_89_3 VPWR VGND VPWR VGND sky130_ef_sc_hd__decap_12
XFILLER_187_173 VPWR VGND VPWR VGND sky130_ef_sc_hd__decap_12
XFILLER_230_280 VPWR VGND VPWR VGND sky130_ef_sc_hd__decap_12
XTAP_TAPCELL_ROW_234_3941 VGND VPWR sky130_fd_sc_hd__tapvpwrvgnd_1
XTAP_TAPCELL_ROW_234_3952 VGND VPWR sky130_fd_sc_hd__tapvpwrvgnd_1
XFILLER_54_1380 VPWR VGND VPWR VGND sky130_ef_sc_hd__decap_12
XTAP_TAPCELL_ROW_234_3963 VGND VPWR sky130_fd_sc_hd__tapvpwrvgnd_1
XTAP_TAPCELL_ROW_230_3805 VGND VPWR sky130_fd_sc_hd__tapvpwrvgnd_1
XTAP_TAPCELL_ROW_230_3816 VGND VPWR sky130_fd_sc_hd__tapvpwrvgnd_1
XFILLER_175_357 VPWR VGND VPWR VGND sky130_ef_sc_hd__decap_12
XFILLER_89_1421 VPWR VGND VPWR VGND sky130_ef_sc_hd__decap_12
XFILLER_11_1206 VPWR VGND VPWR VGND sky130_ef_sc_hd__decap_12
XFILLER_190_316 VGND VGND VPWR VPWR sky130_fd_sc_hd__decap_6
XFILLER_239_1112 VGND VGND VPWR VPWR sky130_fd_sc_hd__decap_6
Xmax_cap201 _188_ VGND VGND VPWR VPWR net201 sky130_fd_sc_hd__clkbuf_1
XFILLER_102_1356 VPWR VGND VPWR VGND sky130_ef_sc_hd__decap_12
Xmax_cap212 _172_ VGND VGND VPWR VPWR net212 sky130_fd_sc_hd__clkbuf_1
Xwire490 net491 VGND VGND VPWR VPWR net490 sky130_fd_sc_hd__clkbuf_1
XFILLER_89_1476 VPWR VGND VPWR VGND sky130_ef_sc_hd__decap_12
XFILLER_237_68 VPWR VGND VPWR VGND sky130_ef_sc_hd__decap_12
XFILLER_171_541 VPWR VGND VPWR VGND sky130_ef_sc_hd__decap_12
Xmax_cap245 net246 VGND VGND VPWR VPWR net245 sky130_fd_sc_hd__clkbuf_1
XTAP_TAPCELL_ROW_228_3723 VGND VPWR sky130_fd_sc_hd__tapvpwrvgnd_1
XFILLER_252_1312 VPWR VGND VPWR VGND sky130_ef_sc_hd__decap_12
XFILLER_171_596 VGND VGND VPWR VPWR sky130_fd_sc_hd__decap_6
XFILLER_217_1432 VPWR VGND VPWR VGND sky130_ef_sc_hd__decap_12
XTAP_TAPCELL_ROW_228_3734 VGND VPWR sky130_fd_sc_hd__tapvpwrvgnd_1
XTAP_TAPCELL_ROW_228_3745 VGND VPWR sky130_fd_sc_hd__tapvpwrvgnd_1
XFILLER_48_1184 VPWR VGND VPWR VGND sky130_ef_sc_hd__decap_12
XTAP_TAPCELL_ROW_163_2_5967 VGND VPWR sky130_fd_sc_hd__tapvpwrvgnd_1
XFILLER_170_1023 VPWR VGND VPWR VGND sky130_ef_sc_hd__decap_12
XTAP_TAPCELL_ROW_224_3609 VGND VPWR sky130_fd_sc_hd__tapvpwrvgnd_1
XFILLER_253_56 VPWR VGND VPWR VGND sky130_ef_sc_hd__decap_12
XFILLER_252_1367 VPWR VGND VPWR VGND sky130_ef_sc_hd__decap_12
XFILLER_217_1487 VPWR VGND VPWR VGND sky130_ef_sc_hd__decap_12
XFILLER_135_1165 VPWR VGND VPWR VGND sky130_ef_sc_hd__decap_12
XTAP_TAPCELL_ROW_99_2_5453 VGND VPWR sky130_fd_sc_hd__tapvpwrvgnd_1
XFILLER_170_1078 VPWR VGND VPWR VGND sky130_ef_sc_hd__decap_12
XFILLER_22_1313 VPWR VGND VPWR VGND sky130_ef_sc_hd__decap_12
XFILLER_226_531 VGND VGND VPWR VPWR sky130_fd_sc_hd__decap_6
XFILLER_254_851 VPWR VGND VPWR VGND sky130_ef_sc_hd__decap_12
XFILLER_22_1368 VPWR VGND VPWR VGND sky130_ef_sc_hd__decap_12
XFILLER_199_928 VPWR VGND VPWR VGND sky130_ef_sc_hd__decap_12
XFILLER_107_1201 VGND VGND VPWR VPWR sky130_fd_sc_hd__decap_4
XFILLER_178_151 VPWR VGND VPWR VGND sky130_ef_sc_hd__decap_12
XFILLER_55_1177 VPWR VGND VPWR VGND sky130_ef_sc_hd__decap_12
XPHY_EDGE_ROW_137_2_Left_639 VGND VGND VPWR VPWR sky130_fd_sc_hd__decap_3
XFILLER_146_1294 VPWR VGND VPWR VGND sky130_ef_sc_hd__decap_12
XFILLER_181_1174 VPWR VGND VPWR VGND sky130_ef_sc_hd__decap_12
XFILLER_166_335 VPWR VGND VPWR VGND sky130_ef_sc_hd__decap_12
XFILLER_33_1464 VPWR VGND VPWR VGND sky130_ef_sc_hd__decap_12
XFILLER_31_35 VGND VGND VPWR VPWR sky130_fd_sc_hd__fill_1
XFILLER_193_154 VPWR VGND VPWR VGND sky130_ef_sc_hd__decap_12
XFILLER_120_1423 VPWR VGND VPWR VGND sky130_ef_sc_hd__decap_12
XFILLER_182_839 VPWR VGND VPWR VGND sky130_ef_sc_hd__decap_12
XTAP_TAPCELL_ROW_27_2_4878 VGND VPWR sky130_fd_sc_hd__tapvpwrvgnd_1
XFILLER_181_338 VGND VGND VPWR VPWR sky130_fd_sc_hd__decap_6
XFILLER_174_390 VPWR VGND VPWR VGND sky130_ef_sc_hd__decap_12
XFILLER_120_1478 VGND VGND VPWR VPWR sky130_fd_sc_hd__decap_6
XFILLER_147_68 VGND VGND VPWR VPWR sky130_fd_sc_hd__decap_3
XFILLER_218_1207 VPWR VGND VPWR VGND sky130_ef_sc_hd__decap_12
XFILLER_190_894 VPWR VGND VPWR VGND sky130_ef_sc_hd__decap_12
Xoutput46 net546 VGND VGND VPWR VPWR acc_out[12] sky130_fd_sc_hd__buf_2
XFILLER_66_1251 VPWR VGND VPWR VGND sky130_ef_sc_hd__decap_12
Xoutput57 net57 VGND VGND VPWR VPWR acc_out[22] sky130_fd_sc_hd__buf_2
Xoutput68 net562 VGND VGND VPWR VPWR acc_out[3] sky130_fd_sc_hd__buf_2
XFILLER_0_223 VGND VGND VPWR VPWR sky130_fd_sc_hd__decap_8
XFILLER_157_1390 VPWR VGND VPWR VGND sky130_ef_sc_hd__decap_12
XFILLER_192_1281 VPWR VGND VPWR VGND sky130_ef_sc_hd__decap_12
XFILLER_163_56 VPWR VGND VPWR VGND sky130_ef_sc_hd__decap_12
XTAP_TAPCELL_ROW_244_4281 VGND VPWR sky130_fd_sc_hd__tapvpwrvgnd_1
XPHY_EDGE_ROW_115_1_Right_771 VGND VGND VPWR VPWR sky130_fd_sc_hd__decap_3
XTAP_TAPCELL_ROW_244_4292 VGND VPWR sky130_fd_sc_hd__tapvpwrvgnd_1
XFILLER_248_144 VGND VGND VPWR VPWR sky130_fd_sc_hd__decap_6
XFILLER_114_1227 VPWR VGND VPWR VGND sky130_ef_sc_hd__decap_12
XFILLER_193_3 VPWR VGND VPWR VGND sky130_ef_sc_hd__decap_12
XFILLER_237_818 VPWR VGND VPWR VGND sky130_ef_sc_hd__decap_12
XFILLER_249_689 VPWR VGND VPWR VGND sky130_ef_sc_hd__decap_12
XTAP_TAPCELL_ROW_240_4145 VGND VPWR sky130_fd_sc_hd__tapvpwrvgnd_1
XTAP_TAPCELL_ROW_240_4156 VGND VPWR sky130_fd_sc_hd__tapvpwrvgnd_1
XTAP_TAPCELL_ROW_240_4167 VGND VPWR sky130_fd_sc_hd__tapvpwrvgnd_1
XFILLER_40_1435 VGND VGND VPWR VPWR sky130_fd_sc_hd__decap_6
X_642_ clknet_3_0__leaf_clk acc_core.adder.cla_blocks\[2\].block.sum\[0\] _050_ VGND
+ VGND VPWR VPWR net73 sky130_fd_sc_hd__dfrtp_1
XFILLER_56_65 VGND VGND VPWR VPWR sky130_fd_sc_hd__decap_6
XFILLER_217_553 VGND VGND VPWR VPWR sky130_fd_sc_hd__decap_6
XFILLER_229_1303 VPWR VGND VPWR VGND sky130_ef_sc_hd__decap_12
XFILLER_245_873 VPWR VGND VPWR VGND sky130_ef_sc_hd__decap_12
XTAP_TAPCELL_ROW_6_1070 VGND VPWR sky130_fd_sc_hd__tapvpwrvgnd_1
XTAP_TAPCELL_ROW_6_1081 VGND VPWR sky130_fd_sc_hd__tapvpwrvgnd_1
XTAP_TAPCELL_ROW_6_1092 VGND VPWR sky130_fd_sc_hd__tapvpwrvgnd_1
X_573_ net667 VGND VGND VPWR VPWR _055_ sky130_fd_sc_hd__inv_2
XFILLER_229_1358 VPWR VGND VPWR VGND sky130_ef_sc_hd__decap_12
XPHY_EDGE_ROW_51_2_Right_142 VGND VGND VPWR VPWR sky130_fd_sc_hd__decap_3
XTAP_TAPCELL_ROW_197_2642 VGND VPWR sky130_fd_sc_hd__tapvpwrvgnd_1
XTAP_TAPCELL_ROW_197_2653 VGND VPWR sky130_fd_sc_hd__tapvpwrvgnd_1
XTAP_TAPCELL_ROW_238_4074 VGND VPWR sky130_fd_sc_hd__tapvpwrvgnd_1
XTAP_TAPCELL_ROW_197_2664 VGND VPWR sky130_fd_sc_hd__tapvpwrvgnd_1
XTAP_TAPCELL_ROW_238_4085 VGND VPWR sky130_fd_sc_hd__tapvpwrvgnd_1
XTAP_TAPCELL_ROW_193_2506 VGND VPWR sky130_fd_sc_hd__tapvpwrvgnd_1
XTAP_TAPCELL_ROW_238_4096 VGND VPWR sky130_fd_sc_hd__tapvpwrvgnd_1
XFILLER_242_1514 VGND VGND VPWR VPWR sky130_fd_sc_hd__fill_1
XTAP_TAPCELL_ROW_193_2517 VGND VPWR sky130_fd_sc_hd__tapvpwrvgnd_1
XFILLER_198_961 VGND VGND VPWR VPWR sky130_fd_sc_hd__decap_6
XTAP_TAPCELL_ROW_193_2528 VGND VPWR sky130_fd_sc_hd__tapvpwrvgnd_1
XFILLER_212_280 VPWR VGND VPWR VGND sky130_ef_sc_hd__decap_12
XFILLER_34_1239 VPWR VGND VPWR VGND sky130_ef_sc_hd__decap_12
XFILLER_169_173 VPWR VGND VPWR VGND sky130_ef_sc_hd__decap_12
XFILLER_199_1413 VGND VGND VPWR VPWR sky130_fd_sc_hd__decap_6
XFILLER_8_323 VGND VGND VPWR VPWR sky130_fd_sc_hd__decap_4
XFILLER_125_1378 VPWR VGND VPWR VGND sky130_ef_sc_hd__decap_12
XFILLER_184_132 VPWR VGND VPWR VGND sky130_ef_sc_hd__decap_12
XFILLER_200_464 VPWR VGND VPWR VGND sky130_ef_sc_hd__decap_12
Xclkbuf_3_1__f_clk clknet_0_clk VGND VGND VPWR VPWR clknet_3_1__leaf_clk sky130_fd_sc_hd__clkbuf_16
XFILLER_240_1293 VPWR VGND VPWR VGND sky130_ef_sc_hd__decap_12
XFILLER_8_378 VGND VGND VPWR VPWR sky130_fd_sc_hd__fill_1
XFILLER_172_316 VGND VGND VPWR VPWR sky130_fd_sc_hd__decap_6
XFILLER_184_187 VGND VGND VPWR VPWR sky130_fd_sc_hd__decap_6
XFILLER_181_861 VPWR VGND VPWR VGND sky130_ef_sc_hd__decap_12
XFILLER_158_1165 VPWR VGND VPWR VGND sky130_ef_sc_hd__decap_12
XFILLER_193_1045 VPWR VGND VPWR VGND sky130_ef_sc_hd__decap_12
XFILLER_207_27 VPWR VGND VPWR VGND sky130_ef_sc_hd__decap_12
XTAP_TAPCELL_ROW_12_1_1248 VGND VPWR sky130_fd_sc_hd__tapvpwrvgnd_1
XTAP_TAPCELL_ROW_148_2_5847 VGND VPWR sky130_fd_sc_hd__tapvpwrvgnd_1
XFILLER_10_1294 VPWR VGND VPWR VGND sky130_ef_sc_hd__decap_12
XTAP_TAPCELL_ROW_117_2_5594 VGND VPWR sky130_fd_sc_hd__tapvpwrvgnd_1
XFILLER_45_1335 VPWR VGND VPWR VGND sky130_ef_sc_hd__decap_12
XFILLER_239_111 VPWR VGND VPWR VGND sky130_ef_sc_hd__decap_12
XFILLER_136_1485 VPWR VGND VPWR VGND sky130_ef_sc_hd__decap_12
XFILLER_223_15 VPWR VGND VPWR VGND sky130_ef_sc_hd__decap_12
XFILLER_234_1097 VPWR VGND VPWR VGND sky130_ef_sc_hd__decap_12
XFILLER_239_166 VGND VGND VPWR VPWR sky130_fd_sc_hd__decap_6
XFILLER_132_1349 VGND VGND VPWR VPWR sky130_fd_sc_hd__decap_6
XFILLER_208_531 VGND VGND VPWR VPWR sky130_fd_sc_hd__decap_6
XFILLER_236_851 VPWR VGND VPWR VGND sky130_ef_sc_hd__decap_12
XPHY_EDGE_ROW_128_2_Right_219 VGND VGND VPWR VPWR sky130_fd_sc_hd__decap_3
XFILLER_169_1272 VPWR VGND VPWR VGND sky130_ef_sc_hd__decap_12
XFILLER_165_1114 VPWR VGND VPWR VGND sky130_ef_sc_hd__decap_12
XFILLER_21_1390 VPWR VGND VPWR VGND sky130_ef_sc_hd__decap_12
XFILLER_78_1177 VGND VGND VPWR VPWR sky130_fd_sc_hd__decap_6
XFILLER_251_854 VGND VGND VPWR VPWR sky130_fd_sc_hd__decap_6
XFILLER_165_1147 VGND VGND VPWR VPWR sky130_fd_sc_hd__decap_8
XFILLER_56_1442 VPWR VGND VPWR VGND sky130_ef_sc_hd__decap_12
XPHY_EDGE_ROW_72_1_Left_327 VGND VGND VPWR VPWR sky130_fd_sc_hd__decap_3
XFILLER_210_206 VPWR VGND VPWR VGND sky130_ef_sc_hd__decap_12
XFILLER_241_1002 VPWR VGND VPWR VGND sky130_ef_sc_hd__decap_12
XFILLER_52_1306 VGND VGND VPWR VPWR sky130_fd_sc_hd__decap_6
XFILLER_189_983 VGND VGND VPWR VPWR sky130_fd_sc_hd__decap_6
XFILLER_206_1133 VGND VGND VPWR VPWR sky130_fd_sc_hd__decap_6
XFILLER_56_1497 VPWR VGND VPWR VGND sky130_ef_sc_hd__decap_12
XFILLER_143_1445 VPWR VGND VPWR VGND sky130_ef_sc_hd__decap_12
XTAP_TAPCELL_ROW_13_2_4764 VGND VPWR sky130_fd_sc_hd__tapvpwrvgnd_1
XFILLER_241_1057 VPWR VGND VPWR VGND sky130_ef_sc_hd__decap_12
XFILLER_248_34 VPWR VGND VPWR VGND sky130_ef_sc_hd__decap_12
XFILLER_175_154 VPWR VGND VPWR VGND sky130_ef_sc_hd__decap_12
XFILLER_178_1508 VGND VGND VPWR VPWR sky130_fd_sc_hd__decap_6
XFILLER_191_603 VPWR VGND VPWR VGND sky130_ef_sc_hd__decap_12
XFILLER_248_89 VPWR VGND VPWR VGND sky130_ef_sc_hd__decap_12
XFILLER_191_658 VPWR VGND VPWR VGND sky130_ef_sc_hd__decap_12
XFILLER_89_1273 VPWR VGND VPWR VGND sky130_ef_sc_hd__decap_12
XFILLER_117_27 VPWR VGND VPWR VGND sky130_ef_sc_hd__decap_12
XFILLER_172_894 VPWR VGND VPWR VGND sky130_ef_sc_hd__decap_12
XFILLER_63_1402 VPWR VGND VPWR VGND sky130_ef_sc_hd__decap_12
XFILLER_137_1249 VPWR VGND VPWR VGND sky130_ef_sc_hd__decap_12
XFILLER_252_1164 VPWR VGND VPWR VGND sky130_ef_sc_hd__decap_12
XFILLER_63_1457 VGND VGND VPWR VPWR sky130_fd_sc_hd__decap_6
XFILLER_217_1284 VGND VGND VPWR VPWR sky130_fd_sc_hd__decap_6
XFILLER_219_818 VPWR VGND VPWR VGND sky130_ef_sc_hd__decap_12
XFILLER_133_15 VPWR VGND VPWR VGND sky130_ef_sc_hd__decap_12
XFILLER_98_1509 VGND VGND VPWR VPWR sky130_fd_sc_hd__decap_6
XFILLER_246_648 VPWR VGND VPWR VGND sky130_ef_sc_hd__decap_12
XFILLER_230_1484 VPWR VGND VPWR VGND sky130_ef_sc_hd__decap_12
XFILLER_2_1226 VPWR VGND VPWR VGND sky130_ef_sc_hd__decap_12
XFILLER_22_1165 VPWR VGND VPWR VGND sky130_ef_sc_hd__decap_12
XFILLER_227_873 VPWR VGND VPWR VGND sky130_ef_sc_hd__decap_12
XFILLER_242_832 VGND VGND VPWR VPWR sky130_fd_sc_hd__decap_6
XFILLER_57_1206 VPWR VGND VPWR VGND sky130_ef_sc_hd__decap_12
XFILLER_199_725 VGND VGND VPWR VPWR sky130_fd_sc_hd__decap_6
XFILLER_148_1356 VPWR VGND VPWR VGND sky130_ef_sc_hd__decap_12
XTAP_TAPCELL_ROW_200_2760 VGND VPWR sky130_fd_sc_hd__tapvpwrvgnd_1
XTAP_TAPCELL_ROW_200_2771 VGND VPWR sky130_fd_sc_hd__tapvpwrvgnd_1
XFILLER_228_1391 VGND VGND VPWR VPWR sky130_fd_sc_hd__decap_6
XFILLER_201_228 VPWR VGND VPWR VGND sky130_ef_sc_hd__decap_12
XTAP_TAPCELL_ROW_252_4561 VGND VPWR sky130_fd_sc_hd__tapvpwrvgnd_1
XFILLER_42_34 VPWR VGND VPWR VGND sky130_ef_sc_hd__decap_12
XTAP_TAPCELL_ROW_252_4572 VGND VPWR sky130_fd_sc_hd__tapvpwrvgnd_1
XTAP_TAPCELL_ROW_252_4583 VGND VPWR sky130_fd_sc_hd__tapvpwrvgnd_1
XFILLER_158_34 VPWR VGND VPWR VGND sky130_ef_sc_hd__decap_12
XFILLER_166_132 VPWR VGND VPWR VGND sky130_ef_sc_hd__decap_12
XFILLER_194_452 VPWR VGND VPWR VGND sky130_ef_sc_hd__decap_12
XFILLER_33_1261 VPWR VGND VPWR VGND sky130_ef_sc_hd__decap_12
XTAP_TAPCELL_ROW_91_2_5393 VGND VPWR sky130_fd_sc_hd__tapvpwrvgnd_1
XFILLER_120_1220 VGND VGND VPWR VPWR sky130_fd_sc_hd__decap_6
XFILLER_5_315 VGND VGND VPWR VPWR sky130_fd_sc_hd__fill_1
XFILLER_166_187 VGND VGND VPWR VPWR sky130_fd_sc_hd__decap_6
XFILLER_182_636 VPWR VGND VPWR VGND sky130_ef_sc_hd__decap_12
XTAP_TAPCELL_ROW_134_2_5733 VGND VPWR sky130_fd_sc_hd__tapvpwrvgnd_1
XFILLER_68_1313 VPWR VGND VPWR VGND sky130_ef_sc_hd__decap_12
XFILLER_206_3 VPWR VGND VPWR VGND sky130_ef_sc_hd__decap_12
XFILLER_218_1004 VGND VGND VPWR VPWR sky130_fd_sc_hd__decap_6
XFILLER_174_22 VPWR VGND VPWR VGND sky130_ef_sc_hd__decap_12
XFILLER_68_1368 VPWR VGND VPWR VGND sky130_ef_sc_hd__decap_12
XFILLER_155_1316 VPWR VGND VPWR VGND sky130_ef_sc_hd__decap_12
XFILLER_190_1207 VPWR VGND VPWR VGND sky130_ef_sc_hd__decap_12
XTAP_TAPCELL_ROW_246_4354 VGND VPWR sky130_fd_sc_hd__tapvpwrvgnd_1
XFILLER_190_691 VPWR VGND VPWR VGND sky130_ef_sc_hd__decap_12
XTAP_TAPCELL_ROW_246_4365 VGND VPWR sky130_fd_sc_hd__tapvpwrvgnd_1
XTAP_TAPCELL_ROW_246_4376 VGND VPWR sky130_fd_sc_hd__tapvpwrvgnd_1
XFILLER_174_77 VPWR VGND VPWR VGND sky130_ef_sc_hd__decap_12
XFILLER_194_1398 VPWR VGND VPWR VGND sky130_ef_sc_hd__decap_12
XTAP_TAPCELL_ROW_242_4218 VGND VPWR sky130_fd_sc_hd__tapvpwrvgnd_1
XTAP_TAPCELL_ROW_242_4229 VGND VPWR sky130_fd_sc_hd__tapvpwrvgnd_1
XFILLER_3_39 VGND VGND VPWR VPWR sky130_fd_sc_hd__decap_4
XFILLER_249_431 VPWR VGND VPWR VGND sky130_ef_sc_hd__decap_12
XTAP_TAPCELL_ROW_37_2_4960 VGND VPWR sky130_fd_sc_hd__tapvpwrvgnd_1
XTAP_TAPCELL_ROW_52_2_5077 VGND VPWR sky130_fd_sc_hd__tapvpwrvgnd_1
XFILLER_1_598 VGND VGND VPWR VPWR sky130_fd_sc_hd__fill_1
XFILLER_237_615 VPWR VGND VPWR VGND sky130_ef_sc_hd__decap_12
XPHY_EDGE_ROW_116_1_Right_772 VGND VGND VPWR VPWR sky130_fd_sc_hd__decap_3
XFILLER_231_1248 VPWR VGND VPWR VGND sky130_ef_sc_hd__decap_12
XFILLER_249_486 VPWR VGND VPWR VGND sky130_ef_sc_hd__decap_12
XTAP_TAPCELL_ROW_8_1143 VGND VPWR sky130_fd_sc_hd__tapvpwrvgnd_1
XTAP_TAPCELL_ROW_8_1154 VGND VPWR sky130_fd_sc_hd__tapvpwrvgnd_1
XFILLER_190_65 VPWR VGND VPWR VGND sky130_ef_sc_hd__decap_12
XTAP_TAPCELL_ROW_8_1165 VGND VPWR sky130_fd_sc_hd__tapvpwrvgnd_1
XTAP_TAPCELL_ROW_4_1007 VGND VPWR sky130_fd_sc_hd__tapvpwrvgnd_1
XFILLER_218_851 VPWR VGND VPWR VGND sky130_ef_sc_hd__decap_12
XTAP_TAPCELL_ROW_4_1018 VGND VPWR sky130_fd_sc_hd__tapvpwrvgnd_1
XFILLER_131_1371 VGND VGND VPWR VPWR sky130_fd_sc_hd__decap_6
XTAP_TAPCELL_ROW_199_2704 VGND VPWR sky130_fd_sc_hd__tapvpwrvgnd_1
XTAP_TAPCELL_ROW_4_1029 VGND VPWR sky130_fd_sc_hd__tapvpwrvgnd_1
XTAP_TAPCELL_ROW_199_2715 VGND VPWR sky130_fd_sc_hd__tapvpwrvgnd_1
XTAP_TAPCELL_ROW_199_2726 VGND VPWR sky130_fd_sc_hd__tapvpwrvgnd_1
XFILLER_229_1100 VPWR VGND VPWR VGND sky130_ef_sc_hd__decap_12
XFILLER_245_670 VPWR VGND VPWR VGND sky130_ef_sc_hd__decap_12
X_625_ clknet_3_5__leaf_clk dout0\[23\] _033_ VGND VGND VPWR VPWR dout0_q\[23\] sky130_fd_sc_hd__dfrtp_1
XTAP_TAPCELL_ROW_199_2737 VGND VPWR sky130_fd_sc_hd__tapvpwrvgnd_1
XFILLER_79_1464 VPWR VGND VPWR VGND sky130_ef_sc_hd__decap_12
XFILLER_166_1434 VGND VGND VPWR VPWR sky130_fd_sc_hd__decap_6
XFILLER_75_1328 VGND VGND VPWR VPWR sky130_fd_sc_hd__decap_6
XFILLER_229_1155 VGND VGND VPWR VPWR sky130_fd_sc_hd__decap_6
XFILLER_233_854 VGND VGND VPWR VPWR sky130_fd_sc_hd__decap_6
XTAP_TAPCELL_ROW_30_2_4903 VGND VPWR sky130_fd_sc_hd__tapvpwrvgnd_1
X_556_ net671 VGND VGND VPWR VPWR _038_ sky130_fd_sc_hd__inv_2
XFILLER_207_1420 VPWR VGND VPWR VGND sky130_ef_sc_hd__decap_12
XPHY_EDGE_ROW_52_2_Right_143 VGND VGND VPWR VPWR sky130_fd_sc_hd__decap_3
X_487_ _122_ net87 net497 VGND VGND VPWR VPWR _250_ sky130_fd_sc_hd__a21o_1
XFILLER_242_1355 VPWR VGND VPWR VGND sky130_ef_sc_hd__decap_12
XFILLER_9_610 VPWR VGND VPWR VGND sky130_ef_sc_hd__decap_12
XFILLER_207_1475 VPWR VGND VPWR VGND sky130_ef_sc_hd__decap_12
XFILLER_9_643 VGND VGND VPWR VPWR sky130_fd_sc_hd__decap_8
XFILLER_8_120 VPWR VGND VPWR VGND sky130_ef_sc_hd__decap_12
XFILLER_200_261 VPWR VGND VPWR VGND sky130_ef_sc_hd__decap_12
XFILLER_173_603 VPWR VGND VPWR VGND sky130_ef_sc_hd__decap_12
XFILLER_185_474 VPWR VGND VPWR VGND sky130_ef_sc_hd__decap_12
XFILLER_240_1090 VGND VGND VPWR VPWR sky130_fd_sc_hd__decap_6
XFILLER_8_175 VGND VGND VPWR VPWR sky130_fd_sc_hd__fill_1
XFILLER_218_15 VGND VGND VPWR VPWR sky130_fd_sc_hd__decap_6
XFILLER_173_658 VPWR VGND VPWR VGND sky130_ef_sc_hd__decap_12
XFILLER_12_1356 VPWR VGND VPWR VGND sky130_ef_sc_hd__decap_12
XFILLER_86_1435 VGND VGND VPWR VPWR sky130_fd_sc_hd__decap_6
XFILLER_234_58 VGND VGND VPWR VPWR sky130_fd_sc_hd__decap_6
XTAP_TAPCELL_ROW_118_1_1407 VGND VPWR sky130_fd_sc_hd__tapvpwrvgnd_1
XFILLER_136_1282 VPWR VGND VPWR VGND sky130_ef_sc_hd__decap_12
XFILLER_171_1162 VPWR VGND VPWR VGND sky130_ef_sc_hd__decap_12
XFILLER_255_412 VGND VGND VPWR VPWR sky130_fd_sc_hd__decap_8
XFILLER_228_648 VPWR VGND VPWR VGND sky130_ef_sc_hd__decap_12
XFILLER_110_1411 VPWR VGND VPWR VGND sky130_ef_sc_hd__decap_12
XFILLER_209_873 VPWR VGND VPWR VGND sky130_ef_sc_hd__decap_12
XFILLER_250_46 VPWR VGND VPWR VGND sky130_ef_sc_hd__decap_12
XFILLER_110_1466 VPWR VGND VPWR VGND sky130_ef_sc_hd__decap_12
XFILLER_224_832 VGND VGND VPWR VPWR sky130_fd_sc_hd__decap_6
XFILLER_145_1507 VGND VGND VPWR VPWR sky130_fd_sc_hd__decap_8
XFILLER_243_1119 VPWR VGND VPWR VGND sky130_ef_sc_hd__decap_12
XFILLER_17_1201 VGND VGND VPWR VPWR sky130_fd_sc_hd__decap_4
XFILLER_195_216 VPWR VGND VPWR VGND sky130_ef_sc_hd__decap_12
XFILLER_250_194 VPWR VGND VPWR VGND sky130_ef_sc_hd__decap_12
XFILLER_56_1294 VPWR VGND VPWR VGND sky130_ef_sc_hd__decap_12
XFILLER_143_1242 VGND VGND VPWR VPWR sky130_fd_sc_hd__decap_6
XTAP_TAPCELL_ROW_76_2_5273 VGND VPWR sky130_fd_sc_hd__tapvpwrvgnd_1
XFILLER_176_452 VPWR VGND VPWR VGND sky130_ef_sc_hd__decap_12
XTAP_TAPCELL_ROW_119_2_5613 VGND VPWR sky130_fd_sc_hd__tapvpwrvgnd_1
XFILLER_178_1305 VGND VGND VPWR VPWR sky130_fd_sc_hd__decap_6
XFILLER_191_400 VPWR VGND VPWR VGND sky130_ef_sc_hd__decap_12
XTAP_TAPCELL_ROW_176_1899 VGND VPWR sky130_fd_sc_hd__tapvpwrvgnd_1
XFILLER_30_1423 VPWR VGND VPWR VGND sky130_ef_sc_hd__decap_12
XFILLER_128_15 VGND VGND VPWR VPWR sky130_fd_sc_hd__decap_6
XFILLER_191_455 VPWR VGND VPWR VGND sky130_ef_sc_hd__decap_12
XFILLER_30_1478 VGND VGND VPWR VPWR sky130_fd_sc_hd__decap_6
XFILLER_254_1226 VPWR VGND VPWR VGND sky130_ef_sc_hd__decap_12
XFILLER_172_691 VPWR VGND VPWR VGND sky130_ef_sc_hd__decap_12
XFILLER_219_1346 VPWR VGND VPWR VGND sky130_ef_sc_hd__decap_12
XFILLER_67_1390 VPWR VGND VPWR VGND sky130_ef_sc_hd__decap_12
XTAP_TAPCELL_ROW_153_1_1459 VGND VPWR sky130_fd_sc_hd__tapvpwrvgnd_1
XFILLER_144_58 VGND VGND VPWR VPWR sky130_fd_sc_hd__decap_6
XFILLER_219_615 VPWR VGND VPWR VGND sky130_ef_sc_hd__decap_12
XFILLER_24_1227 VPWR VGND VPWR VGND sky130_ef_sc_hd__decap_12
Xfanout666 net672 VGND VGND VPWR VPWR net666 sky130_fd_sc_hd__buf_4
XFILLER_189_1401 VPWR VGND VPWR VGND sky130_ef_sc_hd__decap_12
XFILLER_98_1306 VGND VGND VPWR VPWR sky130_fd_sc_hd__decap_6
XFILLER_246_445 VGND VGND VPWR VPWR sky130_fd_sc_hd__decap_6
XFILLER_189_1456 VGND VGND VPWR VPWR sky130_fd_sc_hd__decap_6
XFILLER_2_1023 VPWR VGND VPWR VGND sky130_ef_sc_hd__decap_12
XFILLER_230_1281 VPWR VGND VPWR VGND sky130_ef_sc_hd__decap_12
XFILLER_160_46 VPWR VGND VPWR VGND sky130_ef_sc_hd__decap_12
XTAP_TAPCELL_ROW_202_2811 VGND VPWR sky130_fd_sc_hd__tapvpwrvgnd_1
XFILLER_227_670 VPWR VGND VPWR VGND sky130_ef_sc_hd__decap_12
XTAP_TAPCELL_ROW_206_2980 VGND VPWR sky130_fd_sc_hd__tapvpwrvgnd_1
XTAP_TAPCELL_ROW_202_2822 VGND VPWR sky130_fd_sc_hd__tapvpwrvgnd_1
XTAP_TAPCELL_ROW_202_2833 VGND VPWR sky130_fd_sc_hd__tapvpwrvgnd_1
XFILLER_2_1078 VPWR VGND VPWR VGND sky130_ef_sc_hd__decap_12
X_410_ _184_ net124 net207 VGND VGND VPWR VPWR _199_ sky130_fd_sc_hd__a21o_1
XFILLER_215_854 VGND VGND VPWR VPWR sky130_fd_sc_hd__decap_6
XTAP_TAPCELL_ROW_254_4634 VGND VPWR sky130_fd_sc_hd__tapvpwrvgnd_1
XFILLER_183_1033 VPWR VGND VPWR VGND sky130_ef_sc_hd__decap_12
XTAP_TAPCELL_ROW_254_4645 VGND VPWR sky130_fd_sc_hd__tapvpwrvgnd_1
XTAP_TAPCELL_ROW_254_4656 VGND VPWR sky130_fd_sc_hd__tapvpwrvgnd_1
XFILLER_156_3 VPWR VGND VPWR VGND sky130_ef_sc_hd__decap_12
XFILLER_53_44 VGND VGND VPWR VPWR sky130_fd_sc_hd__decap_6
X_341_ net595 net540 net572 VGND VGND VPWR VPWR _130_ sky130_fd_sc_hd__nand3_1
XTAP_TAPCELL_ROW_250_4509 VGND VPWR sky130_fd_sc_hd__tapvpwrvgnd_1
XFILLER_169_44 VPWR VGND VPWR VGND sky130_ef_sc_hd__decap_12
XFILLER_183_1088 VPWR VGND VPWR VGND sky130_ef_sc_hd__decap_12
XPHY_EDGE_ROW_18_2_Left_520 VGND VGND VPWR VPWR sky130_fd_sc_hd__decap_3
XFILLER_186_249 VPWR VGND VPWR VGND sky130_ef_sc_hd__decap_12
XFILLER_169_99 VPWR VGND VPWR VGND sky130_ef_sc_hd__decap_12
XFILLER_35_1378 VPWR VGND VPWR VGND sky130_ef_sc_hd__decap_12
XFILLER_122_1337 VPWR VGND VPWR VGND sky130_ef_sc_hd__decap_12
XFILLER_210_581 VPWR VGND VPWR VGND sky130_ef_sc_hd__decap_12
XFILLER_167_474 VPWR VGND VPWR VGND sky130_ef_sc_hd__decap_12
XFILLER_182_433 VPWR VGND VPWR VGND sky130_ef_sc_hd__decap_12
XFILLER_5_123 VGND VGND VPWR VPWR sky130_fd_sc_hd__decap_6
XTAP_TAPCELL_ROW_248_4427 VGND VPWR sky130_fd_sc_hd__tapvpwrvgnd_1
XTAP_TAPCELL_ROW_248_4438 VGND VPWR sky130_fd_sc_hd__tapvpwrvgnd_1
XTAP_TAPCELL_ROW_248_4449 VGND VPWR sky130_fd_sc_hd__tapvpwrvgnd_1
XFILLER_6_679 VGND VGND VPWR VPWR sky130_fd_sc_hd__decap_3
XFILLER_170_617 VGND VGND VPWR VPWR sky130_fd_sc_hd__decap_6
XFILLER_237_1413 VGND VGND VPWR VPWR sky130_fd_sc_hd__decap_6
XFILLER_182_488 VGND VGND VPWR VPWR sky130_fd_sc_hd__decap_6
XFILLER_185_87 VPWR VGND VPWR VGND sky130_ef_sc_hd__decap_12
XFILLER_194_1140 VPWR VGND VPWR VGND sky130_ef_sc_hd__decap_12
XFILLER_5_189 VGND VGND VPWR VPWR sky130_fd_sc_hd__decap_3
XFILLER_68_1165 VPWR VGND VPWR VGND sky130_ef_sc_hd__decap_12
XFILLER_190_1004 VGND VGND VPWR VPWR sky130_fd_sc_hd__decap_6
XFILLER_194_1195 VPWR VGND VPWR VGND sky130_ef_sc_hd__decap_12
XTAP_TAPCELL_ROW_164_2_5972 VGND VPWR sky130_fd_sc_hd__tapvpwrvgnd_1
XFILLER_2_874 VGND VGND VPWR VPWR sky130_fd_sc_hd__decap_6
XFILLER_155_1168 VPWR VGND VPWR VGND sky130_ef_sc_hd__decap_12
XFILLER_46_1485 VPWR VGND VPWR VGND sky130_ef_sc_hd__decap_12
XFILLER_133_1433 VPWR VGND VPWR VGND sky130_ef_sc_hd__decap_12
XFILLER_231_1045 VPWR VGND VPWR VGND sky130_ef_sc_hd__decap_12
XFILLER_237_412 VPWR VGND VPWR VGND sky130_ef_sc_hd__decap_12
XFILLER_249_283 VPWR VGND VPWR VGND sky130_ef_sc_hd__decap_12
XFILLER_42_1349 VGND VGND VPWR VPWR sky130_fd_sc_hd__decap_6
XPHY_EDGE_ROW_117_1_Right_773 VGND VGND VPWR VPWR sky130_fd_sc_hd__decap_3
XFILLER_238_968 VPWR VGND VPWR VGND sky130_ef_sc_hd__decap_12
XFILLER_133_1488 VPWR VGND VPWR VGND sky130_ef_sc_hd__decap_12
XFILLER_253_916 VPWR VGND VPWR VGND sky130_ef_sc_hd__decap_12
XFILLER_237_467 VGND VGND VPWR VPWR sky130_fd_sc_hd__decap_6
XFILLER_206_832 VGND VGND VPWR VPWR sky130_fd_sc_hd__decap_6
XFILLER_79_1261 VPWR VGND VPWR VGND sky130_ef_sc_hd__decap_12
XTAP_TAPCELL_ROW_156_2_5909 VGND VPWR sky130_fd_sc_hd__tapvpwrvgnd_1
X_608_ clknet_3_1__leaf_clk dout0\[6\] _016_ VGND VGND VPWR VPWR dout0_q\[6\] sky130_fd_sc_hd__dfrtp_1
X_539_ net668 VGND VGND VPWR VPWR _021_ sky130_fd_sc_hd__inv_2
XFILLER_177_216 VPWR VGND VPWR VGND sky130_ef_sc_hd__decap_12
XFILLER_220_323 VPWR VGND VPWR VGND sky130_ef_sc_hd__decap_12
XFILLER_232_194 VPWR VGND VPWR VGND sky130_ef_sc_hd__decap_12
XPHY_EDGE_ROW_53_2_Right_144 VGND VGND VPWR VPWR sky130_fd_sc_hd__decap_3
XFILLER_242_1152 VPWR VGND VPWR VGND sky130_ef_sc_hd__decap_12
XFILLER_53_1445 VPWR VGND VPWR VGND sky130_ef_sc_hd__decap_12
XFILLER_207_1272 VPWR VGND VPWR VGND sky130_ef_sc_hd__decap_12
XFILLER_220_378 VPWR VGND VPWR VGND sky130_ef_sc_hd__decap_12
XFILLER_173_400 VPWR VGND VPWR VGND sky130_ef_sc_hd__decap_12
XFILLER_71_3 VPWR VGND VPWR VGND sky130_ef_sc_hd__decap_12
XTAP_TAPCELL_ROW_28_2_4883 VGND VPWR sky130_fd_sc_hd__tapvpwrvgnd_1
XFILLER_185_271 VPWR VGND VPWR VGND sky130_ef_sc_hd__decap_12
XTAP_TAPCELL_ROW_171_1730 VGND VPWR sky130_fd_sc_hd__tapvpwrvgnd_1
XFILLER_173_455 VPWR VGND VPWR VGND sky130_ef_sc_hd__decap_12
XTAP_TAPCELL_ROW_171_1741 VGND VPWR sky130_fd_sc_hd__tapvpwrvgnd_1
XTAP_TAPCELL_ROW_212_3162 VGND VPWR sky130_fd_sc_hd__tapvpwrvgnd_1
XTAP_TAPCELL_ROW_171_1752 VGND VPWR sky130_fd_sc_hd__tapvpwrvgnd_1
XTAP_TAPCELL_ROW_212_3173 VGND VPWR sky130_fd_sc_hd__tapvpwrvgnd_1
XFILLER_255_1513 VGND VGND VPWR VPWR sky130_fd_sc_hd__fill_2
XFILLER_103_1292 VPWR VGND VPWR VGND sky130_ef_sc_hd__decap_12
XTAP_TAPCELL_ROW_212_3184 VGND VPWR sky130_fd_sc_hd__tapvpwrvgnd_1
XFILLER_216_1508 VGND VGND VPWR VPWR sky130_fd_sc_hd__decap_6
XFILLER_245_68 VPWR VGND VPWR VGND sky130_ef_sc_hd__decap_12
XFILLER_47_1249 VPWR VGND VPWR VGND sky130_ef_sc_hd__decap_12
XFILLER_134_1208 VPWR VGND VPWR VGND sky130_ef_sc_hd__decap_12
XTAP_TAPCELL_ROW_21_2_4826 VGND VPWR sky130_fd_sc_hd__tapvpwrvgnd_1
XFILLER_138_1399 VPWR VGND VPWR VGND sky130_ef_sc_hd__decap_12
XFILLER_151_1500 VGND VGND VPWR VPWR sky130_fd_sc_hd__decap_6
XFILLER_247_209 VGND VGND VPWR VPWR sky130_fd_sc_hd__decap_6
XTAP_TAPCELL_ROW_165_1501 VGND VPWR sky130_fd_sc_hd__tapvpwrvgnd_1
XTAP_TAPCELL_ROW_169_1670 VGND VPWR sky130_fd_sc_hd__tapvpwrvgnd_1
XTAP_TAPCELL_ROW_165_1512 VGND VPWR sky130_fd_sc_hd__tapvpwrvgnd_1
XTAP_TAPCELL_ROW_169_1681 VGND VPWR sky130_fd_sc_hd__tapvpwrvgnd_1
XPHY_EDGE_ROW_146_2_Left_648 VGND VGND VPWR VPWR sky130_fd_sc_hd__decap_3
XTAP_TAPCELL_ROW_165_1523 VGND VPWR sky130_fd_sc_hd__tapvpwrvgnd_1
XTAP_TAPCELL_ROW_165_1534 VGND VPWR sky130_fd_sc_hd__tapvpwrvgnd_1
XTAP_TAPCELL_ROW_165_1545 VGND VPWR sky130_fd_sc_hd__tapvpwrvgnd_1
XFILLER_228_445 VGND VGND VPWR VPWR sky130_fd_sc_hd__decap_6
XFILLER_255_253 VPWR VGND VPWR VGND sky130_ef_sc_hd__decap_12
XFILLER_209_670 VPWR VGND VPWR VGND sky130_ef_sc_hd__decap_12
XFILLER_255_286 VGND VGND VPWR VPWR sky130_fd_sc_hd__decap_8
XFILLER_244_949 VPWR VGND VPWR VGND sky130_ef_sc_hd__decap_12
XPHY_EDGE_ROW_16_1_Left_271 VGND VGND VPWR VPWR sky130_fd_sc_hd__decap_3
XFILLER_237_990 VPWR VGND VPWR VGND sky130_ef_sc_hd__decap_12
XFILLER_110_1263 VGND VGND VPWR VPWR sky130_fd_sc_hd__decap_6
XFILLER_58_1356 VPWR VGND VPWR VGND sky130_ef_sc_hd__decap_12
XFILLER_145_1304 VPWR VGND VPWR VGND sky130_ef_sc_hd__decap_12
XFILLER_208_1047 VGND VGND VPWR VPWR sky130_fd_sc_hd__decap_6
XFILLER_145_1359 VPWR VGND VPWR VGND sky130_ef_sc_hd__decap_12
XFILLER_211_345 VPWR VGND VPWR VGND sky130_ef_sc_hd__decap_12
XFILLER_168_249 VPWR VGND VPWR VGND sky130_ef_sc_hd__decap_12
Xwire308 net309 VGND VGND VPWR VPWR net308 sky130_fd_sc_hd__clkbuf_1
Xwire319 net320 VGND VGND VPWR VPWR net319 sky130_fd_sc_hd__clkbuf_1
XFILLER_30_1220 VGND VGND VPWR VPWR sky130_fd_sc_hd__decap_6
XFILLER_165_967 VPWR VGND VPWR VGND sky130_ef_sc_hd__decap_12
XFILLER_192_753 VPWR VGND VPWR VGND sky130_ef_sc_hd__decap_12
XFILLER_191_252 VGND VGND VPWR VPWR sky130_fd_sc_hd__decap_6
XFILLER_219_80 VGND VGND VPWR VPWR sky130_fd_sc_hd__decap_6
XFILLER_180_937 VPWR VGND VPWR VGND sky130_ef_sc_hd__decap_12
XFILLER_156_1411 VPWR VGND VPWR VGND sky130_ef_sc_hd__decap_12
XTAP_TAPCELL_ROW_149_2_5852 VGND VPWR sky130_fd_sc_hd__tapvpwrvgnd_1
XFILLER_254_1023 VPWR VGND VPWR VGND sky130_ef_sc_hd__decap_12
XFILLER_65_1316 VPWR VGND VPWR VGND sky130_ef_sc_hd__decap_12
XFILLER_219_1143 VPWR VGND VPWR VGND sky130_ef_sc_hd__decap_12
XFILLER_155_68 VGND VGND VPWR VPWR sky130_fd_sc_hd__decap_3
XFILLER_156_1466 VPWR VGND VPWR VGND sky130_ef_sc_hd__decap_12
XFILLER_191_1346 VPWR VGND VPWR VGND sky130_ef_sc_hd__decap_12
XFILLER_254_1078 VPWR VGND VPWR VGND sky130_ef_sc_hd__decap_12
XFILLER_219_1198 VGND VGND VPWR VPWR sky130_fd_sc_hd__decap_6
XFILLER_48_22 VPWR VGND VPWR VGND sky130_ef_sc_hd__decap_12
XFILLER_219_412 VPWR VGND VPWR VGND sky130_ef_sc_hd__decap_12
XFILLER_247_732 VPWR VGND VPWR VGND sky130_ef_sc_hd__decap_12
XTAP_TAPCELL_ROW_98_2_5449 VGND VPWR sky130_fd_sc_hd__tapvpwrvgnd_1
XFILLER_171_56 VPWR VGND VPWR VGND sky130_ef_sc_hd__decap_12
XTAP_TAPCELL_ROW_204_2906 VGND VPWR sky130_fd_sc_hd__tapvpwrvgnd_1
XFILLER_232_1398 VPWR VGND VPWR VGND sky130_ef_sc_hd__decap_12
XFILLER_235_916 VPWR VGND VPWR VGND sky130_ef_sc_hd__decap_12
XTAP_TAPCELL_ROW_67_2_5196 VGND VPWR sky130_fd_sc_hd__tapvpwrvgnd_1
XFILLER_219_467 VGND VGND VPWR VPWR sky130_fd_sc_hd__decap_6
XFILLER_247_787 VPWR VGND VPWR VGND sky130_ef_sc_hd__decap_12
XFILLER_41_1371 VGND VGND VPWR VPWR sky130_fd_sc_hd__decap_6
XTAP_TAPCELL_ROW_111_2_5553 VGND VPWR sky130_fd_sc_hd__tapvpwrvgnd_1
XTAP_TAPCELL_ROW_181_2081 VGND VPWR sky130_fd_sc_hd__tapvpwrvgnd_1
XTAP_TAPCELL_ROW_181_2092 VGND VPWR sky130_fd_sc_hd__tapvpwrvgnd_1
XFILLER_76_1423 VPWR VGND VPWR VGND sky130_ef_sc_hd__decap_12
XFILLER_64_65 VGND VGND VPWR VPWR sky130_fd_sc_hd__decap_6
XFILLER_243_971 VPWR VGND VPWR VGND sky130_ef_sc_hd__decap_12
XFILLER_76_1478 VGND VGND VPWR VPWR sky130_fd_sc_hd__decap_6
XFILLER_202_323 VPWR VGND VPWR VGND sky130_ef_sc_hd__decap_12
XFILLER_214_194 VPWR VGND VPWR VGND sky130_ef_sc_hd__decap_12
XTAP_TAPCELL_ROW_60_2_5139 VGND VPWR sky130_fd_sc_hd__tapvpwrvgnd_1
X_324_ net596 dout0_q\[24\] net59 VGND VGND VPWR VPWR _113_ sky130_fd_sc_hd__a21oi_1
XFILLER_202_378 VPWR VGND VPWR VGND sky130_ef_sc_hd__decap_12
XFILLER_126_1270 VPWR VGND VPWR VGND sky130_ef_sc_hd__decap_12
XFILLER_204_1434 VGND VGND VPWR VPWR sky130_fd_sc_hd__decap_6
XFILLER_167_271 VPWR VGND VPWR VGND sky130_ef_sc_hd__decap_12
XFILLER_182_230 VGND VGND VPWR VPWR sky130_fd_sc_hd__decap_6
Xmax_cap608 net609 VGND VGND VPWR VPWR net608 sky130_fd_sc_hd__clkbuf_1
XFILLER_171_904 VPWR VGND VPWR VGND sky130_ef_sc_hd__decap_12
XFILLER_183_775 VPWR VGND VPWR VGND sky130_ef_sc_hd__decap_12
Xmax_cap619 rd_addr\[0\] VGND VGND VPWR VPWR net619 sky130_fd_sc_hd__clkbuf_1
XFILLER_6_487 VGND VGND VPWR VPWR sky130_fd_sc_hd__fill_1
XFILLER_100_1454 VPWR VGND VPWR VGND sky130_ef_sc_hd__decap_12
XPHY_EDGE_ROW_144_1_Left_399 VGND VGND VPWR VPWR sky130_fd_sc_hd__decap_3
XFILLER_171_959 VPWR VGND VPWR VGND sky130_ef_sc_hd__decap_12
XFILLER_215_27 VPWR VGND VPWR VGND sky130_ef_sc_hd__decap_12
XFILLER_250_1410 VPWR VGND VPWR VGND sky130_ef_sc_hd__decap_12
XFILLER_229_209 VGND VGND VPWR VPWR sky130_fd_sc_hd__decap_6
XPHY_EDGE_ROW_81_1_Left_336 VGND VGND VPWR VPWR sky130_fd_sc_hd__decap_3
XFILLER_1_181 VGND VGND VPWR VPWR sky130_fd_sc_hd__fill_2
XFILLER_238_710 VPWR VGND VPWR VGND sky130_ef_sc_hd__decap_12
XFILLER_46_1282 VPWR VGND VPWR VGND sky130_ef_sc_hd__decap_12
XFILLER_133_1230 VPWR VGND VPWR VGND sky130_ef_sc_hd__decap_12
XFILLER_250_1465 VPWR VGND VPWR VGND sky130_ef_sc_hd__decap_12
XFILLER_238_765 VPWR VGND VPWR VGND sky130_ef_sc_hd__decap_12
XFILLER_42_1168 VPWR VGND VPWR VGND sky130_ef_sc_hd__decap_12
XFILLER_133_1285 VGND VGND VPWR VPWR sky130_fd_sc_hd__decap_6
XFILLER_253_713 VPWR VGND VPWR VGND sky130_ef_sc_hd__decap_12
XFILLER_20_1411 VPWR VGND VPWR VGND sky130_ef_sc_hd__decap_12
XPHY_EDGE_ROW_118_1_Right_774 VGND VGND VPWR VPWR sky130_fd_sc_hd__decap_3
XFILLER_231_15 VPWR VGND VPWR VGND sky130_ef_sc_hd__decap_12
XFILLER_226_949 VPWR VGND VPWR VGND sky130_ef_sc_hd__decap_12
XFILLER_219_990 VPWR VGND VPWR VGND sky130_ef_sc_hd__decap_12
XTAP_TAPCELL_ROW_220_3442 VGND VPWR sky130_fd_sc_hd__tapvpwrvgnd_1
XFILLER_168_1348 VGND VGND VPWR VPWR sky130_fd_sc_hd__decap_6
XTAP_TAPCELL_ROW_220_3453 VGND VPWR sky130_fd_sc_hd__tapvpwrvgnd_1
XFILLER_253_768 VGND VGND VPWR VPWR sky130_fd_sc_hd__decap_6
XTAP_TAPCELL_ROW_220_3464 VGND VPWR sky130_fd_sc_hd__tapvpwrvgnd_1
XFILLER_20_1466 VPWR VGND VPWR VGND sky130_ef_sc_hd__decap_12
XFILLER_55_1507 VGND VGND VPWR VPWR sky130_fd_sc_hd__decap_8
XFILLER_209_1334 VPWR VGND VPWR VGND sky130_ef_sc_hd__decap_12
XFILLER_220_120 VPWR VGND VPWR VGND sky130_ef_sc_hd__decap_12
XFILLER_244_1269 VPWR VGND VPWR VGND sky130_ef_sc_hd__decap_12
XFILLER_209_1389 VPWR VGND VPWR VGND sky130_ef_sc_hd__decap_12
XTAP_TAPCELL_ROW_18_1_1257 VGND VPWR sky130_fd_sc_hd__tapvpwrvgnd_1
XFILLER_53_1242 VGND VGND VPWR VPWR sky130_fd_sc_hd__decap_6
XTAP_TAPCELL_ROW_177_1950 VGND VPWR sky130_fd_sc_hd__tapvpwrvgnd_1
XTAP_TAPCELL_ROW_218_3371 VGND VPWR sky130_fd_sc_hd__tapvpwrvgnd_1
XPHY_EDGE_ROW_54_2_Right_145 VGND VGND VPWR VPWR sky130_fd_sc_hd__decap_3
XTAP_TAPCELL_ROW_177_1961 VGND VPWR sky130_fd_sc_hd__tapvpwrvgnd_1
XFILLER_193_517 VPWR VGND VPWR VGND sky130_ef_sc_hd__decap_12
XTAP_TAPCELL_ROW_218_3382 VGND VPWR sky130_fd_sc_hd__tapvpwrvgnd_1
XFILLER_220_175 VPWR VGND VPWR VGND sky130_ef_sc_hd__decap_12
XTAP_TAPCELL_ROW_173_1803 VGND VPWR sky130_fd_sc_hd__tapvpwrvgnd_1
XTAP_TAPCELL_ROW_218_3393 VGND VPWR sky130_fd_sc_hd__tapvpwrvgnd_1
XTAP_TAPCELL_ROW_173_1814 VGND VPWR sky130_fd_sc_hd__tapvpwrvgnd_1
XTAP_TAPCELL_ROW_214_3235 VGND VPWR sky130_fd_sc_hd__tapvpwrvgnd_1
XFILLER_144_1392 VGND VGND VPWR VPWR sky130_fd_sc_hd__decap_6
XTAP_TAPCELL_ROW_173_1825 VGND VPWR sky130_fd_sc_hd__tapvpwrvgnd_1
XTAP_TAPCELL_ROW_214_3246 VGND VPWR sky130_fd_sc_hd__tapvpwrvgnd_1
XTAP_TAPCELL_ROW_214_3257 VGND VPWR sky130_fd_sc_hd__tapvpwrvgnd_1
XFILLER_101_1218 VPWR VGND VPWR VGND sky130_ef_sc_hd__decap_12
XFILLER_174_753 VPWR VGND VPWR VGND sky130_ef_sc_hd__decap_12
XFILLER_179_1444 VPWR VGND VPWR VGND sky130_ef_sc_hd__decap_12
XFILLER_88_1349 VGND VGND VPWR VPWR sky130_fd_sc_hd__decap_6
XFILLER_109_39 VGND VGND VPWR VPWR sky130_fd_sc_hd__decap_4
XFILLER_173_252 VGND VGND VPWR VPWR sky130_fd_sc_hd__decap_6
XFILLER_179_1499 VGND VGND VPWR VPWR sky130_fd_sc_hd__decap_6
XFILLER_216_1305 VGND VGND VPWR VPWR sky130_fd_sc_hd__decap_6
XFILLER_255_1387 VPWR VGND VPWR VGND sky130_ef_sc_hd__decap_12
XFILLER_125_27 VPWR VGND VPWR VGND sky130_ef_sc_hd__decap_12
XFILLER_170_992 VPWR VGND VPWR VGND sky130_ef_sc_hd__decap_12
XFILLER_251_1229 VPWR VGND VPWR VGND sky130_ef_sc_hd__decap_12
XFILLER_248_507 VPWR VGND VPWR VGND sky130_ef_sc_hd__decap_12
XTAP_TAPCELL_ROW_167_1607 VGND VPWR sky130_fd_sc_hd__tapvpwrvgnd_1
XTAP_TAPCELL_ROW_208_3028 VGND VPWR sky130_fd_sc_hd__tapvpwrvgnd_1
XTAP_TAPCELL_ROW_84_2_5335 VGND VPWR sky130_fd_sc_hd__tapvpwrvgnd_1
XFILLER_138_1196 VPWR VGND VPWR VGND sky130_ef_sc_hd__decap_12
XTAP_TAPCELL_ROW_167_1618 VGND VPWR sky130_fd_sc_hd__tapvpwrvgnd_1
XFILLER_173_1076 VPWR VGND VPWR VGND sky130_ef_sc_hd__decap_12
XTAP_TAPCELL_ROW_208_3039 VGND VPWR sky130_fd_sc_hd__tapvpwrvgnd_1
XTAP_TAPCELL_ROW_53_2_5082 VGND VPWR sky130_fd_sc_hd__tapvpwrvgnd_1
XFILLER_229_732 VPWR VGND VPWR VGND sky130_ef_sc_hd__decap_12
XPHY_EDGE_ROW_254_Left_509 VGND VGND VPWR VPWR sky130_fd_sc_hd__decap_3
XFILLER_112_1325 VPWR VGND VPWR VGND sky130_ef_sc_hd__decap_12
XFILLER_217_916 VPWR VGND VPWR VGND sky130_ef_sc_hd__decap_12
XFILLER_99_1445 VPWR VGND VPWR VGND sky130_ef_sc_hd__decap_12
XFILLER_229_787 VPWR VGND VPWR VGND sky130_ef_sc_hd__decap_12
XFILLER_141_15 VPWR VGND VPWR VGND sky130_ef_sc_hd__decap_12
XFILLER_18_58 VGND VGND VPWR VPWR sky130_fd_sc_hd__decap_6
XFILLER_244_746 VGND VGND VPWR VPWR sky130_fd_sc_hd__decap_6
XFILLER_3_1162 VPWR VGND VPWR VGND sky130_ef_sc_hd__decap_12
XFILLER_227_1401 VPWR VGND VPWR VGND sky130_ef_sc_hd__decap_12
XFILLER_225_971 VPWR VGND VPWR VGND sky130_ef_sc_hd__decap_12
XTAP_TAPCELL_ROW_45_2_5019 VGND VPWR sky130_fd_sc_hd__tapvpwrvgnd_1
XFILLER_227_1456 VGND VGND VPWR VPWR sky130_fd_sc_hd__decap_6
XFILLER_34_46 VGND VGND VPWR VPWR sky130_fd_sc_hd__decap_6
XFILLER_149_1292 VPWR VGND VPWR VGND sky130_ef_sc_hd__decap_12
XFILLER_184_1183 VPWR VGND VPWR VGND sky130_ef_sc_hd__decap_12
XFILLER_180_1047 VGND VGND VPWR VPWR sky130_fd_sc_hd__decap_6
XFILLER_211_142 VPWR VGND VPWR VGND sky130_ef_sc_hd__decap_12
XFILLER_145_1189 VPWR VGND VPWR VGND sky130_ef_sc_hd__decap_12
XFILLER_196_366 VPWR VGND VPWR VGND sky130_ef_sc_hd__decap_12
XFILLER_123_1421 VPWR VGND VPWR VGND sky130_ef_sc_hd__decap_12
Xclkload1 clknet_3_1__leaf_clk VGND VGND VPWR VPWR clkload1/Y sky130_fd_sc_hd__inv_6
XFILLER_211_197 VPWR VGND VPWR VGND sky130_ef_sc_hd__decap_12
XFILLER_221_1033 VPWR VGND VPWR VGND sky130_ef_sc_hd__decap_12
XFILLER_32_1337 VPWR VGND VPWR VGND sky130_ef_sc_hd__decap_12
Xwire127 _147_ VGND VGND VPWR VPWR net127 sky130_fd_sc_hd__clkbuf_1
XFILLER_50_34 VGND VGND VPWR VPWR sky130_fd_sc_hd__decap_8
XFILLER_123_1476 VPWR VGND VPWR VGND sky130_ef_sc_hd__decap_12
XFILLER_166_34 VPWR VGND VPWR VGND sky130_ef_sc_hd__decap_12
XFILLER_192_550 VPWR VGND VPWR VGND sky130_ef_sc_hd__decap_12
XFILLER_221_1088 VPWR VGND VPWR VGND sky130_ef_sc_hd__decap_12
XFILLER_119_3 VPWR VGND VPWR VGND sky130_ef_sc_hd__decap_12
XFILLER_4_925 VPWR VGND VPWR VGND sky130_ef_sc_hd__decap_12
XFILLER_180_734 VPWR VGND VPWR VGND sky130_ef_sc_hd__decap_12
XFILLER_166_89 VPWR VGND VPWR VGND sky130_ef_sc_hd__decap_12
XFILLER_180_789 VGND VGND VPWR VPWR sky130_fd_sc_hd__decap_6
XFILLER_191_1143 VPWR VGND VPWR VGND sky130_ef_sc_hd__decap_12
XFILLER_156_1263 VGND VGND VPWR VPWR sky130_fd_sc_hd__decap_6
XFILLER_182_22 VPWR VGND VPWR VGND sky130_ef_sc_hd__decap_12
XFILLER_239_529 VPWR VGND VPWR VGND sky130_ef_sc_hd__decap_12
XTAP_TAPCELL_ROW_187_2290 VGND VPWR sky130_fd_sc_hd__tapvpwrvgnd_1
XFILLER_182_77 VPWR VGND VPWR VGND sky130_ef_sc_hd__decap_12
XFILLER_191_1198 VGND VGND VPWR VPWR sky130_fd_sc_hd__decap_6
XFILLER_232_1140 VPWR VGND VPWR VGND sky130_ef_sc_hd__decap_12
XFILLER_43_1433 VPWR VGND VPWR VGND sky130_ef_sc_hd__decap_12
XTAP_TAPCELL_ROW_183_2154 VGND VPWR sky130_fd_sc_hd__tapvpwrvgnd_1
XTAP_TAPCELL_ROW_183_2165 VGND VPWR sky130_fd_sc_hd__tapvpwrvgnd_1
XTAP_TAPCELL_ROW_183_2176 VGND VPWR sky130_fd_sc_hd__tapvpwrvgnd_1
XFILLER_232_1195 VPWR VGND VPWR VGND sky130_ef_sc_hd__decap_12
XFILLER_43_1488 VPWR VGND VPWR VGND sky130_ef_sc_hd__decap_12
XFILLER_235_713 VPWR VGND VPWR VGND sky130_ef_sc_hd__decap_12
XFILLER_247_584 VPWR VGND VPWR VGND sky130_ef_sc_hd__decap_12
XFILLER_208_949 VPWR VGND VPWR VGND sky130_ef_sc_hd__decap_12
XTAP_TAPCELL_ROW_3_980 VGND VPWR sky130_fd_sc_hd__tapvpwrvgnd_1
XTAP_TAPCELL_ROW_3_991 VGND VPWR sky130_fd_sc_hd__tapvpwrvgnd_1
XFILLER_235_768 VGND VGND VPWR VPWR sky130_fd_sc_hd__decap_6
XFILLER_76_1220 VGND VGND VPWR VPWR sky130_fd_sc_hd__decap_6
XFILLER_163_1201 VGND VGND VPWR VPWR sky130_fd_sc_hd__decap_4
XFILLER_167_1370 VGND VGND VPWR VPWR sky130_fd_sc_hd__decap_6
XTAP_TAPCELL_ROW_141_2_5792 VGND VPWR sky130_fd_sc_hd__tapvpwrvgnd_1
XFILLER_202_120 VPWR VGND VPWR VGND sky130_ef_sc_hd__decap_12
X_307_ net596 net531 dout0_q\[25\] VGND VGND VPWR VPWR _096_ sky130_fd_sc_hd__and3_1
XFILLER_175_517 VPWR VGND VPWR VGND sky130_ef_sc_hd__decap_12
XFILLER_202_175 VPWR VGND VPWR VGND sky130_ef_sc_hd__decap_12
XFILLER_187_388 VPWR VGND VPWR VGND sky130_ef_sc_hd__decap_12
XFILLER_230_495 VPWR VGND VPWR VGND sky130_ef_sc_hd__decap_12
XFILLER_243_1291 VPWR VGND VPWR VGND sky130_ef_sc_hd__decap_12
Xwire650 net21 VGND VGND VPWR VPWR net650 sky130_fd_sc_hd__buf_1
Xwire661 net12 VGND VGND VPWR VPWR net661 sky130_fd_sc_hd__buf_1
XTAP_TAPCELL_ROW_90_2_5378 VGND VPWR sky130_fd_sc_hd__tapvpwrvgnd_1
XFILLER_171_701 VPWR VGND VPWR VGND sky130_ef_sc_hd__decap_12
XTAP_TAPCELL_ROW_232_3880 VGND VPWR sky130_fd_sc_hd__tapvpwrvgnd_1
XFILLER_239_1327 VGND VGND VPWR VPWR sky130_fd_sc_hd__decap_6
XTAP_TAPCELL_ROW_232_3891 VGND VPWR sky130_fd_sc_hd__tapvpwrvgnd_1
XFILLER_6_251 VGND VGND VPWR VPWR sky130_fd_sc_hd__fill_1
XFILLER_183_572 VPWR VGND VPWR VGND sky130_ef_sc_hd__decap_12
XTAP_TAPCELL_ROW_133_2_5729 VGND VPWR sky130_fd_sc_hd__tapvpwrvgnd_1
XFILLER_196_1054 VPWR VGND VPWR VGND sky130_ef_sc_hd__decap_12
XFILLER_13_1292 VPWR VGND VPWR VGND sky130_ef_sc_hd__decap_12
XFILLER_6_284 VGND VGND VPWR VPWR sky130_fd_sc_hd__fill_1
XFILLER_100_1251 VPWR VGND VPWR VGND sky130_ef_sc_hd__decap_12
XTAP_TAPCELL_ROW_102_2_5476 VGND VPWR sky130_fd_sc_hd__tapvpwrvgnd_1
XFILLER_171_756 VPWR VGND VPWR VGND sky130_ef_sc_hd__decap_12
XFILLER_226_15 VGND VGND VPWR VPWR sky130_fd_sc_hd__decap_6
XTAP_TAPCELL_ROW_70_2_5221 VGND VPWR sky130_fd_sc_hd__tapvpwrvgnd_1
XFILLER_87_1371 VGND VGND VPWR VPWR sky130_fd_sc_hd__decap_6
XTAP_TAPCELL_ROW_69_2_5215 VGND VPWR sky130_fd_sc_hd__tapvpwrvgnd_1
XFILLER_44_1208 VPWR VGND VPWR VGND sky130_ef_sc_hd__decap_12
XFILLER_34_3 VPWR VGND VPWR VGND sky130_ef_sc_hd__decap_12
XFILLER_61_1500 VGND VGND VPWR VPWR sky130_fd_sc_hd__decap_6
XFILLER_48_1399 VPWR VGND VPWR VGND sky130_ef_sc_hd__decap_12
XFILLER_135_1347 VPWR VGND VPWR VGND sky130_ef_sc_hd__decap_12
XFILLER_170_1238 VPWR VGND VPWR VGND sky130_ef_sc_hd__decap_12
XTAP_TAPCELL_ROW_226_3651 VGND VPWR sky130_fd_sc_hd__tapvpwrvgnd_1
XTAP_TAPCELL_ROW_226_3662 VGND VPWR sky130_fd_sc_hd__tapvpwrvgnd_1
XTAP_TAPCELL_ROW_226_3673 VGND VPWR sky130_fd_sc_hd__tapvpwrvgnd_1
XFILLER_250_1262 VGND VGND VPWR VPWR sky130_fd_sc_hd__decap_6
XTAP_TAPCELL_ROW_222_3515 VGND VPWR sky130_fd_sc_hd__tapvpwrvgnd_1
XTAP_TAPCELL_ROW_222_3526 VGND VPWR sky130_fd_sc_hd__tapvpwrvgnd_1
XTAP_TAPCELL_ROW_222_3537 VGND VPWR sky130_fd_sc_hd__tapvpwrvgnd_1
XFILLER_238_562 VPWR VGND VPWR VGND sky130_ef_sc_hd__decap_12
XFILLER_242_58 VGND VGND VPWR VPWR sky130_fd_sc_hd__decap_6
XTAP_TAPCELL_ROW_1_906 VGND VPWR sky130_fd_sc_hd__tapvpwrvgnd_1
XFILLER_253_510 VGND VGND VPWR VPWR sky130_fd_sc_hd__decap_6
XTAP_TAPCELL_ROW_1_917 VGND VPWR sky130_fd_sc_hd__tapvpwrvgnd_1
XTAP_TAPCELL_ROW_1_928 VGND VPWR sky130_fd_sc_hd__tapvpwrvgnd_1
XFILLER_226_746 VGND VGND VPWR VPWR sky130_fd_sc_hd__decap_6
XPHY_EDGE_ROW_119_1_Right_775 VGND VGND VPWR VPWR sky130_fd_sc_hd__decap_3
XFILLER_0_1324 VPWR VGND VPWR VGND sky130_ef_sc_hd__decap_12
XFILLER_20_1263 VGND VGND VPWR VPWR sky130_fd_sc_hd__decap_6
XFILLER_207_971 VPWR VGND VPWR VGND sky130_ef_sc_hd__decap_12
XFILLER_244_1011 VPWR VGND VPWR VGND sky130_ef_sc_hd__decap_12
XFILLER_0_1357 VGND VGND VPWR VPWR sky130_fd_sc_hd__decap_8
XFILLER_55_1304 VPWR VGND VPWR VGND sky130_ef_sc_hd__decap_12
XFILLER_209_1131 VPWR VGND VPWR VGND sky130_ef_sc_hd__decap_12
XFILLER_240_237 VPWR VGND VPWR VGND sky130_ef_sc_hd__decap_12
XFILLER_181_1334 VPWR VGND VPWR VGND sky130_ef_sc_hd__decap_12
XFILLER_146_1454 VPWR VGND VPWR VGND sky130_ef_sc_hd__decap_12
XTAP_TAPCELL_ROW_216_3308 VGND VPWR sky130_fd_sc_hd__tapvpwrvgnd_1
XFILLER_244_1066 VPWR VGND VPWR VGND sky130_ef_sc_hd__decap_12
XFILLER_55_1359 VPWR VGND VPWR VGND sky130_ef_sc_hd__decap_12
XFILLER_90_1239 VPWR VGND VPWR VGND sky130_ef_sc_hd__decap_12
XFILLER_209_1186 VPWR VGND VPWR VGND sky130_ef_sc_hd__decap_12
XTAP_TAPCELL_ROW_216_3319 VGND VPWR sky130_fd_sc_hd__tapvpwrvgnd_1
XFILLER_178_366 VPWR VGND VPWR VGND sky130_ef_sc_hd__decap_12
XFILLER_181_1389 VPWR VGND VPWR VGND sky130_ef_sc_hd__decap_12
XFILLER_193_314 VPWR VGND VPWR VGND sky130_ef_sc_hd__decap_12
XPHY_EDGE_ROW_55_2_Right_146 VGND VGND VPWR VPWR sky130_fd_sc_hd__decap_3
XFILLER_174_550 VPWR VGND VPWR VGND sky130_ef_sc_hd__decap_12
XFILLER_193_369 VPWR VGND VPWR VGND sky130_ef_sc_hd__decap_12
XFILLER_179_1241 VGND VGND VPWR VPWR sky130_fd_sc_hd__decap_6
XFILLER_20_15 VGND VGND VPWR VPWR sky130_fd_sc_hd__decap_6
XFILLER_136_15 VGND VGND VPWR VPWR sky130_fd_sc_hd__decap_6
XFILLER_66_1411 VPWR VGND VPWR VGND sky130_ef_sc_hd__decap_12
XFILLER_192_1441 VPWR VGND VPWR VGND sky130_ef_sc_hd__decap_12
XFILLER_1_928 VPWR VGND VPWR VGND sky130_ef_sc_hd__decap_12
XFILLER_66_1466 VPWR VGND VPWR VGND sky130_ef_sc_hd__decap_12
XFILLER_153_1414 VGND VGND VPWR VPWR sky130_fd_sc_hd__decap_6
XFILLER_251_1026 VGND VGND VPWR VPWR sky130_fd_sc_hd__decap_6
XFILLER_248_304 VPWR VGND VPWR VGND sky130_ef_sc_hd__decap_12
XFILLER_192_1496 VPWR VGND VPWR VGND sky130_ef_sc_hd__decap_12
XFILLER_248_359 VGND VGND VPWR VPWR sky130_fd_sc_hd__decap_6
XFILLER_152_58 VGND VGND VPWR VPWR sky130_fd_sc_hd__decap_6
XFILLER_217_713 VPWR VGND VPWR VGND sky130_ef_sc_hd__decap_12
XFILLER_99_1242 VGND VGND VPWR VPWR sky130_fd_sc_hd__decap_6
XFILLER_229_584 VPWR VGND VPWR VGND sky130_ef_sc_hd__decap_12
XFILLER_112_1177 VGND VGND VPWR VPWR sky130_fd_sc_hd__decap_6
XTAP_TAPCELL_ROW_157_2_5914 VGND VPWR sky130_fd_sc_hd__tapvpwrvgnd_1
XFILLER_217_768 VGND VGND VPWR VPWR sky130_fd_sc_hd__decap_6
XTAP_TAPCELL_ROW_126_2_5672 VGND VPWR sky130_fd_sc_hd__tapvpwrvgnd_1
XFILLER_147_1218 VPWR VGND VPWR VGND sky130_ef_sc_hd__decap_12
XFILLER_182_1109 VPWR VGND VPWR VGND sky130_ef_sc_hd__decap_12
XFILLER_188_108 VPWR VGND VPWR VGND sky130_ef_sc_hd__decap_12
XFILLER_231_259 VPWR VGND VPWR VGND sky130_ef_sc_hd__decap_12
XTAP_TAPCELL_ROW_195_2570 VGND VPWR sky130_fd_sc_hd__tapvpwrvgnd_1
XTAP_TAPCELL_ROW_195_2581 VGND VPWR sky130_fd_sc_hd__tapvpwrvgnd_1
XFILLER_200_624 VPWR VGND VPWR VGND sky130_ef_sc_hd__decap_12
XFILLER_236_3 VPWR VGND VPWR VGND sky130_ef_sc_hd__decap_12
XFILLER_61_44 VGND VGND VPWR VPWR sky130_fd_sc_hd__fill_2
XFILLER_196_163 VPWR VGND VPWR VGND sky130_ef_sc_hd__decap_12
XFILLER_36_1270 VPWR VGND VPWR VGND sky130_ef_sc_hd__decap_12
XFILLER_169_388 VPWR VGND VPWR VGND sky130_ef_sc_hd__decap_12
XTAP_TAPCELL_ROW_195_2592 VGND VPWR sky130_fd_sc_hd__tapvpwrvgnd_1
XFILLER_212_495 VPWR VGND VPWR VGND sky130_ef_sc_hd__decap_12
XTAP_TAPCELL_ROW_75_2_5258 VGND VPWR sky130_fd_sc_hd__tapvpwrvgnd_1
XTAP_TAPCELL_ROW_191_2434 VGND VPWR sky130_fd_sc_hd__tapvpwrvgnd_1
XTAP_TAPCELL_ROW_159_1_1468 VGND VPWR sky130_fd_sc_hd__tapvpwrvgnd_1
XTAP_TAPCELL_ROW_191_2445 VGND VPWR sky130_fd_sc_hd__tapvpwrvgnd_1
XFILLER_240_1453 VPWR VGND VPWR VGND sky130_ef_sc_hd__decap_12
XFILLER_8_538 VGND VGND VPWR VPWR sky130_fd_sc_hd__fill_1
XFILLER_177_44 VPWR VGND VPWR VGND sky130_ef_sc_hd__decap_12
XTAP_TAPCELL_ROW_191_2456 VGND VPWR sky130_fd_sc_hd__tapvpwrvgnd_1
XFILLER_184_347 VPWR VGND VPWR VGND sky130_ef_sc_hd__decap_12
XFILLER_200_679 VPWR VGND VPWR VGND sky130_ef_sc_hd__decap_12
XTAP_TAPCELL_ROW_118_2_5609 VGND VPWR sky130_fd_sc_hd__tapvpwrvgnd_1
XFILLER_123_1273 VPWR VGND VPWR VGND sky130_ef_sc_hd__decap_12
XTAP_TAPCELL_ROW_55_2_5101 VGND VPWR sky130_fd_sc_hd__tapvpwrvgnd_1
XFILLER_177_99 VPWR VGND VPWR VGND sky130_ef_sc_hd__decap_12
XFILLER_158_1325 VPWR VGND VPWR VGND sky130_ef_sc_hd__decap_12
XFILLER_193_1205 VPWR VGND VPWR VGND sky130_ef_sc_hd__decap_12
XFILLER_4_733 VGND VGND VPWR VPWR sky130_fd_sc_hd__fill_1
XFILLER_180_531 VGND VGND VPWR VPWR sky130_fd_sc_hd__decap_6
XTAP_TAPCELL_ROW_42_2_4999 VGND VPWR sky130_fd_sc_hd__tapvpwrvgnd_1
XFILLER_10_1454 VPWR VGND VPWR VGND sky130_ef_sc_hd__decap_12
XTAP_TAPCELL_ROW_189_2363 VGND VPWR sky130_fd_sc_hd__tapvpwrvgnd_1
XTAP_TAPCELL_ROW_189_2374 VGND VPWR sky130_fd_sc_hd__tapvpwrvgnd_1
XTAP_TAPCELL_ROW_185_2216 VGND VPWR sky130_fd_sc_hd__tapvpwrvgnd_1
XTAP_TAPCELL_ROW_189_2385 VGND VPWR sky130_fd_sc_hd__tapvpwrvgnd_1
XFILLER_171_1514 VGND VGND VPWR VPWR sky130_fd_sc_hd__fill_1
XTAP_TAPCELL_ROW_185_2227 VGND VPWR sky130_fd_sc_hd__tapvpwrvgnd_1
XFILLER_193_87 VPWR VGND VPWR VGND sky130_ef_sc_hd__decap_12
XTAP_TAPCELL_ROW_185_2238 VGND VPWR sky130_fd_sc_hd__tapvpwrvgnd_1
XFILLER_239_326 VPWR VGND VPWR VGND sky130_ef_sc_hd__decap_12
XFILLER_132_1509 VGND VGND VPWR VPWR sky130_fd_sc_hd__decap_6
XFILLER_43_1230 VPWR VGND VPWR VGND sky130_ef_sc_hd__decap_12
XFILLER_134_1380 VPWR VGND VPWR VGND sky130_ef_sc_hd__decap_12
XFILLER_248_882 VPWR VGND VPWR VGND sky130_ef_sc_hd__decap_12
XFILLER_43_1285 VGND VGND VPWR VPWR sky130_fd_sc_hd__decap_6
XFILLER_235_510 VGND VGND VPWR VPWR sky130_fd_sc_hd__decap_6
XFILLER_247_381 VGND VGND VPWR VPWR sky130_fd_sc_hd__decap_6
XFILLER_169_1432 VPWR VGND VPWR VGND sky130_ef_sc_hd__decap_12
XFILLER_208_746 VGND VGND VPWR VPWR sky130_fd_sc_hd__decap_6
XFILLER_78_1337 VPWR VGND VPWR VGND sky130_ef_sc_hd__decap_12
XTAP_TAPCELL_ROW_179_2009 VGND VPWR sky130_fd_sc_hd__tapvpwrvgnd_1
XFILLER_169_1487 VPWR VGND VPWR VGND sky130_ef_sc_hd__decap_12
XFILLER_222_237 VPWR VGND VPWR VGND sky130_ef_sc_hd__decap_12
XFILLER_241_1217 VPWR VGND VPWR VGND sky130_ef_sc_hd__decap_12
XFILLER_187_130 VPWR VGND VPWR VGND sky130_ef_sc_hd__decap_12
XFILLER_128_1184 VPWR VGND VPWR VGND sky130_ef_sc_hd__decap_12
XFILLER_206_1348 VGND VGND VPWR VPWR sky130_fd_sc_hd__decap_6
XTAP_TAPCELL_ROW_234_3931 VGND VPWR sky130_fd_sc_hd__tapvpwrvgnd_1
XFILLER_175_314 VPWR VGND VPWR VGND sky130_ef_sc_hd__decap_12
XTAP_TAPCELL_ROW_234_3942 VGND VPWR sky130_fd_sc_hd__tapvpwrvgnd_1
XFILLER_187_185 VPWR VGND VPWR VGND sky130_ef_sc_hd__decap_12
XFILLER_230_292 VPWR VGND VPWR VGND sky130_ef_sc_hd__decap_12
XTAP_TAPCELL_ROW_234_3953 VGND VPWR sky130_fd_sc_hd__tapvpwrvgnd_1
XFILLER_54_1392 VGND VGND VPWR VPWR sky130_fd_sc_hd__decap_6
XTAP_TAPCELL_ROW_230_3806 VGND VPWR sky130_fd_sc_hd__tapvpwrvgnd_1
XTAP_TAPCELL_ROW_230_3817 VGND VPWR sky130_fd_sc_hd__tapvpwrvgnd_1
XFILLER_102_1313 VPWR VGND VPWR VGND sky130_ef_sc_hd__decap_12
XFILLER_175_369 VPWR VGND VPWR VGND sky130_ef_sc_hd__decap_12
XFILLER_191_818 VPWR VGND VPWR VGND sky130_ef_sc_hd__decap_12
XTAP_TAPCELL_ROW_111_1_1396 VGND VPWR sky130_fd_sc_hd__tapvpwrvgnd_1
XPHY_EDGE_ROW_155_2_Left_657 VGND VGND VPWR VPWR sky130_fd_sc_hd__decap_3
XFILLER_11_1218 VPWR VGND VPWR VGND sky130_ef_sc_hd__decap_12
XFILLER_89_1433 VPWR VGND VPWR VGND sky130_ef_sc_hd__decap_12
XFILLER_7_560 VGND VGND VPWR VPWR sky130_fd_sc_hd__fill_2
Xmax_cap202 net203 VGND VGND VPWR VPWR net202 sky130_fd_sc_hd__clkbuf_1
Xwire480 net481 VGND VGND VPWR VPWR net480 sky130_fd_sc_hd__clkbuf_1
Xmax_cap213 net214 VGND VGND VPWR VPWR net213 sky130_fd_sc_hd__clkbuf_1
XFILLER_102_1368 VPWR VGND VPWR VGND sky130_ef_sc_hd__decap_12
Xwire491 net492 VGND VGND VPWR VPWR net491 sky130_fd_sc_hd__clkbuf_1
XFILLER_89_1488 VPWR VGND VPWR VGND sky130_ef_sc_hd__decap_12
XPHY_EDGE_ROW_25_1_Left_280 VGND VGND VPWR VPWR sky130_fd_sc_hd__decap_3
Xmax_cap246 _158_ VGND VGND VPWR VPWR net246 sky130_fd_sc_hd__clkbuf_1
XFILLER_171_553 VGND VGND VPWR VPWR sky130_fd_sc_hd__decap_6
XTAP_TAPCELL_ROW_228_3724 VGND VPWR sky130_fd_sc_hd__tapvpwrvgnd_1
XTAP_TAPCELL_ROW_228_3735 VGND VPWR sky130_fd_sc_hd__tapvpwrvgnd_1
XFILLER_252_1324 VPWR VGND VPWR VGND sky130_ef_sc_hd__decap_12
XFILLER_217_1444 VPWR VGND VPWR VGND sky130_ef_sc_hd__decap_12
XTAP_TAPCELL_ROW_228_3746 VGND VPWR sky130_fd_sc_hd__tapvpwrvgnd_1
XTAP_TAPCELL_ROW_163_2_5968 VGND VPWR sky130_fd_sc_hd__tapvpwrvgnd_1
XFILLER_48_1196 VPWR VGND VPWR VGND sky130_ef_sc_hd__decap_12
XFILLER_170_1035 VPWR VGND VPWR VGND sky130_ef_sc_hd__decap_12
XFILLER_253_68 VPWR VGND VPWR VGND sky130_ef_sc_hd__decap_12
XFILLER_252_1379 VPWR VGND VPWR VGND sky130_ef_sc_hd__decap_12
XFILLER_217_1499 VGND VGND VPWR VPWR sky130_fd_sc_hd__decap_6
XFILLER_246_808 VPWR VGND VPWR VGND sky130_ef_sc_hd__decap_12
XFILLER_135_1177 VPWR VGND VPWR VGND sky130_ef_sc_hd__decap_12
XTAP_TAPCELL_ROW_99_2_5454 VGND VPWR sky130_fd_sc_hd__tapvpwrvgnd_1
XFILLER_22_1325 VPWR VGND VPWR VGND sky130_ef_sc_hd__decap_12
XFILLER_113_1464 VPWR VGND VPWR VGND sky130_ef_sc_hd__decap_12
XFILLER_211_1076 VPWR VGND VPWR VGND sky130_ef_sc_hd__decap_12
XFILLER_254_863 VPWR VGND VPWR VGND sky130_ef_sc_hd__decap_12
XFILLER_59_1292 VPWR VGND VPWR VGND sky130_ef_sc_hd__decap_12
XFILLER_213_259 VPWR VGND VPWR VGND sky130_ef_sc_hd__decap_12
XFILLER_0_1198 VPWR VGND VPWR VGND sky130_ef_sc_hd__decap_12
XFILLER_146_1251 VPWR VGND VPWR VGND sky130_ef_sc_hd__decap_12
XFILLER_181_1131 VPWR VGND VPWR VGND sky130_ef_sc_hd__decap_12
XFILLER_178_163 VPWR VGND VPWR VGND sky130_ef_sc_hd__decap_12
XFILLER_55_1189 VPWR VGND VPWR VGND sky130_ef_sc_hd__decap_12
XFILLER_181_1186 VPWR VGND VPWR VGND sky130_ef_sc_hd__decap_12
XFILLER_33_1421 VPWR VGND VPWR VGND sky130_ef_sc_hd__decap_12
XFILLER_193_111 VPWR VGND VPWR VGND sky130_ef_sc_hd__decap_12
XPHY_EDGE_ROW_87_2_Left_589 VGND VGND VPWR VPWR sky130_fd_sc_hd__decap_3
XFILLER_166_347 VPWR VGND VPWR VGND sky130_ef_sc_hd__decap_12
XFILLER_194_667 VPWR VGND VPWR VGND sky130_ef_sc_hd__decap_12
XFILLER_33_1476 VPWR VGND VPWR VGND sky130_ef_sc_hd__decap_12
XFILLER_193_166 VGND VGND VPWR VPWR sky130_fd_sc_hd__decap_6
XFILLER_222_1183 VPWR VGND VPWR VGND sky130_ef_sc_hd__decap_12
XPHY_EDGE_ROW_56_2_Right_147 VGND VGND VPWR VPWR sky130_fd_sc_hd__decap_3
XTAP_TAPCELL_ROW_27_2_4879 VGND VPWR sky130_fd_sc_hd__tapvpwrvgnd_1
XFILLER_120_1435 VGND VGND VPWR VPWR sky130_fd_sc_hd__decap_6
XFILLER_194_1514 VGND VGND VPWR VPWR sky130_fd_sc_hd__fill_1
XFILLER_190_851 VPWR VGND VPWR VGND sky130_ef_sc_hd__decap_12
XFILLER_218_1219 VGND VGND VPWR VPWR sky130_fd_sc_hd__decap_6
XFILLER_227_80 VGND VGND VPWR VPWR sky130_fd_sc_hd__decap_6
Xoutput47 net544 VGND VGND VPWR VPWR acc_out[13] sky130_fd_sc_hd__buf_2
Xoutput58 net58 VGND VGND VPWR VPWR acc_out[23] sky130_fd_sc_hd__buf_2
XFILLER_0_202 VGND VGND VPWR VPWR sky130_fd_sc_hd__decap_8
XFILLER_66_1263 VGND VGND VPWR VPWR sky130_fd_sc_hd__decap_6
Xoutput69 net559 VGND VGND VPWR VPWR acc_out[4] sky130_fd_sc_hd__buf_2
XFILLER_248_101 VGND VGND VPWR VPWR sky130_fd_sc_hd__decap_6
XFILLER_249_646 VPWR VGND VPWR VGND sky130_ef_sc_hd__decap_12
XFILLER_192_1293 VPWR VGND VPWR VGND sky130_ef_sc_hd__decap_12
XTAP_TAPCELL_ROW_244_4282 VGND VPWR sky130_fd_sc_hd__tapvpwrvgnd_1
XFILLER_163_68 VGND VGND VPWR VPWR sky130_fd_sc_hd__decap_3
XTAP_TAPCELL_ROW_244_4293 VGND VPWR sky130_fd_sc_hd__tapvpwrvgnd_1
XFILLER_114_1239 VPWR VGND VPWR VGND sky130_ef_sc_hd__decap_12
XTAP_TAPCELL_ROW_240_4146 VGND VPWR sky130_fd_sc_hd__tapvpwrvgnd_1
XTAP_TAPCELL_ROW_240_4157 VGND VPWR sky130_fd_sc_hd__tapvpwrvgnd_1
XTAP_TAPCELL_ROW_240_4168 VGND VPWR sky130_fd_sc_hd__tapvpwrvgnd_1
XFILLER_56_22 VPWR VGND VPWR VGND sky130_ef_sc_hd__decap_12
XFILLER_186_3 VPWR VGND VPWR VGND sky130_ef_sc_hd__decap_12
XFILLER_217_510 VGND VGND VPWR VPWR sky130_fd_sc_hd__decap_6
XFILLER_245_830 VPWR VGND VPWR VGND sky130_ef_sc_hd__decap_12
X_641_ clknet_3_0__leaf_clk acc_core.adder.cla_blocks\[1\].block.sum\[3\] _049_ VGND
+ VGND VPWR VPWR net72 sky130_fd_sc_hd__dfrtp_1
XFILLER_229_381 VGND VGND VPWR VPWR sky130_fd_sc_hd__decap_6
XFILLER_5_1076 VPWR VGND VPWR VGND sky130_ef_sc_hd__decap_12
XTAP_TAPCELL_ROW_6_1071 VGND VPWR sky130_fd_sc_hd__tapvpwrvgnd_1
XFILLER_229_1315 VPWR VGND VPWR VGND sky130_ef_sc_hd__decap_12
XFILLER_245_885 VPWR VGND VPWR VGND sky130_ef_sc_hd__decap_12
X_572_ net667 VGND VGND VPWR VPWR _054_ sky130_fd_sc_hd__inv_2
XTAP_TAPCELL_ROW_6_1082 VGND VPWR sky130_fd_sc_hd__tapvpwrvgnd_1
XTAP_TAPCELL_ROW_6_1093 VGND VPWR sky130_fd_sc_hd__tapvpwrvgnd_1
XTAP_TAPCELL_ROW_197_2643 VGND VPWR sky130_fd_sc_hd__tapvpwrvgnd_1
XFILLER_204_237 VPWR VGND VPWR VGND sky130_ef_sc_hd__decap_12
XFILLER_73_1201 VGND VGND VPWR VPWR sky130_fd_sc_hd__decap_4
XFILLER_186_1097 VPWR VGND VPWR VGND sky130_ef_sc_hd__decap_12
XTAP_TAPCELL_ROW_197_2654 VGND VPWR sky130_fd_sc_hd__tapvpwrvgnd_1
XTAP_TAPCELL_ROW_238_4075 VGND VPWR sky130_fd_sc_hd__tapvpwrvgnd_1
XTAP_TAPCELL_ROW_197_2665 VGND VPWR sky130_fd_sc_hd__tapvpwrvgnd_1
XTAP_TAPCELL_ROW_238_4086 VGND VPWR sky130_fd_sc_hd__tapvpwrvgnd_1
XTAP_TAPCELL_ROW_193_2507 VGND VPWR sky130_fd_sc_hd__tapvpwrvgnd_1
XTAP_TAPCELL_ROW_238_4097 VGND VPWR sky130_fd_sc_hd__tapvpwrvgnd_1
XFILLER_72_65 VGND VGND VPWR VPWR sky130_fd_sc_hd__decap_6
XFILLER_169_130 VPWR VGND VPWR VGND sky130_ef_sc_hd__decap_12
XTAP_TAPCELL_ROW_193_2518 VGND VPWR sky130_fd_sc_hd__tapvpwrvgnd_1
XFILLER_125_1335 VPWR VGND VPWR VGND sky130_ef_sc_hd__decap_12
XFILLER_188_65 VPWR VGND VPWR VGND sky130_ef_sc_hd__decap_12
XFILLER_200_421 VPWR VGND VPWR VGND sky130_ef_sc_hd__decap_12
XFILLER_169_185 VPWR VGND VPWR VGND sky130_ef_sc_hd__decap_12
XFILLER_212_292 VPWR VGND VPWR VGND sky130_ef_sc_hd__decap_12
XPHY_EDGE_ROW_90_1_Left_345 VGND VGND VPWR VPWR sky130_fd_sc_hd__decap_3
XFILLER_240_1250 VPWR VGND VPWR VGND sky130_ef_sc_hd__decap_12
XFILLER_205_1370 VGND VGND VPWR VPWR sky130_fd_sc_hd__decap_6
XFILLER_184_144 VGND VGND VPWR VPWR sky130_fd_sc_hd__decap_6
XFILLER_173_818 VPWR VGND VPWR VGND sky130_ef_sc_hd__decap_12
XFILLER_200_476 VPWR VGND VPWR VGND sky130_ef_sc_hd__decap_12
XFILLER_185_689 VPWR VGND VPWR VGND sky130_ef_sc_hd__decap_12
XFILLER_165_391 VGND VGND VPWR VPWR sky130_fd_sc_hd__decap_8
XFILLER_193_1002 VPWR VGND VPWR VGND sky130_ef_sc_hd__decap_12
XFILLER_10_1251 VPWR VGND VPWR VGND sky130_ef_sc_hd__decap_12
XFILLER_181_873 VPWR VGND VPWR VGND sky130_ef_sc_hd__decap_12
XFILLER_101_1390 VPWR VGND VPWR VGND sky130_ef_sc_hd__decap_12
XTAP_TAPCELL_ROW_148_2_5848 VGND VPWR sky130_fd_sc_hd__tapvpwrvgnd_1
XFILLER_158_1177 VGND VGND VPWR VPWR sky130_fd_sc_hd__decap_6
XFILLER_193_1057 VPWR VGND VPWR VGND sky130_ef_sc_hd__decap_12
XFILLER_207_39 VGND VGND VPWR VPWR sky130_fd_sc_hd__decap_4
XTAP_TAPCELL_ROW_117_2_5595 VGND VPWR sky130_fd_sc_hd__tapvpwrvgnd_1
XTAP_TAPCELL_ROW_85_2_5340 VGND VPWR sky130_fd_sc_hd__tapvpwrvgnd_1
XFILLER_136_1442 VPWR VGND VPWR VGND sky130_ef_sc_hd__decap_12
XFILLER_45_1347 VPWR VGND VPWR VGND sky130_ef_sc_hd__decap_12
XFILLER_80_1227 VPWR VGND VPWR VGND sky130_ef_sc_hd__decap_12
XFILLER_234_1054 VPWR VGND VPWR VGND sky130_ef_sc_hd__decap_12
XFILLER_132_1306 VGND VGND VPWR VPWR sky130_fd_sc_hd__decap_6
XFILLER_239_123 VGND VGND VPWR VPWR sky130_fd_sc_hd__decap_6
XFILLER_228_808 VPWR VGND VPWR VGND sky130_ef_sc_hd__decap_12
XFILLER_136_1497 VPWR VGND VPWR VGND sky130_ef_sc_hd__decap_12
XFILLER_171_1377 VPWR VGND VPWR VGND sky130_ef_sc_hd__decap_12
XFILLER_223_27 VPWR VGND VPWR VGND sky130_ef_sc_hd__decap_12
XFILLER_236_863 VPWR VGND VPWR VGND sky130_ef_sc_hd__decap_12
XTAP_TAPCELL_ROW_110_2_5538 VGND VPWR sky130_fd_sc_hd__tapvpwrvgnd_1
XFILLER_251_811 VGND VGND VPWR VPWR sky130_fd_sc_hd__decap_6
XFILLER_169_1284 VGND VGND VPWR VPWR sky130_fd_sc_hd__decap_6
XFILLER_1_1463 VPWR VGND VPWR VGND sky130_ef_sc_hd__decap_12
XFILLER_165_1126 VGND VGND VPWR VPWR sky130_fd_sc_hd__decap_8
XFILLER_189_940 VGND VGND VPWR VPWR sky130_fd_sc_hd__decap_6
XFILLER_56_1454 VPWR VGND VPWR VGND sky130_ef_sc_hd__decap_12
XFILLER_143_1402 VPWR VGND VPWR VGND sky130_ef_sc_hd__decap_12
XFILLER_210_218 VPWR VGND VPWR VGND sky130_ef_sc_hd__decap_12
XFILLER_241_1014 VPWR VGND VPWR VGND sky130_ef_sc_hd__decap_12
XFILLER_182_1484 VPWR VGND VPWR VGND sky130_ef_sc_hd__decap_12
XFILLER_91_1378 VPWR VGND VPWR VGND sky130_ef_sc_hd__decap_12
XTAP_TAPCELL_ROW_13_2_4765 VGND VPWR sky130_fd_sc_hd__tapvpwrvgnd_1
XFILLER_143_1457 VGND VGND VPWR VPWR sky130_fd_sc_hd__decap_6
XFILLER_175_111 VPWR VGND VPWR VGND sky130_ef_sc_hd__decap_12
XFILLER_241_1069 VGND VGND VPWR VPWR sky130_fd_sc_hd__decap_6
XFILLER_176_667 VPWR VGND VPWR VGND sky130_ef_sc_hd__decap_12
XFILLER_248_46 VPWR VGND VPWR VGND sky130_ef_sc_hd__decap_12
XFILLER_175_166 VGND VGND VPWR VPWR sky130_fd_sc_hd__decap_6
XFILLER_191_615 VPWR VGND VPWR VGND sky130_ef_sc_hd__decap_12
XFILLER_89_1230 VPWR VGND VPWR VGND sky130_ef_sc_hd__decap_12
XFILLER_8_880 VGND VGND VPWR VPWR sky130_fd_sc_hd__fill_1
XFILLER_102_1165 VPWR VGND VPWR VGND sky130_ef_sc_hd__decap_12
XFILLER_172_851 VPWR VGND VPWR VGND sky130_ef_sc_hd__decap_12
XFILLER_219_1506 VGND VGND VPWR VPWR sky130_fd_sc_hd__decap_8
XFILLER_89_1285 VGND VGND VPWR VPWR sky130_fd_sc_hd__decap_6
XFILLER_137_1206 VPWR VGND VPWR VGND sky130_ef_sc_hd__decap_12
XFILLER_117_39 VGND VGND VPWR VPWR sky130_fd_sc_hd__decap_4
XFILLER_252_1121 VPWR VGND VPWR VGND sky130_ef_sc_hd__decap_12
XFILLER_63_1414 VGND VGND VPWR VPWR sky130_fd_sc_hd__decap_6
XFILLER_217_1241 VGND VGND VPWR VPWR sky130_fd_sc_hd__decap_6
XFILLER_252_1176 VGND VGND VPWR VPWR sky130_fd_sc_hd__decap_6
XFILLER_246_605 VPWR VGND VPWR VGND sky130_ef_sc_hd__decap_12
XFILLER_133_27 VPWR VGND VPWR VGND sky130_ef_sc_hd__decap_12
XFILLER_230_1441 VPWR VGND VPWR VGND sky130_ef_sc_hd__decap_12
XFILLER_227_830 VPWR VGND VPWR VGND sky130_ef_sc_hd__decap_12
XFILLER_113_1261 VPWR VGND VPWR VGND sky130_ef_sc_hd__decap_12
XFILLER_230_1496 VPWR VGND VPWR VGND sky130_ef_sc_hd__decap_12
XFILLER_254_660 VGND VGND VPWR VPWR sky130_fd_sc_hd__decap_6
XFILLER_22_1177 VGND VGND VPWR VPWR sky130_fd_sc_hd__decap_6
XFILLER_2_1238 VPWR VGND VPWR VGND sky130_ef_sc_hd__decap_12
XFILLER_227_885 VPWR VGND VPWR VGND sky130_ef_sc_hd__decap_12
XFILLER_148_1313 VPWR VGND VPWR VGND sky130_ef_sc_hd__decap_12
XFILLER_57_1218 VPWR VGND VPWR VGND sky130_ef_sc_hd__decap_12
XFILLER_148_1368 VPWR VGND VPWR VGND sky130_ef_sc_hd__decap_12
XFILLER_183_1248 VPWR VGND VPWR VGND sky130_ef_sc_hd__decap_12
XTAP_TAPCELL_ROW_200_2750 VGND VPWR sky130_fd_sc_hd__tapvpwrvgnd_1
XFILLER_186_409 VPWR VGND VPWR VGND sky130_ef_sc_hd__decap_12
XTAP_TAPCELL_ROW_200_2761 VGND VPWR sky130_fd_sc_hd__tapvpwrvgnd_1
XTAP_TAPCELL_ROW_200_2772 VGND VPWR sky130_fd_sc_hd__tapvpwrvgnd_1
XTAP_TAPCELL_ROW_252_4562 VGND VPWR sky130_fd_sc_hd__tapvpwrvgnd_1
XTAP_TAPCELL_ROW_252_4573 VGND VPWR sky130_fd_sc_hd__tapvpwrvgnd_1
XFILLER_42_46 VGND VGND VPWR VPWR sky130_fd_sc_hd__decap_4
XTAP_TAPCELL_ROW_252_4584 VGND VPWR sky130_fd_sc_hd__tapvpwrvgnd_1
XFILLER_220_1109 VPWR VGND VPWR VGND sky130_ef_sc_hd__decap_12
XFILLER_158_46 VPWR VGND VPWR VGND sky130_ef_sc_hd__decap_12
XFILLER_166_144 VGND VGND VPWR VPWR sky130_fd_sc_hd__decap_6
XFILLER_194_464 VPWR VGND VPWR VGND sky130_ef_sc_hd__decap_12
XFILLER_167_689 VPWR VGND VPWR VGND sky130_ef_sc_hd__decap_12
XFILLER_210_796 VPWR VGND VPWR VGND sky130_ef_sc_hd__decap_12
XFILLER_6_828 VGND VGND VPWR VPWR sky130_fd_sc_hd__decap_8
XFILLER_33_1273 VPWR VGND VPWR VGND sky130_ef_sc_hd__decap_12
XFILLER_6_839 VGND VGND VPWR VPWR sky130_fd_sc_hd__decap_8
XFILLER_182_648 VPWR VGND VPWR VGND sky130_ef_sc_hd__decap_12
XTAP_TAPCELL_ROW_134_2_5734 VGND VPWR sky130_fd_sc_hd__tapvpwrvgnd_1
XPHY_EDGE_ROW_57_2_Right_148 VGND VGND VPWR VPWR sky130_fd_sc_hd__decap_3
XFILLER_68_1325 VPWR VGND VPWR VGND sky130_ef_sc_hd__decap_12
XFILLER_101_3 VPWR VGND VPWR VGND sky130_ef_sc_hd__decap_12
XFILLER_159_1464 VPWR VGND VPWR VGND sky130_ef_sc_hd__decap_12
XFILLER_174_34 VPWR VGND VPWR VGND sky130_ef_sc_hd__decap_12
XFILLER_194_1355 VPWR VGND VPWR VGND sky130_ef_sc_hd__decap_12
XTAP_TAPCELL_ROW_246_4355 VGND VPWR sky130_fd_sc_hd__tapvpwrvgnd_1
XFILLER_155_1328 VGND VGND VPWR VPWR sky130_fd_sc_hd__decap_6
XTAP_TAPCELL_ROW_246_4366 VGND VPWR sky130_fd_sc_hd__tapvpwrvgnd_1
XFILLER_190_1219 VGND VGND VPWR VPWR sky130_fd_sc_hd__decap_6
XTAP_TAPCELL_ROW_246_4377 VGND VPWR sky130_fd_sc_hd__tapvpwrvgnd_1
XTAP_TAPCELL_ROW_242_4219 VGND VPWR sky130_fd_sc_hd__tapvpwrvgnd_1
XFILLER_174_89 VPWR VGND VPWR VGND sky130_ef_sc_hd__decap_12
XFILLER_192_1090 VGND VGND VPWR VPWR sky130_fd_sc_hd__decap_6
XFILLER_231_1205 VPWR VGND VPWR VGND sky130_ef_sc_hd__decap_12
XFILLER_249_443 VPWR VGND VPWR VGND sky130_ef_sc_hd__decap_12
XFILLER_42_1509 VGND VGND VPWR VPWR sky130_fd_sc_hd__decap_6
XTAP_TAPCELL_ROW_37_2_4961 VGND VPWR sky130_fd_sc_hd__tapvpwrvgnd_1
XFILLER_190_22 VPWR VGND VPWR VGND sky130_ef_sc_hd__decap_12
XTAP_TAPCELL_ROW_52_2_5078 VGND VPWR sky130_fd_sc_hd__tapvpwrvgnd_1
XFILLER_237_627 VPWR VGND VPWR VGND sky130_ef_sc_hd__decap_12
XFILLER_249_498 VPWR VGND VPWR VGND sky130_ef_sc_hd__decap_12
XFILLER_44_1380 VPWR VGND VPWR VGND sky130_ef_sc_hd__decap_12
XTAP_TAPCELL_ROW_8_1144 VGND VPWR sky130_fd_sc_hd__tapvpwrvgnd_1
XTAP_TAPCELL_ROW_8_1155 VGND VPWR sky130_fd_sc_hd__tapvpwrvgnd_1
XTAP_TAPCELL_ROW_8_1166 VGND VPWR sky130_fd_sc_hd__tapvpwrvgnd_1
XFILLER_190_77 VPWR VGND VPWR VGND sky130_ef_sc_hd__decap_12
XTAP_TAPCELL_ROW_4_1008 VGND VPWR sky130_fd_sc_hd__tapvpwrvgnd_1
XTAP_TAPCELL_ROW_4_1019 VGND VPWR sky130_fd_sc_hd__tapvpwrvgnd_1
XFILLER_79_1421 VPWR VGND VPWR VGND sky130_ef_sc_hd__decap_12
XTAP_TAPCELL_ROW_199_2705 VGND VPWR sky130_fd_sc_hd__tapvpwrvgnd_1
XFILLER_218_863 VPWR VGND VPWR VGND sky130_ef_sc_hd__decap_12
XTAP_TAPCELL_ROW_199_2716 VGND VPWR sky130_fd_sc_hd__tapvpwrvgnd_1
X_624_ clknet_3_4__leaf_clk dout0\[22\] _032_ VGND VGND VPWR VPWR dout0_q\[22\] sky130_fd_sc_hd__dfrtp_1
XTAP_TAPCELL_ROW_199_2727 VGND VPWR sky130_fd_sc_hd__tapvpwrvgnd_1
XFILLER_229_1112 VGND VGND VPWR VPWR sky130_fd_sc_hd__decap_6
XTAP_TAPCELL_ROW_199_2738 VGND VPWR sky130_fd_sc_hd__tapvpwrvgnd_1
XFILLER_233_811 VGND VGND VPWR VPWR sky130_fd_sc_hd__decap_6
XFILLER_245_682 VGND VGND VPWR VPWR sky130_fd_sc_hd__decap_6
XFILLER_79_1476 VPWR VGND VPWR VGND sky130_ef_sc_hd__decap_12
X_555_ net671 VGND VGND VPWR VPWR _037_ sky130_fd_sc_hd__inv_2
XTAP_TAPCELL_ROW_30_2_4904 VGND VPWR sky130_fd_sc_hd__tapvpwrvgnd_1
XFILLER_242_1312 VPWR VGND VPWR VGND sky130_ef_sc_hd__decap_12
X_486_ net501 _248_ VGND VGND VPWR VPWR _249_ sky130_fd_sc_hd__or2_1
XFILLER_207_1432 VPWR VGND VPWR VGND sky130_ef_sc_hd__decap_12
XFILLER_220_538 VPWR VGND VPWR VGND sky130_ef_sc_hd__decap_12
XFILLER_38_1184 VPWR VGND VPWR VGND sky130_ef_sc_hd__decap_12
XFILLER_242_1367 VPWR VGND VPWR VGND sky130_ef_sc_hd__decap_12
XFILLER_9_622 VGND VGND VPWR VPWR sky130_fd_sc_hd__decap_8
XFILLER_207_1487 VPWR VGND VPWR VGND sky130_ef_sc_hd__decap_12
XFILLER_185_431 VPWR VGND VPWR VGND sky130_ef_sc_hd__decap_12
XFILLER_125_1165 VPWR VGND VPWR VGND sky130_ef_sc_hd__decap_12
XFILLER_8_132 VPWR VGND VPWR VGND sky130_ef_sc_hd__decap_12
XFILLER_173_615 VPWR VGND VPWR VGND sky130_ef_sc_hd__decap_12
XFILLER_200_273 VGND VGND VPWR VPWR sky130_fd_sc_hd__decap_6
XFILLER_12_1313 VPWR VGND VPWR VGND sky130_ef_sc_hd__decap_12
XFILLER_185_486 VPWR VGND VPWR VGND sky130_ef_sc_hd__decap_12
XFILLER_195_1119 VPWR VGND VPWR VGND sky130_ef_sc_hd__decap_12
XFILLER_66_6 VPWR VGND VPWR VGND sky130_ef_sc_hd__decap_12
XFILLER_12_1368 VPWR VGND VPWR VGND sky130_ef_sc_hd__decap_12
XFILLER_5_861 VGND VGND VPWR VPWR sky130_fd_sc_hd__fill_1
XFILLER_181_670 VPWR VGND VPWR VGND sky130_ef_sc_hd__decap_12
XFILLER_4_382 VGND VGND VPWR VPWR sky130_fd_sc_hd__fill_2
XTAP_TAPCELL_ROW_210_3090 VGND VPWR sky130_fd_sc_hd__tapvpwrvgnd_1
XFILLER_234_15 VGND VGND VPWR VPWR sky130_fd_sc_hd__decap_6
XFILLER_253_1463 VPWR VGND VPWR VGND sky130_ef_sc_hd__decap_12
XFILLER_228_605 VPWR VGND VPWR VGND sky130_ef_sc_hd__decap_12
XFILLER_171_1174 VPWR VGND VPWR VGND sky130_ef_sc_hd__decap_12
XFILLER_136_1294 VPWR VGND VPWR VGND sky130_ef_sc_hd__decap_12
XPHY_EDGE_ROW_19_2_Right_110 VGND VGND VPWR VPWR sky130_fd_sc_hd__decap_3
XFILLER_209_830 VPWR VGND VPWR VGND sky130_ef_sc_hd__decap_12
XFILLER_3_1514 VGND VGND VPWR VPWR sky130_fd_sc_hd__fill_1
XFILLER_23_1464 VPWR VGND VPWR VGND sky130_ef_sc_hd__decap_12
XFILLER_110_1423 VPWR VGND VPWR VGND sky130_ef_sc_hd__decap_12
XPHY_EDGE_ROW_209_Right_54 VGND VGND VPWR VPWR sky130_fd_sc_hd__decap_3
XFILLER_236_660 VGND VGND VPWR VPWR sky130_fd_sc_hd__decap_6
XFILLER_209_885 VPWR VGND VPWR VGND sky130_ef_sc_hd__decap_12
XFILLER_250_58 VGND VGND VPWR VPWR sky130_fd_sc_hd__decap_6
XFILLER_110_1478 VGND VGND VPWR VPWR sky130_fd_sc_hd__decap_6
XFILLER_1_1260 VPWR VGND VPWR VGND sky130_ef_sc_hd__decap_12
XFILLER_208_1207 VPWR VGND VPWR VGND sky130_ef_sc_hd__decap_12
XFILLER_250_151 VPWR VGND VPWR VGND sky130_ef_sc_hd__decap_12
XFILLER_168_409 VPWR VGND VPWR VGND sky130_ef_sc_hd__decap_12
XFILLER_56_1251 VPWR VGND VPWR VGND sky130_ef_sc_hd__decap_12
XFILLER_147_1390 VPWR VGND VPWR VGND sky130_ef_sc_hd__decap_12
XFILLER_195_228 VPWR VGND VPWR VGND sky130_ef_sc_hd__decap_12
XFILLER_182_1281 VPWR VGND VPWR VGND sky130_ef_sc_hd__decap_12
XFILLER_188_280 VPWR VGND VPWR VGND sky130_ef_sc_hd__decap_12
XTAP_TAPCELL_ROW_120_2_5620 VGND VPWR sky130_fd_sc_hd__tapvpwrvgnd_1
XFILLER_104_1227 VPWR VGND VPWR VGND sky130_ef_sc_hd__decap_12
XTAP_TAPCELL_ROW_119_2_5614 VGND VPWR sky130_fd_sc_hd__tapvpwrvgnd_1
XFILLER_176_464 VPWR VGND VPWR VGND sky130_ef_sc_hd__decap_12
XFILLER_191_412 VPWR VGND VPWR VGND sky130_ef_sc_hd__decap_12
XPHY_EDGE_ROW_218_Right_63 VGND VGND VPWR VPWR sky130_fd_sc_hd__decap_3
XFILLER_30_1435 VGND VGND VPWR VPWR sky130_fd_sc_hd__decap_6
XFILLER_192_968 VPWR VGND VPWR VGND sky130_ef_sc_hd__decap_12
XFILLER_191_467 VGND VGND VPWR VPWR sky130_fd_sc_hd__decap_6
XFILLER_219_1303 VPWR VGND VPWR VGND sky130_ef_sc_hd__decap_12
XFILLER_191_1506 VGND VGND VPWR VPWR sky130_fd_sc_hd__decap_8
XFILLER_254_1238 VPWR VGND VPWR VGND sky130_ef_sc_hd__decap_12
XFILLER_219_1358 VPWR VGND VPWR VGND sky130_ef_sc_hd__decap_12
XFILLER_144_15 VGND VGND VPWR VPWR sky130_fd_sc_hd__decap_6
XFILLER_232_1514 VGND VGND VPWR VPWR sky130_fd_sc_hd__fill_1
XFILLER_246_402 VGND VGND VPWR VPWR sky130_fd_sc_hd__decap_6
Xfanout667 net672 VGND VGND VPWR VPWR net667 sky130_fd_sc_hd__clkbuf_4
XFILLER_24_1239 VPWR VGND VPWR VGND sky130_ef_sc_hd__decap_12
XFILLER_219_627 VPWR VGND VPWR VGND sky130_ef_sc_hd__decap_12
XFILLER_247_947 VPWR VGND VPWR VGND sky130_ef_sc_hd__decap_12
XFILLER_189_1413 VGND VGND VPWR VPWR sky130_fd_sc_hd__decap_6
XFILLER_115_1378 VPWR VGND VPWR VGND sky130_ef_sc_hd__decap_12
XPHY_EDGE_ROW_227_Right_72 VGND VGND VPWR VPWR sky130_fd_sc_hd__decap_3
XFILLER_2_1035 VPWR VGND VPWR VGND sky130_ef_sc_hd__decap_12
XTAP_TAPCELL_ROW_206_2970 VGND VPWR sky130_fd_sc_hd__tapvpwrvgnd_1
XFILLER_215_811 VGND VGND VPWR VPWR sky130_fd_sc_hd__decap_6
XFILLER_230_1293 VPWR VGND VPWR VGND sky130_ef_sc_hd__decap_12
XFILLER_160_58 VGND VGND VPWR VPWR sky130_fd_sc_hd__decap_6
XTAP_TAPCELL_ROW_202_2812 VGND VPWR sky130_fd_sc_hd__tapvpwrvgnd_1
XTAP_TAPCELL_ROW_206_2981 VGND VPWR sky130_fd_sc_hd__tapvpwrvgnd_1
XTAP_TAPCELL_ROW_202_2823 VGND VPWR sky130_fd_sc_hd__tapvpwrvgnd_1
XFILLER_227_682 VGND VGND VPWR VPWR sky130_fd_sc_hd__decap_6
XTAP_TAPCELL_ROW_202_2834 VGND VPWR sky130_fd_sc_hd__tapvpwrvgnd_1
XTAP_TAPCELL_ROW_254_4635 VGND VPWR sky130_fd_sc_hd__tapvpwrvgnd_1
XTAP_TAPCELL_ROW_254_4646 VGND VPWR sky130_fd_sc_hd__tapvpwrvgnd_1
X_340_ _117_ _125_ _128_ VGND VGND VPWR VPWR _129_ sky130_fd_sc_hd__o21ba_1
XFILLER_148_1165 VPWR VGND VPWR VGND sky130_ef_sc_hd__decap_12
XFILLER_183_1045 VPWR VGND VPWR VGND sky130_ef_sc_hd__decap_12
XTAP_TAPCELL_ROW_254_4657 VGND VPWR sky130_fd_sc_hd__tapvpwrvgnd_1
XFILLER_241_173 VPWR VGND VPWR VGND sky130_ef_sc_hd__decap_12
XFILLER_186_206 VPWR VGND VPWR VGND sky130_ef_sc_hd__decap_12
XFILLER_202_538 VPWR VGND VPWR VGND sky130_ef_sc_hd__decap_12
XFILLER_149_3 VPWR VGND VPWR VGND sky130_ef_sc_hd__decap_12
XFILLER_169_56 VPWR VGND VPWR VGND sky130_ef_sc_hd__decap_12
XFILLER_35_1335 VPWR VGND VPWR VGND sky130_ef_sc_hd__decap_12
XFILLER_167_431 VPWR VGND VPWR VGND sky130_ef_sc_hd__decap_12
XFILLER_126_1485 VPWR VGND VPWR VGND sky130_ef_sc_hd__decap_12
XPHY_EDGE_ROW_236_Right_81 VGND VGND VPWR VPWR sky130_fd_sc_hd__decap_3
XFILLER_224_1097 VPWR VGND VPWR VGND sky130_ef_sc_hd__decap_12
XFILLER_122_1349 VGND VGND VPWR VPWR sky130_fd_sc_hd__decap_6
XFILLER_167_486 VPWR VGND VPWR VGND sky130_ef_sc_hd__decap_12
XFILLER_194_261 VPWR VGND VPWR VGND sky130_ef_sc_hd__decap_12
XFILLER_210_593 VPWR VGND VPWR VGND sky130_ef_sc_hd__decap_12
XFILLER_182_445 VGND VGND VPWR VPWR sky130_fd_sc_hd__decap_6
XTAP_TAPCELL_ROW_248_4428 VGND VPWR sky130_fd_sc_hd__tapvpwrvgnd_1
XFILLER_185_44 VPWR VGND VPWR VGND sky130_ef_sc_hd__decap_12
XTAP_TAPCELL_ROW_248_4439 VGND VPWR sky130_fd_sc_hd__tapvpwrvgnd_1
XPHY_EDGE_ROW_58_2_Right_149 VGND VGND VPWR VPWR sky130_fd_sc_hd__decap_3
XFILLER_159_1261 VPWR VGND VPWR VGND sky130_ef_sc_hd__decap_12
XFILLER_185_99 VPWR VGND VPWR VGND sky130_ef_sc_hd__decap_12
XFILLER_191_990 VPWR VGND VPWR VGND sky130_ef_sc_hd__decap_12
XFILLER_194_1152 VPWR VGND VPWR VGND sky130_ef_sc_hd__decap_12
XFILLER_68_1177 VGND VGND VPWR VPWR sky130_fd_sc_hd__decap_6
XFILLER_11_1390 VPWR VGND VPWR VGND sky130_ef_sc_hd__decap_12
XTAP_TAPCELL_ROW_164_2_5973 VGND VPWR sky130_fd_sc_hd__tapvpwrvgnd_1
XFILLER_46_1442 VPWR VGND VPWR VGND sky130_ef_sc_hd__decap_12
XFILLER_231_1002 VPWR VGND VPWR VGND sky130_ef_sc_hd__decap_12
XFILLER_249_240 VPWR VGND VPWR VGND sky130_ef_sc_hd__decap_12
XFILLER_42_1306 VGND VGND VPWR VPWR sky130_fd_sc_hd__decap_6
XFILLER_1_385 VGND VGND VPWR VPWR sky130_fd_sc_hd__fill_2
XFILLER_238_925 VPWR VGND VPWR VGND sky130_ef_sc_hd__decap_12
XPHY_EDGE_ROW_245_Right_90 VGND VGND VPWR VPWR sky130_fd_sc_hd__decap_3
XFILLER_46_1497 VPWR VGND VPWR VGND sky130_ef_sc_hd__decap_12
XFILLER_133_1445 VPWR VGND VPWR VGND sky130_ef_sc_hd__decap_12
XFILLER_231_1057 VPWR VGND VPWR VGND sky130_ef_sc_hd__decap_12
XFILLER_237_424 VGND VGND VPWR VPWR sky130_fd_sc_hd__decap_6
XFILLER_249_295 VGND VGND VPWR VPWR sky130_fd_sc_hd__decap_6
XFILLER_168_1508 VGND VGND VPWR VPWR sky130_fd_sc_hd__decap_6
XFILLER_253_928 VPWR VGND VPWR VGND sky130_ef_sc_hd__decap_12
XFILLER_218_660 VGND VGND VPWR VPWR sky130_fd_sc_hd__decap_6
XFILLER_246_980 VPWR VGND VPWR VGND sky130_ef_sc_hd__decap_12
XPHY_EDGE_ROW_164_2_Left_666 VGND VGND VPWR VPWR sky130_fd_sc_hd__decap_3
X_607_ clknet_3_1__leaf_clk dout0\[5\] _015_ VGND VGND VPWR VPWR dout0_q\[5\] sky130_fd_sc_hd__dfrtp_1
XFILLER_79_1273 VPWR VGND VPWR VGND sky130_ef_sc_hd__decap_12
XTAP_TAPCELL_ROW_93_2_5402 VGND VPWR sky130_fd_sc_hd__tapvpwrvgnd_1
XFILLER_232_151 VPWR VGND VPWR VGND sky130_ef_sc_hd__decap_12
XTAP_TAPCELL_ROW_62_2_5160 VGND VPWR sky130_fd_sc_hd__tapvpwrvgnd_1
X_538_ net668 VGND VGND VPWR VPWR _020_ sky130_fd_sc_hd__inv_2
XFILLER_53_1402 VPWR VGND VPWR VGND sky130_ef_sc_hd__decap_12
XFILLER_127_1249 VPWR VGND VPWR VGND sky130_ef_sc_hd__decap_12
XTAP_TAPCELL_ROW_105_2_5500 VGND VPWR sky130_fd_sc_hd__tapvpwrvgnd_1
XFILLER_220_335 VPWR VGND VPWR VGND sky130_ef_sc_hd__decap_12
XFILLER_177_228 VPWR VGND VPWR VGND sky130_ef_sc_hd__decap_12
X_469_ net150 net116 VGND VGND VPWR VPWR acc_core.adder.cla_blocks\[1\].block.sum\[1\]
+ sky130_fd_sc_hd__xnor2_1
XFILLER_242_1164 VPWR VGND VPWR VGND sky130_ef_sc_hd__decap_12
XFILLER_53_1457 VGND VGND VPWR VPWR sky130_fd_sc_hd__decap_6
XFILLER_9_430 VGND VGND VPWR VPWR sky130_fd_sc_hd__fill_2
XFILLER_207_1284 VGND VGND VPWR VPWR sky130_fd_sc_hd__decap_6
XFILLER_229_15 VPWR VGND VPWR VGND sky130_ef_sc_hd__decap_12
XFILLER_201_560 VPWR VGND VPWR VGND sky130_ef_sc_hd__decap_12
XTAP_TAPCELL_ROW_28_2_4884 VGND VPWR sky130_fd_sc_hd__tapvpwrvgnd_1
XFILLER_88_1509 VGND VGND VPWR VPWR sky130_fd_sc_hd__decap_6
XFILLER_173_412 VPWR VGND VPWR VGND sky130_ef_sc_hd__decap_12
XFILLER_185_283 VPWR VGND VPWR VGND sky130_ef_sc_hd__decap_12
XFILLER_174_968 VPWR VGND VPWR VGND sky130_ef_sc_hd__decap_12
XTAP_TAPCELL_ROW_171_1731 VGND VPWR sky130_fd_sc_hd__tapvpwrvgnd_1
XTAP_TAPCELL_ROW_171_1742 VGND VPWR sky130_fd_sc_hd__tapvpwrvgnd_1
XFILLER_173_467 VGND VGND VPWR VPWR sky130_fd_sc_hd__decap_6
XTAP_TAPCELL_ROW_212_3163 VGND VPWR sky130_fd_sc_hd__tapvpwrvgnd_1
XFILLER_220_1484 VPWR VGND VPWR VGND sky130_ef_sc_hd__decap_12
XFILLER_12_1165 VPWR VGND VPWR VGND sky130_ef_sc_hd__decap_12
XTAP_TAPCELL_ROW_171_1753 VGND VPWR sky130_fd_sc_hd__tapvpwrvgnd_1
XTAP_TAPCELL_ROW_212_3174 VGND VPWR sky130_fd_sc_hd__tapvpwrvgnd_1
XPHY_EDGE_ROW_53_1_Left_308 VGND VGND VPWR VPWR sky130_fd_sc_hd__decap_3
XTAP_TAPCELL_ROW_212_3185 VGND VPWR sky130_fd_sc_hd__tapvpwrvgnd_1
XFILLER_47_1206 VPWR VGND VPWR VGND sky130_ef_sc_hd__decap_12
XFILLER_138_1356 VPWR VGND VPWR VGND sky130_ef_sc_hd__decap_12
XTAP_TAPCELL_ROW_21_2_4827 VGND VPWR sky130_fd_sc_hd__tapvpwrvgnd_1
XFILLER_253_1260 VPWR VGND VPWR VGND sky130_ef_sc_hd__decap_12
XFILLER_218_1391 VGND VGND VPWR VPWR sky130_fd_sc_hd__decap_6
XTAP_TAPCELL_ROW_169_1660 VGND VPWR sky130_fd_sc_hd__tapvpwrvgnd_1
XTAP_TAPCELL_ROW_165_1502 VGND VPWR sky130_fd_sc_hd__tapvpwrvgnd_1
XTAP_TAPCELL_ROW_169_1671 VGND VPWR sky130_fd_sc_hd__tapvpwrvgnd_1
XFILLER_228_402 VGND VGND VPWR VPWR sky130_fd_sc_hd__decap_6
XTAP_TAPCELL_ROW_165_1513 VGND VPWR sky130_fd_sc_hd__tapvpwrvgnd_1
XTAP_TAPCELL_ROW_169_1682 VGND VPWR sky130_fd_sc_hd__tapvpwrvgnd_1
XTAP_TAPCELL_ROW_165_1524 VGND VPWR sky130_fd_sc_hd__tapvpwrvgnd_1
XFILLER_229_947 VPWR VGND VPWR VGND sky130_ef_sc_hd__decap_12
XTAP_TAPCELL_ROW_165_1535 VGND VPWR sky130_fd_sc_hd__tapvpwrvgnd_1
XFILLER_255_232 VPWR VGND VPWR VGND sky130_ef_sc_hd__decap_12
XFILLER_244_906 VPWR VGND VPWR VGND sky130_ef_sc_hd__decap_12
XPHY_EDGE_ROW_96_2_Left_598 VGND VGND VPWR VPWR sky130_fd_sc_hd__decap_3
XTAP_TAPCELL_ROW_165_1546 VGND VPWR sky130_fd_sc_hd__tapvpwrvgnd_1
XFILLER_23_1261 VPWR VGND VPWR VGND sky130_ef_sc_hd__decap_12
XFILLER_255_265 VGND VGND VPWR VPWR sky130_fd_sc_hd__decap_8
XFILLER_110_1220 VGND VGND VPWR VPWR sky130_fd_sc_hd__decap_6
XFILLER_209_682 VGND VGND VPWR VPWR sky130_fd_sc_hd__decap_6
XFILLER_58_1313 VPWR VGND VPWR VGND sky130_ef_sc_hd__decap_12
XFILLER_3_1377 VPWR VGND VPWR VGND sky130_ef_sc_hd__decap_12
XFILLER_252_961 VGND VGND VPWR VPWR sky130_fd_sc_hd__decap_6
XFILLER_208_1004 VGND VGND VPWR VPWR sky130_fd_sc_hd__decap_6
XFILLER_58_1368 VPWR VGND VPWR VGND sky130_ef_sc_hd__decap_12
XFILLER_145_1316 VPWR VGND VPWR VGND sky130_ef_sc_hd__decap_12
XFILLER_180_1207 VPWR VGND VPWR VGND sky130_ef_sc_hd__decap_12
XFILLER_211_302 VPWR VGND VPWR VGND sky130_ef_sc_hd__decap_12
XFILLER_223_173 VPWR VGND VPWR VGND sky130_ef_sc_hd__decap_12
XFILLER_168_206 VPWR VGND VPWR VGND sky130_ef_sc_hd__decap_12
XFILLER_184_1398 VPWR VGND VPWR VGND sky130_ef_sc_hd__decap_12
XFILLER_23_15 VPWR VGND VPWR VGND sky130_ef_sc_hd__decap_12
XFILLER_211_357 VPWR VGND VPWR VGND sky130_ef_sc_hd__decap_12
Xwire309 net310 VGND VGND VPWR VPWR net309 sky130_fd_sc_hd__clkbuf_1
XFILLER_139_15 VPWR VGND VPWR VGND sky130_ef_sc_hd__decap_12
XFILLER_183_209 VGND VGND VPWR VPWR sky130_fd_sc_hd__decap_6
XFILLER_176_261 VPWR VGND VPWR VGND sky130_ef_sc_hd__decap_12
XFILLER_192_710 VPWR VGND VPWR VGND sky130_ef_sc_hd__decap_12
XFILLER_221_1248 VPWR VGND VPWR VGND sky130_ef_sc_hd__decap_12
XFILLER_165_946 VPWR VGND VPWR VGND sky130_ef_sc_hd__decap_12
XFILLER_165_979 VGND VGND VPWR VPWR sky130_fd_sc_hd__decap_8
XFILLER_192_765 VPWR VGND VPWR VGND sky130_ef_sc_hd__decap_12
XFILLER_121_1371 VGND VGND VPWR VPWR sky130_fd_sc_hd__decap_6
XFILLER_219_1100 VPWR VGND VPWR VGND sky130_ef_sc_hd__decap_12
XFILLER_180_949 VPWR VGND VPWR VGND sky130_ef_sc_hd__decap_12
XFILLER_69_1464 VPWR VGND VPWR VGND sky130_ef_sc_hd__decap_12
XTAP_TAPCELL_ROW_149_2_5853 VGND VPWR sky130_fd_sc_hd__tapvpwrvgnd_1
XFILLER_173_990 VPWR VGND VPWR VGND sky130_ef_sc_hd__decap_12
XFILLER_156_1423 VPWR VGND VPWR VGND sky130_ef_sc_hd__decap_12
XFILLER_191_1303 VPWR VGND VPWR VGND sky130_ef_sc_hd__decap_12
XFILLER_254_1035 VPWR VGND VPWR VGND sky130_ef_sc_hd__decap_12
XFILLER_65_1328 VGND VGND VPWR VPWR sky130_fd_sc_hd__decap_6
XFILLER_219_1155 VGND VGND VPWR VPWR sky130_fd_sc_hd__decap_6
XFILLER_156_1478 VGND VGND VPWR VPWR sky130_fd_sc_hd__decap_6
XFILLER_191_1358 VPWR VGND VPWR VGND sky130_ef_sc_hd__decap_12
XFILLER_235_80 VGND VGND VPWR VPWR sky130_fd_sc_hd__decap_6
XFILLER_48_34 VPWR VGND VPWR VGND sky130_ef_sc_hd__decap_12
XFILLER_219_424 VGND VGND VPWR VPWR sky130_fd_sc_hd__decap_6
XFILLER_232_1355 VPWR VGND VPWR VGND sky130_ef_sc_hd__decap_12
XFILLER_247_744 VPWR VGND VPWR VGND sky130_ef_sc_hd__decap_12
XFILLER_171_68 VPWR VGND VPWR VGND sky130_ef_sc_hd__decap_12
XTAP_TAPCELL_ROW_67_2_5197 VGND VPWR sky130_fd_sc_hd__tapvpwrvgnd_1
XTAP_TAPCELL_ROW_204_2907 VGND VPWR sky130_fd_sc_hd__tapvpwrvgnd_1
XFILLER_235_928 VPWR VGND VPWR VGND sky130_ef_sc_hd__decap_12
XFILLER_247_799 VPWR VGND VPWR VGND sky130_ef_sc_hd__decap_12
XTAP_TAPCELL_ROW_181_2082 VGND VPWR sky130_fd_sc_hd__tapvpwrvgnd_1
XFILLER_228_980 VPWR VGND VPWR VGND sky130_ef_sc_hd__decap_12
XFILLER_230_1090 VGND VGND VPWR VPWR sky130_fd_sc_hd__decap_6
XFILLER_64_22 VPWR VGND VPWR VGND sky130_ef_sc_hd__decap_12
XTAP_TAPCELL_ROW_181_2093 VGND VPWR sky130_fd_sc_hd__tapvpwrvgnd_1
XTAP_TAPCELL_ROW_47_2_5040 VGND VPWR sky130_fd_sc_hd__tapvpwrvgnd_1
XFILLER_76_1435 VGND VGND VPWR VPWR sky130_fd_sc_hd__decap_6
XFILLER_243_983 VGND VGND VPWR VPWR sky130_fd_sc_hd__decap_6
XFILLER_214_151 VPWR VGND VPWR VGND sky130_ef_sc_hd__decap_12
XFILLER_202_335 VPWR VGND VPWR VGND sky130_ef_sc_hd__decap_12
X_323_ net596 net532 dout0_q\[24\] VGND VGND VPWR VPWR _112_ sky130_fd_sc_hd__and3_1
XTAP_TAPCELL_ROW_14_2_4770 VGND VPWR sky130_fd_sc_hd__tapvpwrvgnd_1
XFILLER_35_1165 VPWR VGND VPWR VGND sky130_ef_sc_hd__decap_12
XFILLER_80_65 VGND VGND VPWR VPWR sky130_fd_sc_hd__decap_6
XFILLER_126_1282 VPWR VGND VPWR VGND sky130_ef_sc_hd__decap_12
XFILLER_6_400 VGND VGND VPWR VPWR sky130_fd_sc_hd__fill_2
XFILLER_196_65 VPWR VGND VPWR VGND sky130_ef_sc_hd__decap_12
XFILLER_167_283 VPWR VGND VPWR VGND sky130_ef_sc_hd__decap_12
XFILLER_183_732 VPWR VGND VPWR VGND sky130_ef_sc_hd__decap_12
XFILLER_210_390 VPWR VGND VPWR VGND sky130_ef_sc_hd__decap_12
Xmax_cap609 rd_addr\[5\] VGND VGND VPWR VPWR net609 sky130_fd_sc_hd__clkbuf_1
XFILLER_100_1411 VPWR VGND VPWR VGND sky130_ef_sc_hd__decap_12
XFILLER_171_916 VPWR VGND VPWR VGND sky130_ef_sc_hd__decap_12
XFILLER_183_787 VPWR VGND VPWR VGND sky130_ef_sc_hd__decap_12
XFILLER_196_1269 VPWR VGND VPWR VGND sky130_ef_sc_hd__decap_12
XFILLER_100_1466 VPWR VGND VPWR VGND sky130_ef_sc_hd__decap_12
XFILLER_135_1507 VGND VGND VPWR VPWR sky130_fd_sc_hd__decap_8
XFILLER_233_1119 VPWR VGND VPWR VGND sky130_ef_sc_hd__decap_12
XFILLER_215_39 VGND VGND VPWR VPWR sky130_fd_sc_hd__decap_4
XFILLER_250_1422 VPWR VGND VPWR VGND sky130_ef_sc_hd__decap_12
XFILLER_238_722 VPWR VGND VPWR VGND sky130_ef_sc_hd__decap_12
XFILLER_46_1294 VPWR VGND VPWR VGND sky130_ef_sc_hd__decap_12
XFILLER_133_1242 VGND VGND VPWR VPWR sky130_fd_sc_hd__decap_6
XFILLER_250_1477 VGND VGND VPWR VPWR sky130_fd_sc_hd__decap_6
XFILLER_226_906 VPWR VGND VPWR VGND sky130_ef_sc_hd__decap_12
XFILLER_238_777 VPWR VGND VPWR VGND sky130_ef_sc_hd__decap_12
XFILLER_168_1305 VGND VGND VPWR VPWR sky130_fd_sc_hd__decap_6
XFILLER_253_725 VGND VGND VPWR VPWR sky130_fd_sc_hd__decap_6
XTAP_TAPCELL_ROW_224_3590 VGND VPWR sky130_fd_sc_hd__tapvpwrvgnd_1
XFILLER_231_27 VPWR VGND VPWR VGND sky130_ef_sc_hd__decap_12
XFILLER_20_1423 VPWR VGND VPWR VGND sky130_ef_sc_hd__decap_12
XTAP_TAPCELL_ROW_220_3443 VGND VPWR sky130_fd_sc_hd__tapvpwrvgnd_1
XTAP_TAPCELL_ROW_220_3454 VGND VPWR sky130_fd_sc_hd__tapvpwrvgnd_1
XTAP_TAPCELL_ROW_220_3465 VGND VPWR sky130_fd_sc_hd__tapvpwrvgnd_1
XFILLER_20_1478 VGND VGND VPWR VPWR sky130_fd_sc_hd__decap_6
XFILLER_234_961 VGND VGND VPWR VPWR sky130_fd_sc_hd__decap_6
XFILLER_244_1226 VPWR VGND VPWR VGND sky130_ef_sc_hd__decap_12
XFILLER_209_1346 VPWR VGND VPWR VGND sky130_ef_sc_hd__decap_12
XFILLER_205_173 VPWR VGND VPWR VGND sky130_ef_sc_hd__decap_12
XFILLER_220_132 VPWR VGND VPWR VGND sky130_ef_sc_hd__decap_12
XFILLER_57_1390 VPWR VGND VPWR VGND sky130_ef_sc_hd__decap_12
XFILLER_92_1270 VPWR VGND VPWR VGND sky130_ef_sc_hd__decap_12
XTAP_TAPCELL_ROW_177_1940 VGND VPWR sky130_fd_sc_hd__tapvpwrvgnd_1
XTAP_TAPCELL_ROW_177_1951 VGND VPWR sky130_fd_sc_hd__tapvpwrvgnd_1
XTAP_TAPCELL_ROW_218_3372 VGND VPWR sky130_fd_sc_hd__tapvpwrvgnd_1
XTAP_TAPCELL_ROW_177_1962 VGND VPWR sky130_fd_sc_hd__tapvpwrvgnd_1
XTAP_TAPCELL_ROW_218_3383 VGND VPWR sky130_fd_sc_hd__tapvpwrvgnd_1
XTAP_TAPCELL_ROW_173_1804 VGND VPWR sky130_fd_sc_hd__tapvpwrvgnd_1
XFILLER_193_529 VPWR VGND VPWR VGND sky130_ef_sc_hd__decap_12
XTAP_TAPCELL_ROW_218_3394 VGND VPWR sky130_fd_sc_hd__tapvpwrvgnd_1
XFILLER_220_187 VGND VGND VPWR VPWR sky130_fd_sc_hd__decap_6
XFILLER_14_1227 VPWR VGND VPWR VGND sky130_ef_sc_hd__decap_12
XFILLER_174_710 VPWR VGND VPWR VGND sky130_ef_sc_hd__decap_12
XTAP_TAPCELL_ROW_173_1815 VGND VPWR sky130_fd_sc_hd__tapvpwrvgnd_1
XFILLER_179_1401 VPWR VGND VPWR VGND sky130_ef_sc_hd__decap_12
XTAP_TAPCELL_ROW_214_3236 VGND VPWR sky130_fd_sc_hd__tapvpwrvgnd_1
XTAP_TAPCELL_ROW_173_1826 VGND VPWR sky130_fd_sc_hd__tapvpwrvgnd_1
XFILLER_186_581 VPWR VGND VPWR VGND sky130_ef_sc_hd__decap_12
XTAP_TAPCELL_ROW_214_3247 VGND VPWR sky130_fd_sc_hd__tapvpwrvgnd_1
XTAP_TAPCELL_ROW_214_3258 VGND VPWR sky130_fd_sc_hd__tapvpwrvgnd_1
XFILLER_88_1306 VGND VGND VPWR VPWR sky130_fd_sc_hd__decap_6
XFILLER_9_282 VGND VGND VPWR VPWR sky130_fd_sc_hd__decap_8
XFILLER_174_765 VPWR VGND VPWR VGND sky130_ef_sc_hd__decap_12
XFILLER_179_1456 VGND VGND VPWR VPWR sky130_fd_sc_hd__decap_6
XFILLER_220_1281 VPWR VGND VPWR VGND sky130_ef_sc_hd__decap_12
XFILLER_255_1366 VPWR VGND VPWR VGND sky130_ef_sc_hd__decap_12
XFILLER_173_1033 VPWR VGND VPWR VGND sky130_ef_sc_hd__decap_12
XFILLER_255_1399 VGND VGND VPWR VPWR sky130_fd_sc_hd__decap_8
XTAP_TAPCELL_ROW_84_2_5336 VGND VPWR sky130_fd_sc_hd__tapvpwrvgnd_1
XFILLER_125_39 VGND VGND VPWR VPWR sky130_fd_sc_hd__decap_4
XTAP_TAPCELL_ROW_167_1608 VGND VPWR sky130_fd_sc_hd__tapvpwrvgnd_1
XTAP_TAPCELL_ROW_208_3029 VGND VPWR sky130_fd_sc_hd__tapvpwrvgnd_1
XFILLER_248_519 VPWR VGND VPWR VGND sky130_ef_sc_hd__decap_12
XFILLER_173_1088 VPWR VGND VPWR VGND sky130_ef_sc_hd__decap_12
XTAP_TAPCELL_ROW_53_2_5083 VGND VPWR sky130_fd_sc_hd__tapvpwrvgnd_1
XPHY_EDGE_ROW_255_Right_100 VGND VGND VPWR VPWR sky130_fd_sc_hd__decap_3
XFILLER_99_1402 VPWR VGND VPWR VGND sky130_ef_sc_hd__decap_12
XFILLER_190_1391 VGND VGND VPWR VPWR sky130_fd_sc_hd__decap_6
XFILLER_229_744 VPWR VGND VPWR VGND sky130_ef_sc_hd__decap_12
XFILLER_25_1378 VPWR VGND VPWR VGND sky130_ef_sc_hd__decap_12
XFILLER_244_703 VGND VGND VPWR VPWR sky130_fd_sc_hd__decap_6
XFILLER_112_1337 VPWR VGND VPWR VGND sky130_ef_sc_hd__decap_12
XFILLER_217_928 VPWR VGND VPWR VGND sky130_ef_sc_hd__decap_12
XFILLER_99_1457 VGND VGND VPWR VPWR sky130_fd_sc_hd__decap_6
XFILLER_229_799 VPWR VGND VPWR VGND sky130_ef_sc_hd__decap_12
XFILLER_141_27 VPWR VGND VPWR VGND sky130_ef_sc_hd__decap_12
XFILLER_3_1174 VPWR VGND VPWR VGND sky130_ef_sc_hd__decap_12
XFILLER_227_1413 VGND VGND VPWR VPWR sky130_fd_sc_hd__decap_6
XTAP_TAPCELL_ROW_255_4730 VGND VPWR sky130_fd_sc_hd__tapvpwrvgnd_1
XFILLER_184_1140 VPWR VGND VPWR VGND sky130_ef_sc_hd__decap_12
XFILLER_225_983 VGND VGND VPWR VPWR sky130_fd_sc_hd__decap_6
XFILLER_58_1165 VPWR VGND VPWR VGND sky130_ef_sc_hd__decap_12
XFILLER_180_1004 VGND VGND VPWR VPWR sky130_fd_sc_hd__decap_6
XFILLER_34_58 VGND VGND VPWR VPWR sky130_fd_sc_hd__decap_6
XFILLER_196_323 VPWR VGND VPWR VGND sky130_ef_sc_hd__decap_12
XFILLER_184_1195 VPWR VGND VPWR VGND sky130_ef_sc_hd__decap_12
XFILLER_211_154 VPWR VGND VPWR VGND sky130_ef_sc_hd__decap_12
XFILLER_184_507 VPWR VGND VPWR VGND sky130_ef_sc_hd__decap_12
XFILLER_200_839 VPWR VGND VPWR VGND sky130_ef_sc_hd__decap_12
XFILLER_196_378 VPWR VGND VPWR VGND sky130_ef_sc_hd__decap_12
Xwire106 net108 VGND VGND VPWR VPWR net106 sky130_fd_sc_hd__clkbuf_1
XFILLER_36_1485 VPWR VGND VPWR VGND sky130_ef_sc_hd__decap_12
Xclkload2 clknet_3_2__leaf_clk VGND VGND VPWR VPWR clkload2/Y sky130_fd_sc_hd__clkinv_2
XFILLER_123_1433 VPWR VGND VPWR VGND sky130_ef_sc_hd__decap_12
XFILLER_221_1045 VPWR VGND VPWR VGND sky130_ef_sc_hd__decap_12
XFILLER_32_1349 VGND VGND VPWR VPWR sky130_fd_sc_hd__decap_6
XFILLER_123_1488 VPWR VGND VPWR VGND sky130_ef_sc_hd__decap_12
XFILLER_166_46 VPWR VGND VPWR VGND sky130_ef_sc_hd__decap_12
XFILLER_192_562 VPWR VGND VPWR VGND sky130_ef_sc_hd__decap_12
XFILLER_4_937 VPWR VGND VPWR VGND sky130_ef_sc_hd__decap_12
XFILLER_180_746 VGND VGND VPWR VPWR sky130_fd_sc_hd__decap_6
XFILLER_69_1261 VPWR VGND VPWR VGND sky130_ef_sc_hd__decap_12
XFILLER_156_1220 VGND VGND VPWR VPWR sky130_fd_sc_hd__decap_6
XFILLER_191_1100 VPWR VGND VPWR VGND sky130_ef_sc_hd__decap_12
XFILLER_195_1291 VPWR VGND VPWR VGND sky130_ef_sc_hd__decap_12
XFILLER_59_44 VPWR VGND VPWR VGND sky130_ef_sc_hd__decap_12
XFILLER_191_1155 VGND VGND VPWR VPWR sky130_fd_sc_hd__decap_6
XFILLER_182_34 VPWR VGND VPWR VGND sky130_ef_sc_hd__decap_12
XTAP_TAPCELL_ROW_187_2291 VGND VPWR sky130_fd_sc_hd__tapvpwrvgnd_1
XTAP_TAPCELL_ROW_183_2144 VGND VPWR sky130_fd_sc_hd__tapvpwrvgnd_1
XFILLER_43_1445 VPWR VGND VPWR VGND sky130_ef_sc_hd__decap_12
XFILLER_182_89 VPWR VGND VPWR VGND sky130_ef_sc_hd__decap_12
XFILLER_232_1152 VPWR VGND VPWR VGND sky130_ef_sc_hd__decap_12
XTAP_TAPCELL_ROW_183_2155 VGND VPWR sky130_fd_sc_hd__tapvpwrvgnd_1
XFILLER_247_541 VPWR VGND VPWR VGND sky130_ef_sc_hd__decap_12
XTAP_TAPCELL_ROW_183_2166 VGND VPWR sky130_fd_sc_hd__tapvpwrvgnd_1
XTAP_TAPCELL_ROW_183_2177 VGND VPWR sky130_fd_sc_hd__tapvpwrvgnd_1
XFILLER_208_906 VPWR VGND VPWR VGND sky130_ef_sc_hd__decap_12
XFILLER_235_725 VGND VGND VPWR VPWR sky130_fd_sc_hd__decap_6
XFILLER_247_596 VGND VGND VPWR VPWR sky130_fd_sc_hd__decap_6
XTAP_TAPCELL_ROW_3_970 VGND VPWR sky130_fd_sc_hd__tapvpwrvgnd_1
XTAP_TAPCELL_ROW_3_981 VGND VPWR sky130_fd_sc_hd__tapvpwrvgnd_1
XTAP_TAPCELL_ROW_3_992 VGND VPWR sky130_fd_sc_hd__tapvpwrvgnd_1
XFILLER_216_961 VGND VGND VPWR VPWR sky130_fd_sc_hd__decap_6
XFILLER_206_1508 VGND VGND VPWR VPWR sky130_fd_sc_hd__decap_6
XTAP_TAPCELL_ROW_141_2_5793 VGND VPWR sky130_fd_sc_hd__tapvpwrvgnd_1
XFILLER_37_1249 VPWR VGND VPWR VGND sky130_ef_sc_hd__decap_12
XFILLER_202_132 VPWR VGND VPWR VGND sky130_ef_sc_hd__decap_12
XFILLER_124_1208 VPWR VGND VPWR VGND sky130_ef_sc_hd__decap_12
XFILLER_187_345 VPWR VGND VPWR VGND sky130_ef_sc_hd__decap_12
XFILLER_230_452 VPWR VGND VPWR VGND sky130_ef_sc_hd__decap_12
XFILLER_128_1399 VPWR VGND VPWR VGND sky130_ef_sc_hd__decap_12
XFILLER_141_1500 VGND VGND VPWR VPWR sky130_fd_sc_hd__decap_6
X_306_ _094_ VGND VGND VPWR VPWR _095_ sky130_fd_sc_hd__inv_2
XFILLER_175_529 VPWR VGND VPWR VGND sky130_ef_sc_hd__decap_12
XFILLER_202_187 VGND VGND VPWR VPWR sky130_fd_sc_hd__decap_6
XFILLER_168_581 VPWR VGND VPWR VGND sky130_ef_sc_hd__decap_12
Xwire640 net641 VGND VGND VPWR VPWR net640 sky130_fd_sc_hd__buf_1
Xwire651 net20 VGND VGND VPWR VPWR net651 sky130_fd_sc_hd__buf_1
XFILLER_196_1011 VPWR VGND VPWR VGND sky130_ef_sc_hd__decap_12
Xwire662 net11 VGND VGND VPWR VPWR net662 sky130_fd_sc_hd__buf_1
XTAP_TAPCELL_ROW_90_2_5379 VGND VPWR sky130_fd_sc_hd__tapvpwrvgnd_1
XTAP_TAPCELL_ROW_232_3870 VGND VPWR sky130_fd_sc_hd__tapvpwrvgnd_1
Xwire673 net1 VGND VGND VPWR VPWR net673 sky130_fd_sc_hd__clkbuf_1
XTAP_TAPCELL_ROW_232_3881 VGND VPWR sky130_fd_sc_hd__tapvpwrvgnd_1
XFILLER_171_713 VPWR VGND VPWR VGND sky130_ef_sc_hd__decap_12
XTAP_TAPCELL_ROW_232_3892 VGND VPWR sky130_fd_sc_hd__tapvpwrvgnd_1
XFILLER_183_584 VPWR VGND VPWR VGND sky130_ef_sc_hd__decap_12
XFILLER_196_1066 VPWR VGND VPWR VGND sky130_ef_sc_hd__decap_12
XTAP_TAPCELL_ROW_102_2_5477 VGND VPWR sky130_fd_sc_hd__tapvpwrvgnd_1
XTAP_TAPCELL_ROW_70_2_5222 VGND VPWR sky130_fd_sc_hd__tapvpwrvgnd_1
XFILLER_100_1263 VGND VGND VPWR VPWR sky130_fd_sc_hd__decap_6
XFILLER_171_768 VGND VGND VPWR VPWR sky130_fd_sc_hd__decap_6
XTAP_TAPCELL_ROW_69_2_5216 VGND VPWR sky130_fd_sc_hd__tapvpwrvgnd_1
XFILLER_48_1356 VPWR VGND VPWR VGND sky130_ef_sc_hd__decap_12
XFILLER_135_1304 VPWR VGND VPWR VGND sky130_ef_sc_hd__decap_12
XFILLER_135_1359 VPWR VGND VPWR VGND sky130_ef_sc_hd__decap_12
XTAP_TAPCELL_ROW_226_3652 VGND VPWR sky130_fd_sc_hd__tapvpwrvgnd_1
XFILLER_242_15 VGND VGND VPWR VPWR sky130_fd_sc_hd__decap_6
XFILLER_27_3 VPWR VGND VPWR VGND sky130_ef_sc_hd__decap_12
XTAP_TAPCELL_ROW_226_3663 VGND VPWR sky130_fd_sc_hd__tapvpwrvgnd_1
XTAP_TAPCELL_ROW_36_2_4946 VGND VPWR sky130_fd_sc_hd__tapvpwrvgnd_1
XTAP_TAPCELL_ROW_226_3674 VGND VPWR sky130_fd_sc_hd__tapvpwrvgnd_1
XTAP_TAPCELL_ROW_222_3516 VGND VPWR sky130_fd_sc_hd__tapvpwrvgnd_1
XTAP_TAPCELL_ROW_222_3527 VGND VPWR sky130_fd_sc_hd__tapvpwrvgnd_1
XTAP_TAPCELL_ROW_222_3538 VGND VPWR sky130_fd_sc_hd__tapvpwrvgnd_1
XFILLER_226_703 VGND VGND VPWR VPWR sky130_fd_sc_hd__decap_6
XTAP_TAPCELL_ROW_1_907 VGND VPWR sky130_fd_sc_hd__tapvpwrvgnd_1
XFILLER_238_574 VGND VGND VPWR VPWR sky130_fd_sc_hd__decap_6
XTAP_TAPCELL_ROW_1_918 VGND VPWR sky130_fd_sc_hd__tapvpwrvgnd_1
XFILLER_20_1220 VGND VGND VPWR VPWR sky130_fd_sc_hd__decap_6
XFILLER_0_1303 VPWR VGND VPWR VGND sky130_ef_sc_hd__decap_12
XFILLER_0_1336 VGND VGND VPWR VPWR sky130_fd_sc_hd__decap_8
XFILLER_207_983 VGND VGND VPWR VPWR sky130_fd_sc_hd__decap_6
XFILLER_146_1411 VPWR VGND VPWR VGND sky130_ef_sc_hd__decap_12
XFILLER_244_1023 VPWR VGND VPWR VGND sky130_ef_sc_hd__decap_12
XFILLER_209_1143 VPWR VGND VPWR VGND sky130_ef_sc_hd__decap_12
XFILLER_55_1316 VPWR VGND VPWR VGND sky130_ef_sc_hd__decap_12
XFILLER_240_249 VPWR VGND VPWR VGND sky130_ef_sc_hd__decap_12
XPHY_EDGE_ROW_127_2_Left_629 VGND VGND VPWR VPWR sky130_fd_sc_hd__decap_3
XFILLER_178_323 VPWR VGND VPWR VGND sky130_ef_sc_hd__decap_12
XFILLER_146_1466 VPWR VGND VPWR VGND sky130_ef_sc_hd__decap_12
XFILLER_181_1346 VPWR VGND VPWR VGND sky130_ef_sc_hd__decap_12
XTAP_TAPCELL_ROW_216_3309 VGND VPWR sky130_fd_sc_hd__tapvpwrvgnd_1
XFILLER_244_1078 VPWR VGND VPWR VGND sky130_ef_sc_hd__decap_12
XFILLER_209_1198 VGND VGND VPWR VPWR sky130_fd_sc_hd__decap_6
XFILLER_221_474 VPWR VGND VPWR VGND sky130_ef_sc_hd__decap_12
XFILLER_166_507 VPWR VGND VPWR VGND sky130_ef_sc_hd__decap_12
XFILLER_178_378 VPWR VGND VPWR VGND sky130_ef_sc_hd__decap_12
XFILLER_193_326 VPWR VGND VPWR VGND sky130_ef_sc_hd__decap_12
XFILLER_222_1398 VPWR VGND VPWR VGND sky130_ef_sc_hd__decap_12
XFILLER_174_562 VPWR VGND VPWR VGND sky130_ef_sc_hd__decap_12
XFILLER_31_1371 VGND VGND VPWR VPWR sky130_fd_sc_hd__decap_6
XFILLER_66_1423 VPWR VGND VPWR VGND sky130_ef_sc_hd__decap_12
XFILLER_192_1453 VPWR VGND VPWR VGND sky130_ef_sc_hd__decap_12
XFILLER_66_1478 VGND VGND VPWR VPWR sky130_fd_sc_hd__decap_6
XFILLER_248_316 VGND VGND VPWR VPWR sky130_fd_sc_hd__decap_6
XTAP_TAPCELL_ROW_105_1_1387 VGND VPWR sky130_fd_sc_hd__tapvpwrvgnd_1
XFILLER_29_36 VGND VGND VPWR VPWR sky130_fd_sc_hd__decap_6
XPHY_EDGE_ROW_168_Right_13 VGND VGND VPWR VPWR sky130_fd_sc_hd__decap_3
XFILLER_152_15 VGND VGND VPWR VPWR sky130_fd_sc_hd__decap_6
XFILLER_229_541 VPWR VGND VPWR VGND sky130_ef_sc_hd__decap_12
XFILLER_116_1270 VPWR VGND VPWR VGND sky130_ef_sc_hd__decap_12
XFILLER_217_725 VGND VGND VPWR VPWR sky130_fd_sc_hd__decap_6
XFILLER_229_596 VGND VGND VPWR VPWR sky130_fd_sc_hd__decap_6
XTAP_TAPCELL_ROW_157_2_5915 VGND VPWR sky130_fd_sc_hd__tapvpwrvgnd_1
XTAP_TAPCELL_ROW_126_2_5673 VGND VPWR sky130_fd_sc_hd__tapvpwrvgnd_1
XFILLER_231_216 VPWR VGND VPWR VGND sky130_ef_sc_hd__decap_12
XFILLER_196_120 VPWR VGND VPWR VGND sky130_ef_sc_hd__decap_12
XFILLER_212_452 VPWR VGND VPWR VGND sky130_ef_sc_hd__decap_12
XFILLER_169_345 VPWR VGND VPWR VGND sky130_ef_sc_hd__decap_12
XPHY_EDGE_ROW_177_Right_22 VGND VGND VPWR VPWR sky130_fd_sc_hd__decap_3
XFILLER_240_1410 VPWR VGND VPWR VGND sky130_ef_sc_hd__decap_12
XTAP_TAPCELL_ROW_195_2571 VGND VPWR sky130_fd_sc_hd__tapvpwrvgnd_1
XFILLER_184_304 VPWR VGND VPWR VGND sky130_ef_sc_hd__decap_12
XTAP_TAPCELL_ROW_195_2582 VGND VPWR sky130_fd_sc_hd__tapvpwrvgnd_1
XTAP_TAPCELL_ROW_191_2424 VGND VPWR sky130_fd_sc_hd__tapvpwrvgnd_1
XTAP_TAPCELL_ROW_195_2593 VGND VPWR sky130_fd_sc_hd__tapvpwrvgnd_1
XFILLER_200_636 VPWR VGND VPWR VGND sky130_ef_sc_hd__decap_12
XFILLER_131_3 VPWR VGND VPWR VGND sky130_ef_sc_hd__decap_12
XTAP_TAPCELL_ROW_191_2435 VGND VPWR sky130_fd_sc_hd__tapvpwrvgnd_1
XFILLER_196_175 VPWR VGND VPWR VGND sky130_ef_sc_hd__decap_12
XFILLER_36_1282 VPWR VGND VPWR VGND sky130_ef_sc_hd__decap_12
XTAP_TAPCELL_ROW_75_2_5259 VGND VPWR sky130_fd_sc_hd__tapvpwrvgnd_1
XFILLER_123_1230 VPWR VGND VPWR VGND sky130_ef_sc_hd__decap_12
XTAP_TAPCELL_ROW_191_2446 VGND VPWR sky130_fd_sc_hd__tapvpwrvgnd_1
XFILLER_229_3 VPWR VGND VPWR VGND sky130_ef_sc_hd__decap_12
XFILLER_240_1465 VPWR VGND VPWR VGND sky130_ef_sc_hd__decap_12
XFILLER_177_56 VPWR VGND VPWR VGND sky130_ef_sc_hd__decap_12
XTAP_TAPCELL_ROW_191_2457 VGND VPWR sky130_fd_sc_hd__tapvpwrvgnd_1
XFILLER_184_359 VGND VGND VPWR VPWR sky130_fd_sc_hd__decap_6
XFILLER_123_1285 VGND VGND VPWR VPWR sky130_fd_sc_hd__decap_6
XTAP_TAPCELL_ROW_55_2_5102 VGND VPWR sky130_fd_sc_hd__tapvpwrvgnd_1
XFILLER_10_1411 VPWR VGND VPWR VGND sky130_ef_sc_hd__decap_12
XFILLER_193_1217 VPWR VGND VPWR VGND sky130_ef_sc_hd__decap_12
XFILLER_158_1337 VPWR VGND VPWR VGND sky130_ef_sc_hd__decap_12
XFILLER_3_222 VGND VGND VPWR VPWR sky130_fd_sc_hd__decap_8
XFILLER_10_1466 VPWR VGND VPWR VGND sky130_ef_sc_hd__decap_12
XFILLER_193_44 VPWR VGND VPWR VGND sky130_ef_sc_hd__decap_12
XTAP_TAPCELL_ROW_189_2364 VGND VPWR sky130_fd_sc_hd__tapvpwrvgnd_1
XTAP_TAPCELL_ROW_189_2375 VGND VPWR sky130_fd_sc_hd__tapvpwrvgnd_1
XFILLER_45_1507 VGND VGND VPWR VPWR sky130_fd_sc_hd__decap_8
XTAP_TAPCELL_ROW_185_2217 VGND VPWR sky130_fd_sc_hd__tapvpwrvgnd_1
XTAP_TAPCELL_ROW_189_2386 VGND VPWR sky130_fd_sc_hd__tapvpwrvgnd_1
XTAP_TAPCELL_ROW_185_2228 VGND VPWR sky130_fd_sc_hd__tapvpwrvgnd_1
XTAP_TAPCELL_ROW_185_2239 VGND VPWR sky130_fd_sc_hd__tapvpwrvgnd_1
XPHY_EDGE_ROW_186_Right_31 VGND VGND VPWR VPWR sky130_fd_sc_hd__decap_3
XFILLER_193_99 VPWR VGND VPWR VGND sky130_ef_sc_hd__decap_12
XFILLER_234_1269 VPWR VGND VPWR VGND sky130_ef_sc_hd__decap_12
XFILLER_239_338 VGND VGND VPWR VPWR sky130_fd_sc_hd__decap_6
XFILLER_43_1242 VGND VGND VPWR VPWR sky130_fd_sc_hd__decap_6
XFILLER_208_703 VGND VGND VPWR VPWR sky130_fd_sc_hd__decap_6
XFILLER_134_1392 VGND VGND VPWR VPWR sky130_fd_sc_hd__decap_6
XFILLER_248_894 VPWR VGND VPWR VGND sky130_ef_sc_hd__decap_12
XFILLER_169_1444 VPWR VGND VPWR VGND sky130_ef_sc_hd__decap_12
XFILLER_78_1349 VGND VGND VPWR VPWR sky130_fd_sc_hd__decap_6
XFILLER_169_1499 VGND VGND VPWR VPWR sky130_fd_sc_hd__decap_6
XPHY_EDGE_ROW_62_1_Left_317 VGND VGND VPWR VPWR sky130_fd_sc_hd__decap_3
XPHY_EDGE_ROW_195_Right_40 VGND VGND VPWR VPWR sky130_fd_sc_hd__decap_3
XFILLER_206_1305 VGND VGND VPWR VPWR sky130_fd_sc_hd__decap_6
XFILLER_222_249 VPWR VGND VPWR VGND sky130_ef_sc_hd__decap_12
XFILLER_241_1229 VPWR VGND VPWR VGND sky130_ef_sc_hd__decap_12
XFILLER_187_142 VPWR VGND VPWR VGND sky130_ef_sc_hd__decap_12
XFILLER_203_474 VPWR VGND VPWR VGND sky130_ef_sc_hd__decap_12
XFILLER_128_1196 VPWR VGND VPWR VGND sky130_ef_sc_hd__decap_12
XTAP_TAPCELL_ROW_234_3932 VGND VPWR sky130_fd_sc_hd__tapvpwrvgnd_1
XTAP_TAPCELL_ROW_234_3943 VGND VPWR sky130_fd_sc_hd__tapvpwrvgnd_1
XFILLER_175_326 VPWR VGND VPWR VGND sky130_ef_sc_hd__decap_12
XTAP_TAPCELL_ROW_234_3954 VGND VPWR sky130_fd_sc_hd__tapvpwrvgnd_1
XFILLER_187_197 VPWR VGND VPWR VGND sky130_ef_sc_hd__decap_12
XTAP_TAPCELL_ROW_230_3807 VGND VPWR sky130_fd_sc_hd__tapvpwrvgnd_1
XTAP_TAPCELL_ROW_230_3818 VGND VPWR sky130_fd_sc_hd__tapvpwrvgnd_1
XFILLER_102_1325 VPWR VGND VPWR VGND sky130_ef_sc_hd__decap_12
XFILLER_237_15 VPWR VGND VPWR VGND sky130_ef_sc_hd__decap_12
XFILLER_89_1445 VPWR VGND VPWR VGND sky130_ef_sc_hd__decap_12
XFILLER_184_882 VPWR VGND VPWR VGND sky130_ef_sc_hd__decap_12
Xwire470 net471 VGND VGND VPWR VPWR net470 sky130_fd_sc_hd__clkbuf_1
Xmax_cap203 _187_ VGND VGND VPWR VPWR net203 sky130_fd_sc_hd__clkbuf_1
Xwire481 net482 VGND VGND VPWR VPWR net481 sky130_fd_sc_hd__clkbuf_1
Xmax_cap214 net215 VGND VGND VPWR VPWR net214 sky130_fd_sc_hd__clkbuf_1
XFILLER_171_510 VGND VGND VPWR VPWR sky130_fd_sc_hd__decap_6
Xwire492 net493 VGND VGND VPWR VPWR net492 sky130_fd_sc_hd__clkbuf_1
XFILLER_183_381 VGND VGND VPWR VPWR sky130_fd_sc_hd__decap_6
Xmax_cap247 net248 VGND VGND VPWR VPWR net247 sky130_fd_sc_hd__clkbuf_1
XFILLER_217_1401 VPWR VGND VPWR VGND sky130_ef_sc_hd__decap_12
XTAP_TAPCELL_ROW_228_3725 VGND VPWR sky130_fd_sc_hd__tapvpwrvgnd_1
XTAP_TAPCELL_ROW_228_3736 VGND VPWR sky130_fd_sc_hd__tapvpwrvgnd_1
XFILLER_252_1336 VPWR VGND VPWR VGND sky130_ef_sc_hd__decap_12
XTAP_TAPCELL_ROW_228_3747 VGND VPWR sky130_fd_sc_hd__tapvpwrvgnd_1
XFILLER_139_1292 VPWR VGND VPWR VGND sky130_ef_sc_hd__decap_12
XFILLER_217_1456 VGND VGND VPWR VPWR sky130_fd_sc_hd__decap_6
XFILLER_174_1183 VPWR VGND VPWR VGND sky130_ef_sc_hd__decap_12
XTAP_TAPCELL_ROW_163_2_5969 VGND VPWR sky130_fd_sc_hd__tapvpwrvgnd_1
XFILLER_170_1047 VGND VGND VPWR VPWR sky130_fd_sc_hd__decap_6
XTAP_TAPCELL_ROW_99_2_5455 VGND VPWR sky130_fd_sc_hd__tapvpwrvgnd_1
XFILLER_135_1189 VPWR VGND VPWR VGND sky130_ef_sc_hd__decap_12
XFILLER_239_861 VPWR VGND VPWR VGND sky130_ef_sc_hd__decap_12
XFILLER_113_1421 VPWR VGND VPWR VGND sky130_ef_sc_hd__decap_12
XFILLER_211_1033 VPWR VGND VPWR VGND sky130_ef_sc_hd__decap_12
XFILLER_254_820 VPWR VGND VPWR VGND sky130_ef_sc_hd__decap_12
XFILLER_22_1337 VPWR VGND VPWR VGND sky130_ef_sc_hd__decap_12
XFILLER_113_1476 VPWR VGND VPWR VGND sky130_ef_sc_hd__decap_12
XFILLER_211_1088 VPWR VGND VPWR VGND sky130_ef_sc_hd__decap_12
XFILLER_254_875 VGND VGND VPWR VPWR sky130_fd_sc_hd__decap_6
XPHY_EDGE_ROW_149_2_Right_240 VGND VGND VPWR VPWR sky130_fd_sc_hd__decap_3
XFILLER_213_216 VPWR VGND VPWR VGND sky130_ef_sc_hd__decap_12
XFILLER_0_1177 VPWR VGND VPWR VGND sky130_ef_sc_hd__decap_12
XFILLER_178_120 VPWR VGND VPWR VGND sky130_ef_sc_hd__decap_12
XFILLER_94_1184 VPWR VGND VPWR VGND sky130_ef_sc_hd__decap_12
XFILLER_146_1263 VGND VGND VPWR VPWR sky130_fd_sc_hd__decap_6
XFILLER_181_1143 VPWR VGND VPWR VGND sky130_ef_sc_hd__decap_12
XFILLER_166_304 VPWR VGND VPWR VGND sky130_ef_sc_hd__decap_12
XFILLER_221_271 VPWR VGND VPWR VGND sky130_ef_sc_hd__decap_12
XFILLER_194_624 VPWR VGND VPWR VGND sky130_ef_sc_hd__decap_12
XFILLER_178_175 VPWR VGND VPWR VGND sky130_ef_sc_hd__decap_12
XFILLER_181_1198 VGND VGND VPWR VPWR sky130_fd_sc_hd__decap_6
XFILLER_33_1433 VPWR VGND VPWR VGND sky130_ef_sc_hd__decap_12
XFILLER_193_123 VGND VGND VPWR VPWR sky130_fd_sc_hd__decap_6
XFILLER_222_1140 VPWR VGND VPWR VGND sky130_ef_sc_hd__decap_12
XFILLER_31_15 VPWR VGND VPWR VGND sky130_ef_sc_hd__decap_12
XFILLER_166_359 VGND VGND VPWR VPWR sky130_fd_sc_hd__decap_6
XFILLER_182_808 VPWR VGND VPWR VGND sky130_ef_sc_hd__decap_12
XFILLER_194_679 VPWR VGND VPWR VGND sky130_ef_sc_hd__decap_12
XTAP_TAPCELL_ROW_250_4490 VGND VPWR sky130_fd_sc_hd__tapvpwrvgnd_1
XFILLER_147_15 VPWR VGND VPWR VGND sky130_ef_sc_hd__decap_12
XFILLER_33_1488 VPWR VGND VPWR VGND sky130_ef_sc_hd__decap_12
XFILLER_222_1195 VPWR VGND VPWR VGND sky130_ef_sc_hd__decap_12
XPHY_EDGE_ROW_1_Right_1 VGND VGND VPWR VPWR sky130_fd_sc_hd__decap_3
XFILLER_190_863 VPWR VGND VPWR VGND sky130_ef_sc_hd__decap_12
XFILLER_66_1220 VGND VGND VPWR VPWR sky130_fd_sc_hd__decap_6
XFILLER_1_704 VGND VGND VPWR VPWR sky130_fd_sc_hd__fill_2
Xoutput48 net542 VGND VGND VPWR VPWR acc_out[14] sky130_fd_sc_hd__buf_2
XFILLER_153_1201 VGND VGND VPWR VPWR sky130_fd_sc_hd__decap_4
XFILLER_192_1250 VPWR VGND VPWR VGND sky130_ef_sc_hd__decap_12
XFILLER_249_603 VPWR VGND VPWR VGND sky130_ef_sc_hd__decap_12
Xoutput59 net532 VGND VGND VPWR VPWR acc_out[24] sky130_fd_sc_hd__buf_2
XTAP_TAPCELL_ROW_244_4283 VGND VPWR sky130_fd_sc_hd__tapvpwrvgnd_1
XFILLER_249_658 VPWR VGND VPWR VGND sky130_ef_sc_hd__decap_12
XTAP_TAPCELL_ROW_244_4294 VGND VPWR sky130_fd_sc_hd__tapvpwrvgnd_1
XTAP_TAPCELL_ROW_240_4147 VGND VPWR sky130_fd_sc_hd__tapvpwrvgnd_1
XTAP_TAPCELL_ROW_240_4158 VGND VPWR sky130_fd_sc_hd__tapvpwrvgnd_1
XTAP_TAPCELL_ROW_240_4169 VGND VPWR sky130_fd_sc_hd__tapvpwrvgnd_1
XFILLER_233_1291 VPWR VGND VPWR VGND sky130_ef_sc_hd__decap_12
XFILLER_243_80 VGND VGND VPWR VPWR sky130_fd_sc_hd__decap_6
XFILLER_56_34 VPWR VGND VPWR VGND sky130_ef_sc_hd__decap_12
XFILLER_5_1033 VPWR VGND VPWR VGND sky130_ef_sc_hd__decap_12
X_640_ clknet_3_3__leaf_clk acc_core.adder.cla_blocks\[1\].block.sum\[2\] _048_ VGND
+ VGND VPWR VPWR net71 sky130_fd_sc_hd__dfrtp_1
XFILLER_245_842 VPWR VGND VPWR VGND sky130_ef_sc_hd__decap_12
XFILLER_5_1088 VPWR VGND VPWR VGND sky130_ef_sc_hd__decap_12
XFILLER_179_3 VPWR VGND VPWR VGND sky130_ef_sc_hd__decap_12
XTAP_TAPCELL_ROW_6_1072 VGND VPWR sky130_fd_sc_hd__tapvpwrvgnd_1
X_571_ net667 VGND VGND VPWR VPWR _053_ sky130_fd_sc_hd__inv_2
XTAP_TAPCELL_ROW_6_1083 VGND VPWR sky130_fd_sc_hd__tapvpwrvgnd_1
XFILLER_229_1327 VGND VGND VPWR VPWR sky130_fd_sc_hd__decap_6
XFILLER_245_897 VGND VGND VPWR VPWR sky130_fd_sc_hd__decap_6
XTAP_TAPCELL_ROW_6_1094 VGND VPWR sky130_fd_sc_hd__tapvpwrvgnd_1
XFILLER_186_1054 VPWR VGND VPWR VGND sky130_ef_sc_hd__decap_12
XFILLER_72_22 VPWR VGND VPWR VGND sky130_ef_sc_hd__decap_12
XTAP_TAPCELL_ROW_197_2644 VGND VPWR sky130_fd_sc_hd__tapvpwrvgnd_1
XFILLER_77_1371 VGND VGND VPWR VPWR sky130_fd_sc_hd__decap_6
XTAP_TAPCELL_ROW_197_2655 VGND VPWR sky130_fd_sc_hd__tapvpwrvgnd_1
XFILLER_204_249 VPWR VGND VPWR VGND sky130_ef_sc_hd__decap_12
XTAP_TAPCELL_ROW_238_4076 VGND VPWR sky130_fd_sc_hd__tapvpwrvgnd_1
XTAP_TAPCELL_ROW_197_2666 VGND VPWR sky130_fd_sc_hd__tapvpwrvgnd_1
XTAP_TAPCELL_ROW_238_4087 VGND VPWR sky130_fd_sc_hd__tapvpwrvgnd_1
XTAP_TAPCELL_ROW_193_2508 VGND VPWR sky130_fd_sc_hd__tapvpwrvgnd_1
XFILLER_188_22 VPWR VGND VPWR VGND sky130_ef_sc_hd__decap_12
XTAP_TAPCELL_ROW_238_4098 VGND VPWR sky130_fd_sc_hd__tapvpwrvgnd_1
XTAP_TAPCELL_ROW_193_2519 VGND VPWR sky130_fd_sc_hd__tapvpwrvgnd_1
XFILLER_169_142 VPWR VGND VPWR VGND sky130_ef_sc_hd__decap_12
XFILLER_34_1208 VPWR VGND VPWR VGND sky130_ef_sc_hd__decap_12
XFILLER_51_1500 VGND VGND VPWR VPWR sky130_fd_sc_hd__decap_6
XFILLER_38_1399 VPWR VGND VPWR VGND sky130_ef_sc_hd__decap_12
XFILLER_125_1347 VPWR VGND VPWR VGND sky130_ef_sc_hd__decap_12
XFILLER_160_1227 VPWR VGND VPWR VGND sky130_ef_sc_hd__decap_12
XFILLER_184_101 VGND VGND VPWR VPWR sky130_fd_sc_hd__decap_6
XFILLER_188_77 VPWR VGND VPWR VGND sky130_ef_sc_hd__decap_12
XFILLER_200_433 VPWR VGND VPWR VGND sky130_ef_sc_hd__decap_12
XFILLER_169_197 VPWR VGND VPWR VGND sky130_ef_sc_hd__decap_12
XFILLER_185_646 VPWR VGND VPWR VGND sky130_ef_sc_hd__decap_12
XFILLER_240_1262 VGND VGND VPWR VPWR sky130_fd_sc_hd__decap_6
XFILLER_200_488 VGND VGND VPWR VPWR sky130_fd_sc_hd__decap_6
XFILLER_166_882 VPWR VGND VPWR VGND sky130_ef_sc_hd__decap_12
XFILLER_165_370 VGND VGND VPWR VPWR sky130_fd_sc_hd__decap_8
XFILLER_181_830 VPWR VGND VPWR VGND sky130_ef_sc_hd__decap_12
XFILLER_193_1014 VPWR VGND VPWR VGND sky130_ef_sc_hd__decap_12
XFILLER_10_1263 VGND VGND VPWR VPWR sky130_fd_sc_hd__decap_6
XFILLER_181_885 VPWR VGND VPWR VGND sky130_ef_sc_hd__decap_12
XTAP_TAPCELL_ROW_148_2_5849 VGND VPWR sky130_fd_sc_hd__tapvpwrvgnd_1
XFILLER_4_586 VGND VGND VPWR VPWR sky130_fd_sc_hd__fill_2
XFILLER_193_1069 VGND VGND VPWR VPWR sky130_fd_sc_hd__decap_6
XFILLER_45_1304 VPWR VGND VPWR VGND sky130_ef_sc_hd__decap_12
XTAP_TAPCELL_ROW_117_2_5596 VGND VPWR sky130_fd_sc_hd__tapvpwrvgnd_1
XFILLER_234_1011 VPWR VGND VPWR VGND sky130_ef_sc_hd__decap_12
XTAP_TAPCELL_ROW_85_2_5341 VGND VPWR sky130_fd_sc_hd__tapvpwrvgnd_1
XFILLER_136_1454 VPWR VGND VPWR VGND sky130_ef_sc_hd__decap_12
XFILLER_171_1334 VPWR VGND VPWR VGND sky130_ef_sc_hd__decap_12
XTAP_TAPCELL_ROW_74_1_1340 VGND VPWR sky130_fd_sc_hd__tapvpwrvgnd_1
XFILLER_45_1359 VPWR VGND VPWR VGND sky130_ef_sc_hd__decap_12
XFILLER_80_1239 VPWR VGND VPWR VGND sky130_ef_sc_hd__decap_12
XFILLER_234_1066 VPWR VGND VPWR VGND sky130_ef_sc_hd__decap_12
XFILLER_0_770 VGND VGND VPWR VPWR sky130_fd_sc_hd__decap_6
XFILLER_171_1389 VPWR VGND VPWR VGND sky130_ef_sc_hd__decap_12
XFILLER_0_792 VGND VGND VPWR VPWR sky130_fd_sc_hd__fill_2
XFILLER_223_39 VGND VGND VPWR VPWR sky130_fd_sc_hd__decap_4
XFILLER_236_820 VPWR VGND VPWR VGND sky130_ef_sc_hd__decap_12
XFILLER_248_691 VPWR VGND VPWR VGND sky130_ef_sc_hd__decap_12
XTAP_TAPCELL_ROW_110_2_5539 VGND VPWR sky130_fd_sc_hd__tapvpwrvgnd_1
XFILLER_169_1241 VGND VGND VPWR VPWR sky130_fd_sc_hd__decap_6
XFILLER_236_875 VGND VGND VPWR VPWR sky130_fd_sc_hd__decap_6
XFILLER_1_1420 VPWR VGND VPWR VGND sky130_ef_sc_hd__decap_12
XFILLER_165_1105 VGND VGND VPWR VPWR sky130_fd_sc_hd__decap_8
XFILLER_56_1411 VPWR VGND VPWR VGND sky130_ef_sc_hd__decap_12
XFILLER_1_1475 VPWR VGND VPWR VGND sky130_ef_sc_hd__decap_12
XFILLER_250_366 VPWR VGND VPWR VGND sky130_ef_sc_hd__decap_12
XFILLER_182_1441 VPWR VGND VPWR VGND sky130_ef_sc_hd__decap_12
XFILLER_245_1162 VPWR VGND VPWR VGND sky130_ef_sc_hd__decap_12
XFILLER_91_1335 VPWR VGND VPWR VGND sky130_ef_sc_hd__decap_12
XFILLER_56_1466 VPWR VGND VPWR VGND sky130_ef_sc_hd__decap_12
XFILLER_94_3 VPWR VGND VPWR VGND sky130_ef_sc_hd__decap_12
XFILLER_143_1414 VGND VGND VPWR VPWR sky130_fd_sc_hd__decap_6
XFILLER_241_1026 VGND VGND VPWR VPWR sky130_fd_sc_hd__decap_6
XFILLER_203_271 VPWR VGND VPWR VGND sky130_ef_sc_hd__decap_12
XFILLER_176_624 VPWR VGND VPWR VGND sky130_ef_sc_hd__decap_12
XFILLER_182_1496 VPWR VGND VPWR VGND sky130_ef_sc_hd__decap_12
XTAP_TAPCELL_ROW_13_2_4766 VGND VPWR sky130_fd_sc_hd__tapvpwrvgnd_1
XFILLER_188_495 VPWR VGND VPWR VGND sky130_ef_sc_hd__decap_12
XFILLER_175_123 VGND VGND VPWR VPWR sky130_fd_sc_hd__decap_6
XFILLER_248_58 VGND VGND VPWR VPWR sky130_fd_sc_hd__decap_6
XFILLER_176_679 VPWR VGND VPWR VGND sky130_ef_sc_hd__decap_12
XFILLER_191_627 VPWR VGND VPWR VGND sky130_ef_sc_hd__decap_12
XFILLER_89_1242 VGND VGND VPWR VPWR sky130_fd_sc_hd__decap_6
XFILLER_102_1177 VGND VGND VPWR VPWR sky130_fd_sc_hd__decap_6
XFILLER_172_863 VPWR VGND VPWR VGND sky130_ef_sc_hd__decap_12
XFILLER_137_1218 VPWR VGND VPWR VGND sky130_ef_sc_hd__decap_12
XFILLER_172_1109 VPWR VGND VPWR VGND sky130_ef_sc_hd__decap_12
XFILLER_252_1133 VGND VGND VPWR VPWR sky130_fd_sc_hd__decap_6
XFILLER_246_617 VGND VGND VPWR VPWR sky130_fd_sc_hd__decap_6
XFILLER_133_39 VGND VGND VPWR VPWR sky130_fd_sc_hd__decap_4
XFILLER_26_1270 VPWR VGND VPWR VGND sky130_ef_sc_hd__decap_12
XFILLER_230_1453 VPWR VGND VPWR VGND sky130_ef_sc_hd__decap_12
XFILLER_227_842 VPWR VGND VPWR VGND sky130_ef_sc_hd__decap_12
XFILLER_113_1273 VPWR VGND VPWR VGND sky130_ef_sc_hd__decap_12
XFILLER_26_15 VGND VGND VPWR VPWR sky130_fd_sc_hd__decap_6
XFILLER_227_897 VGND VGND VPWR VPWR sky130_fd_sc_hd__decap_6
XFILLER_148_1325 VPWR VGND VPWR VGND sky130_ef_sc_hd__decap_12
XFILLER_183_1205 VPWR VGND VPWR VGND sky130_ef_sc_hd__decap_12
XFILLER_198_237 VPWR VGND VPWR VGND sky130_ef_sc_hd__decap_12
XTAP_TAPCELL_ROW_200_2740 VGND VPWR sky130_fd_sc_hd__tapvpwrvgnd_1
XTAP_TAPCELL_ROW_200_2751 VGND VPWR sky130_fd_sc_hd__tapvpwrvgnd_1
XTAP_TAPCELL_ROW_200_2762 VGND VPWR sky130_fd_sc_hd__tapvpwrvgnd_1
XFILLER_241_388 VPWR VGND VPWR VGND sky130_ef_sc_hd__decap_12
XTAP_TAPCELL_ROW_200_2773 VGND VPWR sky130_fd_sc_hd__tapvpwrvgnd_1
XTAP_TAPCELL_ROW_252_4563 VGND VPWR sky130_fd_sc_hd__tapvpwrvgnd_1
XTAP_TAPCELL_ROW_252_4574 VGND VPWR sky130_fd_sc_hd__tapvpwrvgnd_1
XFILLER_166_101 VGND VGND VPWR VPWR sky130_fd_sc_hd__decap_6
XTAP_TAPCELL_ROW_252_4585 VGND VPWR sky130_fd_sc_hd__tapvpwrvgnd_1
XFILLER_122_1509 VGND VGND VPWR VPWR sky130_fd_sc_hd__decap_6
XFILLER_194_421 VPWR VGND VPWR VGND sky130_ef_sc_hd__decap_12
XFILLER_210_753 VPWR VGND VPWR VGND sky130_ef_sc_hd__decap_12
XFILLER_167_646 VPWR VGND VPWR VGND sky130_ef_sc_hd__decap_12
XFILLER_42_69 VGND VGND VPWR VPWR sky130_fd_sc_hd__fill_2
XFILLER_33_1230 VPWR VGND VPWR VGND sky130_ef_sc_hd__decap_12
XFILLER_6_807 VGND VGND VPWR VPWR sky130_fd_sc_hd__fill_1
XFILLER_158_58 VGND VGND VPWR VPWR sky130_fd_sc_hd__decap_6
XFILLER_182_605 VPWR VGND VPWR VGND sky130_ef_sc_hd__decap_12
XTAP_TAPCELL_ROW_80_1_1350 VGND VPWR sky130_fd_sc_hd__tapvpwrvgnd_1
XFILLER_124_1380 VPWR VGND VPWR VGND sky130_ef_sc_hd__decap_12
XFILLER_194_476 VPWR VGND VPWR VGND sky130_ef_sc_hd__decap_12
XFILLER_33_1285 VGND VGND VPWR VPWR sky130_fd_sc_hd__decap_6
XTAP_TAPCELL_ROW_134_2_5735 VGND VPWR sky130_fd_sc_hd__tapvpwrvgnd_1
XFILLER_159_1421 VPWR VGND VPWR VGND sky130_ef_sc_hd__decap_12
XFILLER_194_1312 VPWR VGND VPWR VGND sky130_ef_sc_hd__decap_12
XTAP_TAPCELL_ROW_103_2_5482 VGND VPWR sky130_fd_sc_hd__tapvpwrvgnd_1
XFILLER_68_1337 VPWR VGND VPWR VGND sky130_ef_sc_hd__decap_12
XFILLER_190_660 VGND VGND VPWR VPWR sky130_fd_sc_hd__decap_6
XFILLER_159_1476 VPWR VGND VPWR VGND sky130_ef_sc_hd__decap_12
XFILLER_174_46 VPWR VGND VPWR VGND sky130_ef_sc_hd__decap_12
XFILLER_194_1367 VPWR VGND VPWR VGND sky130_ef_sc_hd__decap_12
XTAP_TAPCELL_ROW_246_4356 VGND VPWR sky130_fd_sc_hd__tapvpwrvgnd_1
XTAP_TAPCELL_ROW_246_4367 VGND VPWR sky130_fd_sc_hd__tapvpwrvgnd_1
XFILLER_249_400 VPWR VGND VPWR VGND sky130_ef_sc_hd__decap_12
XTAP_TAPCELL_ROW_246_4378 VGND VPWR sky130_fd_sc_hd__tapvpwrvgnd_1
XTAP_TAPCELL_ROW_242_4209 VGND VPWR sky130_fd_sc_hd__tapvpwrvgnd_1
XFILLER_231_1217 VPWR VGND VPWR VGND sky130_ef_sc_hd__decap_12
XFILLER_249_455 VPWR VGND VPWR VGND sky130_ef_sc_hd__decap_12
XFILLER_67_44 VPWR VGND VPWR VGND sky130_ef_sc_hd__decap_12
XFILLER_118_1184 VPWR VGND VPWR VGND sky130_ef_sc_hd__decap_12
XTAP_TAPCELL_ROW_52_2_5079 VGND VPWR sky130_fd_sc_hd__tapvpwrvgnd_1
XFILLER_190_34 VPWR VGND VPWR VGND sky130_ef_sc_hd__decap_12
XTAP_TAPCELL_ROW_8_1145 VGND VPWR sky130_fd_sc_hd__tapvpwrvgnd_1
XFILLER_237_639 VGND VGND VPWR VPWR sky130_fd_sc_hd__decap_6
XTAP_TAPCELL_ROW_8_1156 VGND VPWR sky130_fd_sc_hd__tapvpwrvgnd_1
XFILLER_218_820 VPWR VGND VPWR VGND sky130_ef_sc_hd__decap_12
XFILLER_44_1392 VGND VGND VPWR VPWR sky130_fd_sc_hd__decap_6
XTAP_TAPCELL_ROW_8_1167 VGND VPWR sky130_fd_sc_hd__tapvpwrvgnd_1
XTAP_TAPCELL_ROW_4_1009 VGND VPWR sky130_fd_sc_hd__tapvpwrvgnd_1
XFILLER_190_89 VPWR VGND VPWR VGND sky130_ef_sc_hd__decap_12
XTAP_TAPCELL_ROW_199_2706 VGND VPWR sky130_fd_sc_hd__tapvpwrvgnd_1
X_623_ clknet_3_4__leaf_clk dout0\[21\] _031_ VGND VGND VPWR VPWR dout0_q\[21\] sky130_fd_sc_hd__dfrtp_1
XFILLER_79_1433 VPWR VGND VPWR VGND sky130_ef_sc_hd__decap_12
XTAP_TAPCELL_ROW_199_2717 VGND VPWR sky130_fd_sc_hd__tapvpwrvgnd_1
XFILLER_218_875 VGND VGND VPWR VPWR sky130_fd_sc_hd__decap_6
XTAP_TAPCELL_ROW_199_2728 VGND VPWR sky130_fd_sc_hd__tapvpwrvgnd_1
X_554_ net670 VGND VGND VPWR VPWR _036_ sky130_fd_sc_hd__inv_2
XFILLER_79_1488 VPWR VGND VPWR VGND sky130_ef_sc_hd__decap_12
XTAP_TAPCELL_ROW_30_2_4905 VGND VPWR sky130_fd_sc_hd__tapvpwrvgnd_1
XFILLER_189_259 VPWR VGND VPWR VGND sky130_ef_sc_hd__decap_12
XFILLER_232_366 VPWR VGND VPWR VGND sky130_ef_sc_hd__decap_12
X_485_ net496 net101 net174 VGND VGND VPWR VPWR _248_ sky130_fd_sc_hd__a21oi_1
XFILLER_199_87 VPWR VGND VPWR VGND sky130_ef_sc_hd__decap_12
XFILLER_242_1324 VPWR VGND VPWR VGND sky130_ef_sc_hd__decap_12
XFILLER_207_1444 VPWR VGND VPWR VGND sky130_ef_sc_hd__decap_12
XFILLER_38_1196 VPWR VGND VPWR VGND sky130_ef_sc_hd__decap_12
XFILLER_200_230 VGND VGND VPWR VPWR sky130_fd_sc_hd__decap_6
XFILLER_242_1379 VPWR VGND VPWR VGND sky130_ef_sc_hd__decap_12
XFILLER_207_1499 VGND VGND VPWR VPWR sky130_fd_sc_hd__decap_6
XFILLER_185_443 VPWR VGND VPWR VGND sky130_ef_sc_hd__decap_12
XFILLER_201_775 VPWR VGND VPWR VGND sky130_ef_sc_hd__decap_12
XFILLER_125_1177 VPWR VGND VPWR VGND sky130_ef_sc_hd__decap_12
XFILLER_8_144 VGND VGND VPWR VPWR sky130_fd_sc_hd__decap_6
XPHY_EDGE_ROW_205_Left_460 VGND VGND VPWR VPWR sky130_fd_sc_hd__decap_3
XFILLER_173_627 VPWR VGND VPWR VGND sky130_ef_sc_hd__decap_12
XFILLER_12_1325 VPWR VGND VPWR VGND sky130_ef_sc_hd__decap_12
XFILLER_185_498 VPWR VGND VPWR VGND sky130_ef_sc_hd__decap_12
XFILLER_103_1464 VPWR VGND VPWR VGND sky130_ef_sc_hd__decap_12
XFILLER_201_1076 VPWR VGND VPWR VGND sky130_ef_sc_hd__decap_12
XFILLER_181_682 VGND VGND VPWR VPWR sky130_fd_sc_hd__decap_6
XFILLER_253_1420 VPWR VGND VPWR VGND sky130_ef_sc_hd__decap_12
XTAP_TAPCELL_ROW_210_3091 VGND VPWR sky130_fd_sc_hd__tapvpwrvgnd_1
XFILLER_49_1292 VPWR VGND VPWR VGND sky130_ef_sc_hd__decap_12
XFILLER_136_1251 VPWR VGND VPWR VGND sky130_ef_sc_hd__decap_12
XFILLER_171_1131 VPWR VGND VPWR VGND sky130_ef_sc_hd__decap_12
XFILLER_253_1475 VPWR VGND VPWR VGND sky130_ef_sc_hd__decap_12
XPHY_EDGE_ROW_136_2_Left_638 VGND VGND VPWR VPWR sky130_fd_sc_hd__decap_3
XFILLER_228_617 VGND VGND VPWR VPWR sky130_fd_sc_hd__decap_6
XFILLER_171_1186 VPWR VGND VPWR VGND sky130_ef_sc_hd__decap_12
XFILLER_23_1421 VPWR VGND VPWR VGND sky130_ef_sc_hd__decap_12
XFILLER_97_1500 VGND VGND VPWR VPWR sky130_fd_sc_hd__decap_6
XFILLER_209_842 VPWR VGND VPWR VGND sky130_ef_sc_hd__decap_12
XFILLER_250_15 VGND VGND VPWR VPWR sky130_fd_sc_hd__decap_6
XFILLER_23_1476 VPWR VGND VPWR VGND sky130_ef_sc_hd__decap_12
XFILLER_212_1183 VPWR VGND VPWR VGND sky130_ef_sc_hd__decap_12
XFILLER_242_108 VPWR VGND VPWR VGND sky130_ef_sc_hd__decap_12
XFILLER_110_1435 VGND VGND VPWR VPWR sky130_fd_sc_hd__decap_6
XFILLER_209_897 VGND VGND VPWR VPWR sky130_fd_sc_hd__decap_6
XFILLER_184_1514 VGND VGND VPWR VPWR sky130_fd_sc_hd__fill_1
XFILLER_1_1272 VPWR VGND VPWR VGND sky130_ef_sc_hd__decap_12
XFILLER_208_1219 VGND VGND VPWR VPWR sky130_fd_sc_hd__decap_6
XFILLER_211_517 VPWR VGND VPWR VGND sky130_ef_sc_hd__decap_12
XFILLER_250_163 VPWR VGND VPWR VGND sky130_ef_sc_hd__decap_12
XTAP_TAPCELL_ROW_140_2_5778 VGND VPWR sky130_fd_sc_hd__tapvpwrvgnd_1
XFILLER_223_388 VPWR VGND VPWR VGND sky130_ef_sc_hd__decap_12
XFILLER_56_1263 VGND VGND VPWR VPWR sky130_fd_sc_hd__decap_6
XFILLER_91_1165 VPWR VGND VPWR VGND sky130_ef_sc_hd__decap_12
XFILLER_176_421 VPWR VGND VPWR VGND sky130_ef_sc_hd__decap_12
XFILLER_182_1293 VPWR VGND VPWR VGND sky130_ef_sc_hd__decap_12
XFILLER_188_292 VPWR VGND VPWR VGND sky130_ef_sc_hd__decap_12
XTAP_TAPCELL_ROW_120_2_5621 VGND VPWR sky130_fd_sc_hd__tapvpwrvgnd_1
XFILLER_12_17 VGND VGND VPWR VPWR sky130_fd_sc_hd__decap_4
XTAP_TAPCELL_ROW_119_2_5615 VGND VPWR sky130_fd_sc_hd__tapvpwrvgnd_1
XFILLER_104_1239 VPWR VGND VPWR VGND sky130_ef_sc_hd__decap_12
XFILLER_192_925 VPWR VGND VPWR VGND sky130_ef_sc_hd__decap_12
XFILLER_176_476 VPWR VGND VPWR VGND sky130_ef_sc_hd__decap_12
XFILLER_191_424 VGND VGND VPWR VPWR sky130_fd_sc_hd__decap_6
XFILLER_219_1315 VPWR VGND VPWR VGND sky130_ef_sc_hd__decap_12
XFILLER_172_660 VGND VGND VPWR VPWR sky130_fd_sc_hd__decap_6
XFILLER_63_1201 VGND VGND VPWR VPWR sky130_fd_sc_hd__decap_4
XFILLER_176_1097 VPWR VGND VPWR VGND sky130_ef_sc_hd__decap_12
XFILLER_247_904 VPWR VGND VPWR VGND sky130_ef_sc_hd__decap_12
XFILLER_115_1335 VPWR VGND VPWR VGND sky130_ef_sc_hd__decap_12
Xfanout668 net672 VGND VGND VPWR VPWR net668 sky130_fd_sc_hd__buf_4
XFILLER_219_639 VGND VGND VPWR VPWR sky130_fd_sc_hd__decap_6
XFILLER_247_959 VPWR VGND VPWR VGND sky130_ef_sc_hd__decap_12
XFILLER_230_1250 VPWR VGND VPWR VGND sky130_ef_sc_hd__decap_12
XFILLER_160_15 VGND VGND VPWR VPWR sky130_fd_sc_hd__decap_6
XFILLER_6_1183 VPWR VGND VPWR VGND sky130_ef_sc_hd__decap_12
XTAP_TAPCELL_ROW_206_2960 VGND VPWR sky130_fd_sc_hd__tapvpwrvgnd_1
XTAP_TAPCELL_ROW_206_2971 VGND VPWR sky130_fd_sc_hd__tapvpwrvgnd_1
XFILLER_2_1047 VGND VGND VPWR VPWR sky130_fd_sc_hd__decap_6
XTAP_TAPCELL_ROW_202_2813 VGND VPWR sky130_fd_sc_hd__tapvpwrvgnd_1
XTAP_TAPCELL_ROW_206_2982 VGND VPWR sky130_fd_sc_hd__tapvpwrvgnd_1
XTAP_TAPCELL_ROW_202_2824 VGND VPWR sky130_fd_sc_hd__tapvpwrvgnd_1
XFILLER_183_1002 VPWR VGND VPWR VGND sky130_ef_sc_hd__decap_12
XTAP_TAPCELL_ROW_202_2835 VGND VPWR sky130_fd_sc_hd__tapvpwrvgnd_1
XTAP_TAPCELL_ROW_254_4636 VGND VPWR sky130_fd_sc_hd__tapvpwrvgnd_1
XFILLER_241_130 VPWR VGND VPWR VGND sky130_ef_sc_hd__decap_12
XTAP_TAPCELL_ROW_254_4647 VGND VPWR sky130_fd_sc_hd__tapvpwrvgnd_1
XFILLER_183_1057 VPWR VGND VPWR VGND sky130_ef_sc_hd__decap_12
XFILLER_214_366 VPWR VGND VPWR VGND sky130_ef_sc_hd__decap_12
XTAP_TAPCELL_ROW_254_4658 VGND VPWR sky130_fd_sc_hd__tapvpwrvgnd_1
XFILLER_148_1177 VGND VGND VPWR VPWR sky130_fd_sc_hd__decap_6
XFILLER_53_57 VPWR VGND VPWR VGND sky130_ef_sc_hd__decap_12
XFILLER_241_185 VPWR VGND VPWR VGND sky130_ef_sc_hd__decap_12
XFILLER_186_218 VPWR VGND VPWR VGND sky130_ef_sc_hd__decap_12
XFILLER_126_1442 VPWR VGND VPWR VGND sky130_ef_sc_hd__decap_12
XFILLER_70_1227 VPWR VGND VPWR VGND sky130_ef_sc_hd__decap_12
XFILLER_169_68 VPWR VGND VPWR VGND sky130_ef_sc_hd__decap_12
XFILLER_224_1054 VPWR VGND VPWR VGND sky130_ef_sc_hd__decap_12
XFILLER_35_1347 VPWR VGND VPWR VGND sky130_ef_sc_hd__decap_12
XFILLER_122_1306 VGND VGND VPWR VPWR sky130_fd_sc_hd__decap_6
XFILLER_167_443 VPWR VGND VPWR VGND sky130_ef_sc_hd__decap_12
XFILLER_210_550 VPWR VGND VPWR VGND sky130_ef_sc_hd__decap_12
XFILLER_126_1497 VPWR VGND VPWR VGND sky130_ef_sc_hd__decap_12
XFILLER_182_402 VGND VGND VPWR VPWR sky130_fd_sc_hd__decap_6
XFILLER_194_273 VGND VGND VPWR VPWR sky130_fd_sc_hd__decap_6
XFILLER_167_498 VPWR VGND VPWR VGND sky130_ef_sc_hd__decap_12
XFILLER_183_947 VPWR VGND VPWR VGND sky130_ef_sc_hd__decap_12
XFILLER_211_3 VPWR VGND VPWR VGND sky130_ef_sc_hd__decap_12
XTAP_TAPCELL_ROW_248_4429 VGND VPWR sky130_fd_sc_hd__tapvpwrvgnd_1
XPHY_EDGE_ROW_134_1_Left_389 VGND VGND VPWR VPWR sky130_fd_sc_hd__decap_3
XFILLER_185_56 VPWR VGND VPWR VGND sky130_ef_sc_hd__decap_12
XFILLER_5_169 VGND VGND VPWR VPWR sky130_fd_sc_hd__decap_3
XFILLER_159_1273 VPWR VGND VPWR VGND sky130_ef_sc_hd__decap_12
XFILLER_194_1164 VPWR VGND VPWR VGND sky130_ef_sc_hd__decap_12
XPHY_EDGE_ROW_71_1_Left_326 VGND VGND VPWR VPWR sky130_fd_sc_hd__decap_3
XFILLER_78_65 VGND VGND VPWR VPWR sky130_fd_sc_hd__decap_6
XTAP_TAPCELL_ROW_164_2_5974 VGND VPWR sky130_fd_sc_hd__tapvpwrvgnd_1
XFILLER_46_1454 VPWR VGND VPWR VGND sky130_ef_sc_hd__decap_12
XFILLER_133_1402 VPWR VGND VPWR VGND sky130_ef_sc_hd__decap_12
XFILLER_231_1014 VPWR VGND VPWR VGND sky130_ef_sc_hd__decap_12
XFILLER_249_252 VGND VGND VPWR VPWR sky130_fd_sc_hd__decap_6
XFILLER_172_1484 VPWR VGND VPWR VGND sky130_ef_sc_hd__decap_12
XFILLER_81_1378 VPWR VGND VPWR VGND sky130_ef_sc_hd__decap_12
XFILLER_238_937 VPWR VGND VPWR VGND sky130_ef_sc_hd__decap_12
XFILLER_133_1457 VGND VGND VPWR VPWR sky130_fd_sc_hd__decap_6
XFILLER_231_1069 VGND VGND VPWR VPWR sky130_fd_sc_hd__decap_6
XFILLER_79_1230 VPWR VGND VPWR VGND sky130_ef_sc_hd__decap_12
XFILLER_224_108 VPWR VGND VPWR VGND sky130_ef_sc_hd__decap_12
XFILLER_246_992 VPWR VGND VPWR VGND sky130_ef_sc_hd__decap_12
X_606_ clknet_3_1__leaf_clk dout0\[4\] _014_ VGND VGND VPWR VPWR dout0_q\[4\] sky130_fd_sc_hd__dfrtp_1
XFILLER_209_1506 VGND VGND VPWR VPWR sky130_fd_sc_hd__decap_8
XFILLER_79_1285 VGND VGND VPWR VPWR sky130_fd_sc_hd__decap_6
XTAP_TAPCELL_ROW_125_2_5658 VGND VPWR sky130_fd_sc_hd__tapvpwrvgnd_1
XTAP_TAPCELL_ROW_93_2_5403 VGND VPWR sky130_fd_sc_hd__tapvpwrvgnd_1
XFILLER_127_1206 VPWR VGND VPWR VGND sky130_ef_sc_hd__decap_12
X_537_ net667 VGND VGND VPWR VPWR _019_ sky130_fd_sc_hd__inv_2
XTAP_TAPCELL_ROW_62_2_5161 VGND VPWR sky130_fd_sc_hd__tapvpwrvgnd_1
XFILLER_205_388 VPWR VGND VPWR VGND sky130_ef_sc_hd__decap_12
XFILLER_232_163 VPWR VGND VPWR VGND sky130_ef_sc_hd__decap_12
XFILLER_242_1121 VPWR VGND VPWR VGND sky130_ef_sc_hd__decap_12
XFILLER_53_1414 VGND VGND VPWR VPWR sky130_fd_sc_hd__decap_6
XTAP_TAPCELL_ROW_105_2_5501 VGND VPWR sky130_fd_sc_hd__tapvpwrvgnd_1
XFILLER_207_1241 VGND VGND VPWR VPWR sky130_fd_sc_hd__decap_6
X_468_ net154 net104 VGND VGND VPWR VPWR acc_core.adder.cla_blocks\[1\].block.sum\[2\]
+ sky130_fd_sc_hd__xnor2_1
XFILLER_220_347 VPWR VGND VPWR VGND sky130_ef_sc_hd__decap_12
XFILLER_92_1485 VPWR VGND VPWR VGND sky130_ef_sc_hd__decap_12
XFILLER_242_1176 VGND VGND VPWR VPWR sky130_fd_sc_hd__decap_6
XFILLER_9_442 VGND VGND VPWR VPWR sky130_fd_sc_hd__fill_2
XFILLER_185_240 VPWR VGND VPWR VGND sky130_ef_sc_hd__decap_12
XFILLER_229_27 VPWR VGND VPWR VGND sky130_ef_sc_hd__decap_12
X_399_ net591 net587 net565 VGND VGND VPWR VPWR _188_ sky130_fd_sc_hd__nand3_1
XFILLER_201_572 VPWR VGND VPWR VGND sky130_ef_sc_hd__decap_12
XFILLER_174_925 VPWR VGND VPWR VGND sky130_ef_sc_hd__decap_12
XFILLER_186_796 VPWR VGND VPWR VGND sky130_ef_sc_hd__decap_12
XTAP_TAPCELL_ROW_28_2_4885 VGND VPWR sky130_fd_sc_hd__tapvpwrvgnd_1
XFILLER_220_1441 VPWR VGND VPWR VGND sky130_ef_sc_hd__decap_12
XFILLER_173_424 VGND VGND VPWR VPWR sky130_fd_sc_hd__decap_6
XFILLER_185_295 VGND VGND VPWR VPWR sky130_fd_sc_hd__decap_6
XTAP_TAPCELL_ROW_62_1_1322 VGND VPWR sky130_fd_sc_hd__tapvpwrvgnd_1
XTAP_TAPCELL_ROW_175_1890 VGND VPWR sky130_fd_sc_hd__tapvpwrvgnd_1
XFILLER_103_1261 VPWR VGND VPWR VGND sky130_ef_sc_hd__decap_12
XTAP_TAPCELL_ROW_171_1732 VGND VPWR sky130_fd_sc_hd__tapvpwrvgnd_1
XTAP_TAPCELL_ROW_171_1743 VGND VPWR sky130_fd_sc_hd__tapvpwrvgnd_1
XTAP_TAPCELL_ROW_212_3164 VGND VPWR sky130_fd_sc_hd__tapvpwrvgnd_1
XFILLER_220_1496 VPWR VGND VPWR VGND sky130_ef_sc_hd__decap_12
XFILLER_255_1504 VGND VGND VPWR VPWR sky130_fd_sc_hd__decap_8
XTAP_TAPCELL_ROW_171_1754 VGND VPWR sky130_fd_sc_hd__tapvpwrvgnd_1
XTAP_TAPCELL_ROW_212_3175 VGND VPWR sky130_fd_sc_hd__tapvpwrvgnd_1
XFILLER_57_3 VPWR VGND VPWR VGND sky130_ef_sc_hd__decap_12
XFILLER_12_1177 VGND VGND VPWR VPWR sky130_fd_sc_hd__decap_6
XTAP_TAPCELL_ROW_212_3186 VGND VPWR sky130_fd_sc_hd__tapvpwrvgnd_1
XFILLER_245_15 VPWR VGND VPWR VGND sky130_ef_sc_hd__decap_12
XFILLER_138_1313 VPWR VGND VPWR VGND sky130_ef_sc_hd__decap_12
XFILLER_182_980 VPWR VGND VPWR VGND sky130_ef_sc_hd__decap_12
XFILLER_47_1218 VPWR VGND VPWR VGND sky130_ef_sc_hd__decap_12
XFILLER_4_180 VGND VGND VPWR VPWR sky130_fd_sc_hd__decap_8
XFILLER_173_1248 VPWR VGND VPWR VGND sky130_ef_sc_hd__decap_12
XFILLER_138_1368 VPWR VGND VPWR VGND sky130_ef_sc_hd__decap_12
XTAP_TAPCELL_ROW_21_2_4828 VGND VPWR sky130_fd_sc_hd__tapvpwrvgnd_1
XFILLER_229_904 VPWR VGND VPWR VGND sky130_ef_sc_hd__decap_12
XFILLER_253_1272 VPWR VGND VPWR VGND sky130_ef_sc_hd__decap_12
XTAP_TAPCELL_ROW_169_1661 VGND VPWR sky130_fd_sc_hd__tapvpwrvgnd_1
XTAP_TAPCELL_ROW_165_1503 VGND VPWR sky130_fd_sc_hd__tapvpwrvgnd_1
XTAP_TAPCELL_ROW_169_1672 VGND VPWR sky130_fd_sc_hd__tapvpwrvgnd_1
XTAP_TAPCELL_ROW_165_1514 VGND VPWR sky130_fd_sc_hd__tapvpwrvgnd_1
XTAP_TAPCELL_ROW_169_1683 VGND VPWR sky130_fd_sc_hd__tapvpwrvgnd_1
XFILLER_255_211 VPWR VGND VPWR VGND sky130_ef_sc_hd__decap_12
XTAP_TAPCELL_ROW_165_1525 VGND VPWR sky130_fd_sc_hd__tapvpwrvgnd_1
XFILLER_229_959 VPWR VGND VPWR VGND sky130_ef_sc_hd__decap_12
XTAP_TAPCELL_ROW_165_1536 VGND VPWR sky130_fd_sc_hd__tapvpwrvgnd_1
XFILLER_210_1109 VPWR VGND VPWR VGND sky130_ef_sc_hd__decap_12
XTAP_TAPCELL_ROW_165_1547 VGND VPWR sky130_fd_sc_hd__tapvpwrvgnd_1
XFILLER_255_244 VGND VGND VPWR VPWR sky130_fd_sc_hd__decap_8
XFILLER_244_918 VGND VGND VPWR VPWR sky130_fd_sc_hd__decap_6
XFILLER_3_1334 VPWR VGND VPWR VGND sky130_ef_sc_hd__decap_12
XFILLER_23_1273 VPWR VGND VPWR VGND sky130_ef_sc_hd__decap_12
XFILLER_58_1325 VPWR VGND VPWR VGND sky130_ef_sc_hd__decap_12
XFILLER_3_1389 VPWR VGND VPWR VGND sky130_ef_sc_hd__decap_12
XFILLER_223_130 VPWR VGND VPWR VGND sky130_ef_sc_hd__decap_12
XFILLER_149_1464 VPWR VGND VPWR VGND sky130_ef_sc_hd__decap_12
XFILLER_184_1355 VPWR VGND VPWR VGND sky130_ef_sc_hd__decap_12
XFILLER_247_1076 VPWR VGND VPWR VGND sky130_ef_sc_hd__decap_12
XFILLER_93_1249 VPWR VGND VPWR VGND sky130_ef_sc_hd__decap_12
XFILLER_145_1328 VGND VGND VPWR VPWR sky130_fd_sc_hd__decap_6
XFILLER_180_1219 VGND VGND VPWR VPWR sky130_fd_sc_hd__decap_6
XFILLER_211_314 VPWR VGND VPWR VGND sky130_ef_sc_hd__decap_12
XFILLER_168_218 VPWR VGND VPWR VGND sky130_ef_sc_hd__decap_12
XFILLER_223_185 VPWR VGND VPWR VGND sky130_ef_sc_hd__decap_12
XFILLER_196_538 VPWR VGND VPWR VGND sky130_ef_sc_hd__decap_12
XFILLER_23_27 VGND VGND VPWR VPWR sky130_fd_sc_hd__decap_4
XFILLER_182_1090 VGND VGND VPWR VPWR sky130_fd_sc_hd__decap_6
XFILLER_211_369 VPWR VGND VPWR VGND sky130_ef_sc_hd__decap_12
XFILLER_221_1205 VPWR VGND VPWR VGND sky130_ef_sc_hd__decap_12
XFILLER_32_1509 VGND VGND VPWR VPWR sky130_fd_sc_hd__decap_6
XFILLER_139_27 VPWR VGND VPWR VGND sky130_ef_sc_hd__decap_12
XFILLER_165_925 VPWR VGND VPWR VGND sky130_ef_sc_hd__decap_12
XFILLER_176_273 VGND VGND VPWR VPWR sky130_fd_sc_hd__decap_6
XFILLER_192_722 VPWR VGND VPWR VGND sky130_ef_sc_hd__decap_12
XFILLER_34_1380 VPWR VGND VPWR VGND sky130_ef_sc_hd__decap_12
XFILLER_165_958 VGND VGND VPWR VPWR sky130_fd_sc_hd__fill_2
XFILLER_69_1421 VPWR VGND VPWR VGND sky130_ef_sc_hd__decap_12
XFILLER_180_906 VPWR VGND VPWR VGND sky130_ef_sc_hd__decap_12
XFILLER_192_777 VPWR VGND VPWR VGND sky130_ef_sc_hd__decap_12
XFILLER_155_15 VPWR VGND VPWR VGND sky130_ef_sc_hd__decap_12
XFILLER_219_1112 VGND VGND VPWR VPWR sky130_fd_sc_hd__decap_6
XTAP_TAPCELL_ROW_150_2_5860 VGND VPWR sky130_fd_sc_hd__tapvpwrvgnd_1
XTAP_TAPCELL_ROW_149_2_5854 VGND VPWR sky130_fd_sc_hd__tapvpwrvgnd_1
XFILLER_69_1476 VPWR VGND VPWR VGND sky130_ef_sc_hd__decap_12
XFILLER_156_1435 VGND VGND VPWR VPWR sky130_fd_sc_hd__decap_6
XFILLER_191_1315 VPWR VGND VPWR VGND sky130_ef_sc_hd__decap_12
XFILLER_254_1047 VGND VGND VPWR VPWR sky130_fd_sc_hd__decap_6
XFILLER_232_1312 VPWR VGND VPWR VGND sky130_ef_sc_hd__decap_12
XFILLER_247_701 VPWR VGND VPWR VGND sky130_ef_sc_hd__decap_12
XFILLER_28_1184 VPWR VGND VPWR VGND sky130_ef_sc_hd__decap_12
XTAP_TAPCELL_ROW_9_1240 VGND VPWR sky130_fd_sc_hd__tapvpwrvgnd_1
XFILLER_232_1367 VPWR VGND VPWR VGND sky130_ef_sc_hd__decap_12
XFILLER_4_1109 VPWR VGND VPWR VGND sky130_ef_sc_hd__decap_12
XFILLER_247_756 VPWR VGND VPWR VGND sky130_ef_sc_hd__decap_12
XFILLER_115_1165 VPWR VGND VPWR VGND sky130_ef_sc_hd__decap_12
XTAP_TAPCELL_ROW_204_2908 VGND VPWR sky130_fd_sc_hd__tapvpwrvgnd_1
XTAP_TAPCELL_ROW_67_2_5198 VGND VPWR sky130_fd_sc_hd__tapvpwrvgnd_1
XFILLER_206_108 VPWR VGND VPWR VGND sky130_ef_sc_hd__decap_12
XTAP_TAPCELL_ROW_181_2083 VGND VPWR sky130_fd_sc_hd__tapvpwrvgnd_1
XTAP_TAPCELL_ROW_181_2094 VGND VPWR sky130_fd_sc_hd__tapvpwrvgnd_1
XFILLER_185_1119 VPWR VGND VPWR VGND sky130_ef_sc_hd__decap_12
XFILLER_228_992 VPWR VGND VPWR VGND sky130_ef_sc_hd__decap_12
XFILLER_251_80 VGND VGND VPWR VPWR sky130_fd_sc_hd__decap_6
XFILLER_64_34 VPWR VGND VPWR VGND sky130_ef_sc_hd__decap_12
XFILLER_243_940 VGND VGND VPWR VPWR sky130_fd_sc_hd__decap_6
XTAP_TAPCELL_ROW_47_2_5041 VGND VPWR sky130_fd_sc_hd__tapvpwrvgnd_1
XFILLER_161_3 VPWR VGND VPWR VGND sky130_ef_sc_hd__decap_12
XFILLER_214_163 VPWR VGND VPWR VGND sky130_ef_sc_hd__decap_12
X_322_ _103_ _107_ _110_ VGND VGND VPWR VPWR _111_ sky130_fd_sc_hd__o21bai_1
XFILLER_80_22 VPWR VGND VPWR VGND sky130_ef_sc_hd__decap_12
XFILLER_202_347 VPWR VGND VPWR VGND sky130_ef_sc_hd__decap_12
XFILLER_230_667 VPWR VGND VPWR VGND sky130_ef_sc_hd__decap_12
XFILLER_243_1463 VPWR VGND VPWR VGND sky130_ef_sc_hd__decap_12
XTAP_TAPCELL_ROW_14_2_4771 VGND VPWR sky130_fd_sc_hd__tapvpwrvgnd_1
XFILLER_196_22 VPWR VGND VPWR VGND sky130_ef_sc_hd__decap_12
XFILLER_167_240 VPWR VGND VPWR VGND sky130_ef_sc_hd__decap_12
XFILLER_195_560 VPWR VGND VPWR VGND sky130_ef_sc_hd__decap_12
XFILLER_35_1177 VPWR VGND VPWR VGND sky130_ef_sc_hd__decap_12
XFILLER_126_1294 VPWR VGND VPWR VGND sky130_ef_sc_hd__decap_12
XFILLER_168_796 VPWR VGND VPWR VGND sky130_ef_sc_hd__decap_12
XFILLER_196_77 VPWR VGND VPWR VGND sky130_ef_sc_hd__decap_12
XFILLER_167_295 VGND VGND VPWR VPWR sky130_fd_sc_hd__decap_6
XFILLER_183_744 VPWR VGND VPWR VGND sky130_ef_sc_hd__decap_12
XFILLER_196_1226 VPWR VGND VPWR VGND sky130_ef_sc_hd__decap_12
XFILLER_13_1464 VPWR VGND VPWR VGND sky130_ef_sc_hd__decap_12
XFILLER_100_1423 VPWR VGND VPWR VGND sky130_ef_sc_hd__decap_12
XFILLER_171_928 VPWR VGND VPWR VGND sky130_ef_sc_hd__decap_12
XFILLER_183_799 VPWR VGND VPWR VGND sky130_ef_sc_hd__decap_12
XFILLER_100_1478 VGND VGND VPWR VPWR sky130_fd_sc_hd__decap_6
XFILLER_9_1009 VPWR VGND VPWR VGND sky130_ef_sc_hd__decap_12
XFILLER_46_1251 VPWR VGND VPWR VGND sky130_ef_sc_hd__decap_12
XFILLER_250_1434 VGND VGND VPWR VPWR sky130_fd_sc_hd__decap_6
XFILLER_137_1390 VPWR VGND VPWR VGND sky130_ef_sc_hd__decap_12
XFILLER_172_1281 VPWR VGND VPWR VGND sky130_ef_sc_hd__decap_12
XFILLER_238_734 VPWR VGND VPWR VGND sky130_ef_sc_hd__decap_12
XFILLER_226_918 VGND VGND VPWR VPWR sky130_fd_sc_hd__decap_6
XFILLER_238_789 VGND VGND VPWR VPWR sky130_fd_sc_hd__decap_6
XTAP_TAPCELL_ROW_224_3580 VGND VPWR sky130_fd_sc_hd__tapvpwrvgnd_1
XTAP_TAPCELL_ROW_224_3591 VGND VPWR sky130_fd_sc_hd__tapvpwrvgnd_1
XFILLER_231_39 VGND VGND VPWR VPWR sky130_fd_sc_hd__decap_4
XFILLER_20_1435 VGND VGND VPWR VPWR sky130_fd_sc_hd__decap_6
XTAP_TAPCELL_ROW_220_3444 VGND VPWR sky130_fd_sc_hd__tapvpwrvgnd_1
XTAP_TAPCELL_ROW_220_3455 VGND VPWR sky130_fd_sc_hd__tapvpwrvgnd_1
Xclkbuf_3_7__f_clk clknet_0_clk VGND VGND VPWR VPWR clknet_3_7__leaf_clk sky130_fd_sc_hd__clkbuf_16
XTAP_TAPCELL_ROW_220_3466 VGND VPWR sky130_fd_sc_hd__tapvpwrvgnd_1
XFILLER_209_1303 VPWR VGND VPWR VGND sky130_ef_sc_hd__decap_12
XFILLER_205_130 VPWR VGND VPWR VGND sky130_ef_sc_hd__decap_12
XFILLER_240_409 VPWR VGND VPWR VGND sky130_ef_sc_hd__decap_12
XFILLER_181_1506 VGND VGND VPWR VPWR sky130_fd_sc_hd__decap_8
XFILLER_244_1238 VPWR VGND VPWR VGND sky130_ef_sc_hd__decap_12
XFILLER_209_1358 VPWR VGND VPWR VGND sky130_ef_sc_hd__decap_12
XFILLER_205_185 VPWR VGND VPWR VGND sky130_ef_sc_hd__decap_12
XFILLER_178_538 VPWR VGND VPWR VGND sky130_ef_sc_hd__decap_12
XFILLER_220_144 VGND VGND VPWR VPWR sky130_fd_sc_hd__decap_6
XFILLER_92_1282 VPWR VGND VPWR VGND sky130_ef_sc_hd__decap_12
XTAP_TAPCELL_ROW_177_1941 VGND VPWR sky130_fd_sc_hd__tapvpwrvgnd_1
XFILLER_222_1514 VGND VGND VPWR VPWR sky130_fd_sc_hd__fill_1
XTAP_TAPCELL_ROW_177_1952 VGND VPWR sky130_fd_sc_hd__tapvpwrvgnd_1
XTAP_TAPCELL_ROW_218_3373 VGND VPWR sky130_fd_sc_hd__tapvpwrvgnd_1
XFILLER_221_689 VPWR VGND VPWR VGND sky130_ef_sc_hd__decap_12
XTAP_TAPCELL_ROW_177_1963 VGND VPWR sky130_fd_sc_hd__tapvpwrvgnd_1
XTAP_TAPCELL_ROW_218_3384 VGND VPWR sky130_fd_sc_hd__tapvpwrvgnd_1
XTAP_TAPCELL_ROW_173_1805 VGND VPWR sky130_fd_sc_hd__tapvpwrvgnd_1
XTAP_TAPCELL_ROW_218_3395 VGND VPWR sky130_fd_sc_hd__tapvpwrvgnd_1
XTAP_TAPCELL_ROW_173_1816 VGND VPWR sky130_fd_sc_hd__tapvpwrvgnd_1
XTAP_TAPCELL_ROW_214_3237 VGND VPWR sky130_fd_sc_hd__tapvpwrvgnd_1
XFILLER_14_1239 VPWR VGND VPWR VGND sky130_ef_sc_hd__decap_12
XFILLER_174_722 VPWR VGND VPWR VGND sky130_ef_sc_hd__decap_12
XTAP_TAPCELL_ROW_173_1827 VGND VPWR sky130_fd_sc_hd__tapvpwrvgnd_1
XFILLER_179_1413 VGND VGND VPWR VPWR sky130_fd_sc_hd__decap_6
XTAP_TAPCELL_ROW_214_3248 VGND VPWR sky130_fd_sc_hd__tapvpwrvgnd_1
XFILLER_186_593 VPWR VGND VPWR VGND sky130_ef_sc_hd__decap_12
XTAP_TAPCELL_ROW_214_3259 VGND VPWR sky130_fd_sc_hd__tapvpwrvgnd_1
XFILLER_105_1378 VPWR VGND VPWR VGND sky130_ef_sc_hd__decap_12
XTAP_TAPCELL_ROW_135_2_5740 VGND VPWR sky130_fd_sc_hd__tapvpwrvgnd_1
XFILLER_174_777 VPWR VGND VPWR VGND sky130_ef_sc_hd__decap_12
XFILLER_220_1293 VPWR VGND VPWR VGND sky130_ef_sc_hd__decap_12
XFILLER_255_1345 VPWR VGND VPWR VGND sky130_ef_sc_hd__decap_12
XFILLER_170_961 VGND VGND VPWR VPWR sky130_fd_sc_hd__decap_6
XFILLER_255_1378 VGND VGND VPWR VPWR sky130_fd_sc_hd__decap_8
XFILLER_138_1165 VPWR VGND VPWR VGND sky130_ef_sc_hd__decap_12
XFILLER_173_1045 VPWR VGND VPWR VGND sky130_ef_sc_hd__decap_12
XTAP_TAPCELL_ROW_208_3019 VGND VPWR sky130_fd_sc_hd__tapvpwrvgnd_1
XTAP_TAPCELL_ROW_167_1609 VGND VPWR sky130_fd_sc_hd__tapvpwrvgnd_1
XTAP_TAPCELL_ROW_84_2_5337 VGND VPWR sky130_fd_sc_hd__tapvpwrvgnd_1
XFILLER_229_701 VPWR VGND VPWR VGND sky130_ef_sc_hd__decap_12
XTAP_TAPCELL_ROW_53_2_5084 VGND VPWR sky130_fd_sc_hd__tapvpwrvgnd_1
XFILLER_25_1335 VPWR VGND VPWR VGND sky130_ef_sc_hd__decap_12
XFILLER_99_1414 VGND VGND VPWR VPWR sky130_fd_sc_hd__decap_6
XFILLER_229_756 VPWR VGND VPWR VGND sky130_ef_sc_hd__decap_12
XFILLER_116_1485 VPWR VGND VPWR VGND sky130_ef_sc_hd__decap_12
XFILLER_214_1097 VPWR VGND VPWR VGND sky130_ef_sc_hd__decap_12
XFILLER_112_1349 VGND VGND VPWR VPWR sky130_fd_sc_hd__decap_6
XFILLER_3_1131 VPWR VGND VPWR VGND sky130_ef_sc_hd__decap_12
XFILLER_141_39 VGND VGND VPWR VPWR sky130_fd_sc_hd__decap_4
XFILLER_225_940 VGND VGND VPWR VPWR sky130_fd_sc_hd__decap_6
XTAP_TAPCELL_ROW_255_4720 VGND VPWR sky130_fd_sc_hd__tapvpwrvgnd_1
XFILLER_3_1186 VPWR VGND VPWR VGND sky130_ef_sc_hd__decap_12
XTAP_TAPCELL_ROW_255_4731 VGND VPWR sky130_fd_sc_hd__tapvpwrvgnd_1
XTAP_TAPCELL_ROW_31_2_4910 VGND VPWR sky130_fd_sc_hd__tapvpwrvgnd_1
XFILLER_149_1261 VPWR VGND VPWR VGND sky130_ef_sc_hd__decap_12
XFILLER_34_15 VGND VGND VPWR VPWR sky130_fd_sc_hd__decap_6
XFILLER_184_1152 VPWR VGND VPWR VGND sky130_ef_sc_hd__decap_12
XFILLER_58_1177 VGND VGND VPWR VPWR sky130_fd_sc_hd__decap_6
XFILLER_211_111 VPWR VGND VPWR VGND sky130_ef_sc_hd__decap_12
XFILLER_196_335 VPWR VGND VPWR VGND sky130_ef_sc_hd__decap_12
XFILLER_212_667 VPWR VGND VPWR VGND sky130_ef_sc_hd__decap_12
XFILLER_36_1442 VPWR VGND VPWR VGND sky130_ef_sc_hd__decap_12
XFILLER_211_166 VGND VGND VPWR VPWR sky130_fd_sc_hd__decap_6
XFILLER_221_1002 VPWR VGND VPWR VGND sky130_ef_sc_hd__decap_12
XFILLER_32_1306 VGND VGND VPWR VPWR sky130_fd_sc_hd__decap_6
XFILLER_184_519 VPWR VGND VPWR VGND sky130_ef_sc_hd__decap_12
XFILLER_7_209 VGND VGND VPWR VPWR sky130_fd_sc_hd__decap_6
XFILLER_177_560 VPWR VGND VPWR VGND sky130_ef_sc_hd__decap_12
Xclkload3 clknet_3_3__leaf_clk VGND VGND VPWR VPWR clkload3/Y sky130_fd_sc_hd__clkinv_4
XFILLER_36_1497 VPWR VGND VPWR VGND sky130_ef_sc_hd__decap_12
XFILLER_123_1445 VPWR VGND VPWR VGND sky130_ef_sc_hd__decap_12
XFILLER_221_1057 VPWR VGND VPWR VGND sky130_ef_sc_hd__decap_12
XFILLER_180_703 VGND VGND VPWR VPWR sky130_fd_sc_hd__decap_6
XFILLER_192_574 VGND VGND VPWR VPWR sky130_fd_sc_hd__decap_6
XFILLER_165_799 VPWR VGND VPWR VGND sky130_ef_sc_hd__decap_12
XFILLER_166_58 VGND VGND VPWR VPWR sky130_fd_sc_hd__decap_6
XFILLER_4_949 VPWR VGND VPWR VGND sky130_ef_sc_hd__decap_12
XFILLER_69_1273 VPWR VGND VPWR VGND sky130_ef_sc_hd__decap_12
XFILLER_191_1112 VGND VGND VPWR VPWR sky130_fd_sc_hd__decap_6
XFILLER_3_459 VGND VGND VPWR VPWR sky130_fd_sc_hd__fill_1
XFILLER_59_56 VPWR VGND VPWR VGND sky130_ef_sc_hd__decap_12
XFILLER_43_1402 VPWR VGND VPWR VGND sky130_ef_sc_hd__decap_12
XFILLER_182_46 VPWR VGND VPWR VGND sky130_ef_sc_hd__decap_12
XFILLER_117_1249 VPWR VGND VPWR VGND sky130_ef_sc_hd__decap_12
XTAP_TAPCELL_ROW_187_2292 VGND VPWR sky130_fd_sc_hd__tapvpwrvgnd_1
XTAP_TAPCELL_ROW_183_2145 VGND VPWR sky130_fd_sc_hd__tapvpwrvgnd_1
XTAP_TAPCELL_ROW_183_2156 VGND VPWR sky130_fd_sc_hd__tapvpwrvgnd_1
XFILLER_43_1457 VGND VGND VPWR VPWR sky130_fd_sc_hd__decap_6
XFILLER_232_1164 VPWR VGND VPWR VGND sky130_ef_sc_hd__decap_12
XTAP_TAPCELL_ROW_183_2167 VGND VPWR sky130_fd_sc_hd__tapvpwrvgnd_1
XFILLER_247_553 VGND VGND VPWR VPWR sky130_fd_sc_hd__decap_6
XTAP_TAPCELL_ROW_183_2178 VGND VPWR sky130_fd_sc_hd__tapvpwrvgnd_1
XFILLER_8_1097 VPWR VGND VPWR VGND sky130_ef_sc_hd__decap_12
XFILLER_208_918 VGND VGND VPWR VPWR sky130_fd_sc_hd__decap_6
XFILLER_75_44 VPWR VGND VPWR VGND sky130_ef_sc_hd__decap_12
XFILLER_78_1509 VGND VGND VPWR VPWR sky130_fd_sc_hd__decap_6
XTAP_TAPCELL_ROW_3_971 VGND VPWR sky130_fd_sc_hd__tapvpwrvgnd_1
XTAP_TAPCELL_ROW_3_982 VGND VPWR sky130_fd_sc_hd__tapvpwrvgnd_1
XTAP_TAPCELL_ROW_3_993 VGND VPWR sky130_fd_sc_hd__tapvpwrvgnd_1
XFILLER_210_1484 VPWR VGND VPWR VGND sky130_ef_sc_hd__decap_12
XFILLER_222_409 VPWR VGND VPWR VGND sky130_ef_sc_hd__decap_12
XFILLER_245_1514 VGND VGND VPWR VPWR sky130_fd_sc_hd__fill_1
XFILLER_37_1206 VPWR VGND VPWR VGND sky130_ef_sc_hd__decap_12
XFILLER_187_302 VPWR VGND VPWR VGND sky130_ef_sc_hd__decap_12
XFILLER_242_280 VPWR VGND VPWR VGND sky130_ef_sc_hd__decap_12
XFILLER_199_173 VPWR VGND VPWR VGND sky130_ef_sc_hd__decap_12
XFILLER_128_1356 VPWR VGND VPWR VGND sky130_ef_sc_hd__decap_12
XFILLER_202_144 VGND VGND VPWR VPWR sky130_fd_sc_hd__decap_6
XFILLER_243_1260 VPWR VGND VPWR VGND sky130_ef_sc_hd__decap_12
X_305_ _092_ _093_ VGND VGND VPWR VPWR _094_ sky130_fd_sc_hd__or2_1
XFILLER_187_357 VPWR VGND VPWR VGND sky130_ef_sc_hd__decap_12
XFILLER_203_689 VPWR VGND VPWR VGND sky130_ef_sc_hd__decap_12
XFILLER_230_464 VPWR VGND VPWR VGND sky130_ef_sc_hd__decap_12
XTAP_TAPCELL_ROW_77_2_5280 VGND VPWR sky130_fd_sc_hd__tapvpwrvgnd_1
XFILLER_208_1391 VGND VGND VPWR VPWR sky130_fd_sc_hd__decap_6
XPHY_EDGE_ROW_145_2_Left_647 VGND VGND VPWR VPWR sky130_fd_sc_hd__decap_3
XFILLER_7_721 VGND VGND VPWR VPWR sky130_fd_sc_hd__decap_8
Xwire630 net39 VGND VGND VPWR VPWR net630 sky130_fd_sc_hd__buf_1
XFILLER_168_593 VPWR VGND VPWR VGND sky130_ef_sc_hd__decap_12
Xwire641 net3 VGND VGND VPWR VPWR net641 sky130_fd_sc_hd__clkbuf_1
XFILLER_7_732 VPWR VGND VPWR VGND sky130_ef_sc_hd__decap_12
Xwire652 net653 VGND VGND VPWR VPWR net652 sky130_fd_sc_hd__clkbuf_1
XFILLER_183_541 VPWR VGND VPWR VGND sky130_ef_sc_hd__decap_12
XTAP_TAPCELL_ROW_232_3860 VGND VPWR sky130_fd_sc_hd__tapvpwrvgnd_1
XFILLER_6_220 VGND VGND VPWR VPWR sky130_fd_sc_hd__fill_2
XFILLER_196_1023 VPWR VGND VPWR VGND sky130_ef_sc_hd__decap_12
XTAP_TAPCELL_ROW_232_3871 VGND VPWR sky130_fd_sc_hd__tapvpwrvgnd_1
Xwire663 net10 VGND VGND VPWR VPWR net663 sky130_fd_sc_hd__buf_1
XTAP_TAPCELL_ROW_232_3882 VGND VPWR sky130_fd_sc_hd__tapvpwrvgnd_1
XPHY_EDGE_ROW_15_1_Left_270 VGND VGND VPWR VPWR sky130_fd_sc_hd__decap_3
XFILLER_13_1261 VPWR VGND VPWR VGND sky130_ef_sc_hd__decap_12
XTAP_TAPCELL_ROW_232_3893 VGND VPWR sky130_fd_sc_hd__tapvpwrvgnd_1
XFILLER_100_1220 VGND VGND VPWR VPWR sky130_fd_sc_hd__decap_6
XFILLER_171_725 VGND VGND VPWR VPWR sky130_fd_sc_hd__decap_6
XFILLER_183_596 VGND VGND VPWR VPWR sky130_fd_sc_hd__decap_6
XTAP_TAPCELL_ROW_102_2_5478 VGND VPWR sky130_fd_sc_hd__tapvpwrvgnd_1
XFILLER_196_1078 VPWR VGND VPWR VGND sky130_ef_sc_hd__decap_12
XFILLER_48_1313 VPWR VGND VPWR VGND sky130_ef_sc_hd__decap_12
XFILLER_6_297 VGND VGND VPWR VPWR sky130_fd_sc_hd__decap_3
XTAP_TAPCELL_ROW_70_2_5223 VGND VPWR sky130_fd_sc_hd__tapvpwrvgnd_1
XTAP_TAPCELL_ROW_69_2_5217 VGND VPWR sky130_fd_sc_hd__tapvpwrvgnd_1
XFILLER_3_971 VPWR VGND VPWR VGND sky130_ef_sc_hd__decap_12
XFILLER_48_1368 VPWR VGND VPWR VGND sky130_ef_sc_hd__decap_12
XFILLER_135_1316 VPWR VGND VPWR VGND sky130_ef_sc_hd__decap_12
XFILLER_170_1207 VPWR VGND VPWR VGND sky130_ef_sc_hd__decap_12
XFILLER_174_1398 VPWR VGND VPWR VGND sky130_ef_sc_hd__decap_12
XFILLER_2_492 VGND VGND VPWR VPWR sky130_fd_sc_hd__fill_2
XTAP_TAPCELL_ROW_226_3653 VGND VPWR sky130_fd_sc_hd__tapvpwrvgnd_1
XTAP_TAPCELL_ROW_226_3664 VGND VPWR sky130_fd_sc_hd__tapvpwrvgnd_1
XTAP_TAPCELL_ROW_36_2_4947 VGND VPWR sky130_fd_sc_hd__tapvpwrvgnd_1
XTAP_TAPCELL_ROW_226_3675 VGND VPWR sky130_fd_sc_hd__tapvpwrvgnd_1
XFILLER_238_531 VGND VGND VPWR VPWR sky130_fd_sc_hd__decap_6
XTAP_TAPCELL_ROW_222_3517 VGND VPWR sky130_fd_sc_hd__tapvpwrvgnd_1
XTAP_TAPCELL_ROW_222_3528 VGND VPWR sky130_fd_sc_hd__tapvpwrvgnd_1
XFILLER_211_1248 VPWR VGND VPWR VGND sky130_ef_sc_hd__decap_12
XTAP_TAPCELL_ROW_222_3539 VGND VPWR sky130_fd_sc_hd__tapvpwrvgnd_1
XTAP_TAPCELL_ROW_1_908 VGND VPWR sky130_fd_sc_hd__tapvpwrvgnd_1
XTAP_TAPCELL_ROW_1_919 VGND VPWR sky130_fd_sc_hd__tapvpwrvgnd_1
XFILLER_207_940 VGND VGND VPWR VPWR sky130_fd_sc_hd__decap_6
XFILLER_0_1315 VGND VGND VPWR VPWR sky130_fd_sc_hd__decap_8
XFILLER_4_1484 VPWR VGND VPWR VGND sky130_ef_sc_hd__decap_12
XFILLER_111_1371 VGND VGND VPWR VPWR sky130_fd_sc_hd__decap_6
XPHY_EDGE_ROW_159_1_Left_414 VGND VGND VPWR VPWR sky130_fd_sc_hd__decap_3
XFILLER_209_1100 VPWR VGND VPWR VGND sky130_ef_sc_hd__decap_12
XFILLER_240_206 VPWR VGND VPWR VGND sky130_ef_sc_hd__decap_12
XFILLER_59_1464 VPWR VGND VPWR VGND sky130_ef_sc_hd__decap_12
XFILLER_146_1423 VPWR VGND VPWR VGND sky130_ef_sc_hd__decap_12
XFILLER_181_1303 VPWR VGND VPWR VGND sky130_ef_sc_hd__decap_12
XFILLER_244_1035 VPWR VGND VPWR VGND sky130_ef_sc_hd__decap_12
XFILLER_55_1328 VGND VGND VPWR VPWR sky130_fd_sc_hd__decap_6
XTAP_TAPCELL_ROW_50_1_1304 VGND VPWR sky130_fd_sc_hd__tapvpwrvgnd_1
XFILLER_90_1208 VPWR VGND VPWR VGND sky130_ef_sc_hd__decap_12
XFILLER_209_1155 VGND VGND VPWR VPWR sky130_fd_sc_hd__decap_6
XFILLER_221_431 VPWR VGND VPWR VGND sky130_ef_sc_hd__decap_12
XFILLER_94_1399 VPWR VGND VPWR VGND sky130_ef_sc_hd__decap_12
XFILLER_178_335 VPWR VGND VPWR VGND sky130_ef_sc_hd__decap_12
XFILLER_146_1478 VGND VGND VPWR VPWR sky130_fd_sc_hd__decap_6
XFILLER_181_1358 VPWR VGND VPWR VGND sky130_ef_sc_hd__decap_12
XPHY_EDGE_ROW_77_2_Left_579 VGND VGND VPWR VPWR sky130_fd_sc_hd__decap_3
XFILLER_166_519 VPWR VGND VPWR VGND sky130_ef_sc_hd__decap_12
XFILLER_221_486 VPWR VGND VPWR VGND sky130_ef_sc_hd__decap_12
XFILLER_194_839 VPWR VGND VPWR VGND sky130_ef_sc_hd__decap_12
XFILLER_193_338 VGND VGND VPWR VPWR sky130_fd_sc_hd__decap_6
XFILLER_222_1355 VPWR VGND VPWR VGND sky130_ef_sc_hd__decap_12
XFILLER_186_390 VPWR VGND VPWR VGND sky130_ef_sc_hd__decap_12
XFILLER_174_574 VGND VGND VPWR VPWR sky130_fd_sc_hd__decap_6
XFILLER_220_1090 VGND VGND VPWR VPWR sky130_fd_sc_hd__decap_6
XFILLER_192_1410 VPWR VGND VPWR VGND sky130_ef_sc_hd__decap_12
XFILLER_66_1435 VGND VGND VPWR VPWR sky130_fd_sc_hd__decap_6
XFILLER_0_418 VGND VGND VPWR VPWR sky130_fd_sc_hd__fill_2
XFILLER_249_818 VPWR VGND VPWR VGND sky130_ef_sc_hd__decap_12
XFILLER_192_1465 VPWR VGND VPWR VGND sky130_ef_sc_hd__decap_12
XFILLER_29_15 VPWR VGND VPWR VGND sky130_ef_sc_hd__decap_12
XFILLER_25_1165 VPWR VGND VPWR VGND sky130_ef_sc_hd__decap_12
XFILLER_116_1282 VPWR VGND VPWR VGND sky130_ef_sc_hd__decap_12
XFILLER_229_553 VGND VGND VPWR VPWR sky130_fd_sc_hd__decap_6
XFILLER_5_1248 VPWR VGND VPWR VGND sky130_ef_sc_hd__decap_12
XTAP_TAPCELL_ROW_157_2_5916 VGND VPWR sky130_fd_sc_hd__tapvpwrvgnd_1
XFILLER_204_409 VPWR VGND VPWR VGND sky130_ef_sc_hd__decap_12
XFILLER_45_58 VPWR VGND VPWR VGND sky130_ef_sc_hd__decap_12
XPHY_EDGE_ROW_143_1_Left_398 VGND VGND VPWR VPWR sky130_fd_sc_hd__decap_3
XFILLER_186_1269 VPWR VGND VPWR VGND sky130_ef_sc_hd__decap_12
XFILLER_231_228 VPWR VGND VPWR VGND sky130_ef_sc_hd__decap_12
XFILLER_169_302 VPWR VGND VPWR VGND sky130_ef_sc_hd__decap_12
XFILLER_224_280 VPWR VGND VPWR VGND sky130_ef_sc_hd__decap_12
XFILLER_125_1507 VGND VGND VPWR VPWR sky130_fd_sc_hd__decap_8
XFILLER_169_357 VPWR VGND VPWR VGND sky130_ef_sc_hd__decap_12
XFILLER_196_132 VPWR VGND VPWR VGND sky130_ef_sc_hd__decap_12
XFILLER_212_464 VPWR VGND VPWR VGND sky130_ef_sc_hd__decap_12
XFILLER_223_1119 VPWR VGND VPWR VGND sky130_ef_sc_hd__decap_12
XPHY_EDGE_ROW_80_1_Left_335 VGND VGND VPWR VPWR sky130_fd_sc_hd__decap_3
XTAP_TAPCELL_ROW_195_2572 VGND VPWR sky130_fd_sc_hd__tapvpwrvgnd_1
XFILLER_240_1422 VPWR VGND VPWR VGND sky130_ef_sc_hd__decap_12
XFILLER_8_507 VGND VGND VPWR VPWR sky130_fd_sc_hd__fill_1
XTAP_TAPCELL_ROW_195_2583 VGND VPWR sky130_fd_sc_hd__tapvpwrvgnd_1
XFILLER_8_518 VGND VGND VPWR VPWR sky130_fd_sc_hd__decap_4
XFILLER_184_316 VGND VGND VPWR VPWR sky130_fd_sc_hd__decap_6
XTAP_TAPCELL_ROW_191_2425 VGND VPWR sky130_fd_sc_hd__tapvpwrvgnd_1
XTAP_TAPCELL_ROW_195_2594 VGND VPWR sky130_fd_sc_hd__tapvpwrvgnd_1
XTAP_TAPCELL_ROW_191_2436 VGND VPWR sky130_fd_sc_hd__tapvpwrvgnd_1
XFILLER_200_648 VPWR VGND VPWR VGND sky130_ef_sc_hd__decap_12
XTAP_TAPCELL_ROW_191_2447 VGND VPWR sky130_fd_sc_hd__tapvpwrvgnd_1
XFILLER_196_187 VGND VGND VPWR VPWR sky130_fd_sc_hd__decap_6
XFILLER_36_1294 VPWR VGND VPWR VGND sky130_ef_sc_hd__decap_12
XTAP_TAPCELL_ROW_29_2_4890 VGND VPWR sky130_fd_sc_hd__tapvpwrvgnd_1
XFILLER_123_1242 VGND VGND VPWR VPWR sky130_fd_sc_hd__decap_6
XTAP_TAPCELL_ROW_191_2458 VGND VPWR sky130_fd_sc_hd__tapvpwrvgnd_1
XFILLER_240_1477 VGND VGND VPWR VPWR sky130_fd_sc_hd__decap_6
XFILLER_177_68 VPWR VGND VPWR VGND sky130_ef_sc_hd__decap_12
XFILLER_124_3 VPWR VGND VPWR VGND sky130_ef_sc_hd__decap_12
XFILLER_6_19 VGND VGND VPWR VPWR sky130_fd_sc_hd__fill_2
XFILLER_193_861 VPWR VGND VPWR VGND sky130_ef_sc_hd__decap_12
XTAP_TAPCELL_ROW_55_2_5103 VGND VPWR sky130_fd_sc_hd__tapvpwrvgnd_1
XFILLER_10_1423 VPWR VGND VPWR VGND sky130_ef_sc_hd__decap_12
XFILLER_158_1349 VGND VGND VPWR VPWR sky130_fd_sc_hd__decap_6
XFILLER_193_1229 VPWR VGND VPWR VGND sky130_ef_sc_hd__decap_12
XFILLER_10_1478 VGND VGND VPWR VPWR sky130_fd_sc_hd__decap_6
XFILLER_3_245 VGND VGND VPWR VPWR sky130_fd_sc_hd__fill_2
XTAP_TAPCELL_ROW_189_2354 VGND VPWR sky130_fd_sc_hd__tapvpwrvgnd_1
XTAP_TAPCELL_ROW_189_2365 VGND VPWR sky130_fd_sc_hd__tapvpwrvgnd_1
XFILLER_193_56 VPWR VGND VPWR VGND sky130_ef_sc_hd__decap_12
XTAP_TAPCELL_ROW_189_2376 VGND VPWR sky130_fd_sc_hd__tapvpwrvgnd_1
XTAP_TAPCELL_ROW_185_2218 VGND VPWR sky130_fd_sc_hd__tapvpwrvgnd_1
XTAP_TAPCELL_ROW_189_2387 VGND VPWR sky130_fd_sc_hd__tapvpwrvgnd_1
XFILLER_234_1226 VPWR VGND VPWR VGND sky130_ef_sc_hd__decap_12
XTAP_TAPCELL_ROW_185_2229 VGND VPWR sky130_fd_sc_hd__tapvpwrvgnd_1
XFILLER_47_1390 VPWR VGND VPWR VGND sky130_ef_sc_hd__decap_12
XFILLER_82_1270 VPWR VGND VPWR VGND sky130_ef_sc_hd__decap_12
XFILLER_86_65 VGND VGND VPWR VPWR sky130_fd_sc_hd__decap_6
XFILLER_248_851 VPWR VGND VPWR VGND sky130_ef_sc_hd__decap_12
XFILLER_169_1401 VPWR VGND VPWR VGND sky130_ef_sc_hd__decap_12
XFILLER_78_1306 VGND VGND VPWR VPWR sky130_fd_sc_hd__decap_6
XFILLER_169_1456 VGND VGND VPWR VPWR sky130_fd_sc_hd__decap_6
XFILLER_210_1281 VPWR VGND VPWR VGND sky130_ef_sc_hd__decap_12
XFILLER_222_206 VPWR VGND VPWR VGND sky130_ef_sc_hd__decap_12
XFILLER_203_431 VPWR VGND VPWR VGND sky130_ef_sc_hd__decap_12
XFILLER_245_1377 VPWR VGND VPWR VGND sky130_ef_sc_hd__decap_12
XFILLER_187_154 VPWR VGND VPWR VGND sky130_ef_sc_hd__decap_12
XFILLER_230_261 VPWR VGND VPWR VGND sky130_ef_sc_hd__decap_12
XFILLER_203_486 VPWR VGND VPWR VGND sky130_ef_sc_hd__decap_12
XTAP_TAPCELL_ROW_234_3933 VGND VPWR sky130_fd_sc_hd__tapvpwrvgnd_1
XFILLER_176_839 VPWR VGND VPWR VGND sky130_ef_sc_hd__decap_12
XTAP_TAPCELL_ROW_234_3944 VGND VPWR sky130_fd_sc_hd__tapvpwrvgnd_1
XTAP_TAPCELL_ROW_234_3955 VGND VPWR sky130_fd_sc_hd__tapvpwrvgnd_1
XFILLER_175_338 VGND VGND VPWR VPWR sky130_fd_sc_hd__decap_6
XFILLER_89_1402 VPWR VGND VPWR VGND sky130_ef_sc_hd__decap_12
XFILLER_180_1391 VGND VGND VPWR VPWR sky130_fd_sc_hd__decap_6
XTAP_TAPCELL_ROW_230_3808 VGND VPWR sky130_fd_sc_hd__tapvpwrvgnd_1
XFILLER_168_390 VPWR VGND VPWR VGND sky130_ef_sc_hd__decap_12
XTAP_TAPCELL_ROW_230_3819 VGND VPWR sky130_fd_sc_hd__tapvpwrvgnd_1
XFILLER_15_1378 VPWR VGND VPWR VGND sky130_ef_sc_hd__decap_12
Xwire460 net461 VGND VGND VPWR VPWR net460 sky130_fd_sc_hd__clkbuf_1
XFILLER_102_1337 VPWR VGND VPWR VGND sky130_ef_sc_hd__decap_12
XFILLER_237_27 VPWR VGND VPWR VGND sky130_ef_sc_hd__decap_12
Xwire471 net472 VGND VGND VPWR VPWR net471 sky130_fd_sc_hd__clkbuf_1
XFILLER_89_1457 VGND VGND VPWR VPWR sky130_fd_sc_hd__decap_6
Xmax_cap204 net205 VGND VGND VPWR VPWR net204 sky130_fd_sc_hd__clkbuf_1
XFILLER_184_894 VPWR VGND VPWR VGND sky130_ef_sc_hd__decap_12
Xwire482 net483 VGND VGND VPWR VPWR net482 sky130_fd_sc_hd__clkbuf_1
Xmax_cap215 _171_ VGND VGND VPWR VPWR net215 sky130_fd_sc_hd__clkbuf_1
Xwire493 net494 VGND VGND VPWR VPWR net493 sky130_fd_sc_hd__clkbuf_1
XFILLER_217_1413 VGND VGND VPWR VPWR sky130_fd_sc_hd__decap_6
XFILLER_174_1140 VPWR VGND VPWR VGND sky130_ef_sc_hd__decap_12
XTAP_TAPCELL_ROW_228_3726 VGND VPWR sky130_fd_sc_hd__tapvpwrvgnd_1
XTAP_TAPCELL_ROW_228_3737 VGND VPWR sky130_fd_sc_hd__tapvpwrvgnd_1
XFILLER_253_15 VPWR VGND VPWR VGND sky130_ef_sc_hd__decap_12
XFILLER_48_1165 VPWR VGND VPWR VGND sky130_ef_sc_hd__decap_12
XTAP_TAPCELL_ROW_228_3748 VGND VPWR sky130_fd_sc_hd__tapvpwrvgnd_1
XFILLER_170_1004 VGND VGND VPWR VPWR sky130_fd_sc_hd__decap_6
XFILLER_252_1348 VGND VGND VPWR VPWR sky130_fd_sc_hd__decap_6
XFILLER_174_1195 VPWR VGND VPWR VGND sky130_ef_sc_hd__decap_12
XTAP_TAPCELL_ROW_99_2_5456 VGND VPWR sky130_fd_sc_hd__tapvpwrvgnd_1
XFILLER_239_873 VPWR VGND VPWR VGND sky130_ef_sc_hd__decap_12
XTAP_TAPCELL_ROW_143_2_5802 VGND VPWR sky130_fd_sc_hd__tapvpwrvgnd_1
XFILLER_26_1485 VPWR VGND VPWR VGND sky130_ef_sc_hd__decap_12
XFILLER_113_1433 VPWR VGND VPWR VGND sky130_ef_sc_hd__decap_12
XFILLER_211_1045 VPWR VGND VPWR VGND sky130_ef_sc_hd__decap_12
XFILLER_254_832 VGND VGND VPWR VPWR sky130_fd_sc_hd__decap_6
XFILLER_22_1349 VGND VGND VPWR VPWR sky130_fd_sc_hd__decap_6
XTAP_TAPCELL_ROW_112_2_5560 VGND VPWR sky130_fd_sc_hd__tapvpwrvgnd_1
XFILLER_113_1488 VPWR VGND VPWR VGND sky130_ef_sc_hd__decap_12
XFILLER_4_1281 VPWR VGND VPWR VGND sky130_ef_sc_hd__decap_12
XTAP_TAPCELL_ROW_68_1_1331 VGND VPWR sky130_fd_sc_hd__tapvpwrvgnd_1
XFILLER_0_1156 VPWR VGND VPWR VGND sky130_ef_sc_hd__decap_12
XFILLER_213_228 VPWR VGND VPWR VGND sky130_ef_sc_hd__decap_12
XFILLER_59_1261 VPWR VGND VPWR VGND sky130_ef_sc_hd__decap_12
XFILLER_146_1220 VGND VGND VPWR VPWR sky130_fd_sc_hd__decap_6
XFILLER_181_1100 VPWR VGND VPWR VGND sky130_ef_sc_hd__decap_12
XFILLER_206_280 VPWR VGND VPWR VGND sky130_ef_sc_hd__decap_12
XFILLER_0_1189 VGND VGND VPWR VPWR sky130_fd_sc_hd__decap_8
XFILLER_185_1291 VPWR VGND VPWR VGND sky130_ef_sc_hd__decap_12
XTAP_TAPCELL_ROW_61_2_5146 VGND VPWR sky130_fd_sc_hd__tapvpwrvgnd_1
XFILLER_94_1196 VPWR VGND VPWR VGND sky130_ef_sc_hd__decap_12
XFILLER_178_132 VPWR VGND VPWR VGND sky130_ef_sc_hd__decap_12
XFILLER_181_1155 VGND VGND VPWR VPWR sky130_fd_sc_hd__decap_6
XFILLER_166_316 VGND VGND VPWR VPWR sky130_fd_sc_hd__decap_6
XFILLER_221_283 VPWR VGND VPWR VGND sky130_ef_sc_hd__decap_12
XFILLER_178_187 VGND VGND VPWR VPWR sky130_fd_sc_hd__decap_6
XFILLER_194_636 VPWR VGND VPWR VGND sky130_ef_sc_hd__decap_12
XFILLER_210_968 VPWR VGND VPWR VGND sky130_ef_sc_hd__decap_12
XFILLER_222_1152 VPWR VGND VPWR VGND sky130_ef_sc_hd__decap_12
XFILLER_33_1445 VPWR VGND VPWR VGND sky130_ef_sc_hd__decap_12
XFILLER_31_27 VGND VGND VPWR VPWR sky130_fd_sc_hd__decap_8
XTAP_TAPCELL_ROW_250_4491 VGND VPWR sky130_fd_sc_hd__tapvpwrvgnd_1
XFILLER_175_861 VPWR VGND VPWR VGND sky130_ef_sc_hd__decap_12
XFILLER_147_27 VPWR VGND VPWR VGND sky130_ef_sc_hd__decap_12
XFILLER_190_820 VPWR VGND VPWR VGND sky130_ef_sc_hd__decap_12
XFILLER_190_875 VGND VGND VPWR VPWR sky130_fd_sc_hd__decap_6
Xoutput49 net49 VGND VGND VPWR VPWR acc_out[15] sky130_fd_sc_hd__buf_2
XFILLER_157_1371 VGND VGND VPWR VPWR sky130_fd_sc_hd__decap_6
XFILLER_163_15 VPWR VGND VPWR VGND sky130_ef_sc_hd__decap_12
XFILLER_192_1262 VGND VGND VPWR VPWR sky130_fd_sc_hd__decap_6
XFILLER_249_615 VPWR VGND VPWR VGND sky130_ef_sc_hd__decap_12
XFILLER_27_1249 VPWR VGND VPWR VGND sky130_ef_sc_hd__decap_12
XTAP_TAPCELL_ROW_244_4284 VGND VPWR sky130_fd_sc_hd__tapvpwrvgnd_1
XFILLER_114_1208 VPWR VGND VPWR VGND sky130_ef_sc_hd__decap_12
XTAP_TAPCELL_ROW_244_4295 VGND VPWR sky130_fd_sc_hd__tapvpwrvgnd_1
XFILLER_131_1500 VGND VGND VPWR VPWR sky130_fd_sc_hd__decap_6
XFILLER_118_1399 VPWR VGND VPWR VGND sky130_ef_sc_hd__decap_12
XTAP_TAPCELL_ROW_240_4148 VGND VPWR sky130_fd_sc_hd__tapvpwrvgnd_1
XTAP_TAPCELL_ROW_240_4159 VGND VPWR sky130_fd_sc_hd__tapvpwrvgnd_1
XFILLER_5_1045 VPWR VGND VPWR VGND sky130_ef_sc_hd__decap_12
XFILLER_56_46 VPWR VGND VPWR VGND sky130_ef_sc_hd__decap_12
XFILLER_245_854 VGND VGND VPWR VPWR sky130_fd_sc_hd__decap_6
XFILLER_186_1011 VPWR VGND VPWR VGND sky130_ef_sc_hd__decap_12
X_570_ net667 VGND VGND VPWR VPWR _052_ sky130_fd_sc_hd__inv_2
XTAP_TAPCELL_ROW_6_1073 VGND VPWR sky130_fd_sc_hd__tapvpwrvgnd_1
XTAP_TAPCELL_ROW_6_1084 VGND VPWR sky130_fd_sc_hd__tapvpwrvgnd_1
XTAP_TAPCELL_ROW_6_1095 VGND VPWR sky130_fd_sc_hd__tapvpwrvgnd_1
XFILLER_204_206 VPWR VGND VPWR VGND sky130_ef_sc_hd__decap_12
XTAP_TAPCELL_ROW_178_2000 VGND VPWR sky130_fd_sc_hd__tapvpwrvgnd_1
XFILLER_186_1066 VPWR VGND VPWR VGND sky130_ef_sc_hd__decap_12
XTAP_TAPCELL_ROW_197_2634 VGND VPWR sky130_fd_sc_hd__tapvpwrvgnd_1
XTAP_TAPCELL_ROW_197_2645 VGND VPWR sky130_fd_sc_hd__tapvpwrvgnd_1
XFILLER_72_34 VPWR VGND VPWR VGND sky130_ef_sc_hd__decap_12
XTAP_TAPCELL_ROW_197_2656 VGND VPWR sky130_fd_sc_hd__tapvpwrvgnd_1
XTAP_TAPCELL_ROW_238_4077 VGND VPWR sky130_fd_sc_hd__tapvpwrvgnd_1
XTAP_TAPCELL_ROW_197_2667 VGND VPWR sky130_fd_sc_hd__tapvpwrvgnd_1
XTAP_TAPCELL_ROW_238_4088 VGND VPWR sky130_fd_sc_hd__tapvpwrvgnd_1
XTAP_TAPCELL_ROW_193_2509 VGND VPWR sky130_fd_sc_hd__tapvpwrvgnd_1
XTAP_TAPCELL_ROW_238_4099 VGND VPWR sky130_fd_sc_hd__tapvpwrvgnd_1
XFILLER_241_3 VPWR VGND VPWR VGND sky130_ef_sc_hd__decap_12
XFILLER_38_1356 VPWR VGND VPWR VGND sky130_ef_sc_hd__decap_12
XFILLER_125_1304 VPWR VGND VPWR VGND sky130_ef_sc_hd__decap_12
XFILLER_188_34 VPWR VGND VPWR VGND sky130_ef_sc_hd__decap_12
XFILLER_169_154 VPWR VGND VPWR VGND sky130_ef_sc_hd__decap_12
XFILLER_185_603 VPWR VGND VPWR VGND sky130_ef_sc_hd__decap_12
XFILLER_212_261 VPWR VGND VPWR VGND sky130_ef_sc_hd__decap_12
XFILLER_197_474 VPWR VGND VPWR VGND sky130_ef_sc_hd__decap_12
XFILLER_240_581 VPWR VGND VPWR VGND sky130_ef_sc_hd__decap_12
XFILLER_125_1359 VPWR VGND VPWR VGND sky130_ef_sc_hd__decap_12
XFILLER_160_1239 VPWR VGND VPWR VGND sky130_ef_sc_hd__decap_12
XFILLER_188_89 VPWR VGND VPWR VGND sky130_ef_sc_hd__decap_12
XFILLER_200_445 VGND VGND VPWR VPWR sky130_fd_sc_hd__decap_6
XFILLER_185_658 VPWR VGND VPWR VGND sky130_ef_sc_hd__decap_12
XFILLER_166_894 VPWR VGND VPWR VGND sky130_ef_sc_hd__decap_12
XFILLER_197_1162 VPWR VGND VPWR VGND sky130_ef_sc_hd__decap_12
XFILLER_10_1220 VGND VGND VPWR VPWR sky130_fd_sc_hd__decap_6
XFILLER_181_842 VPWR VGND VPWR VGND sky130_ef_sc_hd__decap_12
XFILLER_193_1026 VGND VGND VPWR VPWR sky130_fd_sc_hd__decap_6
XFILLER_181_897 VGND VGND VPWR VPWR sky130_fd_sc_hd__decap_6
XFILLER_136_1411 VPWR VGND VPWR VGND sky130_ef_sc_hd__decap_12
XTAP_TAPCELL_ROW_117_2_5597 VGND VPWR sky130_fd_sc_hd__tapvpwrvgnd_1
XFILLER_45_1316 VPWR VGND VPWR VGND sky130_ef_sc_hd__decap_12
XTAP_TAPCELL_ROW_85_2_5342 VGND VPWR sky130_fd_sc_hd__tapvpwrvgnd_1
XFILLER_234_1023 VPWR VGND VPWR VGND sky130_ef_sc_hd__decap_12
XTAP_TAPCELL_ROW_74_1_1341 VGND VPWR sky130_fd_sc_hd__tapvpwrvgnd_1
XFILLER_136_1466 VPWR VGND VPWR VGND sky130_ef_sc_hd__decap_12
XFILLER_171_1346 VPWR VGND VPWR VGND sky130_ef_sc_hd__decap_12
XFILLER_234_1078 VPWR VGND VPWR VGND sky130_ef_sc_hd__decap_12
XFILLER_251_1370 VGND VGND VPWR VPWR sky130_fd_sc_hd__decap_6
XFILLER_236_832 VGND VGND VPWR VPWR sky130_fd_sc_hd__decap_6
XFILLER_212_1398 VPWR VGND VPWR VGND sky130_ef_sc_hd__decap_12
XFILLER_1_1432 VPWR VGND VPWR VGND sky130_ef_sc_hd__decap_12
XFILLER_21_1371 VGND VGND VPWR VPWR sky130_fd_sc_hd__decap_6
XTAP_TAPCELL_ROW_46_2_5026 VGND VPWR sky130_fd_sc_hd__tapvpwrvgnd_1
XFILLER_250_323 VPWR VGND VPWR VGND sky130_ef_sc_hd__decap_12
XFILLER_56_1423 VPWR VGND VPWR VGND sky130_ef_sc_hd__decap_12
XFILLER_1_1487 VPWR VGND VPWR VGND sky130_ef_sc_hd__decap_12
XFILLER_250_378 VPWR VGND VPWR VGND sky130_ef_sc_hd__decap_12
XFILLER_182_1453 VPWR VGND VPWR VGND sky130_ef_sc_hd__decap_12
XFILLER_245_1174 VPWR VGND VPWR VGND sky130_ef_sc_hd__decap_12
XFILLER_91_1347 VPWR VGND VPWR VGND sky130_ef_sc_hd__decap_12
XFILLER_188_452 VPWR VGND VPWR VGND sky130_ef_sc_hd__decap_12
XFILLER_56_1478 VGND VGND VPWR VPWR sky130_fd_sc_hd__decap_6
Xclkbuf_0_clk clk VGND VGND VPWR VPWR clknet_0_clk sky130_fd_sc_hd__clkbuf_16
XFILLER_203_283 VPWR VGND VPWR VGND sky130_ef_sc_hd__decap_12
XFILLER_248_15 VGND VGND VPWR VPWR sky130_fd_sc_hd__decap_6
XTAP_TAPCELL_ROW_13_2_4767 VGND VPWR sky130_fd_sc_hd__tapvpwrvgnd_1
XFILLER_87_3 VPWR VGND VPWR VGND sky130_ef_sc_hd__decap_12
XFILLER_176_636 VPWR VGND VPWR VGND sky130_ef_sc_hd__decap_12
XFILLER_106_1270 VPWR VGND VPWR VGND sky130_ef_sc_hd__decap_12
XFILLER_191_639 VGND VGND VPWR VPWR sky130_fd_sc_hd__decap_6
XFILLER_8_882 VPWR VGND VPWR VGND sky130_ef_sc_hd__decap_12
XFILLER_172_820 VPWR VGND VPWR VGND sky130_ef_sc_hd__decap_12
XFILLER_184_691 VPWR VGND VPWR VGND sky130_ef_sc_hd__decap_12
Xwire290 net291 VGND VGND VPWR VPWR net290 sky130_fd_sc_hd__clkbuf_1
XFILLER_172_875 VGND VGND VPWR VPWR sky130_fd_sc_hd__decap_6
XFILLER_230_1410 VPWR VGND VPWR VGND sky130_ef_sc_hd__decap_12
XPHY_EDGE_ROW_0_Left_256 VGND VGND VPWR VPWR sky130_fd_sc_hd__decap_3
XFILLER_239_670 VPWR VGND VPWR VGND sky130_ef_sc_hd__decap_12
XFILLER_26_1282 VPWR VGND VPWR VGND sky130_ef_sc_hd__decap_12
XFILLER_113_1230 VPWR VGND VPWR VGND sky130_ef_sc_hd__decap_12
XFILLER_2_1207 VPWR VGND VPWR VGND sky130_ef_sc_hd__decap_12
XFILLER_230_1465 VPWR VGND VPWR VGND sky130_ef_sc_hd__decap_12
XFILLER_227_854 VGND VGND VPWR VPWR sky130_fd_sc_hd__decap_6
XFILLER_6_1398 VPWR VGND VPWR VGND sky130_ef_sc_hd__decap_12
XFILLER_113_1285 VGND VGND VPWR VPWR sky130_fd_sc_hd__decap_6
XFILLER_148_1337 VPWR VGND VPWR VGND sky130_ef_sc_hd__decap_12
XFILLER_183_1217 VPWR VGND VPWR VGND sky130_ef_sc_hd__decap_12
XFILLER_241_345 VPWR VGND VPWR VGND sky130_ef_sc_hd__decap_12
XFILLER_198_249 VPWR VGND VPWR VGND sky130_ef_sc_hd__decap_12
XTAP_TAPCELL_ROW_200_2741 VGND VPWR sky130_fd_sc_hd__tapvpwrvgnd_1
XTAP_TAPCELL_ROW_200_2752 VGND VPWR sky130_fd_sc_hd__tapvpwrvgnd_1
XFILLER_201_209 VGND VGND VPWR VPWR sky130_fd_sc_hd__decap_6
XTAP_TAPCELL_ROW_200_2763 VGND VPWR sky130_fd_sc_hd__tapvpwrvgnd_1
XFILLER_35_1507 VGND VGND VPWR VPWR sky130_fd_sc_hd__decap_8
XFILLER_167_603 VPWR VGND VPWR VGND sky130_ef_sc_hd__decap_12
XFILLER_210_710 VPWR VGND VPWR VGND sky130_ef_sc_hd__decap_12
XFILLER_42_15 VGND VGND VPWR VPWR sky130_fd_sc_hd__decap_6
XFILLER_179_474 VPWR VGND VPWR VGND sky130_ef_sc_hd__decap_12
XFILLER_222_581 VPWR VGND VPWR VGND sky130_ef_sc_hd__decap_12
XTAP_TAPCELL_ROW_252_4564 VGND VPWR sky130_fd_sc_hd__tapvpwrvgnd_1
XTAP_TAPCELL_ROW_252_4575 VGND VPWR sky130_fd_sc_hd__tapvpwrvgnd_1
XTAP_TAPCELL_ROW_252_4586 VGND VPWR sky130_fd_sc_hd__tapvpwrvgnd_1
XFILLER_158_15 VGND VGND VPWR VPWR sky130_fd_sc_hd__decap_6
XFILLER_224_1269 VPWR VGND VPWR VGND sky130_ef_sc_hd__decap_12
XFILLER_194_433 VPWR VGND VPWR VGND sky130_ef_sc_hd__decap_12
XFILLER_210_765 VPWR VGND VPWR VGND sky130_ef_sc_hd__decap_12
XFILLER_167_658 VPWR VGND VPWR VGND sky130_ef_sc_hd__decap_12
XFILLER_33_1242 VGND VGND VPWR VPWR sky130_fd_sc_hd__decap_6
XFILLER_182_617 VGND VGND VPWR VPWR sky130_fd_sc_hd__decap_6
XFILLER_124_1392 VGND VGND VPWR VPWR sky130_fd_sc_hd__decap_6
XFILLER_194_488 VGND VGND VPWR VPWR sky130_fd_sc_hd__decap_6
XTAP_TAPCELL_ROW_134_2_5736 VGND VPWR sky130_fd_sc_hd__tapvpwrvgnd_1
XFILLER_159_1433 VPWR VGND VPWR VGND sky130_ef_sc_hd__decap_12
XFILLER_194_1324 VPWR VGND VPWR VGND sky130_ef_sc_hd__decap_12
XTAP_TAPCELL_ROW_103_2_5483 VGND VPWR sky130_fd_sc_hd__tapvpwrvgnd_1
XFILLER_68_1349 VGND VGND VPWR VPWR sky130_fd_sc_hd__decap_6
XFILLER_159_1488 VPWR VGND VPWR VGND sky130_ef_sc_hd__decap_12
XTAP_TAPCELL_ROW_246_4357 VGND VPWR sky130_fd_sc_hd__tapvpwrvgnd_1
XFILLER_174_58 VGND VGND VPWR VPWR sky130_fd_sc_hd__decap_6
XFILLER_194_1379 VPWR VGND VPWR VGND sky130_ef_sc_hd__decap_12
XTAP_TAPCELL_ROW_246_4368 VGND VPWR sky130_fd_sc_hd__tapvpwrvgnd_1
XTAP_TAPCELL_ROW_246_4379 VGND VPWR sky130_fd_sc_hd__tapvpwrvgnd_1
XFILLER_249_412 VPWR VGND VPWR VGND sky130_ef_sc_hd__decap_12
XFILLER_231_1229 VPWR VGND VPWR VGND sky130_ef_sc_hd__decap_12
XFILLER_249_467 VGND VGND VPWR VPWR sky130_fd_sc_hd__decap_6
XFILLER_67_56 VPWR VGND VPWR VGND sky130_ef_sc_hd__decap_12
XFILLER_118_1196 VPWR VGND VPWR VGND sky130_ef_sc_hd__decap_12
XFILLER_191_3 VPWR VGND VPWR VGND sky130_ef_sc_hd__decap_12
XFILLER_190_46 VPWR VGND VPWR VGND sky130_ef_sc_hd__decap_12
XTAP_TAPCELL_ROW_8_1146 VGND VPWR sky130_fd_sc_hd__tapvpwrvgnd_1
XTAP_TAPCELL_ROW_8_1157 VGND VPWR sky130_fd_sc_hd__tapvpwrvgnd_1
XFILLER_218_832 VGND VGND VPWR VPWR sky130_fd_sc_hd__decap_6
XTAP_TAPCELL_ROW_8_1168 VGND VPWR sky130_fd_sc_hd__tapvpwrvgnd_1
XPHY_EDGE_ROW_154_2_Left_656 VGND VGND VPWR VPWR sky130_fd_sc_hd__decap_3
X_622_ clknet_3_4__leaf_clk dout0\[20\] _030_ VGND VGND VPWR VPWR dout0_q\[20\] sky130_fd_sc_hd__dfrtp_1
XTAP_TAPCELL_ROW_199_2707 VGND VPWR sky130_fd_sc_hd__tapvpwrvgnd_1
XTAP_TAPCELL_ROW_199_2718 VGND VPWR sky130_fd_sc_hd__tapvpwrvgnd_1
XFILLER_79_1445 VPWR VGND VPWR VGND sky130_ef_sc_hd__decap_12
XTAP_TAPCELL_ROW_199_2729 VGND VPWR sky130_fd_sc_hd__tapvpwrvgnd_1
XFILLER_83_44 VPWR VGND VPWR VGND sky130_ef_sc_hd__decap_12
X_553_ net670 VGND VGND VPWR VPWR _035_ sky130_fd_sc_hd__inv_2
XFILLER_189_216 VPWR VGND VPWR VGND sky130_ef_sc_hd__decap_12
XFILLER_232_323 VPWR VGND VPWR VGND sky130_ef_sc_hd__decap_12
XFILLER_244_194 VPWR VGND VPWR VGND sky130_ef_sc_hd__decap_12
XFILLER_199_44 VPWR VGND VPWR VGND sky130_ef_sc_hd__decap_12
XFILLER_207_1401 VPWR VGND VPWR VGND sky130_ef_sc_hd__decap_12
X_484_ net163 net109 VGND VGND VPWR VPWR acc_core.adder.cla_blocks\[3\].block.sum\[0\]
+ sky130_fd_sc_hd__xor2_1
XFILLER_220_507 VPWR VGND VPWR VGND sky130_ef_sc_hd__decap_12
XFILLER_232_378 VPWR VGND VPWR VGND sky130_ef_sc_hd__decap_12
XFILLER_199_99 VPWR VGND VPWR VGND sky130_ef_sc_hd__decap_12
XFILLER_242_1336 VPWR VGND VPWR VGND sky130_ef_sc_hd__decap_12
XFILLER_129_1292 VPWR VGND VPWR VGND sky130_ef_sc_hd__decap_12
XFILLER_185_400 VPWR VGND VPWR VGND sky130_ef_sc_hd__decap_12
XFILLER_207_1456 VGND VGND VPWR VPWR sky130_fd_sc_hd__decap_6
XFILLER_201_732 VPWR VGND VPWR VGND sky130_ef_sc_hd__decap_12
XFILLER_197_271 VPWR VGND VPWR VGND sky130_ef_sc_hd__decap_12
XFILLER_8_101 VGND VGND VPWR VPWR sky130_fd_sc_hd__decap_6
XFILLER_90_1380 VPWR VGND VPWR VGND sky130_ef_sc_hd__decap_12
XFILLER_185_455 VPWR VGND VPWR VGND sky130_ef_sc_hd__decap_12
XFILLER_125_1189 VPWR VGND VPWR VGND sky130_ef_sc_hd__decap_12
XFILLER_201_787 VPWR VGND VPWR VGND sky130_ef_sc_hd__decap_12
XFILLER_103_1421 VPWR VGND VPWR VGND sky130_ef_sc_hd__decap_12
XFILLER_32_70 VGND VGND VPWR VPWR sky130_fd_sc_hd__fill_1
XFILLER_201_1033 VPWR VGND VPWR VGND sky130_ef_sc_hd__decap_12
XFILLER_173_639 VGND VGND VPWR VPWR sky130_fd_sc_hd__decap_6
XFILLER_12_1337 VPWR VGND VPWR VGND sky130_ef_sc_hd__decap_12
XFILLER_166_691 VPWR VGND VPWR VGND sky130_ef_sc_hd__decap_12
XFILLER_103_1476 VPWR VGND VPWR VGND sky130_ef_sc_hd__decap_12
XFILLER_165_190 VPWR VGND VPWR VGND sky130_ef_sc_hd__decap_12
XPHY_EDGE_ROW_79_2_Right_170 VGND VGND VPWR VPWR sky130_fd_sc_hd__decap_3
XFILLER_201_1088 VPWR VGND VPWR VGND sky130_ef_sc_hd__decap_12
XFILLER_4_351 VGND VGND VPWR VPWR sky130_fd_sc_hd__fill_1
XTAP_TAPCELL_ROW_210_3092 VGND VPWR sky130_fd_sc_hd__tapvpwrvgnd_1
XFILLER_253_1432 VPWR VGND VPWR VGND sky130_ef_sc_hd__decap_12
XFILLER_84_1184 VPWR VGND VPWR VGND sky130_ef_sc_hd__decap_12
XFILLER_136_1263 VGND VGND VPWR VPWR sky130_fd_sc_hd__decap_6
XFILLER_171_1143 VPWR VGND VPWR VGND sky130_ef_sc_hd__decap_12
XFILLER_253_1487 VPWR VGND VPWR VGND sky130_ef_sc_hd__decap_12
XFILLER_45_1168 VPWR VGND VPWR VGND sky130_ef_sc_hd__decap_12
XPHY_EDGE_ROW_86_2_Left_588 VGND VGND VPWR VPWR sky130_fd_sc_hd__decap_3
XFILLER_171_1198 VGND VGND VPWR VPWR sky130_fd_sc_hd__decap_6
XFILLER_249_990 VPWR VGND VPWR VGND sky130_ef_sc_hd__decap_12
XFILLER_23_1433 VPWR VGND VPWR VGND sky130_ef_sc_hd__decap_12
XFILLER_212_1140 VPWR VGND VPWR VGND sky130_ef_sc_hd__decap_12
XFILLER_209_854 VGND VGND VPWR VPWR sky130_fd_sc_hd__decap_6
XFILLER_23_1488 VPWR VGND VPWR VGND sky130_ef_sc_hd__decap_12
XFILLER_212_1195 VPWR VGND VPWR VGND sky130_ef_sc_hd__decap_12
XFILLER_250_120 VPWR VGND VPWR VGND sky130_ef_sc_hd__decap_12
XFILLER_223_345 VPWR VGND VPWR VGND sky130_ef_sc_hd__decap_12
XFILLER_56_1220 VGND VGND VPWR VPWR sky130_fd_sc_hd__decap_6
XFILLER_1_1284 VGND VGND VPWR VPWR sky130_fd_sc_hd__decap_6
XFILLER_211_529 VPWR VGND VPWR VGND sky130_ef_sc_hd__decap_12
XFILLER_250_175 VPWR VGND VPWR VGND sky130_ef_sc_hd__decap_12
XTAP_TAPCELL_ROW_140_2_5779 VGND VPWR sky130_fd_sc_hd__tapvpwrvgnd_1
XFILLER_143_1201 VGND VGND VPWR VPWR sky130_fd_sc_hd__decap_4
XFILLER_182_1250 VPWR VGND VPWR VGND sky130_ef_sc_hd__decap_12
XFILLER_204_581 VPWR VGND VPWR VGND sky130_ef_sc_hd__decap_12
XFILLER_91_1177 VPWR VGND VPWR VGND sky130_ef_sc_hd__decap_12
XFILLER_176_433 VPWR VGND VPWR VGND sky130_ef_sc_hd__decap_12
XTAP_TAPCELL_ROW_120_2_5622 VGND VPWR sky130_fd_sc_hd__tapvpwrvgnd_1
XTAP_TAPCELL_ROW_119_2_5616 VGND VPWR sky130_fd_sc_hd__tapvpwrvgnd_1
XFILLER_176_488 VGND VGND VPWR VPWR sky130_fd_sc_hd__decap_6
XFILLER_192_937 VPWR VGND VPWR VGND sky130_ef_sc_hd__decap_12
XFILLER_223_1291 VPWR VGND VPWR VGND sky130_ef_sc_hd__decap_12
XFILLER_254_1207 VPWR VGND VPWR VGND sky130_ef_sc_hd__decap_12
XFILLER_219_1327 VGND VGND VPWR VPWR sky130_fd_sc_hd__decap_6
XFILLER_176_1054 VPWR VGND VPWR VGND sky130_ef_sc_hd__decap_12
XFILLER_67_1371 VGND VGND VPWR VPWR sky130_fd_sc_hd__decap_6
XFILLER_24_1208 VPWR VGND VPWR VGND sky130_ef_sc_hd__decap_12
XPHY_EDGE_ROW_10_1_Left_511 VGND VGND VPWR VPWR sky130_fd_sc_hd__decap_3
XFILLER_247_916 VPWR VGND VPWR VGND sky130_ef_sc_hd__decap_12
XTAP_TAPCELL_ROW_56_1_1313 VGND VPWR sky130_fd_sc_hd__tapvpwrvgnd_1
XFILLER_41_1500 VGND VGND VPWR VPWR sky130_fd_sc_hd__decap_6
XFILLER_28_1399 VPWR VGND VPWR VGND sky130_ef_sc_hd__decap_12
Xfanout669 net672 VGND VGND VPWR VPWR net669 sky130_fd_sc_hd__buf_4
XFILLER_115_1347 VPWR VGND VPWR VGND sky130_ef_sc_hd__decap_12
XFILLER_150_1227 VPWR VGND VPWR VGND sky130_ef_sc_hd__decap_12
XFILLER_37_15 VPWR VGND VPWR VGND sky130_ef_sc_hd__decap_12
XFILLER_6_1140 VPWR VGND VPWR VGND sky130_ef_sc_hd__decap_12
XFILLER_230_1262 VGND VGND VPWR VPWR sky130_fd_sc_hd__decap_6
XFILLER_2_1004 VGND VGND VPWR VPWR sky130_fd_sc_hd__decap_6
XTAP_TAPCELL_ROW_206_2950 VGND VPWR sky130_fd_sc_hd__tapvpwrvgnd_1
XFILLER_6_1195 VPWR VGND VPWR VGND sky130_ef_sc_hd__decap_12
XTAP_TAPCELL_ROW_206_2961 VGND VPWR sky130_fd_sc_hd__tapvpwrvgnd_1
XTAP_TAPCELL_ROW_206_2972 VGND VPWR sky130_fd_sc_hd__tapvpwrvgnd_1
XTAP_TAPCELL_ROW_202_2814 VGND VPWR sky130_fd_sc_hd__tapvpwrvgnd_1
XTAP_TAPCELL_ROW_206_2983 VGND VPWR sky130_fd_sc_hd__tapvpwrvgnd_1
XTAP_TAPCELL_ROW_202_2825 VGND VPWR sky130_fd_sc_hd__tapvpwrvgnd_1
XTAP_TAPCELL_ROW_202_2836 VGND VPWR sky130_fd_sc_hd__tapvpwrvgnd_1
XFILLER_214_323 VPWR VGND VPWR VGND sky130_ef_sc_hd__decap_12
XFILLER_183_1014 VPWR VGND VPWR VGND sky130_ef_sc_hd__decap_12
XFILLER_226_194 VPWR VGND VPWR VGND sky130_ef_sc_hd__decap_12
XTAP_TAPCELL_ROW_254_4637 VGND VPWR sky130_fd_sc_hd__tapvpwrvgnd_1
XFILLER_241_142 VPWR VGND VPWR VGND sky130_ef_sc_hd__decap_12
XTAP_TAPCELL_ROW_254_4648 VGND VPWR sky130_fd_sc_hd__tapvpwrvgnd_1
XFILLER_202_507 VPWR VGND VPWR VGND sky130_ef_sc_hd__decap_12
XTAP_TAPCELL_ROW_254_4659 VGND VPWR sky130_fd_sc_hd__tapvpwrvgnd_1
XFILLER_214_378 VPWR VGND VPWR VGND sky130_ef_sc_hd__decap_12
XFILLER_183_1069 VGND VGND VPWR VPWR sky130_fd_sc_hd__decap_6
XFILLER_35_1304 VPWR VGND VPWR VGND sky130_ef_sc_hd__decap_12
XFILLER_224_1011 VPWR VGND VPWR VGND sky130_ef_sc_hd__decap_12
XFILLER_53_69 VGND VGND VPWR VPWR sky130_fd_sc_hd__fill_2
XFILLER_241_197 VPWR VGND VPWR VGND sky130_ef_sc_hd__decap_12
XFILLER_167_400 VPWR VGND VPWR VGND sky130_ef_sc_hd__decap_12
XFILLER_165_1492 VPWR VGND VPWR VGND sky130_ef_sc_hd__decap_12
XFILLER_179_271 VPWR VGND VPWR VGND sky130_ef_sc_hd__decap_12
XFILLER_126_1454 VPWR VGND VPWR VGND sky130_ef_sc_hd__decap_12
XFILLER_70_1239 VPWR VGND VPWR VGND sky130_ef_sc_hd__decap_12
XFILLER_35_1359 VPWR VGND VPWR VGND sky130_ef_sc_hd__decap_12
XFILLER_224_1066 VPWR VGND VPWR VGND sky130_ef_sc_hd__decap_12
XFILLER_194_230 VGND VGND VPWR VPWR sky130_fd_sc_hd__decap_6
XFILLER_167_455 VPWR VGND VPWR VGND sky130_ef_sc_hd__decap_12
XFILLER_183_904 VPWR VGND VPWR VGND sky130_ef_sc_hd__decap_12
XFILLER_210_562 VPWR VGND VPWR VGND sky130_ef_sc_hd__decap_12
XFILLER_161_1378 VPWR VGND VPWR VGND sky130_ef_sc_hd__decap_12
XFILLER_195_775 VPWR VGND VPWR VGND sky130_ef_sc_hd__decap_12
XFILLER_249_80 VGND VGND VPWR VPWR sky130_fd_sc_hd__decap_6
XFILLER_6_638 VGND VGND VPWR VPWR sky130_fd_sc_hd__decap_4
XFILLER_183_959 VPWR VGND VPWR VGND sky130_ef_sc_hd__decap_12
XTAP_TAPCELL_ROW_248_4419 VGND VPWR sky130_fd_sc_hd__tapvpwrvgnd_1
XFILLER_159_1230 VPWR VGND VPWR VGND sky130_ef_sc_hd__decap_12
XFILLER_185_68 VPWR VGND VPWR VGND sky130_ef_sc_hd__decap_12
XFILLER_194_1121 VPWR VGND VPWR VGND sky130_ef_sc_hd__decap_12
XFILLER_204_3 VPWR VGND VPWR VGND sky130_ef_sc_hd__decap_12
XFILLER_78_22 VPWR VGND VPWR VGND sky130_ef_sc_hd__decap_12
XFILLER_159_1285 VGND VGND VPWR VPWR sky130_fd_sc_hd__decap_6
XFILLER_1_310 VGND VGND VPWR VPWR sky130_fd_sc_hd__fill_2
XFILLER_194_1176 VGND VGND VPWR VPWR sky130_fd_sc_hd__decap_6
XFILLER_46_1411 VPWR VGND VPWR VGND sky130_ef_sc_hd__decap_12
XFILLER_2_855 VGND VGND VPWR VPWR sky130_fd_sc_hd__fill_2
XTAP_TAPCELL_ROW_164_2_5975 VGND VPWR sky130_fd_sc_hd__tapvpwrvgnd_1
XFILLER_172_1441 VPWR VGND VPWR VGND sky130_ef_sc_hd__decap_12
XFILLER_81_1335 VPWR VGND VPWR VGND sky130_ef_sc_hd__decap_12
XFILLER_235_1162 VPWR VGND VPWR VGND sky130_ef_sc_hd__decap_12
XFILLER_46_1466 VPWR VGND VPWR VGND sky130_ef_sc_hd__decap_12
XFILLER_133_1414 VGND VGND VPWR VPWR sky130_fd_sc_hd__decap_6
XFILLER_231_1026 VGND VGND VPWR VPWR sky130_fd_sc_hd__decap_6
XFILLER_172_1496 VPWR VGND VPWR VGND sky130_ef_sc_hd__decap_12
XFILLER_238_949 VPWR VGND VPWR VGND sky130_ef_sc_hd__decap_12
XFILLER_94_65 VGND VGND VPWR VPWR sky130_fd_sc_hd__decap_6
XFILLER_79_1242 VGND VGND VPWR VPWR sky130_fd_sc_hd__decap_6
X_605_ clknet_3_1__leaf_clk dout0\[3\] _013_ VGND VGND VPWR VPWR dout0_q\[3\] sky130_fd_sc_hd__dfrtp_1
XTAP_TAPCELL_ROW_125_2_5659 VGND VPWR sky130_fd_sc_hd__tapvpwrvgnd_1
XFILLER_232_120 VPWR VGND VPWR VGND sky130_ef_sc_hd__decap_12
XFILLER_205_345 VPWR VGND VPWR VGND sky130_ef_sc_hd__decap_12
X_536_ net667 VGND VGND VPWR VPWR _018_ sky130_fd_sc_hd__inv_2
XTAP_TAPCELL_ROW_93_2_5404 VGND VPWR sky130_fd_sc_hd__tapvpwrvgnd_1
XFILLER_127_1218 VPWR VGND VPWR VGND sky130_ef_sc_hd__decap_12
XFILLER_220_304 VPWR VGND VPWR VGND sky130_ef_sc_hd__decap_12
XFILLER_92_1442 VPWR VGND VPWR VGND sky130_ef_sc_hd__decap_12
XFILLER_232_175 VPWR VGND VPWR VGND sky130_ef_sc_hd__decap_12
X_467_ net155 _241_ VGND VGND VPWR VPWR acc_core.adder.cla_blocks\[1\].block.sum\[3\]
+ sky130_fd_sc_hd__xnor2_1
XFILLER_242_1133 VGND VGND VPWR VPWR sky130_fd_sc_hd__decap_6
XTAP_TAPCELL_ROW_105_2_5502 VGND VPWR sky130_fd_sc_hd__tapvpwrvgnd_1
XFILLER_220_359 VGND VGND VPWR VPWR sky130_fd_sc_hd__decap_6
XFILLER_9_421 VGND VGND VPWR VPWR sky130_fd_sc_hd__decap_6
XFILLER_92_1497 VPWR VGND VPWR VGND sky130_ef_sc_hd__decap_12
XFILLER_186_753 VPWR VGND VPWR VGND sky130_ef_sc_hd__decap_12
X_398_ net586 net592 net563 VGND VGND VPWR VPWR _187_ sky130_fd_sc_hd__nand3_1
XFILLER_185_252 VGND VGND VPWR VPWR sky130_fd_sc_hd__decap_6
XFILLER_201_584 VPWR VGND VPWR VGND sky130_ef_sc_hd__decap_12
XFILLER_229_39 VGND VGND VPWR VPWR sky130_fd_sc_hd__decap_4
XFILLER_16_1270 VPWR VGND VPWR VGND sky130_ef_sc_hd__decap_12
XFILLER_174_937 VPWR VGND VPWR VGND sky130_ef_sc_hd__decap_12
XTAP_TAPCELL_ROW_28_2_4886 VGND VPWR sky130_fd_sc_hd__tapvpwrvgnd_1
XFILLER_220_1453 VPWR VGND VPWR VGND sky130_ef_sc_hd__decap_12
XTAP_TAPCELL_ROW_175_1880 VGND VPWR sky130_fd_sc_hd__tapvpwrvgnd_1
XFILLER_199_1076 VPWR VGND VPWR VGND sky130_ef_sc_hd__decap_12
XTAP_TAPCELL_ROW_62_1_1323 VGND VPWR sky130_fd_sc_hd__tapvpwrvgnd_1
XTAP_TAPCELL_ROW_175_1891 VGND VPWR sky130_fd_sc_hd__tapvpwrvgnd_1
XTAP_TAPCELL_ROW_171_1733 VGND VPWR sky130_fd_sc_hd__tapvpwrvgnd_1
XFILLER_103_1273 VPWR VGND VPWR VGND sky130_ef_sc_hd__decap_12
XTAP_TAPCELL_ROW_171_1744 VGND VPWR sky130_fd_sc_hd__tapvpwrvgnd_1
XTAP_TAPCELL_ROW_212_3165 VGND VPWR sky130_fd_sc_hd__tapvpwrvgnd_1
XTAP_TAPCELL_ROW_171_1755 VGND VPWR sky130_fd_sc_hd__tapvpwrvgnd_1
XTAP_TAPCELL_ROW_212_3176 VGND VPWR sky130_fd_sc_hd__tapvpwrvgnd_1
XTAP_TAPCELL_ROW_212_3187 VGND VPWR sky130_fd_sc_hd__tapvpwrvgnd_1
XFILLER_245_27 VPWR VGND VPWR VGND sky130_ef_sc_hd__decap_12
XFILLER_138_1325 VPWR VGND VPWR VGND sky130_ef_sc_hd__decap_12
XFILLER_173_1205 VPWR VGND VPWR VGND sky130_ef_sc_hd__decap_12
XFILLER_182_992 VPWR VGND VPWR VGND sky130_ef_sc_hd__decap_12
XFILLER_5_682 VGND VGND VPWR VPWR sky130_fd_sc_hd__decap_6
XTAP_TAPCELL_ROW_21_2_4829 VGND VPWR sky130_fd_sc_hd__tapvpwrvgnd_1
XFILLER_229_916 VPWR VGND VPWR VGND sky130_ef_sc_hd__decap_12
XFILLER_253_1284 VGND VGND VPWR VPWR sky130_fd_sc_hd__decap_6
XFILLER_4_96 VGND VGND VPWR VPWR sky130_fd_sc_hd__fill_1
XTAP_TAPCELL_ROW_169_1662 VGND VPWR sky130_fd_sc_hd__tapvpwrvgnd_1
XTAP_TAPCELL_ROW_165_1504 VGND VPWR sky130_fd_sc_hd__tapvpwrvgnd_1
XTAP_TAPCELL_ROW_169_1673 VGND VPWR sky130_fd_sc_hd__tapvpwrvgnd_1
XTAP_TAPCELL_ROW_165_1515 VGND VPWR sky130_fd_sc_hd__tapvpwrvgnd_1
XTAP_TAPCELL_ROW_169_1684 VGND VPWR sky130_fd_sc_hd__tapvpwrvgnd_1
XFILLER_112_1509 VGND VGND VPWR VPWR sky130_fd_sc_hd__decap_6
XTAP_TAPCELL_ROW_165_1526 VGND VPWR sky130_fd_sc_hd__tapvpwrvgnd_1
XFILLER_255_223 VGND VGND VPWR VPWR sky130_fd_sc_hd__decap_8
XTAP_TAPCELL_ROW_165_1537 VGND VPWR sky130_fd_sc_hd__tapvpwrvgnd_1
XFILLER_23_1230 VPWR VGND VPWR VGND sky130_ef_sc_hd__decap_12
XTAP_TAPCELL_ROW_165_1548 VGND VPWR sky130_fd_sc_hd__tapvpwrvgnd_1
XFILLER_114_1380 VPWR VGND VPWR VGND sky130_ef_sc_hd__decap_12
XFILLER_237_971 VPWR VGND VPWR VGND sky130_ef_sc_hd__decap_12
XFILLER_3_1346 VPWR VGND VPWR VGND sky130_ef_sc_hd__decap_12
XFILLER_23_1285 VGND VGND VPWR VPWR sky130_fd_sc_hd__decap_6
XFILLER_149_1421 VPWR VGND VPWR VGND sky130_ef_sc_hd__decap_12
XFILLER_247_1033 VPWR VGND VPWR VGND sky130_ef_sc_hd__decap_12
XFILLER_184_1312 VPWR VGND VPWR VGND sky130_ef_sc_hd__decap_12
XFILLER_93_1206 VPWR VGND VPWR VGND sky130_ef_sc_hd__decap_12
XFILLER_208_194 VPWR VGND VPWR VGND sky130_ef_sc_hd__decap_12
XFILLER_58_1337 VPWR VGND VPWR VGND sky130_ef_sc_hd__decap_12
XFILLER_223_142 VPWR VGND VPWR VGND sky130_ef_sc_hd__decap_12
XFILLER_149_1476 VPWR VGND VPWR VGND sky130_ef_sc_hd__decap_12
XFILLER_184_1367 VPWR VGND VPWR VGND sky130_ef_sc_hd__decap_12
XFILLER_247_1088 VPWR VGND VPWR VGND sky130_ef_sc_hd__decap_12
XFILLER_211_326 VPWR VGND VPWR VGND sky130_ef_sc_hd__decap_12
XFILLER_223_197 VPWR VGND VPWR VGND sky130_ef_sc_hd__decap_12
XFILLER_165_904 VPWR VGND VPWR VGND sky130_ef_sc_hd__decap_12
XFILLER_176_230 VGND VGND VPWR VPWR sky130_fd_sc_hd__decap_6
XFILLER_221_1217 VPWR VGND VPWR VGND sky130_ef_sc_hd__decap_12
XFILLER_108_1184 VPWR VGND VPWR VGND sky130_ef_sc_hd__decap_12
XFILLER_139_39 VGND VGND VPWR VPWR sky130_fd_sc_hd__decap_4
XFILLER_177_775 VPWR VGND VPWR VGND sky130_ef_sc_hd__decap_12
XFILLER_220_882 VPWR VGND VPWR VGND sky130_ef_sc_hd__decap_12
XFILLER_165_937 VGND VGND VPWR VPWR sky130_fd_sc_hd__decap_8
XFILLER_192_734 VPWR VGND VPWR VGND sky130_ef_sc_hd__decap_12
XFILLER_34_1392 VGND VGND VPWR VPWR sky130_fd_sc_hd__decap_6
XFILLER_180_918 VGND VGND VPWR VPWR sky130_fd_sc_hd__decap_6
XFILLER_69_1433 VPWR VGND VPWR VGND sky130_ef_sc_hd__decap_12
XFILLER_192_789 VGND VGND VPWR VPWR sky130_fd_sc_hd__decap_6
XFILLER_254_1004 VGND VGND VPWR VPWR sky130_fd_sc_hd__decap_6
XTAP_TAPCELL_ROW_150_2_5861 VGND VPWR sky130_fd_sc_hd__tapvpwrvgnd_1
XTAP_TAPCELL_ROW_149_2_5855 VGND VPWR sky130_fd_sc_hd__tapvpwrvgnd_1
XFILLER_155_27 VPWR VGND VPWR VGND sky130_ef_sc_hd__decap_12
XFILLER_195_1463 VPWR VGND VPWR VGND sky130_ef_sc_hd__decap_12
XFILLER_69_1488 VPWR VGND VPWR VGND sky130_ef_sc_hd__decap_12
XPHY_EDGE_ROW_224_Left_479 VGND VGND VPWR VPWR sky130_fd_sc_hd__decap_3
XFILLER_191_1327 VGND VGND VPWR VPWR sky130_fd_sc_hd__decap_6
XFILLER_232_1324 VPWR VGND VPWR VGND sky130_ef_sc_hd__decap_12
XFILLER_247_713 VPWR VGND VPWR VGND sky130_ef_sc_hd__decap_12
XFILLER_171_15 VPWR VGND VPWR VGND sky130_ef_sc_hd__decap_12
XFILLER_28_1196 VPWR VGND VPWR VGND sky130_ef_sc_hd__decap_12
XTAP_TAPCELL_ROW_9_1230 VGND VPWR sky130_fd_sc_hd__tapvpwrvgnd_1
XTAP_TAPCELL_ROW_9_1241 VGND VPWR sky130_fd_sc_hd__tapvpwrvgnd_1
XFILLER_232_1379 VPWR VGND VPWR VGND sky130_ef_sc_hd__decap_12
XFILLER_247_768 VGND VGND VPWR VPWR sky130_fd_sc_hd__decap_6
XFILLER_115_1177 VPWR VGND VPWR VGND sky130_ef_sc_hd__decap_12
XTAP_TAPCELL_ROW_67_2_5199 VGND VPWR sky130_fd_sc_hd__tapvpwrvgnd_1
XTAP_TAPCELL_ROW_204_2909 VGND VPWR sky130_fd_sc_hd__tapvpwrvgnd_1
XTAP_TAPCELL_ROW_181_2084 VGND VPWR sky130_fd_sc_hd__tapvpwrvgnd_1
XTAP_TAPCELL_ROW_181_2095 VGND VPWR sky130_fd_sc_hd__tapvpwrvgnd_1
XFILLER_255_790 VGND VGND VPWR VPWR sky130_fd_sc_hd__decap_8
XFILLER_64_46 VGND VGND VPWR VPWR sky130_fd_sc_hd__fill_2
XFILLER_64_57 VGND VGND VPWR VPWR sky130_fd_sc_hd__decap_6
XFILLER_214_120 VPWR VGND VPWR VGND sky130_ef_sc_hd__decap_12
XPHY_EDGE_ROW_233_Left_488 VGND VGND VPWR VPWR sky130_fd_sc_hd__decap_3
XFILLER_154_3 VPWR VGND VPWR VGND sky130_ef_sc_hd__decap_12
XFILLER_202_304 VPWR VGND VPWR VGND sky130_ef_sc_hd__decap_12
XFILLER_243_1420 VPWR VGND VPWR VGND sky130_ef_sc_hd__decap_12
X_321_ _102_ net138 _109_ net509 VGND VGND VPWR VPWR _110_ sky130_fd_sc_hd__a211o_1
XFILLER_187_517 VPWR VGND VPWR VGND sky130_ef_sc_hd__decap_12
XFILLER_214_175 VPWR VGND VPWR VGND sky130_ef_sc_hd__decap_12
XFILLER_230_624 VPWR VGND VPWR VGND sky130_ef_sc_hd__decap_12
XFILLER_242_495 VPWR VGND VPWR VGND sky130_ef_sc_hd__decap_12
XFILLER_199_388 VPWR VGND VPWR VGND sky130_ef_sc_hd__decap_12
XFILLER_39_1292 VPWR VGND VPWR VGND sky130_ef_sc_hd__decap_12
XTAP_TAPCELL_ROW_14_2_4772 VGND VPWR sky130_fd_sc_hd__tapvpwrvgnd_1
XFILLER_80_34 VPWR VGND VPWR VGND sky130_ef_sc_hd__decap_12
XFILLER_202_359 VGND VGND VPWR VPWR sky130_fd_sc_hd__decap_6
XFILLER_126_1251 VPWR VGND VPWR VGND sky130_ef_sc_hd__decap_12
XFILLER_230_679 VPWR VGND VPWR VGND sky130_ef_sc_hd__decap_12
XFILLER_243_1475 VPWR VGND VPWR VGND sky130_ef_sc_hd__decap_12
XFILLER_168_753 VPWR VGND VPWR VGND sky130_ef_sc_hd__decap_12
XFILLER_183_701 VPWR VGND VPWR VGND sky130_ef_sc_hd__decap_12
XFILLER_196_34 VPWR VGND VPWR VGND sky130_ef_sc_hd__decap_12
XFILLER_167_252 VGND VGND VPWR VPWR sky130_fd_sc_hd__decap_6
XFILLER_195_572 VPWR VGND VPWR VGND sky130_ef_sc_hd__decap_12
XFILLER_35_1189 VPWR VGND VPWR VGND sky130_ef_sc_hd__decap_12
XFILLER_13_1421 VPWR VGND VPWR VGND sky130_ef_sc_hd__decap_12
XFILLER_7_947 VPWR VGND VPWR VGND sky130_ef_sc_hd__decap_12
XFILLER_87_1500 VGND VGND VPWR VPWR sky130_fd_sc_hd__decap_6
XFILLER_183_756 VPWR VGND VPWR VGND sky130_ef_sc_hd__decap_12
XFILLER_196_89 VPWR VGND VPWR VGND sky130_ef_sc_hd__decap_12
XFILLER_196_1238 VPWR VGND VPWR VGND sky130_ef_sc_hd__decap_12
XFILLER_202_1183 VPWR VGND VPWR VGND sky130_ef_sc_hd__decap_12
XFILLER_13_1476 VPWR VGND VPWR VGND sky130_ef_sc_hd__decap_12
XPHY_EDGE_ROW_242_Left_497 VGND VGND VPWR VPWR sky130_fd_sc_hd__decap_3
XFILLER_100_1435 VGND VGND VPWR VPWR sky130_fd_sc_hd__decap_6
XFILLER_174_1514 VGND VGND VPWR VPWR sky130_fd_sc_hd__fill_1
XFILLER_2_652 VGND VGND VPWR VPWR sky130_fd_sc_hd__fill_2
XFILLER_46_1263 VGND VGND VPWR VPWR sky130_fd_sc_hd__decap_6
XFILLER_1_173 VGND VGND VPWR VPWR sky130_fd_sc_hd__fill_2
XFILLER_81_1165 VPWR VGND VPWR VGND sky130_ef_sc_hd__decap_12
XFILLER_172_1293 VPWR VGND VPWR VGND sky130_ef_sc_hd__decap_12
XFILLER_238_746 VGND VGND VPWR VPWR sky130_fd_sc_hd__decap_6
XTAP_TAPCELL_ROW_224_3581 VGND VPWR sky130_fd_sc_hd__tapvpwrvgnd_1
XFILLER_219_971 VPWR VGND VPWR VGND sky130_ef_sc_hd__decap_12
XTAP_TAPCELL_ROW_224_3592 VGND VPWR sky130_fd_sc_hd__tapvpwrvgnd_1
XTAP_TAPCELL_ROW_220_3445 VGND VPWR sky130_fd_sc_hd__tapvpwrvgnd_1
XFILLER_252_237 VPWR VGND VPWR VGND sky130_ef_sc_hd__decap_12
XTAP_TAPCELL_ROW_220_3456 VGND VPWR sky130_fd_sc_hd__tapvpwrvgnd_1
XTAP_TAPCELL_ROW_114_1_1400 VGND VPWR sky130_fd_sc_hd__tapvpwrvgnd_1
XTAP_TAPCELL_ROW_220_3467 VGND VPWR sky130_fd_sc_hd__tapvpwrvgnd_1
XFILLER_209_1315 VPWR VGND VPWR VGND sky130_ef_sc_hd__decap_12
XPHY_EDGE_ROW_117_2_Left_619 VGND VGND VPWR VPWR sky130_fd_sc_hd__decap_3
XFILLER_205_142 VPWR VGND VPWR VGND sky130_ef_sc_hd__decap_12
XFILLER_220_101 VGND VGND VPWR VPWR sky130_fd_sc_hd__decap_6
X_519_ net664 VGND VGND VPWR VPWR _001_ sky130_fd_sc_hd__inv_2
XFILLER_53_1201 VGND VGND VPWR VPWR sky130_fd_sc_hd__decap_4
XFILLER_166_1097 VPWR VGND VPWR VGND sky130_ef_sc_hd__decap_12
XFILLER_205_197 VPWR VGND VPWR VGND sky130_ef_sc_hd__decap_12
XFILLER_221_646 VPWR VGND VPWR VGND sky130_ef_sc_hd__decap_12
XTAP_TAPCELL_ROW_177_1942 VGND VPWR sky130_fd_sc_hd__tapvpwrvgnd_1
XFILLER_92_1294 VPWR VGND VPWR VGND sky130_ef_sc_hd__decap_12
XTAP_TAPCELL_ROW_155_2_5898 VGND VPWR sky130_fd_sc_hd__tapvpwrvgnd_1
XTAP_TAPCELL_ROW_177_1953 VGND VPWR sky130_fd_sc_hd__tapvpwrvgnd_1
XTAP_TAPCELL_ROW_218_3374 VGND VPWR sky130_fd_sc_hd__tapvpwrvgnd_1
XTAP_TAPCELL_ROW_177_1964 VGND VPWR sky130_fd_sc_hd__tapvpwrvgnd_1
XFILLER_186_550 VPWR VGND VPWR VGND sky130_ef_sc_hd__decap_12
XFILLER_202_882 VPWR VGND VPWR VGND sky130_ef_sc_hd__decap_12
XTAP_TAPCELL_ROW_218_3385 VGND VPWR sky130_fd_sc_hd__tapvpwrvgnd_1
XFILLER_105_1335 VPWR VGND VPWR VGND sky130_ef_sc_hd__decap_12
XTAP_TAPCELL_ROW_173_1806 VGND VPWR sky130_fd_sc_hd__tapvpwrvgnd_1
XTAP_TAPCELL_ROW_218_3396 VGND VPWR sky130_fd_sc_hd__tapvpwrvgnd_1
XTAP_TAPCELL_ROW_173_1817 VGND VPWR sky130_fd_sc_hd__tapvpwrvgnd_1
XTAP_TAPCELL_ROW_214_3238 VGND VPWR sky130_fd_sc_hd__tapvpwrvgnd_1
XFILLER_201_381 VGND VGND VPWR VPWR sky130_fd_sc_hd__decap_6
XTAP_TAPCELL_ROW_214_3249 VGND VPWR sky130_fd_sc_hd__tapvpwrvgnd_1
XFILLER_174_734 VPWR VGND VPWR VGND sky130_ef_sc_hd__decap_12
XTAP_TAPCELL_ROW_173_1828 VGND VPWR sky130_fd_sc_hd__tapvpwrvgnd_1
XFILLER_9_295 VGND VGND VPWR VPWR sky130_fd_sc_hd__decap_8
XTAP_TAPCELL_ROW_135_2_5741 VGND VPWR sky130_fd_sc_hd__tapvpwrvgnd_1
XFILLER_220_1250 VPWR VGND VPWR VGND sky130_ef_sc_hd__decap_12
XFILLER_174_789 VGND VGND VPWR VPWR sky130_fd_sc_hd__decap_6
XFILLER_255_1324 VPWR VGND VPWR VGND sky130_ef_sc_hd__decap_12
XFILLER_6_980 VPWR VGND VPWR VGND sky130_ef_sc_hd__decap_12
XFILLER_173_1002 VPWR VGND VPWR VGND sky130_ef_sc_hd__decap_12
XFILLER_255_1357 VGND VGND VPWR VPWR sky130_fd_sc_hd__decap_8
XFILLER_138_1177 VGND VGND VPWR VPWR sky130_fd_sc_hd__decap_6
XFILLER_173_1057 VPWR VGND VPWR VGND sky130_ef_sc_hd__decap_12
XTAP_TAPCELL_ROW_53_2_5085 VGND VPWR sky130_fd_sc_hd__tapvpwrvgnd_1
XFILLER_229_713 VPWR VGND VPWR VGND sky130_ef_sc_hd__decap_12
XFILLER_116_1442 VPWR VGND VPWR VGND sky130_ef_sc_hd__decap_12
XFILLER_60_1227 VPWR VGND VPWR VGND sky130_ef_sc_hd__decap_12
XFILLER_25_1347 VPWR VGND VPWR VGND sky130_ef_sc_hd__decap_12
XFILLER_214_1054 VPWR VGND VPWR VGND sky130_ef_sc_hd__decap_12
XFILLER_112_1306 VGND VGND VPWR VPWR sky130_fd_sc_hd__decap_6
XFILLER_229_768 VGND VGND VPWR VPWR sky130_fd_sc_hd__decap_6
XFILLER_116_1497 VPWR VGND VPWR VGND sky130_ef_sc_hd__decap_12
XFILLER_3_1143 VPWR VGND VPWR VGND sky130_ef_sc_hd__decap_12
XTAP_TAPCELL_ROW_255_4710 VGND VPWR sky130_fd_sc_hd__tapvpwrvgnd_1
XFILLER_243_259 VPWR VGND VPWR VGND sky130_ef_sc_hd__decap_12
XTAP_TAPCELL_ROW_255_4721 VGND VPWR sky130_fd_sc_hd__tapvpwrvgnd_1
XTAP_TAPCELL_ROW_31_2_4911 VGND VPWR sky130_fd_sc_hd__tapvpwrvgnd_1
XTAP_TAPCELL_ROW_255_4732 VGND VPWR sky130_fd_sc_hd__tapvpwrvgnd_1
XFILLER_3_1198 VGND VGND VPWR VPWR sky130_fd_sc_hd__decap_6
XFILLER_149_1273 VPWR VGND VPWR VGND sky130_ef_sc_hd__decap_12
XFILLER_184_1164 VPWR VGND VPWR VGND sky130_ef_sc_hd__decap_12
XFILLER_212_624 VPWR VGND VPWR VGND sky130_ef_sc_hd__decap_12
XFILLER_169_517 VPWR VGND VPWR VGND sky130_ef_sc_hd__decap_12
XFILLER_224_495 VPWR VGND VPWR VGND sky130_ef_sc_hd__decap_12
XFILLER_211_123 VGND VGND VPWR VPWR sky130_fd_sc_hd__decap_6
XFILLER_200_808 VPWR VGND VPWR VGND sky130_ef_sc_hd__decap_12
XFILLER_196_347 VPWR VGND VPWR VGND sky130_ef_sc_hd__decap_12
XFILLER_212_679 VPWR VGND VPWR VGND sky130_ef_sc_hd__decap_12
XFILLER_36_1454 VPWR VGND VPWR VGND sky130_ef_sc_hd__decap_12
XFILLER_123_1402 VPWR VGND VPWR VGND sky130_ef_sc_hd__decap_12
XFILLER_221_1014 VPWR VGND VPWR VGND sky130_ef_sc_hd__decap_12
Xwire108 _207_ VGND VGND VPWR VPWR net108 sky130_fd_sc_hd__clkbuf_1
Xclkload4 clknet_3_4__leaf_clk VGND VGND VPWR VPWR clkload4/Y sky130_fd_sc_hd__bufinv_16
XFILLER_177_572 VPWR VGND VPWR VGND sky130_ef_sc_hd__decap_12
XFILLER_71_1378 VPWR VGND VPWR VGND sky130_ef_sc_hd__decap_12
XFILLER_50_15 VGND VGND VPWR VPWR sky130_fd_sc_hd__decap_6
XFILLER_123_1457 VGND VGND VPWR VPWR sky130_fd_sc_hd__decap_6
XFILLER_197_1514 VGND VGND VPWR VPWR sky130_fd_sc_hd__fill_1
XFILLER_192_531 VGND VGND VPWR VPWR sky130_fd_sc_hd__decap_6
XFILLER_221_1069 VGND VGND VPWR VPWR sky130_fd_sc_hd__decap_6
XFILLER_166_15 VGND VGND VPWR VPWR sky130_fd_sc_hd__decap_6
XFILLER_165_778 VPWR VGND VPWR VGND sky130_ef_sc_hd__decap_12
XFILLER_4_906 VPWR VGND VPWR VGND sky130_ef_sc_hd__decap_12
XFILLER_158_1509 VGND VGND VPWR VPWR sky130_fd_sc_hd__decap_6
XPHY_EDGE_ROW_163_2_Left_665 VGND VGND VPWR VPWR sky130_fd_sc_hd__decap_3
XFILLER_69_1230 VPWR VGND VPWR VGND sky130_ef_sc_hd__decap_12
XFILLER_195_1260 VPWR VGND VPWR VGND sky130_ef_sc_hd__decap_12
XFILLER_69_1285 VGND VGND VPWR VPWR sky130_fd_sc_hd__decap_6
XFILLER_117_1206 VPWR VGND VPWR VGND sky130_ef_sc_hd__decap_12
XTAP_TAPCELL_ROW_120_1_1410 VGND VPWR sky130_fd_sc_hd__tapvpwrvgnd_1
XFILLER_59_68 VGND VGND VPWR VPWR sky130_fd_sc_hd__decap_3
XFILLER_182_58 VGND VGND VPWR VPWR sky130_fd_sc_hd__decap_6
XFILLER_43_1414 VGND VGND VPWR VPWR sky130_fd_sc_hd__decap_6
XTAP_TAPCELL_ROW_187_2293 VGND VPWR sky130_fd_sc_hd__tapvpwrvgnd_1
XFILLER_232_1121 VPWR VGND VPWR VGND sky130_ef_sc_hd__decap_12
XFILLER_247_510 VGND VGND VPWR VPWR sky130_fd_sc_hd__decap_6
XFILLER_8_1054 VPWR VGND VPWR VGND sky130_ef_sc_hd__decap_12
XFILLER_82_1485 VPWR VGND VPWR VGND sky130_ef_sc_hd__decap_12
XTAP_TAPCELL_ROW_183_2146 VGND VPWR sky130_fd_sc_hd__tapvpwrvgnd_1
XTAP_TAPCELL_ROW_183_2157 VGND VPWR sky130_fd_sc_hd__tapvpwrvgnd_1
XTAP_TAPCELL_ROW_183_2168 VGND VPWR sky130_fd_sc_hd__tapvpwrvgnd_1
XFILLER_232_1176 VGND VGND VPWR VPWR sky130_fd_sc_hd__decap_6
XFILLER_75_56 VPWR VGND VPWR VGND sky130_ef_sc_hd__decap_12
XFILLER_210_1441 VPWR VGND VPWR VGND sky130_ef_sc_hd__decap_12
XTAP_TAPCELL_ROW_3_972 VGND VPWR sky130_fd_sc_hd__tapvpwrvgnd_1
XTAP_TAPCELL_ROW_3_983 VGND VPWR sky130_fd_sc_hd__tapvpwrvgnd_1
XPHY_EDGE_ROW_100_1_Right_756 VGND VGND VPWR VPWR sky130_fd_sc_hd__decap_3
XFILLER_234_237 VPWR VGND VPWR VGND sky130_ef_sc_hd__decap_12
XPHY_EDGE_ROW_52_1_Left_307 VGND VGND VPWR VPWR sky130_fd_sc_hd__decap_3
XTAP_TAPCELL_ROW_3_994 VGND VPWR sky130_fd_sc_hd__tapvpwrvgnd_1
XFILLER_210_1496 VPWR VGND VPWR VGND sky130_ef_sc_hd__decap_12
XFILLER_199_130 VPWR VGND VPWR VGND sky130_ef_sc_hd__decap_12
XFILLER_128_1313 VPWR VGND VPWR VGND sky130_ef_sc_hd__decap_12
XFILLER_37_1218 VPWR VGND VPWR VGND sky130_ef_sc_hd__decap_12
XFILLER_91_44 VPWR VGND VPWR VGND sky130_ef_sc_hd__decap_12
XFILLER_202_101 VGND VGND VPWR VPWR sky130_fd_sc_hd__decap_6
XFILLER_230_421 VPWR VGND VPWR VGND sky130_ef_sc_hd__decap_12
XFILLER_187_314 VPWR VGND VPWR VGND sky130_ef_sc_hd__decap_12
XFILLER_203_646 VPWR VGND VPWR VGND sky130_ef_sc_hd__decap_12
XFILLER_242_292 VPWR VGND VPWR VGND sky130_ef_sc_hd__decap_12
XFILLER_199_185 VPWR VGND VPWR VGND sky130_ef_sc_hd__decap_12
XFILLER_128_1368 VPWR VGND VPWR VGND sky130_ef_sc_hd__decap_12
X_304_ net597 dout0_q\[28\] net528 VGND VGND VPWR VPWR _093_ sky130_fd_sc_hd__a21oi_1
XTAP_TAPCELL_ROW_77_2_5281 VGND VPWR sky130_fd_sc_hd__tapvpwrvgnd_1
XFILLER_230_476 VPWR VGND VPWR VGND sky130_ef_sc_hd__decap_12
XFILLER_243_1272 VPWR VGND VPWR VGND sky130_ef_sc_hd__decap_12
XFILLER_168_550 VPWR VGND VPWR VGND sky130_ef_sc_hd__decap_12
XFILLER_187_369 VPWR VGND VPWR VGND sky130_ef_sc_hd__decap_12
XFILLER_7_700 VGND VGND VPWR VPWR sky130_fd_sc_hd__fill_1
XPHY_EDGE_ROW_95_2_Left_597 VGND VGND VPWR VPWR sky130_fd_sc_hd__decap_3
XPHY_EDGE_ROW_250_Left_505 VGND VGND VPWR VPWR sky130_fd_sc_hd__decap_3
Xwire631 net38 VGND VGND VPWR VPWR net631 sky130_fd_sc_hd__buf_1
XFILLER_200_1109 VPWR VGND VPWR VGND sky130_ef_sc_hd__decap_12
Xwire642 net29 VGND VGND VPWR VPWR net642 sky130_fd_sc_hd__buf_1
Xwire653 net2 VGND VGND VPWR VPWR net653 sky130_fd_sc_hd__clkbuf_1
XFILLER_7_744 VGND VGND VPWR VPWR sky130_fd_sc_hd__decap_6
XTAP_TAPCELL_ROW_232_3861 VGND VPWR sky130_fd_sc_hd__tapvpwrvgnd_1
XFILLER_183_553 VGND VGND VPWR VPWR sky130_fd_sc_hd__decap_6
XTAP_TAPCELL_ROW_232_3872 VGND VPWR sky130_fd_sc_hd__tapvpwrvgnd_1
XFILLER_196_1035 VPWR VGND VPWR VGND sky130_ef_sc_hd__decap_12
XTAP_TAPCELL_ROW_232_3883 VGND VPWR sky130_fd_sc_hd__tapvpwrvgnd_1
XFILLER_13_1273 VPWR VGND VPWR VGND sky130_ef_sc_hd__decap_12
XTAP_TAPCELL_ROW_102_2_5479 VGND VPWR sky130_fd_sc_hd__tapvpwrvgnd_1
XTAP_TAPCELL_ROW_70_2_5224 VGND VPWR sky130_fd_sc_hd__tapvpwrvgnd_1
XFILLER_48_1325 VPWR VGND VPWR VGND sky130_ef_sc_hd__decap_12
XFILLER_252_1508 VGND VGND VPWR VPWR sky130_fd_sc_hd__decap_6
XFILLER_139_1464 VPWR VGND VPWR VGND sky130_ef_sc_hd__decap_12
XFILLER_174_1355 VPWR VGND VPWR VGND sky130_ef_sc_hd__decap_12
XFILLER_83_1249 VPWR VGND VPWR VGND sky130_ef_sc_hd__decap_12
XFILLER_237_1076 VPWR VGND VPWR VGND sky130_ef_sc_hd__decap_12
XFILLER_3_983 VGND VGND VPWR VPWR sky130_fd_sc_hd__decap_6
XFILLER_135_1328 VGND VGND VPWR VPWR sky130_fd_sc_hd__decap_6
XFILLER_170_1219 VGND VGND VPWR VPWR sky130_fd_sc_hd__decap_6
XTAP_TAPCELL_ROW_226_3654 VGND VPWR sky130_fd_sc_hd__tapvpwrvgnd_1
XTAP_TAPCELL_ROW_36_2_4948 VGND VPWR sky130_fd_sc_hd__tapvpwrvgnd_1
XFILLER_211_1205 VPWR VGND VPWR VGND sky130_ef_sc_hd__decap_12
XTAP_TAPCELL_ROW_226_3665 VGND VPWR sky130_fd_sc_hd__tapvpwrvgnd_1
XFILLER_172_1090 VGND VGND VPWR VPWR sky130_fd_sc_hd__decap_6
XTAP_TAPCELL_ROW_226_3676 VGND VPWR sky130_fd_sc_hd__tapvpwrvgnd_1
XFILLER_22_1509 VGND VGND VPWR VPWR sky130_fd_sc_hd__decap_6
XTAP_TAPCELL_ROW_222_3518 VGND VPWR sky130_fd_sc_hd__tapvpwrvgnd_1
XTAP_TAPCELL_ROW_222_3529 VGND VPWR sky130_fd_sc_hd__tapvpwrvgnd_1
XTAP_TAPCELL_ROW_1_909 VGND VPWR sky130_fd_sc_hd__tapvpwrvgnd_1
XFILLER_4_1441 VPWR VGND VPWR VGND sky130_ef_sc_hd__decap_12
XFILLER_24_1380 VPWR VGND VPWR VGND sky130_ef_sc_hd__decap_12
XFILLER_59_1421 VPWR VGND VPWR VGND sky130_ef_sc_hd__decap_12
XFILLER_4_1496 VPWR VGND VPWR VGND sky130_ef_sc_hd__decap_12
XFILLER_225_259 VPWR VGND VPWR VGND sky130_ef_sc_hd__decap_12
XFILLER_209_1112 VGND VGND VPWR VPWR sky130_fd_sc_hd__decap_6
XFILLER_240_218 VPWR VGND VPWR VGND sky130_ef_sc_hd__decap_12
XFILLER_248_1183 VPWR VGND VPWR VGND sky130_ef_sc_hd__decap_12
XFILLER_59_1476 VPWR VGND VPWR VGND sky130_ef_sc_hd__decap_12
XFILLER_94_1356 VPWR VGND VPWR VGND sky130_ef_sc_hd__decap_12
XFILLER_146_1435 VGND VGND VPWR VPWR sky130_fd_sc_hd__decap_6
XFILLER_181_1315 VPWR VGND VPWR VGND sky130_ef_sc_hd__decap_12
XFILLER_206_495 VPWR VGND VPWR VGND sky130_ef_sc_hd__decap_12
XTAP_TAPCELL_ROW_50_1_1305 VGND VPWR sky130_fd_sc_hd__tapvpwrvgnd_1
XFILLER_244_1047 VGND VGND VPWR VPWR sky130_fd_sc_hd__decap_6
XFILLER_221_443 VPWR VGND VPWR VGND sky130_ef_sc_hd__decap_12
XFILLER_178_347 VPWR VGND VPWR VGND sky130_ef_sc_hd__decap_12
XFILLER_222_1312 VPWR VGND VPWR VGND sky130_ef_sc_hd__decap_12
XFILLER_221_498 VPWR VGND VPWR VGND sky130_ef_sc_hd__decap_12
XFILLER_18_1184 VPWR VGND VPWR VGND sky130_ef_sc_hd__decap_12
XFILLER_222_1367 VPWR VGND VPWR VGND sky130_ef_sc_hd__decap_12
XFILLER_105_1165 VPWR VGND VPWR VGND sky130_ef_sc_hd__decap_12
XFILLER_174_531 VGND VGND VPWR VPWR sky130_fd_sc_hd__decap_6
XFILLER_175_1119 VPWR VGND VPWR VGND sky130_ef_sc_hd__decap_12
XFILLER_192_1422 VPWR VGND VPWR VGND sky130_ef_sc_hd__decap_12
XFILLER_192_1477 VGND VGND VPWR VPWR sky130_fd_sc_hd__decap_6
XFILLER_255_1198 VPWR VGND VPWR VGND sky130_ef_sc_hd__decap_12
XFILLER_29_27 VGND VGND VPWR VPWR sky130_fd_sc_hd__decap_6
XFILLER_229_510 VGND VGND VPWR VPWR sky130_fd_sc_hd__decap_6
XFILLER_233_1463 VPWR VGND VPWR VGND sky130_ef_sc_hd__decap_12
XFILLER_5_1205 VPWR VGND VPWR VGND sky130_ef_sc_hd__decap_12
XFILLER_99_1201 VGND VGND VPWR VPWR sky130_fd_sc_hd__decap_4
XFILLER_25_1177 VPWR VGND VPWR VGND sky130_ef_sc_hd__decap_12
XFILLER_116_1294 VPWR VGND VPWR VGND sky130_ef_sc_hd__decap_12
XFILLER_45_15 VPWR VGND VPWR VGND sky130_ef_sc_hd__decap_12
XFILLER_186_1226 VPWR VGND VPWR VGND sky130_ef_sc_hd__decap_12
XTAP_TAPCELL_ROW_157_2_5917 VGND VPWR sky130_fd_sc_hd__tapvpwrvgnd_1
XFILLER_216_237 VPWR VGND VPWR VGND sky130_ef_sc_hd__decap_12
XFILLER_169_314 VPWR VGND VPWR VGND sky130_ef_sc_hd__decap_12
XFILLER_212_421 VPWR VGND VPWR VGND sky130_ef_sc_hd__decap_12
XFILLER_224_292 VPWR VGND VPWR VGND sky130_ef_sc_hd__decap_12
XFILLER_196_144 VGND VGND VPWR VPWR sky130_fd_sc_hd__decap_6
XFILLER_200_605 VPWR VGND VPWR VGND sky130_ef_sc_hd__decap_12
XFILLER_169_369 VPWR VGND VPWR VGND sky130_ef_sc_hd__decap_12
XFILLER_185_818 VPWR VGND VPWR VGND sky130_ef_sc_hd__decap_12
XTAP_TAPCELL_ROW_195_2573 VGND VPWR sky130_fd_sc_hd__tapvpwrvgnd_1
XFILLER_212_476 VPWR VGND VPWR VGND sky130_ef_sc_hd__decap_12
XFILLER_240_796 VPWR VGND VPWR VGND sky130_ef_sc_hd__decap_12
XFILLER_36_1251 VPWR VGND VPWR VGND sky130_ef_sc_hd__decap_12
XTAP_TAPCELL_ROW_195_2584 VGND VPWR sky130_fd_sc_hd__tapvpwrvgnd_1
XTAP_TAPCELL_ROW_191_2426 VGND VPWR sky130_fd_sc_hd__tapvpwrvgnd_1
XTAP_TAPCELL_ROW_195_2595 VGND VPWR sky130_fd_sc_hd__tapvpwrvgnd_1
XFILLER_197_689 VPWR VGND VPWR VGND sky130_ef_sc_hd__decap_12
XFILLER_240_1434 VGND VGND VPWR VPWR sky130_fd_sc_hd__decap_6
XFILLER_162_1270 VPWR VGND VPWR VGND sky130_ef_sc_hd__decap_12
XTAP_TAPCELL_ROW_191_2437 VGND VPWR sky130_fd_sc_hd__tapvpwrvgnd_1
XFILLER_127_1390 VPWR VGND VPWR VGND sky130_ef_sc_hd__decap_12
XTAP_TAPCELL_ROW_191_2448 VGND VPWR sky130_fd_sc_hd__tapvpwrvgnd_1
XTAP_TAPCELL_ROW_29_2_4891 VGND VPWR sky130_fd_sc_hd__tapvpwrvgnd_1
XFILLER_193_873 VPWR VGND VPWR VGND sky130_ef_sc_hd__decap_12
XTAP_TAPCELL_ROW_55_2_5104 VGND VPWR sky130_fd_sc_hd__tapvpwrvgnd_1
XFILLER_158_1306 VGND VGND VPWR VPWR sky130_fd_sc_hd__decap_6
XFILLER_117_3 VPWR VGND VPWR VGND sky130_ef_sc_hd__decap_12
XFILLER_10_1435 VGND VGND VPWR VPWR sky130_fd_sc_hd__decap_6
XFILLER_4_725 VGND VGND VPWR VPWR sky130_fd_sc_hd__fill_1
XFILLER_197_1377 VPWR VGND VPWR VGND sky130_ef_sc_hd__decap_12
XFILLER_4_747 VGND VGND VPWR VPWR sky130_fd_sc_hd__fill_2
XTAP_TAPCELL_ROW_189_2355 VGND VPWR sky130_fd_sc_hd__tapvpwrvgnd_1
XTAP_TAPCELL_ROW_189_2366 VGND VPWR sky130_fd_sc_hd__tapvpwrvgnd_1
XTAP_TAPCELL_ROW_189_2377 VGND VPWR sky130_fd_sc_hd__tapvpwrvgnd_1
XFILLER_193_68 VPWR VGND VPWR VGND sky130_ef_sc_hd__decap_12
XFILLER_171_1506 VGND VGND VPWR VPWR sky130_fd_sc_hd__decap_8
XTAP_TAPCELL_ROW_185_2219 VGND VPWR sky130_fd_sc_hd__tapvpwrvgnd_1
XTAP_TAPCELL_ROW_189_2388 VGND VPWR sky130_fd_sc_hd__tapvpwrvgnd_1
XTAP_TAPCELL_ROW_22_2_4834 VGND VPWR sky130_fd_sc_hd__tapvpwrvgnd_1
XFILLER_234_1238 VPWR VGND VPWR VGND sky130_ef_sc_hd__decap_12
XFILLER_86_22 VPWR VGND VPWR VGND sky130_ef_sc_hd__decap_12
XFILLER_82_1282 VPWR VGND VPWR VGND sky130_ef_sc_hd__decap_12
XFILLER_212_1514 VGND VGND VPWR VPWR sky130_fd_sc_hd__fill_1
XFILLER_248_863 VPWR VGND VPWR VGND sky130_ef_sc_hd__decap_12
XFILLER_169_1413 VGND VGND VPWR VPWR sky130_fd_sc_hd__decap_6
XFILLER_207_259 VPWR VGND VPWR VGND sky130_ef_sc_hd__decap_12
XPHY_EDGE_ROW_101_1_Right_757 VGND VGND VPWR VPWR sky130_fd_sc_hd__decap_3
XFILLER_210_1293 VPWR VGND VPWR VGND sky130_ef_sc_hd__decap_12
XFILLER_222_218 VPWR VGND VPWR VGND sky130_ef_sc_hd__decap_12
XFILLER_250_538 VPWR VGND VPWR VGND sky130_ef_sc_hd__decap_12
XFILLER_245_1334 VPWR VGND VPWR VGND sky130_ef_sc_hd__decap_12
XFILLER_91_1507 VGND VGND VPWR VPWR sky130_fd_sc_hd__decap_8
XFILLER_187_111 VPWR VGND VPWR VGND sky130_ef_sc_hd__decap_12
XFILLER_203_443 VPWR VGND VPWR VGND sky130_ef_sc_hd__decap_12
XFILLER_128_1165 VPWR VGND VPWR VGND sky130_ef_sc_hd__decap_12
XFILLER_245_1389 VPWR VGND VPWR VGND sky130_ef_sc_hd__decap_12
XFILLER_188_667 VPWR VGND VPWR VGND sky130_ef_sc_hd__decap_12
XFILLER_187_166 VGND VGND VPWR VPWR sky130_fd_sc_hd__decap_6
XFILLER_230_273 VGND VGND VPWR VPWR sky130_fd_sc_hd__decap_6
XTAP_TAPCELL_ROW_234_3934 VGND VPWR sky130_fd_sc_hd__tapvpwrvgnd_1
XFILLER_203_498 VPWR VGND VPWR VGND sky130_ef_sc_hd__decap_12
XTAP_TAPCELL_ROW_234_3945 VGND VPWR sky130_fd_sc_hd__tapvpwrvgnd_1
XTAP_TAPCELL_ROW_234_3956 VGND VPWR sky130_fd_sc_hd__tapvpwrvgnd_1
XFILLER_15_1335 VPWR VGND VPWR VGND sky130_ef_sc_hd__decap_12
XTAP_TAPCELL_ROW_230_3809 VGND VPWR sky130_fd_sc_hd__tapvpwrvgnd_1
XFILLER_89_1414 VGND VGND VPWR VPWR sky130_fd_sc_hd__decap_6
XFILLER_106_1485 VPWR VGND VPWR VGND sky130_ef_sc_hd__decap_12
XFILLER_184_851 VPWR VGND VPWR VGND sky130_ef_sc_hd__decap_12
Xwire450 net451 VGND VGND VPWR VPWR net450 sky130_fd_sc_hd__clkbuf_1
XFILLER_204_1097 VPWR VGND VPWR VGND sky130_ef_sc_hd__decap_12
Xwire461 net462 VGND VGND VPWR VPWR net461 sky130_fd_sc_hd__clkbuf_1
Xwire472 net473 VGND VGND VPWR VPWR net472 sky130_fd_sc_hd__clkbuf_1
Xmax_cap205 _186_ VGND VGND VPWR VPWR net205 sky130_fd_sc_hd__clkbuf_1
XFILLER_102_1349 VGND VGND VPWR VPWR sky130_fd_sc_hd__decap_6
XFILLER_237_39 VGND VGND VPWR VPWR sky130_fd_sc_hd__decap_4
Xwire483 net484 VGND VGND VPWR VPWR net483 sky130_fd_sc_hd__clkbuf_1
XFILLER_167_80 VGND VGND VPWR VPWR sky130_fd_sc_hd__decap_6
XTAP_TAPCELL_ROW_14_1_1250 VGND VPWR sky130_fd_sc_hd__tapvpwrvgnd_1
Xmax_cap216 _168_ VGND VGND VPWR VPWR net216 sky130_fd_sc_hd__clkbuf_1
XFILLER_252_1305 VGND VGND VPWR VPWR sky130_fd_sc_hd__decap_6
XFILLER_139_1261 VPWR VGND VPWR VGND sky130_ef_sc_hd__decap_12
XTAP_TAPCELL_ROW_228_3727 VGND VPWR sky130_fd_sc_hd__tapvpwrvgnd_1
XFILLER_174_1152 VPWR VGND VPWR VGND sky130_ef_sc_hd__decap_12
XTAP_TAPCELL_ROW_228_3738 VGND VPWR sky130_fd_sc_hd__tapvpwrvgnd_1
XTAP_TAPCELL_ROW_228_3749 VGND VPWR sky130_fd_sc_hd__tapvpwrvgnd_1
XFILLER_253_27 VPWR VGND VPWR VGND sky130_ef_sc_hd__decap_12
XFILLER_48_1177 VGND VGND VPWR VPWR sky130_fd_sc_hd__decap_6
XFILLER_32_3 VPWR VGND VPWR VGND sky130_ef_sc_hd__decap_12
XFILLER_239_830 VPWR VGND VPWR VGND sky130_ef_sc_hd__decap_12
XFILLER_26_1442 VPWR VGND VPWR VGND sky130_ef_sc_hd__decap_12
XFILLER_6_1514 VGND VGND VPWR VPWR sky130_fd_sc_hd__fill_1
XTAP_TAPCELL_ROW_99_2_5457 VGND VPWR sky130_fd_sc_hd__tapvpwrvgnd_1
XFILLER_211_1002 VPWR VGND VPWR VGND sky130_ef_sc_hd__decap_12
XFILLER_22_1306 VGND VGND VPWR VPWR sky130_fd_sc_hd__decap_6
XTAP_TAPCELL_ROW_143_2_5803 VGND VPWR sky130_fd_sc_hd__tapvpwrvgnd_1
XFILLER_239_885 VPWR VGND VPWR VGND sky130_ef_sc_hd__decap_12
XFILLER_26_1497 VPWR VGND VPWR VGND sky130_ef_sc_hd__decap_12
XFILLER_113_1445 VPWR VGND VPWR VGND sky130_ef_sc_hd__decap_12
XTAP_TAPCELL_ROW_112_2_5561 VGND VPWR sky130_fd_sc_hd__tapvpwrvgnd_1
XFILLER_211_1057 VPWR VGND VPWR VGND sky130_ef_sc_hd__decap_12
XFILLER_246_1109 VPWR VGND VPWR VGND sky130_ef_sc_hd__decap_12
XFILLER_4_1293 VPWR VGND VPWR VGND sky130_ef_sc_hd__decap_12
XFILLER_0_1135 VPWR VGND VPWR VGND sky130_ef_sc_hd__decap_12
XFILLER_198_409 VPWR VGND VPWR VGND sky130_ef_sc_hd__decap_12
XTAP_TAPCELL_ROW_68_1_1332 VGND VPWR sky130_fd_sc_hd__tapvpwrvgnd_1
XFILLER_59_1273 VPWR VGND VPWR VGND sky130_ef_sc_hd__decap_12
XFILLER_15_18 VPWR VGND VPWR VGND sky130_ef_sc_hd__decap_12
XFILLER_0_1168 VGND VGND VPWR VPWR sky130_fd_sc_hd__decap_8
XFILLER_181_1112 VGND VGND VPWR VPWR sky130_fd_sc_hd__decap_6
XFILLER_206_292 VPWR VGND VPWR VGND sky130_ef_sc_hd__decap_12
XTAP_TAPCELL_ROW_61_2_5147 VGND VPWR sky130_fd_sc_hd__tapvpwrvgnd_1
XFILLER_221_240 VPWR VGND VPWR VGND sky130_ef_sc_hd__decap_12
XFILLER_178_144 VGND VGND VPWR VPWR sky130_fd_sc_hd__decap_6
XFILLER_210_925 VPWR VGND VPWR VGND sky130_ef_sc_hd__decap_12
XFILLER_167_818 VPWR VGND VPWR VGND sky130_ef_sc_hd__decap_12
XFILLER_179_689 VPWR VGND VPWR VGND sky130_ef_sc_hd__decap_12
XFILLER_222_796 VPWR VGND VPWR VGND sky130_ef_sc_hd__decap_12
XFILLER_33_1402 VPWR VGND VPWR VGND sky130_ef_sc_hd__decap_12
XFILLER_107_1249 VPWR VGND VPWR VGND sky130_ef_sc_hd__decap_12
XFILLER_221_295 VGND VGND VPWR VPWR sky130_fd_sc_hd__decap_6
XFILLER_194_648 VPWR VGND VPWR VGND sky130_ef_sc_hd__decap_12
XFILLER_222_1164 VPWR VGND VPWR VGND sky130_ef_sc_hd__decap_12
XFILLER_33_1457 VGND VGND VPWR VPWR sky130_fd_sc_hd__decap_6
XTAP_TAPCELL_ROW_250_4492 VGND VPWR sky130_fd_sc_hd__tapvpwrvgnd_1
XFILLER_175_873 VPWR VGND VPWR VGND sky130_ef_sc_hd__decap_12
XFILLER_147_39 VGND VGND VPWR VPWR sky130_fd_sc_hd__decap_4
XFILLER_68_1509 VGND VGND VPWR VPWR sky130_fd_sc_hd__decap_6
XFILLER_190_832 VGND VGND VPWR VPWR sky130_fd_sc_hd__decap_6
XFILLER_200_1484 VPWR VGND VPWR VGND sky130_ef_sc_hd__decap_12
XFILLER_235_1514 VGND VGND VPWR VPWR sky130_fd_sc_hd__fill_1
XFILLER_27_1206 VPWR VGND VPWR VGND sky130_ef_sc_hd__decap_12
XFILLER_163_27 VPWR VGND VPWR VGND sky130_ef_sc_hd__decap_12
XFILLER_249_627 VPWR VGND VPWR VGND sky130_ef_sc_hd__decap_12
XFILLER_118_1356 VPWR VGND VPWR VGND sky130_ef_sc_hd__decap_12
XTAP_TAPCELL_ROW_244_4285 VGND VPWR sky130_fd_sc_hd__tapvpwrvgnd_1
XTAP_TAPCELL_ROW_244_4296 VGND VPWR sky130_fd_sc_hd__tapvpwrvgnd_1
XFILLER_5_1002 VPWR VGND VPWR VGND sky130_ef_sc_hd__decap_12
XFILLER_233_1260 VPWR VGND VPWR VGND sky130_ef_sc_hd__decap_12
XTAP_TAPCELL_ROW_240_4149 VGND VPWR sky130_fd_sc_hd__tapvpwrvgnd_1
XFILLER_245_811 VGND VGND VPWR VPWR sky130_fd_sc_hd__decap_6
XFILLER_5_1057 VPWR VGND VPWR VGND sky130_ef_sc_hd__decap_12
XFILLER_56_58 VGND VGND VPWR VPWR sky130_fd_sc_hd__decap_6
XPHY_EDGE_ROW_174_Left_429 VGND VGND VPWR VPWR sky130_fd_sc_hd__decap_3
XFILLER_186_1023 VPWR VGND VPWR VGND sky130_ef_sc_hd__decap_12
XTAP_TAPCELL_ROW_6_1074 VGND VPWR sky130_fd_sc_hd__tapvpwrvgnd_1
XTAP_TAPCELL_ROW_6_1085 VGND VPWR sky130_fd_sc_hd__tapvpwrvgnd_1
XTAP_TAPCELL_ROW_6_1096 VGND VPWR sky130_fd_sc_hd__tapvpwrvgnd_1
XTAP_TAPCELL_ROW_178_2001 VGND VPWR sky130_fd_sc_hd__tapvpwrvgnd_1
XFILLER_204_218 VPWR VGND VPWR VGND sky130_ef_sc_hd__decap_12
XFILLER_186_1078 VPWR VGND VPWR VGND sky130_ef_sc_hd__decap_12
XTAP_TAPCELL_ROW_197_2635 VGND VPWR sky130_fd_sc_hd__tapvpwrvgnd_1
XFILLER_232_538 VPWR VGND VPWR VGND sky130_ef_sc_hd__decap_12
XFILLER_38_1313 VPWR VGND VPWR VGND sky130_ef_sc_hd__decap_12
XTAP_TAPCELL_ROW_197_2646 VGND VPWR sky130_fd_sc_hd__tapvpwrvgnd_1
XTAP_TAPCELL_ROW_197_2657 VGND VPWR sky130_fd_sc_hd__tapvpwrvgnd_1
XTAP_TAPCELL_ROW_238_4078 VGND VPWR sky130_fd_sc_hd__tapvpwrvgnd_1
XFILLER_72_46 VPWR VGND VPWR VGND sky130_ef_sc_hd__decap_12
XTAP_TAPCELL_ROW_20_1_1260 VGND VPWR sky130_fd_sc_hd__tapvpwrvgnd_1
XFILLER_169_111 VPWR VGND VPWR VGND sky130_ef_sc_hd__decap_12
XTAP_TAPCELL_ROW_197_2668 VGND VPWR sky130_fd_sc_hd__tapvpwrvgnd_1
XTAP_TAPCELL_ROW_238_4089 VGND VPWR sky130_fd_sc_hd__tapvpwrvgnd_1
XFILLER_197_431 VPWR VGND VPWR VGND sky130_ef_sc_hd__decap_12
XFILLER_38_1368 VPWR VGND VPWR VGND sky130_ef_sc_hd__decap_12
XFILLER_125_1316 VPWR VGND VPWR VGND sky130_ef_sc_hd__decap_12
XFILLER_188_46 VPWR VGND VPWR VGND sky130_ef_sc_hd__decap_12
XFILLER_200_402 VGND VGND VPWR VPWR sky130_fd_sc_hd__decap_6
XFILLER_169_166 VGND VGND VPWR VPWR sky130_fd_sc_hd__decap_6
XFILLER_185_615 VPWR VGND VPWR VGND sky130_ef_sc_hd__decap_12
XFILLER_201_947 VPWR VGND VPWR VGND sky130_ef_sc_hd__decap_12
XFILLER_212_273 VGND VGND VPWR VPWR sky130_fd_sc_hd__decap_6
XFILLER_234_3 VPWR VGND VPWR VGND sky130_ef_sc_hd__decap_12
XFILLER_197_486 VPWR VGND VPWR VGND sky130_ef_sc_hd__decap_12
XFILLER_240_593 VPWR VGND VPWR VGND sky130_ef_sc_hd__decap_12
XFILLER_8_327 VGND VGND VPWR VPWR sky130_fd_sc_hd__fill_1
XFILLER_166_851 VPWR VGND VPWR VGND sky130_ef_sc_hd__decap_12
XPHY_EDGE_ROW_183_Left_438 VGND VGND VPWR VPWR sky130_fd_sc_hd__decap_3
XFILLER_193_670 VPWR VGND VPWR VGND sky130_ef_sc_hd__decap_12
XFILLER_201_1248 VPWR VGND VPWR VGND sky130_ef_sc_hd__decap_12
XFILLER_197_1174 VPWR VGND VPWR VGND sky130_ef_sc_hd__decap_12
XFILLER_181_854 VGND VGND VPWR VPWR sky130_fd_sc_hd__decap_6
XFILLER_101_1371 VGND VGND VPWR VPWR sky130_fd_sc_hd__decap_6
XFILLER_49_1464 VPWR VGND VPWR VGND sky130_ef_sc_hd__decap_12
XFILLER_136_1423 VPWR VGND VPWR VGND sky130_ef_sc_hd__decap_12
XFILLER_171_1303 VPWR VGND VPWR VGND sky130_ef_sc_hd__decap_12
XTAP_TAPCELL_ROW_117_2_5598 VGND VPWR sky130_fd_sc_hd__tapvpwrvgnd_1
XPHY_EDGE_ROW_126_2_Left_628 VGND VGND VPWR VPWR sky130_fd_sc_hd__decap_3
XTAP_TAPCELL_ROW_85_2_5343 VGND VPWR sky130_fd_sc_hd__tapvpwrvgnd_1
XFILLER_234_1035 VPWR VGND VPWR VGND sky130_ef_sc_hd__decap_12
XFILLER_45_1328 VGND VGND VPWR VPWR sky130_fd_sc_hd__decap_6
XFILLER_80_1208 VPWR VGND VPWR VGND sky130_ef_sc_hd__decap_12
XTAP_TAPCELL_ROW_54_2_5090 VGND VPWR sky130_fd_sc_hd__tapvpwrvgnd_1
XFILLER_84_1399 VPWR VGND VPWR VGND sky130_ef_sc_hd__decap_12
XFILLER_0_750 VGND VGND VPWR VPWR sky130_fd_sc_hd__decap_6
XFILLER_171_1358 VPWR VGND VPWR VGND sky130_ef_sc_hd__decap_12
XFILLER_136_1478 VGND VGND VPWR VPWR sky130_fd_sc_hd__decap_6
XFILLER_0_761 VGND VGND VPWR VPWR sky130_fd_sc_hd__decap_4
XFILLER_248_660 VGND VGND VPWR VPWR sky130_fd_sc_hd__decap_6
XPHY_EDGE_ROW_192_Left_447 VGND VGND VPWR VPWR sky130_fd_sc_hd__decap_3
XFILLER_212_1355 VPWR VGND VPWR VGND sky130_ef_sc_hd__decap_12
XFILLER_1_1444 VPWR VGND VPWR VGND sky130_ef_sc_hd__decap_12
XFILLER_210_1090 VGND VGND VPWR VPWR sky130_fd_sc_hd__decap_6
XTAP_TAPCELL_ROW_46_2_5027 VGND VPWR sky130_fd_sc_hd__tapvpwrvgnd_1
XPHY_EDGE_ROW_102_1_Right_758 VGND VGND VPWR VPWR sky130_fd_sc_hd__decap_3
XFILLER_250_335 VPWR VGND VPWR VGND sky130_ef_sc_hd__decap_12
Xmax_cap81 net82 VGND VGND VPWR VPWR net81 sky130_fd_sc_hd__clkbuf_1
XFILLER_182_1410 VPWR VGND VPWR VGND sky130_ef_sc_hd__decap_12
XFILLER_245_1131 VPWR VGND VPWR VGND sky130_ef_sc_hd__decap_12
Xmax_cap92 _248_ VGND VGND VPWR VPWR net92 sky130_fd_sc_hd__clkbuf_1
XFILLER_91_1304 VPWR VGND VPWR VGND sky130_ef_sc_hd__decap_12
XFILLER_56_1435 VGND VGND VPWR VPWR sky130_fd_sc_hd__decap_6
XFILLER_1_1499 VGND VGND VPWR VPWR sky130_fd_sc_hd__decap_6
XFILLER_203_240 VPWR VGND VPWR VGND sky130_ef_sc_hd__decap_12
XFILLER_231_560 VPWR VGND VPWR VGND sky130_ef_sc_hd__decap_12
XFILLER_182_1465 VPWR VGND VPWR VGND sky130_ef_sc_hd__decap_12
XFILLER_245_1186 VPWR VGND VPWR VGND sky130_ef_sc_hd__decap_12
XFILLER_91_1359 VPWR VGND VPWR VGND sky130_ef_sc_hd__decap_12
XFILLER_188_464 VPWR VGND VPWR VGND sky130_ef_sc_hd__decap_12
XFILLER_204_796 VPWR VGND VPWR VGND sky130_ef_sc_hd__decap_12
XFILLER_203_295 VGND VGND VPWR VPWR sky130_fd_sc_hd__decap_6
XTAP_TAPCELL_ROW_13_2_4768 VGND VPWR sky130_fd_sc_hd__tapvpwrvgnd_1
XFILLER_176_648 VPWR VGND VPWR VGND sky130_ef_sc_hd__decap_12
XFILLER_7_30 VPWR VGND VPWR VGND sky130_ef_sc_hd__decap_12
XFILLER_15_1165 VPWR VGND VPWR VGND sky130_ef_sc_hd__decap_12
XFILLER_106_1282 VPWR VGND VPWR VGND sky130_ef_sc_hd__decap_12
XFILLER_200_980 VPWR VGND VPWR VGND sky130_ef_sc_hd__decap_12
XFILLER_8_894 VPWR VGND VPWR VGND sky130_ef_sc_hd__decap_12
XFILLER_172_832 VGND VGND VPWR VPWR sky130_fd_sc_hd__decap_6
Xwire280 net281 VGND VGND VPWR VPWR net280 sky130_fd_sc_hd__clkbuf_1
Xwire291 net292 VGND VGND VPWR VPWR net291 sky130_fd_sc_hd__clkbuf_1
XFILLER_176_1269 VPWR VGND VPWR VGND sky130_ef_sc_hd__decap_12
XFILLER_115_1507 VGND VGND VPWR VPWR sky130_fd_sc_hd__decap_8
XFILLER_213_1119 VPWR VGND VPWR VGND sky130_ef_sc_hd__decap_12
XFILLER_230_1422 VPWR VGND VPWR VGND sky130_ef_sc_hd__decap_12
XFILLER_227_811 VGND VGND VPWR VPWR sky130_fd_sc_hd__decap_6
XFILLER_26_1294 VPWR VGND VPWR VGND sky130_ef_sc_hd__decap_12
XFILLER_6_1355 VPWR VGND VPWR VGND sky130_ef_sc_hd__decap_12
XFILLER_113_1242 VGND VGND VPWR VPWR sky130_fd_sc_hd__decap_6
XFILLER_239_682 VGND VGND VPWR VPWR sky130_fd_sc_hd__decap_6
XPHY_EDGE_ROW_64_1_Right_720 VGND VGND VPWR VPWR sky130_fd_sc_hd__decap_3
XFILLER_230_1477 VGND VGND VPWR VPWR sky130_fd_sc_hd__decap_6
XFILLER_2_1219 VGND VGND VPWR VPWR sky130_fd_sc_hd__decap_6
XFILLER_241_302 VPWR VGND VPWR VGND sky130_ef_sc_hd__decap_12
XFILLER_4_1090 VGND VGND VPWR VPWR sky130_fd_sc_hd__decap_6
XFILLER_253_173 VPWR VGND VPWR VGND sky130_ef_sc_hd__decap_12
XFILLER_198_206 VPWR VGND VPWR VGND sky130_ef_sc_hd__decap_12
XFILLER_183_1229 VPWR VGND VPWR VGND sky130_ef_sc_hd__decap_12
XFILLER_214_538 VPWR VGND VPWR VGND sky130_ef_sc_hd__decap_12
XFILLER_148_1349 VGND VGND VPWR VPWR sky130_fd_sc_hd__decap_6
XFILLER_241_357 VPWR VGND VPWR VGND sky130_ef_sc_hd__decap_12
XTAP_TAPCELL_ROW_200_2742 VGND VPWR sky130_fd_sc_hd__tapvpwrvgnd_1
XFILLER_179_431 VPWR VGND VPWR VGND sky130_ef_sc_hd__decap_12
XTAP_TAPCELL_ROW_200_2753 VGND VPWR sky130_fd_sc_hd__tapvpwrvgnd_1
XTAP_TAPCELL_ROW_200_2764 VGND VPWR sky130_fd_sc_hd__tapvpwrvgnd_1
XFILLER_224_1226 VPWR VGND VPWR VGND sky130_ef_sc_hd__decap_12
XFILLER_167_615 VPWR VGND VPWR VGND sky130_ef_sc_hd__decap_12
XFILLER_210_722 VPWR VGND VPWR VGND sky130_ef_sc_hd__decap_12
XTAP_TAPCELL_ROW_252_4565 VGND VPWR sky130_fd_sc_hd__tapvpwrvgnd_1
XFILLER_222_593 VPWR VGND VPWR VGND sky130_ef_sc_hd__decap_12
XTAP_TAPCELL_ROW_252_4576 VGND VPWR sky130_fd_sc_hd__tapvpwrvgnd_1
XFILLER_179_486 VPWR VGND VPWR VGND sky130_ef_sc_hd__decap_12
XTAP_TAPCELL_ROW_252_4587 VGND VPWR sky130_fd_sc_hd__tapvpwrvgnd_1
XFILLER_37_1390 VPWR VGND VPWR VGND sky130_ef_sc_hd__decap_12
XFILLER_72_1270 VPWR VGND VPWR VGND sky130_ef_sc_hd__decap_12
XFILLER_194_445 VGND VGND VPWR VPWR sky130_fd_sc_hd__decap_6
XFILLER_210_777 VPWR VGND VPWR VGND sky130_ef_sc_hd__decap_12
XTAP_TAPCELL_ROW_91_2_5386 VGND VPWR sky130_fd_sc_hd__tapvpwrvgnd_1
XPHY_EDGE_ROW_124_1_Left_379 VGND VGND VPWR VPWR sky130_fd_sc_hd__decap_3
XFILLER_175_670 VPWR VGND VPWR VGND sky130_ef_sc_hd__decap_12
XFILLER_5_319 VGND VGND VPWR VPWR sky130_fd_sc_hd__fill_1
XFILLER_68_1306 VGND VGND VPWR VPWR sky130_fd_sc_hd__decap_6
XTAP_TAPCELL_ROW_134_2_5737 VGND VPWR sky130_fd_sc_hd__tapvpwrvgnd_1
XTAP_TAPCELL_ROW_103_2_5484 VGND VPWR sky130_fd_sc_hd__tapvpwrvgnd_1
XFILLER_159_1445 VPWR VGND VPWR VGND sky130_ef_sc_hd__decap_12
XFILLER_174_15 VGND VGND VPWR VPWR sky130_fd_sc_hd__decap_6
XFILLER_194_1336 VPWR VGND VPWR VGND sky130_ef_sc_hd__decap_12
XFILLER_200_1281 VPWR VGND VPWR VGND sky130_ef_sc_hd__decap_12
XPHY_EDGE_ROW_61_1_Left_316 VGND VGND VPWR VPWR sky130_fd_sc_hd__decap_3
XTAP_TAPCELL_ROW_246_4358 VGND VPWR sky130_fd_sc_hd__tapvpwrvgnd_1
XTAP_TAPCELL_ROW_246_4369 VGND VPWR sky130_fd_sc_hd__tapvpwrvgnd_1
Xmax_cap580 net581 VGND VGND VPWR VPWR net580 sky130_fd_sc_hd__clkbuf_1
XFILLER_249_424 VGND VGND VPWR VPWR sky130_fd_sc_hd__decap_6
XFILLER_7_1119 VPWR VGND VPWR VGND sky130_ef_sc_hd__decap_12
XFILLER_235_1377 VPWR VGND VPWR VGND sky130_ef_sc_hd__decap_12
XFILLER_67_68 VGND VGND VPWR VPWR sky130_fd_sc_hd__decap_3
XTAP_TAPCELL_ROW_8_1147 VGND VPWR sky130_fd_sc_hd__tapvpwrvgnd_1
XFILLER_190_58 VGND VGND VPWR VPWR sky130_fd_sc_hd__decap_6
XTAP_TAPCELL_ROW_8_1158 VGND VPWR sky130_fd_sc_hd__tapvpwrvgnd_1
XFILLER_170_1391 VGND VGND VPWR VPWR sky130_fd_sc_hd__decap_6
XTAP_TAPCELL_ROW_8_1169 VGND VPWR sky130_fd_sc_hd__tapvpwrvgnd_1
XFILLER_79_1402 VPWR VGND VPWR VGND sky130_ef_sc_hd__decap_12
XFILLER_184_3 VPWR VGND VPWR VGND sky130_ef_sc_hd__decap_12
X_621_ clknet_3_4__leaf_clk dout0\[19\] _029_ VGND VGND VPWR VPWR dout0_q\[19\] sky130_fd_sc_hd__dfrtp_1
XTAP_TAPCELL_ROW_199_2708 VGND VPWR sky130_fd_sc_hd__tapvpwrvgnd_1
XTAP_TAPCELL_ROW_199_2719 VGND VPWR sky130_fd_sc_hd__tapvpwrvgnd_1
XFILLER_244_151 VPWR VGND VPWR VGND sky130_ef_sc_hd__decap_12
XFILLER_79_1457 VGND VGND VPWR VPWR sky130_fd_sc_hd__decap_6
X_552_ net670 VGND VGND VPWR VPWR _034_ sky130_fd_sc_hd__inv_2
XFILLER_83_56 VPWR VGND VPWR VGND sky130_ef_sc_hd__decap_12
XFILLER_189_228 VPWR VGND VPWR VGND sky130_ef_sc_hd__decap_12
XFILLER_232_335 VPWR VGND VPWR VGND sky130_ef_sc_hd__decap_12
XFILLER_199_56 VPWR VGND VPWR VGND sky130_ef_sc_hd__decap_12
X_483_ net98 _247_ VGND VGND VPWR VPWR acc_core.adder.cla_blocks\[3\].block.sum\[1\]
+ sky130_fd_sc_hd__nor2_1
XFILLER_207_1413 VGND VGND VPWR VPWR sky130_fd_sc_hd__decap_6
XFILLER_220_519 VPWR VGND VPWR VGND sky130_ef_sc_hd__decap_12
XFILLER_246_1484 VPWR VGND VPWR VGND sky130_ef_sc_hd__decap_12
XFILLER_213_560 VPWR VGND VPWR VGND sky130_ef_sc_hd__decap_12
XFILLER_38_1165 VPWR VGND VPWR VGND sky130_ef_sc_hd__decap_12
XFILLER_242_1348 VGND VGND VPWR VPWR sky130_fd_sc_hd__decap_6
XFILLER_164_1184 VPWR VGND VPWR VGND sky130_ef_sc_hd__decap_12
XFILLER_185_412 VPWR VGND VPWR VGND sky130_ef_sc_hd__decap_12
XFILLER_201_744 VPWR VGND VPWR VGND sky130_ef_sc_hd__decap_12
XFILLER_240_390 VPWR VGND VPWR VGND sky130_ef_sc_hd__decap_12
XFILLER_197_283 VPWR VGND VPWR VGND sky130_ef_sc_hd__decap_12
XFILLER_186_968 VPWR VGND VPWR VGND sky130_ef_sc_hd__decap_12
XFILLER_90_1392 VGND VGND VPWR VPWR sky130_fd_sc_hd__decap_6
XFILLER_185_467 VGND VGND VPWR VPWR sky130_fd_sc_hd__decap_6
XFILLER_201_799 VPWR VGND VPWR VGND sky130_ef_sc_hd__decap_12
XFILLER_16_1485 VPWR VGND VPWR VGND sky130_ef_sc_hd__decap_12
XFILLER_103_1433 VPWR VGND VPWR VGND sky130_ef_sc_hd__decap_12
XFILLER_8_179 VPWR VGND VPWR VGND sky130_ef_sc_hd__decap_12
XFILLER_201_1045 VPWR VGND VPWR VGND sky130_ef_sc_hd__decap_12
XFILLER_12_1349 VGND VGND VPWR VPWR sky130_fd_sc_hd__decap_6
XFILLER_5_831 VGND VGND VPWR VPWR sky130_fd_sc_hd__decap_4
XFILLER_103_1488 VPWR VGND VPWR VGND sky130_ef_sc_hd__decap_12
XFILLER_5_886 VPWR VGND VPWR VGND sky130_ef_sc_hd__decap_12
XFILLER_4_363 VGND VGND VPWR VPWR sky130_fd_sc_hd__fill_2
XTAP_TAPCELL_ROW_210_3093 VGND VPWR sky130_fd_sc_hd__tapvpwrvgnd_1
XFILLER_49_1261 VPWR VGND VPWR VGND sky130_ef_sc_hd__decap_12
XFILLER_4_396 VGND VGND VPWR VPWR sky130_fd_sc_hd__fill_2
XFILLER_136_1220 VGND VGND VPWR VPWR sky130_fd_sc_hd__decap_6
XFILLER_171_1100 VPWR VGND VPWR VGND sky130_ef_sc_hd__decap_12
XFILLER_180_194 VPWR VGND VPWR VGND sky130_ef_sc_hd__decap_12
XFILLER_253_1444 VPWR VGND VPWR VGND sky130_ef_sc_hd__decap_12
XFILLER_175_1291 VPWR VGND VPWR VGND sky130_ef_sc_hd__decap_12
XFILLER_84_1196 VPWR VGND VPWR VGND sky130_ef_sc_hd__decap_12
XFILLER_171_1155 VGND VGND VPWR VPWR sky130_fd_sc_hd__decap_6
XFILLER_253_1499 VGND VGND VPWR VPWR sky130_fd_sc_hd__decap_6
XFILLER_209_811 VGND VGND VPWR VPWR sky130_fd_sc_hd__decap_6
XFILLER_3_1506 VGND VGND VPWR VPWR sky130_fd_sc_hd__decap_8
XFILLER_23_1445 VPWR VGND VPWR VGND sky130_ef_sc_hd__decap_12
XFILLER_212_1152 VPWR VGND VPWR VGND sky130_ef_sc_hd__decap_12
XTAP_TAPCELL_ROW_167_1590 VGND VPWR sky130_fd_sc_hd__tapvpwrvgnd_1
XTAP_TAPCELL_ROW_158_2_5922 VGND VPWR sky130_fd_sc_hd__tapvpwrvgnd_1
XTAP_TAPCELL_ROW_127_2_5680 VGND VPWR sky130_fd_sc_hd__tapvpwrvgnd_1
XFILLER_223_302 VPWR VGND VPWR VGND sky130_ef_sc_hd__decap_12
XFILLER_1_1241 VGND VGND VPWR VPWR sky130_fd_sc_hd__decap_6
XFILLER_235_173 VPWR VGND VPWR VGND sky130_ef_sc_hd__decap_12
XFILLER_247_1248 VPWR VGND VPWR VGND sky130_ef_sc_hd__decap_12
XFILLER_250_132 VPWR VGND VPWR VGND sky130_ef_sc_hd__decap_12
XFILLER_223_357 VPWR VGND VPWR VGND sky130_ef_sc_hd__decap_12
XPHY_EDGE_ROW_103_1_Right_759 VGND VGND VPWR VPWR sky130_fd_sc_hd__decap_3
XFILLER_95_1292 VPWR VGND VPWR VGND sky130_ef_sc_hd__decap_12
XFILLER_147_1371 VGND VGND VPWR VPWR sky130_fd_sc_hd__decap_6
XFILLER_195_209 VGND VGND VPWR VPWR sky130_fd_sc_hd__decap_6
XFILLER_182_1262 VGND VGND VPWR VPWR sky130_fd_sc_hd__decap_6
XFILLER_250_187 VGND VGND VPWR VPWR sky130_fd_sc_hd__decap_6
XFILLER_188_261 VPWR VGND VPWR VGND sky130_ef_sc_hd__decap_12
XFILLER_204_593 VPWR VGND VPWR VGND sky130_ef_sc_hd__decap_12
XTAP_TAPCELL_ROW_161_1_1471 VGND VPWR sky130_fd_sc_hd__tapvpwrvgnd_1
XFILLER_17_1249 VPWR VGND VPWR VGND sky130_ef_sc_hd__decap_12
XTAP_TAPCELL_ROW_76_2_5266 VGND VPWR sky130_fd_sc_hd__tapvpwrvgnd_1
XFILLER_91_1189 VPWR VGND VPWR VGND sky130_ef_sc_hd__decap_12
XFILLER_104_1208 VPWR VGND VPWR VGND sky130_ef_sc_hd__decap_12
XFILLER_176_445 VGND VGND VPWR VPWR sky130_fd_sc_hd__decap_6
XTAP_TAPCELL_ROW_120_2_5623 VGND VPWR sky130_fd_sc_hd__tapvpwrvgnd_1
XFILLER_108_1399 VPWR VGND VPWR VGND sky130_ef_sc_hd__decap_12
XTAP_TAPCELL_ROW_119_2_5617 VGND VPWR sky130_fd_sc_hd__tapvpwrvgnd_1
XFILLER_121_1500 VGND VGND VPWR VPWR sky130_fd_sc_hd__decap_6
XFILLER_192_949 VPWR VGND VPWR VGND sky130_ef_sc_hd__decap_12
XFILLER_185_990 VPWR VGND VPWR VGND sky130_ef_sc_hd__decap_12
XFILLER_8_691 VPWR VGND VPWR VGND sky130_ef_sc_hd__decap_12
XFILLER_176_1011 VPWR VGND VPWR VGND sky130_ef_sc_hd__decap_12
XFILLER_254_1219 VGND VGND VPWR VPWR sky130_fd_sc_hd__decap_6
XFILLER_176_1066 VPWR VGND VPWR VGND sky130_ef_sc_hd__decap_12
XTAP_TAPCELL_ROW_241_4200 VGND VPWR sky130_fd_sc_hd__tapvpwrvgnd_1
XFILLER_28_1356 VPWR VGND VPWR VGND sky130_ef_sc_hd__decap_12
XFILLER_115_1304 VPWR VGND VPWR VGND sky130_ef_sc_hd__decap_12
XFILLER_247_928 VPWR VGND VPWR VGND sky130_ef_sc_hd__decap_12
XTAP_TAPCELL_ROW_56_1_1314 VGND VPWR sky130_fd_sc_hd__tapvpwrvgnd_1
XFILLER_150_1239 VPWR VGND VPWR VGND sky130_ef_sc_hd__decap_12
XFILLER_115_1359 VPWR VGND VPWR VGND sky130_ef_sc_hd__decap_12
XFILLER_37_27 VPWR VGND VPWR VGND sky130_ef_sc_hd__decap_12
XFILLER_6_1152 VPWR VGND VPWR VGND sky130_ef_sc_hd__decap_12
XTAP_TAPCELL_ROW_206_2951 VGND VPWR sky130_fd_sc_hd__tapvpwrvgnd_1
XPHY_EDGE_ROW_65_1_Right_721 VGND VGND VPWR VPWR sky130_fd_sc_hd__decap_3
XTAP_TAPCELL_ROW_206_2962 VGND VPWR sky130_fd_sc_hd__tapvpwrvgnd_1
XTAP_TAPCELL_ROW_206_2973 VGND VPWR sky130_fd_sc_hd__tapvpwrvgnd_1
XTAP_TAPCELL_ROW_202_2815 VGND VPWR sky130_fd_sc_hd__tapvpwrvgnd_1
XFILLER_226_151 VPWR VGND VPWR VGND sky130_ef_sc_hd__decap_12
XTAP_TAPCELL_ROW_202_2826 VGND VPWR sky130_fd_sc_hd__tapvpwrvgnd_1
XFILLER_187_1162 VPWR VGND VPWR VGND sky130_ef_sc_hd__decap_12
XTAP_TAPCELL_ROW_202_2837 VGND VPWR sky130_fd_sc_hd__tapvpwrvgnd_1
XFILLER_214_335 VPWR VGND VPWR VGND sky130_ef_sc_hd__decap_12
XFILLER_53_15 VPWR VGND VPWR VGND sky130_ef_sc_hd__decap_12
XFILLER_183_1026 VGND VGND VPWR VPWR sky130_fd_sc_hd__decap_6
XTAP_TAPCELL_ROW_254_4638 VGND VPWR sky130_fd_sc_hd__tapvpwrvgnd_1
XTAP_TAPCELL_ROW_254_4649 VGND VPWR sky130_fd_sc_hd__tapvpwrvgnd_1
XFILLER_241_154 VPWR VGND VPWR VGND sky130_ef_sc_hd__decap_12
XFILLER_169_15 VPWR VGND VPWR VGND sky130_ef_sc_hd__decap_12
XFILLER_202_519 VPWR VGND VPWR VGND sky130_ef_sc_hd__decap_12
XFILLER_126_1411 VPWR VGND VPWR VGND sky130_ef_sc_hd__decap_12
XFILLER_230_839 VPWR VGND VPWR VGND sky130_ef_sc_hd__decap_12
XFILLER_165_1471 VPWR VGND VPWR VGND sky130_ef_sc_hd__decap_12
XFILLER_35_1316 VPWR VGND VPWR VGND sky130_ef_sc_hd__decap_12
XFILLER_224_1023 VPWR VGND VPWR VGND sky130_ef_sc_hd__decap_12
XFILLER_167_412 VPWR VGND VPWR VGND sky130_ef_sc_hd__decap_12
XFILLER_161_1335 VPWR VGND VPWR VGND sky130_ef_sc_hd__decap_12
XFILLER_179_283 VPWR VGND VPWR VGND sky130_ef_sc_hd__decap_12
XFILLER_195_732 VPWR VGND VPWR VGND sky130_ef_sc_hd__decap_12
XFILLER_222_390 VPWR VGND VPWR VGND sky130_ef_sc_hd__decap_12
XFILLER_126_1466 VPWR VGND VPWR VGND sky130_ef_sc_hd__decap_12
XFILLER_168_968 VPWR VGND VPWR VGND sky130_ef_sc_hd__decap_12
XFILLER_224_1078 VPWR VGND VPWR VGND sky130_ef_sc_hd__decap_12
XFILLER_241_1370 VGND VGND VPWR VPWR sky130_fd_sc_hd__decap_6
XFILLER_167_467 VGND VGND VPWR VPWR sky130_fd_sc_hd__decap_6
XFILLER_183_916 VPWR VGND VPWR VGND sky130_ef_sc_hd__decap_12
XFILLER_210_574 VGND VGND VPWR VPWR sky130_fd_sc_hd__decap_6
XFILLER_195_787 VPWR VGND VPWR VGND sky130_ef_sc_hd__decap_12
XFILLER_159_1242 VGND VGND VPWR VPWR sky130_fd_sc_hd__decap_6
XFILLER_202_1398 VPWR VGND VPWR VGND sky130_ef_sc_hd__decap_12
XFILLER_191_971 VPWR VGND VPWR VGND sky130_ef_sc_hd__decap_12
XFILLER_194_1133 VGND VGND VPWR VPWR sky130_fd_sc_hd__decap_6
XPHY_EDGE_ROW_205_Right_50 VGND VGND VPWR VPWR sky130_fd_sc_hd__decap_3
XFILLER_11_1371 VGND VGND VPWR VPWR sky130_fd_sc_hd__decap_6
XFILLER_78_34 VPWR VGND VPWR VGND sky130_ef_sc_hd__decap_12
XFILLER_46_1423 VPWR VGND VPWR VGND sky130_ef_sc_hd__decap_12
XTAP_TAPCELL_ROW_164_2_5976 VGND VPWR sky130_fd_sc_hd__tapvpwrvgnd_1
XTAP_TAPCELL_ROW_91_1_1366 VGND VPWR sky130_fd_sc_hd__tapvpwrvgnd_1
XFILLER_172_1453 VPWR VGND VPWR VGND sky130_ef_sc_hd__decap_12
XFILLER_81_1347 VPWR VGND VPWR VGND sky130_ef_sc_hd__decap_12
XFILLER_235_1174 VPWR VGND VPWR VGND sky130_ef_sc_hd__decap_12
XFILLER_238_906 VPWR VGND VPWR VGND sky130_ef_sc_hd__decap_12
XFILLER_1_377 VGND VGND VPWR VPWR sky130_fd_sc_hd__fill_1
XFILLER_46_1478 VGND VGND VPWR VPWR sky130_fd_sc_hd__decap_6
XFILLER_94_22 VPWR VGND VPWR VGND sky130_ef_sc_hd__decap_12
XFILLER_246_961 VGND VGND VPWR VPWR sky130_fd_sc_hd__decap_6
X_604_ clknet_3_0__leaf_clk dout0\[2\] _012_ VGND VGND VPWR VPWR dout0_q\[2\] sky130_fd_sc_hd__dfrtp_1
XFILLER_205_302 VPWR VGND VPWR VGND sky130_ef_sc_hd__decap_12
XFILLER_217_173 VPWR VGND VPWR VGND sky130_ef_sc_hd__decap_12
X_535_ net667 VGND VGND VPWR VPWR _017_ sky130_fd_sc_hd__inv_2
XTAP_TAPCELL_ROW_93_2_5405 VGND VPWR sky130_fd_sc_hd__tapvpwrvgnd_1
XFILLER_232_132 VPWR VGND VPWR VGND sky130_ef_sc_hd__decap_12
XFILLER_205_357 VPWR VGND VPWR VGND sky130_ef_sc_hd__decap_12
XFILLER_177_209 VGND VGND VPWR VPWR sky130_fd_sc_hd__decap_6
XFILLER_220_316 VGND VGND VPWR VPWR sky130_fd_sc_hd__decap_6
XFILLER_246_1281 VPWR VGND VPWR VGND sky130_ef_sc_hd__decap_12
X_466_ _173_ _240_ net215 VGND VGND VPWR VPWR _241_ sky130_fd_sc_hd__a21o_1
XFILLER_92_1454 VPWR VGND VPWR VGND sky130_ef_sc_hd__decap_12
XFILLER_232_187 VGND VGND VPWR VPWR sky130_fd_sc_hd__decap_6
XTAP_TAPCELL_ROW_105_2_5503 VGND VPWR sky130_fd_sc_hd__tapvpwrvgnd_1
XFILLER_186_710 VPWR VGND VPWR VGND sky130_ef_sc_hd__decap_12
XFILLER_198_581 VPWR VGND VPWR VGND sky130_ef_sc_hd__decap_12
XFILLER_9_400 VPWR VGND VPWR VGND sky130_ef_sc_hd__decap_12
XFILLER_201_541 VPWR VGND VPWR VGND sky130_ef_sc_hd__decap_12
X_397_ net586 net592 net563 VGND VGND VPWR VPWR _186_ sky130_fd_sc_hd__a21oi_1
XFILLER_186_765 VPWR VGND VPWR VGND sky130_ef_sc_hd__decap_12
XFILLER_220_1410 VPWR VGND VPWR VGND sky130_ef_sc_hd__decap_12
XFILLER_199_1033 VPWR VGND VPWR VGND sky130_ef_sc_hd__decap_12
XFILLER_201_596 VGND VGND VPWR VPWR sky130_fd_sc_hd__decap_6
XTAP_TAPCELL_ROW_28_2_4887 VGND VPWR sky130_fd_sc_hd__tapvpwrvgnd_1
XFILLER_16_1282 VPWR VGND VPWR VGND sky130_ef_sc_hd__decap_12
XFILLER_103_1230 VPWR VGND VPWR VGND sky130_ef_sc_hd__decap_12
XFILLER_167_990 VPWR VGND VPWR VGND sky130_ef_sc_hd__decap_12
XFILLER_174_949 VPWR VGND VPWR VGND sky130_ef_sc_hd__decap_12
XTAP_TAPCELL_ROW_175_1870 VGND VPWR sky130_fd_sc_hd__tapvpwrvgnd_1
XTAP_TAPCELL_ROW_175_1881 VGND VPWR sky130_fd_sc_hd__tapvpwrvgnd_1
XTAP_TAPCELL_ROW_175_1892 VGND VPWR sky130_fd_sc_hd__tapvpwrvgnd_1
XFILLER_220_1465 VPWR VGND VPWR VGND sky130_ef_sc_hd__decap_12
XFILLER_64_6 VPWR VGND VPWR VGND sky130_ef_sc_hd__decap_12
XTAP_TAPCELL_ROW_171_1734 VGND VPWR sky130_fd_sc_hd__tapvpwrvgnd_1
XFILLER_199_1088 VPWR VGND VPWR VGND sky130_ef_sc_hd__decap_12
XTAP_TAPCELL_ROW_171_1745 VGND VPWR sky130_fd_sc_hd__tapvpwrvgnd_1
XTAP_TAPCELL_ROW_212_3166 VGND VPWR sky130_fd_sc_hd__tapvpwrvgnd_1
XFILLER_103_1285 VGND VGND VPWR VPWR sky130_fd_sc_hd__decap_6
XTAP_TAPCELL_ROW_171_1756 VGND VPWR sky130_fd_sc_hd__tapvpwrvgnd_1
XTAP_TAPCELL_ROW_212_3177 VGND VPWR sky130_fd_sc_hd__tapvpwrvgnd_1
XTAP_TAPCELL_ROW_212_3188 VGND VPWR sky130_fd_sc_hd__tapvpwrvgnd_1
XFILLER_5_661 VGND VGND VPWR VPWR sky130_fd_sc_hd__fill_1
XFILLER_245_39 VGND VGND VPWR VPWR sky130_fd_sc_hd__decap_4
XFILLER_138_1337 VPWR VGND VPWR VGND sky130_ef_sc_hd__decap_12
XFILLER_173_1217 VPWR VGND VPWR VGND sky130_ef_sc_hd__decap_12
XFILLER_175_80 VGND VGND VPWR VPWR sky130_fd_sc_hd__decap_6
XFILLER_253_1241 VGND VGND VPWR VPWR sky130_fd_sc_hd__decap_6
XFILLER_25_1507 VGND VGND VPWR VPWR sky130_fd_sc_hd__decap_8
XTAP_TAPCELL_ROW_169_1663 VGND VPWR sky130_fd_sc_hd__tapvpwrvgnd_1
XFILLER_229_928 VPWR VGND VPWR VGND sky130_ef_sc_hd__decap_12
XTAP_TAPCELL_ROW_165_1505 VGND VPWR sky130_fd_sc_hd__tapvpwrvgnd_1
XTAP_TAPCELL_ROW_169_1674 VGND VPWR sky130_fd_sc_hd__tapvpwrvgnd_1
XFILLER_255_202 VGND VGND VPWR VPWR sky130_fd_sc_hd__decap_8
XTAP_TAPCELL_ROW_165_1516 VGND VPWR sky130_fd_sc_hd__tapvpwrvgnd_1
XTAP_TAPCELL_ROW_169_1685 VGND VPWR sky130_fd_sc_hd__tapvpwrvgnd_1
XTAP_TAPCELL_ROW_165_1527 VGND VPWR sky130_fd_sc_hd__tapvpwrvgnd_1
XFILLER_214_1269 VPWR VGND VPWR VGND sky130_ef_sc_hd__decap_12
XTAP_TAPCELL_ROW_165_1538 VGND VPWR sky130_fd_sc_hd__tapvpwrvgnd_1
XFILLER_3_1303 VPWR VGND VPWR VGND sky130_ef_sc_hd__decap_12
XFILLER_23_1242 VGND VGND VPWR VPWR sky130_fd_sc_hd__decap_6
XFILLER_114_1392 VGND VGND VPWR VPWR sky130_fd_sc_hd__decap_6
XFILLER_208_151 VPWR VGND VPWR VGND sky130_ef_sc_hd__decap_12
XFILLER_237_983 VGND VGND VPWR VPWR sky130_fd_sc_hd__decap_6
XFILLER_3_1358 VPWR VGND VPWR VGND sky130_ef_sc_hd__decap_12
XFILLER_149_1433 VPWR VGND VPWR VGND sky130_ef_sc_hd__decap_12
XFILLER_184_1324 VPWR VGND VPWR VGND sky130_ef_sc_hd__decap_12
XFILLER_247_1045 VPWR VGND VPWR VGND sky130_ef_sc_hd__decap_12
XFILLER_93_1218 VPWR VGND VPWR VGND sky130_ef_sc_hd__decap_12
XFILLER_58_1349 VGND VGND VPWR VPWR sky130_fd_sc_hd__decap_6
XFILLER_149_1488 VPWR VGND VPWR VGND sky130_ef_sc_hd__decap_12
XFILLER_223_154 VPWR VGND VPWR VGND sky130_ef_sc_hd__decap_12
XFILLER_251_474 VPWR VGND VPWR VGND sky130_ef_sc_hd__decap_12
XFILLER_184_1379 VPWR VGND VPWR VGND sky130_ef_sc_hd__decap_12
XFILLER_196_507 VPWR VGND VPWR VGND sky130_ef_sc_hd__decap_12
XFILLER_212_839 VPWR VGND VPWR VGND sky130_ef_sc_hd__decap_12
XFILLER_211_338 VGND VGND VPWR VPWR sky130_fd_sc_hd__decap_6
XFILLER_177_732 VPWR VGND VPWR VGND sky130_ef_sc_hd__decap_12
XFILLER_204_390 VPWR VGND VPWR VGND sky130_ef_sc_hd__decap_12
XFILLER_165_916 VGND VGND VPWR VPWR sky130_fd_sc_hd__decap_8
XFILLER_221_1229 VPWR VGND VPWR VGND sky130_ef_sc_hd__decap_12
XFILLER_108_1196 VPWR VGND VPWR VGND sky130_ef_sc_hd__decap_12
XFILLER_220_894 VPWR VGND VPWR VGND sky130_ef_sc_hd__decap_12
XFILLER_177_787 VPWR VGND VPWR VGND sky130_ef_sc_hd__decap_12
XFILLER_192_746 VGND VGND VPWR VPWR sky130_fd_sc_hd__decap_6
XFILLER_195_1420 VPWR VGND VPWR VGND sky130_ef_sc_hd__decap_12
XFILLER_69_1445 VPWR VGND VPWR VGND sky130_ef_sc_hd__decap_12
XFILLER_173_971 VPWR VGND VPWR VGND sky130_ef_sc_hd__decap_12
XFILLER_2_108 VPWR VGND VPWR VGND sky130_ef_sc_hd__decap_12
XTAP_TAPCELL_ROW_150_2_5862 VGND VPWR sky130_fd_sc_hd__tapvpwrvgnd_1
XTAP_TAPCELL_ROW_149_2_5856 VGND VPWR sky130_fd_sc_hd__tapvpwrvgnd_1
XFILLER_155_39 VGND VGND VPWR VPWR sky130_fd_sc_hd__decap_4
XFILLER_195_1475 VPWR VGND VPWR VGND sky130_ef_sc_hd__decap_12
XFILLER_48_15 VGND VGND VPWR VPWR sky130_fd_sc_hd__decap_6
XFILLER_232_1336 VPWR VGND VPWR VGND sky130_ef_sc_hd__decap_12
XTAP_TAPCELL_ROW_9_1220 VGND VPWR sky130_fd_sc_hd__tapvpwrvgnd_1
XFILLER_119_1292 VPWR VGND VPWR VGND sky130_ef_sc_hd__decap_12
XFILLER_247_725 VGND VGND VPWR VPWR sky130_fd_sc_hd__decap_6
XTAP_TAPCELL_ROW_9_1231 VGND VPWR sky130_fd_sc_hd__tapvpwrvgnd_1
XFILLER_171_27 VPWR VGND VPWR VGND sky130_ef_sc_hd__decap_12
XTAP_TAPCELL_ROW_9_1242 VGND VPWR sky130_fd_sc_hd__tapvpwrvgnd_1
XFILLER_8_1269 VPWR VGND VPWR VGND sky130_ef_sc_hd__decap_12
XFILLER_80_1380 VPWR VGND VPWR VGND sky130_ef_sc_hd__decap_12
XFILLER_115_1189 VPWR VGND VPWR VGND sky130_ef_sc_hd__decap_12
XFILLER_228_961 VGND VGND VPWR VPWR sky130_fd_sc_hd__decap_6
XTAP_TAPCELL_ROW_111_2_5546 VGND VPWR sky130_fd_sc_hd__tapvpwrvgnd_1
XTAP_TAPCELL_ROW_181_2074 VGND VPWR sky130_fd_sc_hd__tapvpwrvgnd_1
XFILLER_104_65 VGND VGND VPWR VPWR sky130_fd_sc_hd__decap_6
XTAP_TAPCELL_ROW_181_2085 VGND VPWR sky130_fd_sc_hd__tapvpwrvgnd_1
XTAP_TAPCELL_ROW_181_2096 VGND VPWR sky130_fd_sc_hd__tapvpwrvgnd_1
XPHY_EDGE_ROW_66_1_Right_722 VGND VGND VPWR VPWR sky130_fd_sc_hd__decap_3
XFILLER_214_132 VPWR VGND VPWR VGND sky130_ef_sc_hd__decap_12
XFILLER_242_452 VPWR VGND VPWR VGND sky130_ef_sc_hd__decap_12
XFILLER_199_345 VPWR VGND VPWR VGND sky130_ef_sc_hd__decap_12
X_320_ _101_ _104_ VGND VGND VPWR VPWR _109_ sky130_fd_sc_hd__and2b_1
XFILLER_202_316 VGND VGND VPWR VPWR sky130_fd_sc_hd__decap_6
XFILLER_243_1432 VPWR VGND VPWR VGND sky130_ef_sc_hd__decap_12
XFILLER_187_529 VPWR VGND VPWR VGND sky130_ef_sc_hd__decap_12
XFILLER_214_187 VGND VGND VPWR VPWR sky130_fd_sc_hd__decap_6
XFILLER_230_636 VPWR VGND VPWR VGND sky130_ef_sc_hd__decap_12
XFILLER_168_710 VPWR VGND VPWR VGND sky130_ef_sc_hd__decap_12
XFILLER_147_3 VPWR VGND VPWR VGND sky130_ef_sc_hd__decap_12
XPHY_EDGE_ROW_135_2_Left_637 VGND VGND VPWR VPWR sky130_fd_sc_hd__decap_3
XTAP_TAPCELL_ROW_14_2_4773 VGND VPWR sky130_fd_sc_hd__tapvpwrvgnd_1
XFILLER_74_1184 VPWR VGND VPWR VGND sky130_ef_sc_hd__decap_12
XFILLER_80_46 VPWR VGND VPWR VGND sky130_ef_sc_hd__decap_12
XFILLER_211_861 VPWR VGND VPWR VGND sky130_ef_sc_hd__decap_12
XFILLER_243_1487 VPWR VGND VPWR VGND sky130_ef_sc_hd__decap_12
XFILLER_126_1263 VGND VGND VPWR VPWR sky130_fd_sc_hd__decap_6
XFILLER_168_765 VPWR VGND VPWR VGND sky130_ef_sc_hd__decap_12
XFILLER_7_904 VPWR VGND VPWR VGND sky130_ef_sc_hd__decap_12
XFILLER_161_1165 VPWR VGND VPWR VGND sky130_ef_sc_hd__decap_12
XFILLER_183_713 VPWR VGND VPWR VGND sky130_ef_sc_hd__decap_12
XFILLER_196_46 VPWR VGND VPWR VGND sky130_ef_sc_hd__decap_12
XFILLER_195_584 VPWR VGND VPWR VGND sky130_ef_sc_hd__decap_12
XFILLER_202_1140 VPWR VGND VPWR VGND sky130_ef_sc_hd__decap_12
XFILLER_13_1433 VPWR VGND VPWR VGND sky130_ef_sc_hd__decap_12
XFILLER_7_959 VPWR VGND VPWR VGND sky130_ef_sc_hd__decap_12
XFILLER_183_768 VGND VGND VPWR VPWR sky130_fd_sc_hd__decap_6
XFILLER_202_1195 VPWR VGND VPWR VGND sky130_ef_sc_hd__decap_12
XFILLER_13_1488 VPWR VGND VPWR VGND sky130_ef_sc_hd__decap_12
XFILLER_89_44 VPWR VGND VPWR VGND sky130_ef_sc_hd__decap_12
XFILLER_2_631 VPWR VGND VPWR VGND sky130_ef_sc_hd__decap_12
XFILLER_46_1220 VGND VGND VPWR VPWR sky130_fd_sc_hd__decap_6
XFILLER_1_130 VPWR VGND VPWR VGND sky130_ef_sc_hd__decap_12
XFILLER_133_1201 VGND VGND VPWR VPWR sky130_fd_sc_hd__decap_4
XFILLER_172_1250 VPWR VGND VPWR VGND sky130_ef_sc_hd__decap_12
XFILLER_238_703 VGND VGND VPWR VPWR sky130_fd_sc_hd__decap_6
XFILLER_81_1177 VPWR VGND VPWR VGND sky130_ef_sc_hd__decap_12
XTAP_TAPCELL_ROW_224_3582 VGND VPWR sky130_fd_sc_hd__tapvpwrvgnd_1
XPHY_EDGE_ROW_149_1_Left_404 VGND VGND VPWR VPWR sky130_fd_sc_hd__decap_3
XFILLER_213_1291 VPWR VGND VPWR VGND sky130_ef_sc_hd__decap_12
XFILLER_219_983 VGND VGND VPWR VPWR sky130_fd_sc_hd__decap_6
XTAP_TAPCELL_ROW_224_3593 VGND VPWR sky130_fd_sc_hd__tapvpwrvgnd_1
XTAP_TAPCELL_ROW_220_3446 VGND VPWR sky130_fd_sc_hd__tapvpwrvgnd_1
XTAP_TAPCELL_ROW_220_3457 VGND VPWR sky130_fd_sc_hd__tapvpwrvgnd_1
XFILLER_252_249 VPWR VGND VPWR VGND sky130_ef_sc_hd__decap_12
XTAP_TAPCELL_ROW_114_1_1401 VGND VPWR sky130_fd_sc_hd__tapvpwrvgnd_1
XTAP_TAPCELL_ROW_220_3468 VGND VPWR sky130_fd_sc_hd__tapvpwrvgnd_1
XFILLER_244_1207 VPWR VGND VPWR VGND sky130_ef_sc_hd__decap_12
XFILLER_209_1327 VGND VGND VPWR VPWR sky130_fd_sc_hd__decap_6
XFILLER_205_154 VPWR VGND VPWR VGND sky130_ef_sc_hd__decap_12
XFILLER_221_603 VPWR VGND VPWR VGND sky130_ef_sc_hd__decap_12
XFILLER_2_1391 VGND VGND VPWR VPWR sky130_fd_sc_hd__decap_6
XFILLER_166_1054 VPWR VGND VPWR VGND sky130_ef_sc_hd__decap_12
XFILLER_248_1398 VPWR VGND VPWR VGND sky130_ef_sc_hd__decap_12
XFILLER_178_507 VPWR VGND VPWR VGND sky130_ef_sc_hd__decap_12
XFILLER_233_474 VPWR VGND VPWR VGND sky130_ef_sc_hd__decap_12
XPHY_EDGE_ROW_67_2_Left_569 VGND VGND VPWR VPWR sky130_fd_sc_hd__decap_3
X_518_ _265_ net75 VGND VGND VPWR VPWR acc_core.adder.cla_blocks\[7\].block.sum\[2\]
+ sky130_fd_sc_hd__xnor2_1
XFILLER_92_1251 VPWR VGND VPWR VGND sky130_ef_sc_hd__decap_12
XFILLER_57_1371 VGND VGND VPWR VPWR sky130_fd_sc_hd__decap_6
XFILLER_221_658 VPWR VGND VPWR VGND sky130_ef_sc_hd__decap_12
X_449_ _090_ _091_ net514 net81 VGND VGND VPWR VPWR _238_ sky130_fd_sc_hd__o22ai_1
XTAP_TAPCELL_ROW_177_1943 VGND VPWR sky130_fd_sc_hd__tapvpwrvgnd_1
XTAP_TAPCELL_ROW_218_3375 VGND VPWR sky130_fd_sc_hd__tapvpwrvgnd_1
XFILLER_14_1208 VPWR VGND VPWR VGND sky130_ef_sc_hd__decap_12
XTAP_TAPCELL_ROW_155_2_5899 VGND VPWR sky130_fd_sc_hd__tapvpwrvgnd_1
XTAP_TAPCELL_ROW_177_1954 VGND VPWR sky130_fd_sc_hd__tapvpwrvgnd_1
XTAP_TAPCELL_ROW_177_1965 VGND VPWR sky130_fd_sc_hd__tapvpwrvgnd_1
XTAP_TAPCELL_ROW_218_3386 VGND VPWR sky130_fd_sc_hd__tapvpwrvgnd_1
XTAP_TAPCELL_ROW_173_1807 VGND VPWR sky130_fd_sc_hd__tapvpwrvgnd_1
XFILLER_186_562 VPWR VGND VPWR VGND sky130_ef_sc_hd__decap_12
XFILLER_202_894 VPWR VGND VPWR VGND sky130_ef_sc_hd__decap_12
XTAP_TAPCELL_ROW_218_3397 VGND VPWR sky130_fd_sc_hd__tapvpwrvgnd_1
XFILLER_31_1500 VGND VGND VPWR VPWR sky130_fd_sc_hd__decap_6
XFILLER_18_1399 VPWR VGND VPWR VGND sky130_ef_sc_hd__decap_12
XFILLER_105_1347 VPWR VGND VPWR VGND sky130_ef_sc_hd__decap_12
XFILLER_140_1227 VPWR VGND VPWR VGND sky130_ef_sc_hd__decap_12
XTAP_TAPCELL_ROW_173_1818 VGND VPWR sky130_fd_sc_hd__tapvpwrvgnd_1
XTAP_TAPCELL_ROW_214_3239 VGND VPWR sky130_fd_sc_hd__tapvpwrvgnd_1
XFILLER_9_274 VGND VGND VPWR VPWR sky130_fd_sc_hd__decap_4
XFILLER_174_746 VGND VGND VPWR VPWR sky130_fd_sc_hd__decap_6
XTAP_TAPCELL_ROW_135_2_5742 VGND VPWR sky130_fd_sc_hd__tapvpwrvgnd_1
XFILLER_220_1262 VGND VGND VPWR VPWR sky130_fd_sc_hd__decap_6
XFILLER_255_1303 VPWR VGND VPWR VGND sky130_ef_sc_hd__decap_12
XFILLER_255_1336 VGND VGND VPWR VPWR sky130_fd_sc_hd__decap_8
XFILLER_6_992 VPWR VGND VPWR VGND sky130_ef_sc_hd__decap_12
XFILLER_173_1014 VPWR VGND VPWR VGND sky130_ef_sc_hd__decap_12
XFILLER_173_1069 VGND VGND VPWR VPWR sky130_fd_sc_hd__decap_6
XFILLER_214_1011 VPWR VGND VPWR VGND sky130_ef_sc_hd__decap_12
XFILLER_25_1304 VPWR VGND VPWR VGND sky130_ef_sc_hd__decap_12
XTAP_TAPCELL_ROW_53_2_5086 VGND VPWR sky130_fd_sc_hd__tapvpwrvgnd_1
XFILLER_116_1454 VPWR VGND VPWR VGND sky130_ef_sc_hd__decap_12
XFILLER_229_725 VGND VGND VPWR VPWR sky130_fd_sc_hd__decap_6
XFILLER_214_1066 VPWR VGND VPWR VGND sky130_ef_sc_hd__decap_12
XFILLER_60_1239 VPWR VGND VPWR VGND sky130_ef_sc_hd__decap_12
XFILLER_25_1359 VPWR VGND VPWR VGND sky130_ef_sc_hd__decap_12
XFILLER_18_18 VGND VGND VPWR VPWR sky130_fd_sc_hd__decap_3
XFILLER_3_1100 VPWR VGND VPWR VGND sky130_ef_sc_hd__decap_12
XFILLER_151_1378 VPWR VGND VPWR VGND sky130_ef_sc_hd__decap_12
XFILLER_7_1291 VPWR VGND VPWR VGND sky130_ef_sc_hd__decap_12
XFILLER_243_216 VPWR VGND VPWR VGND sky130_ef_sc_hd__decap_12
XPHY_EDGE_ROW_133_1_Left_388 VGND VGND VPWR VPWR sky130_fd_sc_hd__decap_3
XFILLER_3_1155 VGND VGND VPWR VPWR sky130_fd_sc_hd__decap_6
XTAP_TAPCELL_ROW_255_4700 VGND VPWR sky130_fd_sc_hd__tapvpwrvgnd_1
XTAP_TAPCELL_ROW_255_4711 VGND VPWR sky130_fd_sc_hd__tapvpwrvgnd_1
XFILLER_149_1230 VPWR VGND VPWR VGND sky130_ef_sc_hd__decap_12
XTAP_TAPCELL_ROW_255_4722 VGND VPWR sky130_fd_sc_hd__tapvpwrvgnd_1
XFILLER_184_1121 VPWR VGND VPWR VGND sky130_ef_sc_hd__decap_12
XTAP_TAPCELL_ROW_255_4733 VGND VPWR sky130_fd_sc_hd__tapvpwrvgnd_1
XTAP_TAPCELL_ROW_31_2_4912 VGND VPWR sky130_fd_sc_hd__tapvpwrvgnd_1
XFILLER_224_452 VPWR VGND VPWR VGND sky130_ef_sc_hd__decap_12
XFILLER_149_1285 VGND VGND VPWR VPWR sky130_fd_sc_hd__decap_6
XFILLER_251_271 VPWR VGND VPWR VGND sky130_ef_sc_hd__decap_12
XPHY_EDGE_ROW_70_1_Left_325 VGND VGND VPWR VPWR sky130_fd_sc_hd__decap_3
XFILLER_184_1176 VGND VGND VPWR VPWR sky130_fd_sc_hd__decap_6
XFILLER_196_304 VPWR VGND VPWR VGND sky130_ef_sc_hd__decap_12
XFILLER_212_636 VPWR VGND VPWR VGND sky130_ef_sc_hd__decap_12
XFILLER_36_1411 VPWR VGND VPWR VGND sky130_ef_sc_hd__decap_12
XFILLER_169_529 VPWR VGND VPWR VGND sky130_ef_sc_hd__decap_12
XFILLER_71_1335 VPWR VGND VPWR VGND sky130_ef_sc_hd__decap_12
XFILLER_196_359 VGND VGND VPWR VPWR sky130_fd_sc_hd__decap_6
XFILLER_225_1162 VPWR VGND VPWR VGND sky130_ef_sc_hd__decap_12
XFILLER_36_1466 VPWR VGND VPWR VGND sky130_ef_sc_hd__decap_12
XFILLER_123_1414 VGND VGND VPWR VPWR sky130_fd_sc_hd__decap_6
Xwire109 _206_ VGND VGND VPWR VPWR net109 sky130_fd_sc_hd__clkbuf_1
XFILLER_221_1026 VGND VGND VPWR VPWR sky130_fd_sc_hd__decap_6
Xclkload5 clknet_3_6__leaf_clk VGND VGND VPWR VPWR clkload5/Y sky130_fd_sc_hd__bufinv_16
XFILLER_162_1485 VPWR VGND VPWR VGND sky130_ef_sc_hd__decap_12
XFILLER_177_584 VPWR VGND VPWR VGND sky130_ef_sc_hd__decap_12
XFILLER_220_691 VPWR VGND VPWR VGND sky130_ef_sc_hd__decap_12
XFILLER_165_757 VPWR VGND VPWR VGND sky130_ef_sc_hd__decap_12
XFILLER_4_918 VGND VGND VPWR VPWR sky130_fd_sc_hd__decap_6
XFILLER_69_1242 VGND VGND VPWR VPWR sky130_fd_sc_hd__decap_6
XFILLER_195_1272 VPWR VGND VPWR VGND sky130_ef_sc_hd__decap_12
XFILLER_182_15 VGND VGND VPWR VPWR sky130_fd_sc_hd__decap_6
XFILLER_117_1218 VPWR VGND VPWR VGND sky130_ef_sc_hd__decap_12
XFILLER_82_1442 VPWR VGND VPWR VGND sky130_ef_sc_hd__decap_12
XFILLER_8_1011 VPWR VGND VPWR VGND sky130_ef_sc_hd__decap_12
XTAP_TAPCELL_ROW_187_2294 VGND VPWR sky130_fd_sc_hd__tapvpwrvgnd_1
XFILLER_232_1133 VGND VGND VPWR VPWR sky130_fd_sc_hd__decap_6
XTAP_TAPCELL_ROW_183_2147 VGND VPWR sky130_fd_sc_hd__tapvpwrvgnd_1
XFILLER_82_1497 VPWR VGND VPWR VGND sky130_ef_sc_hd__decap_12
XFILLER_8_1066 VPWR VGND VPWR VGND sky130_ef_sc_hd__decap_12
XTAP_TAPCELL_ROW_183_2158 VGND VPWR sky130_fd_sc_hd__tapvpwrvgnd_1
XTAP_TAPCELL_ROW_183_2169 VGND VPWR sky130_fd_sc_hd__tapvpwrvgnd_1
XFILLER_75_68 VGND VGND VPWR VPWR sky130_fd_sc_hd__decap_3
XFILLER_210_1453 VPWR VGND VPWR VGND sky130_ef_sc_hd__decap_12
XTAP_TAPCELL_ROW_3_973 VGND VPWR sky130_fd_sc_hd__tapvpwrvgnd_1
XFILLER_189_1076 VPWR VGND VPWR VGND sky130_ef_sc_hd__decap_12
XTAP_TAPCELL_ROW_3_984 VGND VPWR sky130_fd_sc_hd__tapvpwrvgnd_1
XTAP_TAPCELL_ROW_3_995 VGND VPWR sky130_fd_sc_hd__tapvpwrvgnd_1
XFILLER_234_249 VPWR VGND VPWR VGND sky130_ef_sc_hd__decap_12
XPHY_EDGE_ROW_67_1_Right_723 VGND VGND VPWR VPWR sky130_fd_sc_hd__decap_3
XFILLER_203_603 VPWR VGND VPWR VGND sky130_ef_sc_hd__decap_12
XFILLER_199_142 VPWR VGND VPWR VGND sky130_ef_sc_hd__decap_12
XFILLER_215_474 VPWR VGND VPWR VGND sky130_ef_sc_hd__decap_12
XFILLER_128_1325 VPWR VGND VPWR VGND sky130_ef_sc_hd__decap_12
XFILLER_91_56 VPWR VGND VPWR VGND sky130_ef_sc_hd__decap_12
XFILLER_187_326 VPWR VGND VPWR VGND sky130_ef_sc_hd__decap_12
XFILLER_230_433 VPWR VGND VPWR VGND sky130_ef_sc_hd__decap_12
XFILLER_163_1249 VPWR VGND VPWR VGND sky130_ef_sc_hd__decap_12
XFILLER_203_658 VPWR VGND VPWR VGND sky130_ef_sc_hd__decap_12
X_303_ net597 dout0_q\[28\] net528 VGND VGND VPWR VPWR _092_ sky130_fd_sc_hd__and3_1
XFILLER_199_197 VPWR VGND VPWR VGND sky130_ef_sc_hd__decap_12
XFILLER_230_488 VGND VGND VPWR VPWR sky130_fd_sc_hd__decap_6
XFILLER_243_1284 VGND VGND VPWR VPWR sky130_fd_sc_hd__decap_6
XFILLER_168_562 VPWR VGND VPWR VGND sky130_ef_sc_hd__decap_12
XFILLER_196_882 VPWR VGND VPWR VGND sky130_ef_sc_hd__decap_12
XFILLER_183_510 VGND VGND VPWR VPWR sky130_fd_sc_hd__decap_6
Xwire632 net37 VGND VGND VPWR VPWR net632 sky130_fd_sc_hd__buf_1
XFILLER_102_1509 VGND VGND VPWR VPWR sky130_fd_sc_hd__decap_6
XFILLER_195_381 VGND VGND VPWR VPWR sky130_fd_sc_hd__decap_6
Xwire643 net28 VGND VGND VPWR VPWR net643 sky130_fd_sc_hd__buf_1
XFILLER_13_1230 VPWR VGND VPWR VGND sky130_ef_sc_hd__decap_12
XTAP_TAPCELL_ROW_232_3862 VGND VPWR sky130_fd_sc_hd__tapvpwrvgnd_1
Xwire654 net19 VGND VGND VPWR VPWR net654 sky130_fd_sc_hd__buf_1
XTAP_TAPCELL_ROW_232_3873 VGND VPWR sky130_fd_sc_hd__tapvpwrvgnd_1
XTAP_TAPCELL_ROW_232_3884 VGND VPWR sky130_fd_sc_hd__tapvpwrvgnd_1
XFILLER_104_1380 VPWR VGND VPWR VGND sky130_ef_sc_hd__decap_12
XFILLER_196_1047 VGND VGND VPWR VPWR sky130_fd_sc_hd__decap_6
XFILLER_13_1285 VGND VGND VPWR VPWR sky130_fd_sc_hd__decap_6
XFILLER_139_1421 VPWR VGND VPWR VGND sky130_ef_sc_hd__decap_12
XFILLER_170_237 VPWR VGND VPWR VGND sky130_ef_sc_hd__decap_12
XFILLER_174_1312 VPWR VGND VPWR VGND sky130_ef_sc_hd__decap_12
XTAP_TAPCELL_ROW_70_2_5225 VGND VPWR sky130_fd_sc_hd__tapvpwrvgnd_1
XFILLER_83_1206 VPWR VGND VPWR VGND sky130_ef_sc_hd__decap_12
XFILLER_237_1033 VPWR VGND VPWR VGND sky130_ef_sc_hd__decap_12
XFILLER_48_1337 VPWR VGND VPWR VGND sky130_ef_sc_hd__decap_12
XFILLER_3_940 VGND VGND VPWR VPWR sky130_fd_sc_hd__decap_6
XFILLER_139_1476 VPWR VGND VPWR VGND sky130_ef_sc_hd__decap_12
XFILLER_174_1367 VPWR VGND VPWR VGND sky130_ef_sc_hd__decap_12
XFILLER_237_1088 VPWR VGND VPWR VGND sky130_ef_sc_hd__decap_12
XTAP_TAPCELL_ROW_207_3010 VGND VPWR sky130_fd_sc_hd__tapvpwrvgnd_1
XFILLER_254_1391 VGND VGND VPWR VPWR sky130_fd_sc_hd__decap_6
XTAP_TAPCELL_ROW_226_3655 VGND VPWR sky130_fd_sc_hd__tapvpwrvgnd_1
XTAP_TAPCELL_ROW_226_3666 VGND VPWR sky130_fd_sc_hd__tapvpwrvgnd_1
XTAP_TAPCELL_ROW_36_2_4949 VGND VPWR sky130_fd_sc_hd__tapvpwrvgnd_1
XTAP_TAPCELL_ROW_226_3677 VGND VPWR sky130_fd_sc_hd__tapvpwrvgnd_1
XFILLER_211_1217 VPWR VGND VPWR VGND sky130_ef_sc_hd__decap_12
XTAP_TAPCELL_ROW_222_3519 VGND VPWR sky130_fd_sc_hd__tapvpwrvgnd_1
XFILLER_4_1453 VPWR VGND VPWR VGND sky130_ef_sc_hd__decap_12
XFILLER_225_216 VPWR VGND VPWR VGND sky130_ef_sc_hd__decap_12
XFILLER_24_1392 VGND VGND VPWR VPWR sky130_fd_sc_hd__decap_6
XFILLER_1_87 VGND VGND VPWR VPWR sky130_fd_sc_hd__decap_8
XFILLER_248_1140 VPWR VGND VPWR VGND sky130_ef_sc_hd__decap_12
XFILLER_1_98 VPWR VGND VPWR VGND sky130_ef_sc_hd__decap_12
XFILLER_94_1313 VPWR VGND VPWR VGND sky130_ef_sc_hd__decap_12
XFILLER_59_1433 VPWR VGND VPWR VGND sky130_ef_sc_hd__decap_12
XFILLER_206_452 VPWR VGND VPWR VGND sky130_ef_sc_hd__decap_12
XFILLER_244_1004 VGND VGND VPWR VPWR sky130_fd_sc_hd__decap_6
XFILLER_185_1463 VPWR VGND VPWR VGND sky130_ef_sc_hd__decap_12
XFILLER_221_400 VPWR VGND VPWR VGND sky130_ef_sc_hd__decap_12
XFILLER_248_1195 VPWR VGND VPWR VGND sky130_ef_sc_hd__decap_12
XFILLER_94_1368 VPWR VGND VPWR VGND sky130_ef_sc_hd__decap_12
XFILLER_178_304 VPWR VGND VPWR VGND sky130_ef_sc_hd__decap_12
XFILLER_233_271 VPWR VGND VPWR VGND sky130_ef_sc_hd__decap_12
XFILLER_59_1488 VPWR VGND VPWR VGND sky130_ef_sc_hd__decap_12
XFILLER_181_1327 VGND VGND VPWR VPWR sky130_fd_sc_hd__decap_6
XFILLER_221_455 VPWR VGND VPWR VGND sky130_ef_sc_hd__decap_12
XFILLER_178_359 VGND VGND VPWR VPWR sky130_fd_sc_hd__decap_6
XFILLER_194_808 VPWR VGND VPWR VGND sky130_ef_sc_hd__decap_12
XFILLER_222_1324 VPWR VGND VPWR VGND sky130_ef_sc_hd__decap_12
XFILLER_202_691 VPWR VGND VPWR VGND sky130_ef_sc_hd__decap_12
XFILLER_18_1196 VPWR VGND VPWR VGND sky130_ef_sc_hd__decap_12
XFILLER_222_1379 VPWR VGND VPWR VGND sky130_ef_sc_hd__decap_12
XFILLER_105_1177 VPWR VGND VPWR VGND sky130_ef_sc_hd__decap_12
XFILLER_192_1434 VGND VGND VPWR VPWR sky130_fd_sc_hd__decap_6
XFILLER_255_1177 VPWR VGND VPWR VGND sky130_ef_sc_hd__decap_12
XFILLER_233_1420 VPWR VGND VPWR VGND sky130_ef_sc_hd__decap_12
XFILLER_29_1292 VPWR VGND VPWR VGND sky130_ef_sc_hd__decap_12
XFILLER_116_1251 VPWR VGND VPWR VGND sky130_ef_sc_hd__decap_12
XFILLER_5_1217 VPWR VGND VPWR VGND sky130_ef_sc_hd__decap_12
XFILLER_233_1475 VPWR VGND VPWR VGND sky130_ef_sc_hd__decap_12
XFILLER_25_1189 VPWR VGND VPWR VGND sky130_ef_sc_hd__decap_12
XFILLER_77_1500 VGND VGND VPWR VPWR sky130_fd_sc_hd__decap_6
XFILLER_45_27 VPWR VGND VPWR VGND sky130_ef_sc_hd__decap_12
XTAP_TAPCELL_ROW_157_2_5918 VGND VPWR sky130_fd_sc_hd__tapvpwrvgnd_1
XFILLER_186_1238 VPWR VGND VPWR VGND sky130_ef_sc_hd__decap_12
XFILLER_216_249 VPWR VGND VPWR VGND sky130_ef_sc_hd__decap_12
XTAP_TAPCELL_ROW_94_2_5410 VGND VPWR sky130_fd_sc_hd__tapvpwrvgnd_1
XFILLER_196_101 VGND VGND VPWR VPWR sky130_fd_sc_hd__decap_6
XFILLER_101_44 VPWR VGND VPWR VGND sky130_ef_sc_hd__decap_12
XFILLER_169_326 VPWR VGND VPWR VGND sky130_ef_sc_hd__decap_12
XFILLER_212_433 VPWR VGND VPWR VGND sky130_ef_sc_hd__decap_12
XFILLER_197_646 VPWR VGND VPWR VGND sky130_ef_sc_hd__decap_12
XFILLER_240_753 VPWR VGND VPWR VGND sky130_ef_sc_hd__decap_12
XFILLER_61_15 VPWR VGND VPWR VGND sky130_ef_sc_hd__decap_12
XFILLER_200_617 VGND VGND VPWR VPWR sky130_fd_sc_hd__decap_6
XTAP_TAPCELL_ROW_195_2574 VGND VPWR sky130_fd_sc_hd__tapvpwrvgnd_1
XFILLER_177_15 VPWR VGND VPWR VGND sky130_ef_sc_hd__decap_12
XTAP_TAPCELL_ROW_195_2585 VGND VPWR sky130_fd_sc_hd__tapvpwrvgnd_1
XFILLER_212_488 VGND VGND VPWR VPWR sky130_fd_sc_hd__decap_6
XFILLER_61_59 VPWR VGND VPWR VGND sky130_ef_sc_hd__decap_12
XFILLER_36_1263 VGND VGND VPWR VPWR sky130_fd_sc_hd__decap_6
XTAP_TAPCELL_ROW_191_2427 VGND VPWR sky130_fd_sc_hd__tapvpwrvgnd_1
XTAP_TAPCELL_ROW_195_2596 VGND VPWR sky130_fd_sc_hd__tapvpwrvgnd_1
XFILLER_178_882 VPWR VGND VPWR VGND sky130_ef_sc_hd__decap_12
XTAP_TAPCELL_ROW_191_2438 VGND VPWR sky130_fd_sc_hd__tapvpwrvgnd_1
XFILLER_71_1165 VPWR VGND VPWR VGND sky130_ef_sc_hd__decap_12
XFILLER_162_1282 VPWR VGND VPWR VGND sky130_ef_sc_hd__decap_12
XTAP_TAPCELL_ROW_191_2449 VGND VPWR sky130_fd_sc_hd__tapvpwrvgnd_1
XTAP_TAPCELL_ROW_29_2_4892 VGND VPWR sky130_fd_sc_hd__tapvpwrvgnd_1
XFILLER_177_381 VGND VGND VPWR VPWR sky130_fd_sc_hd__decap_6
XFILLER_193_830 VPWR VGND VPWR VGND sky130_ef_sc_hd__decap_12
XFILLER_197_1334 VPWR VGND VPWR VGND sky130_ef_sc_hd__decap_12
XTAP_TAPCELL_ROW_55_2_5105 VGND VPWR sky130_fd_sc_hd__tapvpwrvgnd_1
XFILLER_4_704 VGND VGND VPWR VPWR sky130_fd_sc_hd__fill_2
XFILLER_193_885 VPWR VGND VPWR VGND sky130_ef_sc_hd__decap_12
XFILLER_197_1389 VPWR VGND VPWR VGND sky130_ef_sc_hd__decap_12
XTAP_TAPCELL_ROW_189_2356 VGND VPWR sky130_fd_sc_hd__tapvpwrvgnd_1
XTAP_TAPCELL_ROW_189_2367 VGND VPWR sky130_fd_sc_hd__tapvpwrvgnd_1
XTAP_TAPCELL_ROW_189_2378 VGND VPWR sky130_fd_sc_hd__tapvpwrvgnd_1
XTAP_TAPCELL_ROW_22_2_4835 VGND VPWR sky130_fd_sc_hd__tapvpwrvgnd_1
XFILLER_0_910 VPWR VGND VPWR VGND sky130_ef_sc_hd__decap_12
XFILLER_43_1201 VGND VGND VPWR VPWR sky130_fd_sc_hd__decap_4
XFILLER_248_820 VPWR VGND VPWR VGND sky130_ef_sc_hd__decap_12
XFILLER_86_34 VPWR VGND VPWR VGND sky130_ef_sc_hd__decap_12
XFILLER_82_1294 VPWR VGND VPWR VGND sky130_ef_sc_hd__decap_12
XFILLER_248_875 VGND VGND VPWR VPWR sky130_fd_sc_hd__decap_6
XFILLER_207_216 VPWR VGND VPWR VGND sky130_ef_sc_hd__decap_12
XPHY_EDGE_ROW_130_2_Right_221 VGND VGND VPWR VPWR sky130_fd_sc_hd__decap_3
XFILLER_210_1250 VPWR VGND VPWR VGND sky130_ef_sc_hd__decap_12
XFILLER_203_400 VPWR VGND VPWR VGND sky130_ef_sc_hd__decap_12
XFILLER_215_271 VPWR VGND VPWR VGND sky130_ef_sc_hd__decap_12
XFILLER_245_1346 VPWR VGND VPWR VGND sky130_ef_sc_hd__decap_12
XPHY_EDGE_ROW_68_1_Right_724 VGND VGND VPWR VPWR sky130_fd_sc_hd__decap_3
XFILLER_188_624 VPWR VGND VPWR VGND sky130_ef_sc_hd__decap_12
XFILLER_187_123 VGND VGND VPWR VPWR sky130_fd_sc_hd__decap_6
XFILLER_230_230 VGND VGND VPWR VPWR sky130_fd_sc_hd__decap_6
XFILLER_203_455 VPWR VGND VPWR VGND sky130_ef_sc_hd__decap_12
XFILLER_128_1177 VGND VGND VPWR VPWR sky130_fd_sc_hd__decap_6
XFILLER_176_808 VPWR VGND VPWR VGND sky130_ef_sc_hd__decap_12
XFILLER_231_775 VPWR VGND VPWR VGND sky130_ef_sc_hd__decap_12
XFILLER_93_1390 VPWR VGND VPWR VGND sky130_ef_sc_hd__decap_12
XFILLER_188_679 VPWR VGND VPWR VGND sky130_ef_sc_hd__decap_12
XTAP_TAPCELL_ROW_234_3935 VGND VPWR sky130_fd_sc_hd__tapvpwrvgnd_1
XTAP_TAPCELL_ROW_234_3946 VGND VPWR sky130_fd_sc_hd__tapvpwrvgnd_1
XFILLER_106_1442 VPWR VGND VPWR VGND sky130_ef_sc_hd__decap_12
XFILLER_198_1109 VPWR VGND VPWR VGND sky130_ef_sc_hd__decap_12
XTAP_TAPCELL_ROW_234_3957 VGND VPWR sky130_fd_sc_hd__tapvpwrvgnd_1
XFILLER_50_1227 VPWR VGND VPWR VGND sky130_ef_sc_hd__decap_12
XFILLER_15_1347 VPWR VGND VPWR VGND sky130_ef_sc_hd__decap_12
XFILLER_204_1054 VPWR VGND VPWR VGND sky130_ef_sc_hd__decap_12
XTAP_TAPCELL_ROW_97_1_1375 VGND VPWR sky130_fd_sc_hd__tapvpwrvgnd_1
XFILLER_102_1306 VGND VGND VPWR VPWR sky130_fd_sc_hd__decap_6
Xwire440 net441 VGND VGND VPWR VPWR net440 sky130_fd_sc_hd__clkbuf_1
Xwire451 net452 VGND VGND VPWR VPWR net451 sky130_fd_sc_hd__clkbuf_1
XFILLER_106_1497 VPWR VGND VPWR VGND sky130_ef_sc_hd__decap_12
XFILLER_184_863 VPWR VGND VPWR VGND sky130_ef_sc_hd__decap_12
Xwire462 net463 VGND VGND VPWR VPWR net462 sky130_fd_sc_hd__clkbuf_1
Xwire473 net474 VGND VGND VPWR VPWR net473 sky130_fd_sc_hd__clkbuf_1
Xmax_cap206 net207 VGND VGND VPWR VPWR net206 sky130_fd_sc_hd__clkbuf_1
Xmax_cap217 _167_ VGND VGND VPWR VPWR net217 sky130_fd_sc_hd__clkbuf_1
Xwire484 net485 VGND VGND VPWR VPWR net484 sky130_fd_sc_hd__clkbuf_1
XTAP_TAPCELL_ROW_14_1_1251 VGND VPWR sky130_fd_sc_hd__tapvpwrvgnd_1
XTAP_TAPCELL_ROW_228_3728 VGND VPWR sky130_fd_sc_hd__tapvpwrvgnd_1
XFILLER_139_1273 VPWR VGND VPWR VGND sky130_ef_sc_hd__decap_12
XTAP_TAPCELL_ROW_228_3739 VGND VPWR sky130_fd_sc_hd__tapvpwrvgnd_1
XFILLER_174_1164 VPWR VGND VPWR VGND sky130_ef_sc_hd__decap_12
XFILLER_253_39 VGND VGND VPWR VPWR sky130_fd_sc_hd__decap_4
XFILLER_183_80 VGND VGND VPWR VPWR sky130_fd_sc_hd__decap_6
XFILLER_2_280 VGND VGND VPWR VPWR sky130_fd_sc_hd__decap_3
XFILLER_239_842 VPWR VGND VPWR VGND sky130_ef_sc_hd__decap_12
XFILLER_25_3 VPWR VGND VPWR VGND sky130_ef_sc_hd__decap_12
XFILLER_26_1454 VPWR VGND VPWR VGND sky130_ef_sc_hd__decap_12
XFILLER_113_1402 VPWR VGND VPWR VGND sky130_ef_sc_hd__decap_12
XTAP_TAPCELL_ROW_143_2_5804 VGND VPWR sky130_fd_sc_hd__tapvpwrvgnd_1
XFILLER_211_1014 VPWR VGND VPWR VGND sky130_ef_sc_hd__decap_12
XFILLER_61_1378 VPWR VGND VPWR VGND sky130_ef_sc_hd__decap_12
XFILLER_239_897 VGND VGND VPWR VPWR sky130_fd_sc_hd__decap_6
XFILLER_113_1457 VGND VGND VPWR VPWR sky130_fd_sc_hd__decap_6
XFILLER_187_1514 VGND VGND VPWR VPWR sky130_fd_sc_hd__fill_1
XFILLER_4_1250 VPWR VGND VPWR VGND sky130_ef_sc_hd__decap_12
XFILLER_211_1069 VGND VGND VPWR VPWR sky130_fd_sc_hd__decap_6
XFILLER_148_1509 VGND VGND VPWR VPWR sky130_fd_sc_hd__decap_6
XFILLER_0_1114 VPWR VGND VPWR VGND sky130_ef_sc_hd__decap_12
XFILLER_59_1230 VPWR VGND VPWR VGND sky130_ef_sc_hd__decap_12
XFILLER_241_517 VPWR VGND VPWR VGND sky130_ef_sc_hd__decap_12
XFILLER_253_388 VPWR VGND VPWR VGND sky130_ef_sc_hd__decap_12
XFILLER_0_1147 VGND VGND VPWR VPWR sky130_fd_sc_hd__decap_8
XFILLER_202_65 VPWR VGND VPWR VGND sky130_ef_sc_hd__decap_12
XFILLER_185_1260 VPWR VGND VPWR VGND sky130_ef_sc_hd__decap_12
XFILLER_59_1285 VGND VGND VPWR VPWR sky130_fd_sc_hd__decap_6
XFILLER_94_1165 VPWR VGND VPWR VGND sky130_ef_sc_hd__decap_12
XFILLER_178_101 VGND VGND VPWR VPWR sky130_fd_sc_hd__decap_6
XTAP_TAPCELL_ROW_61_2_5148 VGND VPWR sky130_fd_sc_hd__tapvpwrvgnd_1
XFILLER_179_646 VPWR VGND VPWR VGND sky130_ef_sc_hd__decap_12
XFILLER_222_753 VPWR VGND VPWR VGND sky130_ef_sc_hd__decap_12
XFILLER_107_1206 VPWR VGND VPWR VGND sky130_ef_sc_hd__decap_12
XFILLER_221_252 VGND VGND VPWR VPWR sky130_fd_sc_hd__decap_6
XFILLER_194_605 VPWR VGND VPWR VGND sky130_ef_sc_hd__decap_12
XFILLER_210_937 VPWR VGND VPWR VGND sky130_ef_sc_hd__decap_12
XFILLER_33_1414 VGND VGND VPWR VPWR sky130_fd_sc_hd__decap_6
XFILLER_222_1121 VPWR VGND VPWR VGND sky130_ef_sc_hd__decap_12
XFILLER_72_1485 VPWR VGND VPWR VGND sky130_ef_sc_hd__decap_12
XFILLER_175_830 VPWR VGND VPWR VGND sky130_ef_sc_hd__decap_12
XFILLER_222_1176 VGND VGND VPWR VPWR sky130_fd_sc_hd__decap_6
XTAP_TAPCELL_ROW_250_4493 VGND VPWR sky130_fd_sc_hd__tapvpwrvgnd_1
XFILLER_175_885 VPWR VGND VPWR VGND sky130_ef_sc_hd__decap_12
XFILLER_200_1441 VPWR VGND VPWR VGND sky130_ef_sc_hd__decap_12
XPHY_EDGE_ROW_30_1_Right_686 VGND VGND VPWR VPWR sky130_fd_sc_hd__decap_3
XFILLER_200_1496 VPWR VGND VPWR VGND sky130_ef_sc_hd__decap_12
XFILLER_118_1313 VPWR VGND VPWR VGND sky130_ef_sc_hd__decap_12
XFILLER_27_1218 VPWR VGND VPWR VGND sky130_ef_sc_hd__decap_12
XFILLER_163_39 VGND VGND VPWR VPWR sky130_fd_sc_hd__decap_4
XFILLER_249_639 VGND VGND VPWR VPWR sky130_fd_sc_hd__decap_6
XFILLER_118_1368 VPWR VGND VPWR VGND sky130_ef_sc_hd__decap_12
XTAP_TAPCELL_ROW_244_4286 VGND VPWR sky130_fd_sc_hd__tapvpwrvgnd_1
XTAP_TAPCELL_ROW_244_4297 VGND VPWR sky130_fd_sc_hd__tapvpwrvgnd_1
XPHY_EDGE_ROW_144_2_Left_646 VGND VGND VPWR VPWR sky130_fd_sc_hd__decap_3
XFILLER_233_1272 VPWR VGND VPWR VGND sky130_ef_sc_hd__decap_12
XTAP_TAPCELL_ROW_240_4139 VGND VPWR sky130_fd_sc_hd__tapvpwrvgnd_1
XFILLER_5_1014 VPWR VGND VPWR VGND sky130_ef_sc_hd__decap_12
XFILLER_56_15 VGND VGND VPWR VPWR sky130_fd_sc_hd__decap_6
XFILLER_5_1069 VGND VGND VPWR VPWR sky130_fd_sc_hd__decap_6
XTAP_TAPCELL_ROW_6_1075 VGND VPWR sky130_fd_sc_hd__tapvpwrvgnd_1
XFILLER_186_1035 VPWR VGND VPWR VGND sky130_ef_sc_hd__decap_12
XFILLER_244_366 VPWR VGND VPWR VGND sky130_ef_sc_hd__decap_12
XTAP_TAPCELL_ROW_6_1086 VGND VPWR sky130_fd_sc_hd__tapvpwrvgnd_1
XTAP_TAPCELL_ROW_6_1097 VGND VPWR sky130_fd_sc_hd__tapvpwrvgnd_1
XTAP_TAPCELL_ROW_178_2002 VGND VPWR sky130_fd_sc_hd__tapvpwrvgnd_1
XFILLER_112_65 VGND VGND VPWR VPWR sky130_fd_sc_hd__decap_6
XTAP_TAPCELL_ROW_197_2636 VGND VPWR sky130_fd_sc_hd__tapvpwrvgnd_1
XTAP_TAPCELL_ROW_197_2647 VGND VPWR sky130_fd_sc_hd__tapvpwrvgnd_1
XFILLER_38_1325 VPWR VGND VPWR VGND sky130_ef_sc_hd__decap_12
XTAP_TAPCELL_ROW_197_2658 VGND VPWR sky130_fd_sc_hd__tapvpwrvgnd_1
XTAP_TAPCELL_ROW_238_4079 VGND VPWR sky130_fd_sc_hd__tapvpwrvgnd_1
XFILLER_242_1508 VGND VGND VPWR VPWR sky130_fd_sc_hd__decap_6
XFILLER_129_1464 VPWR VGND VPWR VGND sky130_ef_sc_hd__decap_12
XFILLER_212_230 VGND VGND VPWR VPWR sky130_fd_sc_hd__decap_6
XFILLER_72_58 VGND VGND VPWR VPWR sky130_fd_sc_hd__decap_6
XFILLER_169_123 VGND VGND VPWR VPWR sky130_fd_sc_hd__decap_6
XFILLER_201_904 VPWR VGND VPWR VGND sky130_ef_sc_hd__decap_12
XFILLER_73_1249 VPWR VGND VPWR VGND sky130_ef_sc_hd__decap_12
XFILLER_197_443 VPWR VGND VPWR VGND sky130_ef_sc_hd__decap_12
XFILLER_213_775 VPWR VGND VPWR VGND sky130_ef_sc_hd__decap_12
XFILLER_227_1076 VPWR VGND VPWR VGND sky130_ef_sc_hd__decap_12
XFILLER_240_550 VPWR VGND VPWR VGND sky130_ef_sc_hd__decap_12
XFILLER_125_1328 VGND VGND VPWR VPWR sky130_fd_sc_hd__decap_6
XFILLER_160_1208 VPWR VGND VPWR VGND sky130_ef_sc_hd__decap_12
XFILLER_188_58 VGND VGND VPWR VPWR sky130_fd_sc_hd__decap_6
XFILLER_164_1399 VPWR VGND VPWR VGND sky130_ef_sc_hd__decap_12
XFILLER_185_627 VPWR VGND VPWR VGND sky130_ef_sc_hd__decap_12
XFILLER_201_959 VPWR VGND VPWR VGND sky130_ef_sc_hd__decap_12
XFILLER_197_498 VPWR VGND VPWR VGND sky130_ef_sc_hd__decap_12
XFILLER_201_1205 VPWR VGND VPWR VGND sky130_ef_sc_hd__decap_12
XFILLER_227_3 VPWR VGND VPWR VGND sky130_ef_sc_hd__decap_12
XFILLER_12_1509 VGND VGND VPWR VPWR sky130_fd_sc_hd__decap_6
XFILLER_166_863 VPWR VGND VPWR VGND sky130_ef_sc_hd__decap_12
XFILLER_197_1131 VPWR VGND VPWR VGND sky130_ef_sc_hd__decap_12
XFILLER_181_811 VGND VGND VPWR VPWR sky130_fd_sc_hd__decap_6
XFILLER_193_682 VGND VGND VPWR VPWR sky130_fd_sc_hd__decap_6
XFILLER_14_1380 VPWR VGND VPWR VGND sky130_ef_sc_hd__decap_12
XPHY_EDGE_ROW_158_1_Left_413 VGND VGND VPWR VPWR sky130_fd_sc_hd__decap_3
XFILLER_197_1186 VPWR VGND VPWR VGND sky130_ef_sc_hd__decap_12
XFILLER_49_1421 VPWR VGND VPWR VGND sky130_ef_sc_hd__decap_12
XFILLER_97_44 VPWR VGND VPWR VGND sky130_ef_sc_hd__decap_12
XFILLER_49_1476 VPWR VGND VPWR VGND sky130_ef_sc_hd__decap_12
XFILLER_84_1356 VPWR VGND VPWR VGND sky130_ef_sc_hd__decap_12
XTAP_TAPCELL_ROW_117_2_5599 VGND VPWR sky130_fd_sc_hd__tapvpwrvgnd_1
XFILLER_238_1183 VPWR VGND VPWR VGND sky130_ef_sc_hd__decap_12
XTAP_TAPCELL_ROW_85_2_5344 VGND VPWR sky130_fd_sc_hd__tapvpwrvgnd_1
XFILLER_136_1435 VGND VGND VPWR VPWR sky130_fd_sc_hd__decap_6
XFILLER_171_1315 VPWR VGND VPWR VGND sky130_ef_sc_hd__decap_12
XFILLER_234_1047 VGND VGND VPWR VPWR sky130_fd_sc_hd__decap_6
XTAP_TAPCELL_ROW_54_2_5091 VGND VPWR sky130_fd_sc_hd__tapvpwrvgnd_1
XPHY_EDGE_ROW_76_2_Left_578 VGND VGND VPWR VPWR sky130_fd_sc_hd__decap_3
XFILLER_212_1312 VPWR VGND VPWR VGND sky130_ef_sc_hd__decap_12
XFILLER_0_784 VGND VGND VPWR VPWR sky130_fd_sc_hd__decap_8
XFILLER_254_108 VPWR VGND VPWR VGND sky130_ef_sc_hd__decap_12
XFILLER_212_1367 VPWR VGND VPWR VGND sky130_ef_sc_hd__decap_12
XFILLER_1_1401 VPWR VGND VPWR VGND sky130_ef_sc_hd__decap_12
XPHY_EDGE_ROW_131_2_Right_222 VGND VGND VPWR VPWR sky130_fd_sc_hd__decap_3
XFILLER_223_517 VPWR VGND VPWR VGND sky130_ef_sc_hd__decap_12
XTAP_TAPCELL_ROW_46_2_5028 VGND VPWR sky130_fd_sc_hd__tapvpwrvgnd_1
XFILLER_1_1456 VGND VGND VPWR VPWR sky130_fd_sc_hd__decap_6
XFILLER_235_388 VPWR VGND VPWR VGND sky130_ef_sc_hd__decap_12
XFILLER_250_347 VPWR VGND VPWR VGND sky130_ef_sc_hd__decap_12
Xmax_cap93 _245_ VGND VGND VPWR VPWR net93 sky130_fd_sc_hd__clkbuf_1
XFILLER_182_1422 VPWR VGND VPWR VGND sky130_ef_sc_hd__decap_12
XFILLER_245_1143 VPWR VGND VPWR VGND sky130_ef_sc_hd__decap_12
XFILLER_91_1316 VPWR VGND VPWR VGND sky130_ef_sc_hd__decap_12
XFILLER_188_421 VPWR VGND VPWR VGND sky130_ef_sc_hd__decap_12
XFILLER_204_753 VPWR VGND VPWR VGND sky130_ef_sc_hd__decap_12
XPHY_EDGE_ROW_69_1_Right_725 VGND VGND VPWR VPWR sky130_fd_sc_hd__decap_3
XFILLER_203_252 VGND VGND VPWR VPWR sky130_fd_sc_hd__decap_6
XFILLER_176_605 VPWR VGND VPWR VGND sky130_ef_sc_hd__decap_12
XFILLER_231_572 VPWR VGND VPWR VGND sky130_ef_sc_hd__decap_12
XFILLER_182_1477 VGND VGND VPWR VPWR sky130_fd_sc_hd__decap_6
XFILLER_245_1198 VGND VGND VPWR VPWR sky130_fd_sc_hd__decap_6
XFILLER_188_476 VPWR VGND VPWR VGND sky130_ef_sc_hd__decap_12
XTAP_TAPCELL_ROW_13_2_4769 VGND VPWR sky130_fd_sc_hd__tapvpwrvgnd_1
XFILLER_223_1463 VPWR VGND VPWR VGND sky130_ef_sc_hd__decap_12
XFILLER_89_1201 VGND VGND VPWR VPWR sky130_fd_sc_hd__decap_4
XFILLER_15_1177 VPWR VGND VPWR VGND sky130_ef_sc_hd__decap_12
XFILLER_8_862 VPWR VGND VPWR VGND sky130_ef_sc_hd__decap_12
XFILLER_7_42 VGND VGND VPWR VPWR sky130_fd_sc_hd__fill_1
XFILLER_184_660 VGND VGND VPWR VPWR sky130_fd_sc_hd__decap_6
XFILLER_106_1294 VPWR VGND VPWR VGND sky130_ef_sc_hd__decap_12
XFILLER_200_992 VPWR VGND VPWR VGND sky130_ef_sc_hd__decap_12
Xwire270 net271 VGND VGND VPWR VPWR net270 sky130_fd_sc_hd__clkbuf_1
Xwire281 net282 VGND VGND VPWR VPWR net281 sky130_fd_sc_hd__clkbuf_1
Xwire292 net293 VGND VGND VPWR VPWR net292 sky130_fd_sc_hd__clkbuf_1
XFILLER_176_1226 VPWR VGND VPWR VGND sky130_ef_sc_hd__decap_12
XPHY_EDGE_ROW_142_1_Left_397 VGND VGND VPWR VPWR sky130_fd_sc_hd__decap_3
XFILLER_6_1312 VPWR VGND VPWR VGND sky130_ef_sc_hd__decap_12
XFILLER_26_1251 VPWR VGND VPWR VGND sky130_ef_sc_hd__decap_12
XFILLER_230_1434 VGND VGND VPWR VPWR sky130_fd_sc_hd__decap_6
XFILLER_117_1390 VPWR VGND VPWR VGND sky130_ef_sc_hd__decap_12
XFILLER_152_1270 VPWR VGND VPWR VGND sky130_ef_sc_hd__decap_12
XFILLER_6_1367 VPWR VGND VPWR VGND sky130_ef_sc_hd__decap_12
XFILLER_253_130 VPWR VGND VPWR VGND sky130_ef_sc_hd__decap_12
XFILLER_96_1227 VPWR VGND VPWR VGND sky130_ef_sc_hd__decap_12
XFILLER_148_1306 VGND VGND VPWR VPWR sky130_fd_sc_hd__decap_6
XFILLER_226_366 VPWR VGND VPWR VGND sky130_ef_sc_hd__decap_12
XPHY_EDGE_ROW_5_Right_5 VGND VGND VPWR VPWR sky130_fd_sc_hd__decap_3
XFILLER_241_314 VPWR VGND VPWR VGND sky130_ef_sc_hd__decap_12
XFILLER_187_1377 VPWR VGND VPWR VGND sky130_ef_sc_hd__decap_12
XFILLER_253_185 VPWR VGND VPWR VGND sky130_ef_sc_hd__decap_12
XFILLER_198_218 VPWR VGND VPWR VGND sky130_ef_sc_hd__decap_12
XTAP_TAPCELL_ROW_204_2890 VGND VPWR sky130_fd_sc_hd__tapvpwrvgnd_1
XTAP_TAPCELL_ROW_200_2743 VGND VPWR sky130_fd_sc_hd__tapvpwrvgnd_1
XTAP_TAPCELL_ROW_200_2754 VGND VPWR sky130_fd_sc_hd__tapvpwrvgnd_1
XFILLER_241_369 VPWR VGND VPWR VGND sky130_ef_sc_hd__decap_12
XFILLER_179_443 VPWR VGND VPWR VGND sky130_ef_sc_hd__decap_12
XFILLER_222_550 VPWR VGND VPWR VGND sky130_ef_sc_hd__decap_12
XTAP_TAPCELL_ROW_200_2765 VGND VPWR sky130_fd_sc_hd__tapvpwrvgnd_1
XFILLER_224_1238 VPWR VGND VPWR VGND sky130_ef_sc_hd__decap_12
XFILLER_194_402 VGND VGND VPWR VPWR sky130_fd_sc_hd__decap_6
XTAP_TAPCELL_ROW_252_4566 VGND VPWR sky130_fd_sc_hd__tapvpwrvgnd_1
XFILLER_167_627 VPWR VGND VPWR VGND sky130_ef_sc_hd__decap_12
XFILLER_210_734 VPWR VGND VPWR VGND sky130_ef_sc_hd__decap_12
XTAP_TAPCELL_ROW_252_4577 VGND VPWR sky130_fd_sc_hd__tapvpwrvgnd_1
XFILLER_195_947 VPWR VGND VPWR VGND sky130_ef_sc_hd__decap_12
XTAP_TAPCELL_ROW_252_4588 VGND VPWR sky130_fd_sc_hd__tapvpwrvgnd_1
XFILLER_179_498 VPWR VGND VPWR VGND sky130_ef_sc_hd__decap_12
XFILLER_72_1282 VPWR VGND VPWR VGND sky130_ef_sc_hd__decap_12
XFILLER_202_1514 VGND VGND VPWR VPWR sky130_fd_sc_hd__fill_1
XFILLER_210_789 VGND VGND VPWR VPWR sky130_fd_sc_hd__decap_6
XTAP_TAPCELL_ROW_91_2_5387 VGND VPWR sky130_fd_sc_hd__tapvpwrvgnd_1
XFILLER_159_1402 VPWR VGND VPWR VGND sky130_ef_sc_hd__decap_12
XFILLER_175_682 VGND VGND VPWR VPWR sky130_fd_sc_hd__decap_6
XFILLER_198_1484 VPWR VGND VPWR VGND sky130_ef_sc_hd__decap_12
XTAP_TAPCELL_ROW_103_2_5485 VGND VPWR sky130_fd_sc_hd__tapvpwrvgnd_1
XTAP_TAPCELL_ROW_71_2_5230 VGND VPWR sky130_fd_sc_hd__tapvpwrvgnd_1
XFILLER_159_1457 VGND VGND VPWR VPWR sky130_fd_sc_hd__decap_6
XFILLER_194_1348 VGND VGND VPWR VPWR sky130_fd_sc_hd__decap_6
XPHY_EDGE_ROW_31_1_Right_687 VGND VGND VPWR VPWR sky130_fd_sc_hd__decap_3
XFILLER_200_1293 VPWR VGND VPWR VGND sky130_ef_sc_hd__decap_12
XTAP_TAPCELL_ROW_155_1_1462 VGND VPWR sky130_fd_sc_hd__tapvpwrvgnd_1
XTAP_TAPCELL_ROW_246_4359 VGND VPWR sky130_fd_sc_hd__tapvpwrvgnd_1
XFILLER_235_1334 VPWR VGND VPWR VGND sky130_ef_sc_hd__decap_12
XFILLER_81_1507 VGND VGND VPWR VPWR sky130_fd_sc_hd__decap_8
XFILLER_118_1165 VPWR VGND VPWR VGND sky130_ef_sc_hd__decap_12
XFILLER_235_1389 VPWR VGND VPWR VGND sky130_ef_sc_hd__decap_12
XTAP_TAPCELL_ROW_37_2_4954 VGND VPWR sky130_fd_sc_hd__tapvpwrvgnd_1
XFILLER_190_15 VGND VGND VPWR VPWR sky130_fd_sc_hd__decap_6
XFILLER_236_108 VPWR VGND VPWR VGND sky130_ef_sc_hd__decap_12
XTAP_TAPCELL_ROW_8_1148 VGND VPWR sky130_fd_sc_hd__tapvpwrvgnd_1
XTAP_TAPCELL_ROW_8_1159 VGND VPWR sky130_fd_sc_hd__tapvpwrvgnd_1
X_620_ clknet_3_4__leaf_clk dout0\[18\] _028_ VGND VGND VPWR VPWR dout0_q\[18\] sky130_fd_sc_hd__dfrtp_1
XFILLER_79_1414 VGND VGND VPWR VPWR sky130_fd_sc_hd__decap_6
XTAP_TAPCELL_ROW_199_2709 VGND VPWR sky130_fd_sc_hd__tapvpwrvgnd_1
XFILLER_177_3 VPWR VGND VPWR VGND sky130_ef_sc_hd__decap_12
X_551_ net670 VGND VGND VPWR VPWR _033_ sky130_fd_sc_hd__inv_2
XFILLER_205_517 VPWR VGND VPWR VGND sky130_ef_sc_hd__decap_12
XFILLER_244_163 VPWR VGND VPWR VGND sky130_ef_sc_hd__decap_12
XFILLER_217_388 VPWR VGND VPWR VGND sky130_ef_sc_hd__decap_12
XFILLER_83_68 VGND VGND VPWR VPWR sky130_fd_sc_hd__decap_3
XFILLER_246_1441 VPWR VGND VPWR VGND sky130_ef_sc_hd__decap_12
X_482_ net168 net331 net107 VGND VGND VPWR VPWR _247_ sky130_fd_sc_hd__and3_1
XFILLER_232_347 VPWR VGND VPWR VGND sky130_ef_sc_hd__decap_12
XFILLER_199_68 VPWR VGND VPWR VGND sky130_ef_sc_hd__decap_12
XFILLER_242_1305 VGND VGND VPWR VPWR sky130_fd_sc_hd__decap_6
XFILLER_129_1261 VPWR VGND VPWR VGND sky130_ef_sc_hd__decap_12
XFILLER_201_701 VPWR VGND VPWR VGND sky130_ef_sc_hd__decap_12
XFILLER_197_240 VPWR VGND VPWR VGND sky130_ef_sc_hd__decap_12
XFILLER_246_1496 VPWR VGND VPWR VGND sky130_ef_sc_hd__decap_12
XFILLER_213_572 VPWR VGND VPWR VGND sky130_ef_sc_hd__decap_12
XFILLER_38_1177 VGND VGND VPWR VPWR sky130_fd_sc_hd__decap_6
XFILLER_186_925 VPWR VGND VPWR VGND sky130_ef_sc_hd__decap_12
XFILLER_198_796 VPWR VGND VPWR VGND sky130_ef_sc_hd__decap_12
XFILLER_164_1196 VPWR VGND VPWR VGND sky130_ef_sc_hd__decap_12
XFILLER_185_424 VGND VGND VPWR VPWR sky130_fd_sc_hd__decap_6
XFILLER_197_295 VGND VGND VPWR VPWR sky130_fd_sc_hd__decap_6
XFILLER_201_756 VPWR VGND VPWR VGND sky130_ef_sc_hd__decap_12
XFILLER_16_1442 VPWR VGND VPWR VGND sky130_ef_sc_hd__decap_12
XFILLER_201_1002 VPWR VGND VPWR VGND sky130_ef_sc_hd__decap_12
XFILLER_199_1248 VPWR VGND VPWR VGND sky130_ef_sc_hd__decap_12
XFILLER_12_1306 VGND VGND VPWR VPWR sky130_fd_sc_hd__decap_6
XFILLER_166_660 VGND VGND VPWR VPWR sky130_fd_sc_hd__decap_6
XFILLER_16_1497 VPWR VGND VPWR VGND sky130_ef_sc_hd__decap_12
XFILLER_103_1445 VPWR VGND VPWR VGND sky130_ef_sc_hd__decap_12
XFILLER_194_980 VPWR VGND VPWR VGND sky130_ef_sc_hd__decap_12
XFILLER_201_1057 VPWR VGND VPWR VGND sky130_ef_sc_hd__decap_12
XFILLER_5_821 VGND VGND VPWR VPWR sky130_fd_sc_hd__decap_4
XFILLER_165_181 VGND VGND VPWR VPWR sky130_fd_sc_hd__decap_8
XFILLER_236_1109 VPWR VGND VPWR VGND sky130_ef_sc_hd__decap_12
XFILLER_180_151 VPWR VGND VPWR VGND sky130_ef_sc_hd__decap_12
XFILLER_253_1401 VPWR VGND VPWR VGND sky130_ef_sc_hd__decap_12
XFILLER_5_898 VGND VGND VPWR VPWR sky130_fd_sc_hd__decap_4
XTAP_TAPCELL_ROW_210_3094 VGND VPWR sky130_fd_sc_hd__tapvpwrvgnd_1
XFILLER_49_1273 VPWR VGND VPWR VGND sky130_ef_sc_hd__decap_12
XFILLER_171_1112 VGND VGND VPWR VPWR sky130_fd_sc_hd__decap_6
XFILLER_253_1456 VGND VGND VPWR VPWR sky130_fd_sc_hd__decap_6
XFILLER_23_1402 VPWR VGND VPWR VGND sky130_ef_sc_hd__decap_12
XFILLER_0_581 VGND VGND VPWR VPWR sky130_fd_sc_hd__fill_1
XFILLER_23_1457 VGND VGND VPWR VPWR sky130_fd_sc_hd__decap_6
XTAP_TAPCELL_ROW_167_1591 VGND VPWR sky130_fd_sc_hd__tapvpwrvgnd_1
XFILLER_212_1164 VPWR VGND VPWR VGND sky130_ef_sc_hd__decap_12
XTAP_TAPCELL_ROW_158_2_5923 VGND VPWR sky130_fd_sc_hd__tapvpwrvgnd_1
XFILLER_235_130 VPWR VGND VPWR VGND sky130_ef_sc_hd__decap_12
XFILLER_247_1205 VPWR VGND VPWR VGND sky130_ef_sc_hd__decap_12
XFILLER_208_366 VPWR VGND VPWR VGND sky130_ef_sc_hd__decap_12
XFILLER_58_1509 VGND VGND VPWR VPWR sky130_fd_sc_hd__decap_6
XTAP_TAPCELL_ROW_127_2_5681 VGND VPWR sky130_fd_sc_hd__tapvpwrvgnd_1
XFILLER_223_314 VPWR VGND VPWR VGND sky130_ef_sc_hd__decap_12
XFILLER_235_185 VPWR VGND VPWR VGND sky130_ef_sc_hd__decap_12
XTAP_TAPCELL_ROW_85_1_1357 VGND VPWR sky130_fd_sc_hd__tapvpwrvgnd_1
XPHY_EDGE_ROW_132_2_Right_223 VGND VGND VPWR VPWR sky130_fd_sc_hd__decap_3
XFILLER_250_144 VGND VGND VPWR VPWR sky130_fd_sc_hd__decap_6
XFILLER_223_369 VPWR VGND VPWR VGND sky130_ef_sc_hd__decap_12
XFILLER_225_1514 VGND VGND VPWR VPWR sky130_fd_sc_hd__fill_1
XFILLER_251_689 VPWR VGND VPWR VGND sky130_ef_sc_hd__decap_12
XFILLER_204_550 VPWR VGND VPWR VGND sky130_ef_sc_hd__decap_12
XFILLER_17_1206 VPWR VGND VPWR VGND sky130_ef_sc_hd__decap_12
XFILLER_92_3 VPWR VGND VPWR VGND sky130_ef_sc_hd__decap_12
XFILLER_176_402 VGND VGND VPWR VPWR sky130_fd_sc_hd__decap_6
XFILLER_188_273 VGND VGND VPWR VPWR sky130_fd_sc_hd__decap_6
XFILLER_108_1356 VPWR VGND VPWR VGND sky130_ef_sc_hd__decap_12
XFILLER_177_947 VPWR VGND VPWR VGND sky130_ef_sc_hd__decap_12
XTAP_TAPCELL_ROW_76_2_5267 VGND VPWR sky130_fd_sc_hd__tapvpwrvgnd_1
XTAP_TAPCELL_ROW_120_2_5624 VGND VPWR sky130_fd_sc_hd__tapvpwrvgnd_1
XFILLER_192_906 VPWR VGND VPWR VGND sky130_ef_sc_hd__decap_12
XFILLER_223_1260 VPWR VGND VPWR VGND sky130_ef_sc_hd__decap_12
XTAP_TAPCELL_ROW_56_2_5110 VGND VPWR sky130_fd_sc_hd__tapvpwrvgnd_1
XFILLER_176_1023 VPWR VGND VPWR VGND sky130_ef_sc_hd__decap_12
XFILLER_171_173 VPWR VGND VPWR VGND sky130_ef_sc_hd__decap_12
XFILLER_176_1078 VPWR VGND VPWR VGND sky130_ef_sc_hd__decap_12
XFILLER_28_1313 VPWR VGND VPWR VGND sky130_ef_sc_hd__decap_12
XFILLER_193_1370 VGND VGND VPWR VPWR sky130_fd_sc_hd__decap_6
XTAP_TAPCELL_ROW_241_4201 VGND VPWR sky130_fd_sc_hd__tapvpwrvgnd_1
XFILLER_28_1368 VPWR VGND VPWR VGND sky130_ef_sc_hd__decap_12
XFILLER_115_1316 VPWR VGND VPWR VGND sky130_ef_sc_hd__decap_12
XFILLER_218_108 VPWR VGND VPWR VGND sky130_ef_sc_hd__decap_12
XFILLER_37_39 VGND VGND VPWR VPWR sky130_fd_sc_hd__decap_4
XFILLER_6_1164 VPWR VGND VPWR VGND sky130_ef_sc_hd__decap_12
XTAP_TAPCELL_ROW_206_2952 VGND VPWR sky130_fd_sc_hd__tapvpwrvgnd_1
XTAP_TAPCELL_ROW_206_2963 VGND VPWR sky130_fd_sc_hd__tapvpwrvgnd_1
XTAP_TAPCELL_ROW_206_2974 VGND VPWR sky130_fd_sc_hd__tapvpwrvgnd_1
XTAP_TAPCELL_ROW_202_2816 VGND VPWR sky130_fd_sc_hd__tapvpwrvgnd_1
XTAP_TAPCELL_ROW_239_4130 VGND VPWR sky130_fd_sc_hd__tapvpwrvgnd_1
XFILLER_226_163 VPWR VGND VPWR VGND sky130_ef_sc_hd__decap_12
XTAP_TAPCELL_ROW_202_2827 VGND VPWR sky130_fd_sc_hd__tapvpwrvgnd_1
XFILLER_187_1174 VPWR VGND VPWR VGND sky130_ef_sc_hd__decap_12
XTAP_TAPCELL_ROW_202_2838 VGND VPWR sky130_fd_sc_hd__tapvpwrvgnd_1
XFILLER_241_111 VPWR VGND VPWR VGND sky130_ef_sc_hd__decap_12
XFILLER_214_347 VPWR VGND VPWR VGND sky130_ef_sc_hd__decap_12
XTAP_TAPCELL_ROW_254_4639 VGND VPWR sky130_fd_sc_hd__tapvpwrvgnd_1
XFILLER_242_667 VPWR VGND VPWR VGND sky130_ef_sc_hd__decap_12
XFILLER_53_27 VPWR VGND VPWR VGND sky130_ef_sc_hd__decap_12
XFILLER_165_1450 VPWR VGND VPWR VGND sky130_ef_sc_hd__decap_12
XFILLER_241_166 VGND VGND VPWR VPWR sky130_fd_sc_hd__decap_6
XFILLER_39_1464 VPWR VGND VPWR VGND sky130_ef_sc_hd__decap_12
XFILLER_169_27 VPWR VGND VPWR VGND sky130_ef_sc_hd__decap_12
XFILLER_179_240 VPWR VGND VPWR VGND sky130_ef_sc_hd__decap_12
XFILLER_126_1423 VPWR VGND VPWR VGND sky130_ef_sc_hd__decap_12
XFILLER_165_1483 VGND VGND VPWR VPWR sky130_fd_sc_hd__decap_8
XFILLER_168_925 VPWR VGND VPWR VGND sky130_ef_sc_hd__decap_12
XFILLER_70_1208 VPWR VGND VPWR VGND sky130_ef_sc_hd__decap_12
XFILLER_35_1328 VGND VGND VPWR VPWR sky130_fd_sc_hd__decap_6
XFILLER_224_1035 VPWR VGND VPWR VGND sky130_ef_sc_hd__decap_12
XFILLER_210_531 VGND VGND VPWR VPWR sky130_fd_sc_hd__decap_6
XFILLER_74_1399 VPWR VGND VPWR VGND sky130_ef_sc_hd__decap_12
XFILLER_161_1347 VPWR VGND VPWR VGND sky130_ef_sc_hd__decap_12
XFILLER_167_424 VGND VGND VPWR VPWR sky130_fd_sc_hd__decap_6
XFILLER_179_295 VGND VGND VPWR VPWR sky130_fd_sc_hd__decap_6
XFILLER_195_744 VPWR VGND VPWR VGND sky130_ef_sc_hd__decap_12
XFILLER_126_1478 VGND VGND VPWR VPWR sky130_fd_sc_hd__decap_6
XFILLER_183_928 VPWR VGND VPWR VGND sky130_ef_sc_hd__decap_12
XFILLER_195_799 VPWR VGND VPWR VGND sky130_ef_sc_hd__decap_12
XFILLER_176_980 VPWR VGND VPWR VGND sky130_ef_sc_hd__decap_12
XFILLER_185_15 VPWR VGND VPWR VGND sky130_ef_sc_hd__decap_12
XFILLER_202_1355 VPWR VGND VPWR VGND sky130_ef_sc_hd__decap_12
XFILLER_198_1281 VPWR VGND VPWR VGND sky130_ef_sc_hd__decap_12
XFILLER_191_983 VGND VGND VPWR VPWR sky130_fd_sc_hd__decap_6
XFILLER_200_1090 VGND VGND VPWR VPWR sky130_fd_sc_hd__decap_6
XPHY_EDGE_ROW_32_1_Right_688 VGND VGND VPWR VPWR sky130_fd_sc_hd__decap_3
XFILLER_172_1410 VPWR VGND VPWR VGND sky130_ef_sc_hd__decap_12
XFILLER_78_46 VPWR VGND VPWR VGND sky130_ef_sc_hd__decap_12
XFILLER_81_1304 VPWR VGND VPWR VGND sky130_ef_sc_hd__decap_12
XFILLER_235_1131 VPWR VGND VPWR VGND sky130_ef_sc_hd__decap_12
XFILLER_46_1435 VGND VGND VPWR VPWR sky130_fd_sc_hd__decap_6
XTAP_TAPCELL_ROW_164_2_5977 VGND VPWR sky130_fd_sc_hd__tapvpwrvgnd_1
XFILLER_172_1465 VPWR VGND VPWR VGND sky130_ef_sc_hd__decap_12
XFILLER_81_1359 VPWR VGND VPWR VGND sky130_ef_sc_hd__decap_12
XFILLER_235_1186 VPWR VGND VPWR VGND sky130_ef_sc_hd__decap_12
XFILLER_238_918 VGND VGND VPWR VPWR sky130_fd_sc_hd__decap_6
XFILLER_94_34 VPWR VGND VPWR VGND sky130_ef_sc_hd__decap_12
XFILLER_252_409 VPWR VGND VPWR VGND sky130_ef_sc_hd__decap_12
XFILLER_217_130 VPWR VGND VPWR VGND sky130_ef_sc_hd__decap_12
XFILLER_248_1514 VGND VGND VPWR VPWR sky130_fd_sc_hd__fill_1
X_603_ clknet_3_0__leaf_clk dout0\[1\] _011_ VGND VGND VPWR VPWR dout0_q\[1\] sky130_fd_sc_hd__dfrtp_1
XPHY_EDGE_ROW_107_2_Left_609 VGND VGND VPWR VPWR sky130_fd_sc_hd__decap_3
XFILLER_205_314 VPWR VGND VPWR VGND sky130_ef_sc_hd__decap_12
XFILLER_217_185 VPWR VGND VPWR VGND sky130_ef_sc_hd__decap_12
X_534_ net666 VGND VGND VPWR VPWR _016_ sky130_fd_sc_hd__inv_2
XTAP_TAPCELL_ROW_93_2_5406 VGND VPWR sky130_fd_sc_hd__tapvpwrvgnd_1
XFILLER_92_1411 VPWR VGND VPWR VGND sky130_ef_sc_hd__decap_12
XFILLER_232_144 VGND VGND VPWR VPWR sky130_fd_sc_hd__decap_6
XFILLER_166_1269 VPWR VGND VPWR VGND sky130_ef_sc_hd__decap_12
XFILLER_205_369 VPWR VGND VPWR VGND sky130_ef_sc_hd__decap_12
XFILLER_221_818 VPWR VGND VPWR VGND sky130_ef_sc_hd__decap_12
XFILLER_233_689 VPWR VGND VPWR VGND sky130_ef_sc_hd__decap_12
X_465_ _180_ _199_ _176_ VGND VGND VPWR VPWR _240_ sky130_fd_sc_hd__a21o_1
XFILLER_246_1293 VPWR VGND VPWR VGND sky130_ef_sc_hd__decap_12
XFILLER_92_1466 VPWR VGND VPWR VGND sky130_ef_sc_hd__decap_12
XTAP_TAPCELL_ROW_105_2_5504 VGND VPWR sky130_fd_sc_hd__tapvpwrvgnd_1
XFILLER_186_722 VPWR VGND VPWR VGND sky130_ef_sc_hd__decap_12
XFILLER_9_412 VGND VGND VPWR VPWR sky130_fd_sc_hd__decap_8
XFILLER_105_1507 VGND VGND VPWR VPWR sky130_fd_sc_hd__decap_8
XFILLER_198_593 VPWR VGND VPWR VGND sky130_ef_sc_hd__decap_12
X_396_ _183_ _184_ VGND VGND VPWR VPWR _185_ sky130_fd_sc_hd__nand2b_1
XFILLER_201_553 VGND VGND VPWR VPWR sky130_fd_sc_hd__decap_6
XFILLER_203_1119 VPWR VGND VPWR VGND sky130_ef_sc_hd__decap_12
XFILLER_174_906 VPWR VGND VPWR VGND sky130_ef_sc_hd__decap_12
XFILLER_186_777 VPWR VGND VPWR VGND sky130_ef_sc_hd__decap_12
XFILLER_220_1422 VPWR VGND VPWR VGND sky130_ef_sc_hd__decap_12
XFILLER_199_1045 VPWR VGND VPWR VGND sky130_ef_sc_hd__decap_12
XTAP_TAPCELL_ROW_28_2_4888 VGND VPWR sky130_fd_sc_hd__tapvpwrvgnd_1
XTAP_TAPCELL_ROW_175_1871 VGND VPWR sky130_fd_sc_hd__tapvpwrvgnd_1
XFILLER_16_1294 VPWR VGND VPWR VGND sky130_ef_sc_hd__decap_12
XFILLER_103_1242 VGND VGND VPWR VPWR sky130_fd_sc_hd__decap_6
XTAP_TAPCELL_ROW_175_1882 VGND VPWR sky130_fd_sc_hd__tapvpwrvgnd_1
XTAP_TAPCELL_ROW_171_1724 VGND VPWR sky130_fd_sc_hd__tapvpwrvgnd_1
XTAP_TAPCELL_ROW_175_1893 VGND VPWR sky130_fd_sc_hd__tapvpwrvgnd_1
XTAP_TAPCELL_ROW_171_1735 VGND VPWR sky130_fd_sc_hd__tapvpwrvgnd_1
XFILLER_220_1477 VGND VGND VPWR VPWR sky130_fd_sc_hd__decap_6
XTAP_TAPCELL_ROW_171_1746 VGND VPWR sky130_fd_sc_hd__tapvpwrvgnd_1
XTAP_TAPCELL_ROW_212_3167 VGND VPWR sky130_fd_sc_hd__tapvpwrvgnd_1
XFILLER_182_961 VGND VGND VPWR VPWR sky130_fd_sc_hd__decap_6
XTAP_TAPCELL_ROW_212_3178 VGND VPWR sky130_fd_sc_hd__tapvpwrvgnd_1
XTAP_TAPCELL_ROW_171_1757 VGND VPWR sky130_fd_sc_hd__tapvpwrvgnd_1
XTAP_TAPCELL_ROW_212_3189 VGND VPWR sky130_fd_sc_hd__tapvpwrvgnd_1
XFILLER_138_1349 VGND VGND VPWR VPWR sky130_fd_sc_hd__decap_6
XFILLER_173_1229 VPWR VGND VPWR VGND sky130_ef_sc_hd__decap_12
XFILLER_4_194 VGND VGND VPWR VPWR sky130_fd_sc_hd__fill_2
XFILLER_4_65 VPWR VGND VPWR VGND sky130_ef_sc_hd__decap_12
XFILLER_214_1226 VPWR VGND VPWR VGND sky130_ef_sc_hd__decap_12
XTAP_TAPCELL_ROW_169_1664 VGND VPWR sky130_fd_sc_hd__tapvpwrvgnd_1
XTAP_TAPCELL_ROW_165_1506 VGND VPWR sky130_fd_sc_hd__tapvpwrvgnd_1
XTAP_TAPCELL_ROW_169_1675 VGND VPWR sky130_fd_sc_hd__tapvpwrvgnd_1
XTAP_TAPCELL_ROW_165_1517 VGND VPWR sky130_fd_sc_hd__tapvpwrvgnd_1
XTAP_TAPCELL_ROW_169_1686 VGND VPWR sky130_fd_sc_hd__tapvpwrvgnd_1
XTAP_TAPCELL_ROW_165_1528 VGND VPWR sky130_fd_sc_hd__tapvpwrvgnd_1
XFILLER_62_1270 VPWR VGND VPWR VGND sky130_ef_sc_hd__decap_12
XFILLER_27_1390 VPWR VGND VPWR VGND sky130_ef_sc_hd__decap_12
XTAP_TAPCELL_ROW_165_1539 VGND VPWR sky130_fd_sc_hd__tapvpwrvgnd_1
XFILLER_191_80 VGND VGND VPWR VPWR sky130_fd_sc_hd__decap_6
XFILLER_237_940 VGND VGND VPWR VPWR sky130_fd_sc_hd__decap_6
XFILLER_3_1315 VPWR VGND VPWR VGND sky130_ef_sc_hd__decap_12
XFILLER_247_1002 VPWR VGND VPWR VGND sky130_ef_sc_hd__decap_12
XFILLER_208_163 VPWR VGND VPWR VGND sky130_ef_sc_hd__decap_12
XFILLER_58_1306 VGND VGND VPWR VPWR sky130_fd_sc_hd__decap_6
XFILLER_149_1445 VPWR VGND VPWR VGND sky130_ef_sc_hd__decap_12
XFILLER_223_111 VPWR VGND VPWR VGND sky130_ef_sc_hd__decap_12
XFILLER_251_431 VPWR VGND VPWR VGND sky130_ef_sc_hd__decap_12
XFILLER_184_1336 VPWR VGND VPWR VGND sky130_ef_sc_hd__decap_12
XFILLER_247_1057 VPWR VGND VPWR VGND sky130_ef_sc_hd__decap_12
XFILLER_224_667 VPWR VGND VPWR VGND sky130_ef_sc_hd__decap_12
XPHY_EDGE_ROW_133_2_Right_224 VGND VGND VPWR VPWR sky130_fd_sc_hd__decap_3
XFILLER_223_166 VGND VGND VPWR VPWR sky130_fd_sc_hd__decap_6
XFILLER_251_486 VPWR VGND VPWR VGND sky130_ef_sc_hd__decap_12
XFILLER_196_519 VPWR VGND VPWR VGND sky130_ef_sc_hd__decap_12
XFILLER_189_560 VPWR VGND VPWR VGND sky130_ef_sc_hd__decap_12
XFILLER_210_65 VPWR VGND VPWR VGND sky130_ef_sc_hd__decap_12
XFILLER_177_744 VPWR VGND VPWR VGND sky130_ef_sc_hd__decap_12
XFILLER_220_851 VPWR VGND VPWR VGND sky130_ef_sc_hd__decap_12
XFILLER_225_1377 VPWR VGND VPWR VGND sky130_ef_sc_hd__decap_12
XFILLER_192_703 VGND VGND VPWR VPWR sky130_fd_sc_hd__decap_6
XPHY_EDGE_ROW_153_2_Left_655 VGND VGND VPWR VPWR sky130_fd_sc_hd__decap_3
XFILLER_177_799 VPWR VGND VPWR VGND sky130_ef_sc_hd__decap_12
XFILLER_160_1380 VPWR VGND VPWR VGND sky130_ef_sc_hd__decap_12
XFILLER_69_1402 VPWR VGND VPWR VGND sky130_ef_sc_hd__decap_12
XTAP_TAPCELL_ROW_247_4410 VGND VPWR sky130_fd_sc_hd__tapvpwrvgnd_1
XFILLER_195_1432 VPWR VGND VPWR VGND sky130_ef_sc_hd__decap_12
XFILLER_69_1457 VGND VGND VPWR VPWR sky130_fd_sc_hd__decap_6
XFILLER_173_983 VGND VGND VPWR VPWR sky130_fd_sc_hd__decap_6
XTAP_TAPCELL_ROW_150_2_5863 VGND VPWR sky130_fd_sc_hd__tapvpwrvgnd_1
XTAP_TAPCELL_ROW_149_2_5857 VGND VPWR sky130_fd_sc_hd__tapvpwrvgnd_1
XFILLER_195_1487 VPWR VGND VPWR VGND sky130_ef_sc_hd__decap_12
XFILLER_236_1484 VPWR VGND VPWR VGND sky130_ef_sc_hd__decap_12
XFILLER_8_1226 VPWR VGND VPWR VGND sky130_ef_sc_hd__decap_12
XFILLER_28_1165 VPWR VGND VPWR VGND sky130_ef_sc_hd__decap_12
XTAP_TAPCELL_ROW_9_1210 VGND VPWR sky130_fd_sc_hd__tapvpwrvgnd_1
XTAP_TAPCELL_ROW_9_1221 VGND VPWR sky130_fd_sc_hd__tapvpwrvgnd_1
XFILLER_154_1184 VPWR VGND VPWR VGND sky130_ef_sc_hd__decap_12
XFILLER_232_1348 VGND VGND VPWR VPWR sky130_fd_sc_hd__decap_6
XTAP_TAPCELL_ROW_9_1232 VGND VPWR sky130_fd_sc_hd__tapvpwrvgnd_1
XTAP_TAPCELL_ROW_9_1243 VGND VPWR sky130_fd_sc_hd__tapvpwrvgnd_1
XFILLER_171_39 VGND VGND VPWR VPWR sky130_fd_sc_hd__decap_4
XFILLER_104_22 VPWR VGND VPWR VGND sky130_ef_sc_hd__decap_12
XFILLER_80_1392 VGND VGND VPWR VPWR sky130_fd_sc_hd__decap_6
XTAP_TAPCELL_ROW_111_2_5547 VGND VPWR sky130_fd_sc_hd__tapvpwrvgnd_1
XFILLER_234_409 VPWR VGND VPWR VGND sky130_ef_sc_hd__decap_12
XTAP_TAPCELL_ROW_181_2075 VGND VPWR sky130_fd_sc_hd__tapvpwrvgnd_1
XTAP_TAPCELL_ROW_181_2086 VGND VPWR sky130_fd_sc_hd__tapvpwrvgnd_1
XTAP_TAPCELL_ROW_181_2097 VGND VPWR sky130_fd_sc_hd__tapvpwrvgnd_1
XFILLER_199_302 VPWR VGND VPWR VGND sky130_ef_sc_hd__decap_12
XFILLER_254_280 VPWR VGND VPWR VGND sky130_ef_sc_hd__decap_12
XPHY_EDGE_ROW_6_Left_262 VGND VGND VPWR VPWR sky130_fd_sc_hd__decap_3
XFILLER_203_818 VPWR VGND VPWR VGND sky130_ef_sc_hd__decap_12
XFILLER_214_144 VGND VGND VPWR VPWR sky130_fd_sc_hd__decap_6
XFILLER_242_464 VPWR VGND VPWR VGND sky130_ef_sc_hd__decap_12
XFILLER_199_357 VPWR VGND VPWR VGND sky130_ef_sc_hd__decap_12
XFILLER_215_689 VPWR VGND VPWR VGND sky130_ef_sc_hd__decap_12
XFILLER_39_1261 VPWR VGND VPWR VGND sky130_ef_sc_hd__decap_12
XFILLER_126_1220 VGND VGND VPWR VPWR sky130_fd_sc_hd__decap_6
XFILLER_230_648 VPWR VGND VPWR VGND sky130_ef_sc_hd__decap_12
XFILLER_243_1444 VPWR VGND VPWR VGND sky130_ef_sc_hd__decap_12
XFILLER_120_65 VGND VGND VPWR VPWR sky130_fd_sc_hd__decap_6
XFILLER_168_722 VPWR VGND VPWR VGND sky130_ef_sc_hd__decap_12
XTAP_TAPCELL_ROW_14_2_4774 VGND VPWR sky130_fd_sc_hd__tapvpwrvgnd_1
XFILLER_74_1196 VPWR VGND VPWR VGND sky130_ef_sc_hd__decap_12
XFILLER_195_541 VPWR VGND VPWR VGND sky130_ef_sc_hd__decap_12
XFILLER_80_58 VGND VGND VPWR VPWR sky130_fd_sc_hd__decap_6
XPHY_EDGE_ROW_85_2_Left_587 VGND VGND VPWR VPWR sky130_fd_sc_hd__decap_3
XFILLER_211_873 VPWR VGND VPWR VGND sky130_ef_sc_hd__decap_12
XFILLER_243_1499 VGND VGND VPWR VPWR sky130_fd_sc_hd__decap_6
XTAP_TAPCELL_ROW_143_1_1444 VGND VPWR sky130_fd_sc_hd__tapvpwrvgnd_1
XFILLER_168_777 VPWR VGND VPWR VGND sky130_ef_sc_hd__decap_12
XFILLER_7_916 VPWR VGND VPWR VGND sky130_ef_sc_hd__decap_12
XFILLER_161_1177 VPWR VGND VPWR VGND sky130_ef_sc_hd__decap_12
XFILLER_196_58 VGND VGND VPWR VPWR sky130_fd_sc_hd__decap_6
XFILLER_183_725 VGND VGND VPWR VPWR sky130_fd_sc_hd__decap_6
XFILLER_195_596 VGND VGND VPWR VPWR sky130_fd_sc_hd__decap_6
XFILLER_196_1207 VPWR VGND VPWR VGND sky130_ef_sc_hd__decap_12
XFILLER_13_1445 VPWR VGND VPWR VGND sky130_ef_sc_hd__decap_12
XFILLER_202_1152 VPWR VGND VPWR VGND sky130_ef_sc_hd__decap_12
XFILLER_89_56 VPWR VGND VPWR VGND sky130_ef_sc_hd__decap_12
XTAP_TAPCELL_ROW_230_3790 VGND VPWR sky130_fd_sc_hd__tapvpwrvgnd_1
XFILLER_237_1248 VPWR VGND VPWR VGND sky130_ef_sc_hd__decap_12
XPHY_EDGE_ROW_33_1_Right_689 VGND VGND VPWR VPWR sky130_fd_sc_hd__decap_3
XFILLER_1_142 VPWR VGND VPWR VGND sky130_ef_sc_hd__decap_12
XFILLER_85_1292 VPWR VGND VPWR VGND sky130_ef_sc_hd__decap_12
XFILLER_137_1371 VGND VGND VPWR VPWR sky130_fd_sc_hd__decap_6
XFILLER_172_1262 VGND VGND VPWR VPWR sky130_fd_sc_hd__decap_6
XFILLER_1_186 VPWR VGND VPWR VGND sky130_ef_sc_hd__decap_12
XFILLER_81_1189 VPWR VGND VPWR VGND sky130_ef_sc_hd__decap_12
XFILLER_219_940 VGND VGND VPWR VPWR sky130_fd_sc_hd__decap_6
XFILLER_111_1500 VGND VGND VPWR VPWR sky130_fd_sc_hd__decap_6
XTAP_TAPCELL_ROW_224_3583 VGND VPWR sky130_fd_sc_hd__tapvpwrvgnd_1
XFILLER_252_206 VPWR VGND VPWR VGND sky130_ef_sc_hd__decap_12
XTAP_TAPCELL_ROW_224_3594 VGND VPWR sky130_fd_sc_hd__tapvpwrvgnd_1
XPHY_EDGE_ROW_99_1_Left_354 VGND VGND VPWR VPWR sky130_fd_sc_hd__decap_3
XTAP_TAPCELL_ROW_220_3447 VGND VPWR sky130_fd_sc_hd__tapvpwrvgnd_1
XTAP_TAPCELL_ROW_220_3458 VGND VPWR sky130_fd_sc_hd__tapvpwrvgnd_1
XFILLER_205_111 VPWR VGND VPWR VGND sky130_ef_sc_hd__decap_12
XTAP_TAPCELL_ROW_220_3469 VGND VPWR sky130_fd_sc_hd__tapvpwrvgnd_1
XFILLER_166_1011 VPWR VGND VPWR VGND sky130_ef_sc_hd__decap_12
XFILLER_233_431 VPWR VGND VPWR VGND sky130_ef_sc_hd__decap_12
XFILLER_248_1355 VPWR VGND VPWR VGND sky130_ef_sc_hd__decap_12
XFILLER_206_667 VPWR VGND VPWR VGND sky130_ef_sc_hd__decap_12
XFILLER_244_1219 VGND VGND VPWR VPWR sky130_fd_sc_hd__decap_6
X_517_ net516 net512 net80 net518 VGND VGND VPWR VPWR _267_ sky130_fd_sc_hd__o31a_1
XFILLER_205_166 VGND VGND VPWR VPWR sky130_fd_sc_hd__decap_6
XFILLER_221_615 VPWR VGND VPWR VGND sky130_ef_sc_hd__decap_12
XFILLER_166_1066 VPWR VGND VPWR VGND sky130_ef_sc_hd__decap_12
XFILLER_178_519 VPWR VGND VPWR VGND sky130_ef_sc_hd__decap_12
XFILLER_233_486 VPWR VGND VPWR VGND sky130_ef_sc_hd__decap_12
XFILLER_246_1090 VGND VGND VPWR VPWR sky130_fd_sc_hd__decap_6
XFILLER_92_1263 VGND VGND VPWR VPWR sky130_fd_sc_hd__decap_6
X_448_ _090_ net517 net513 net81 VGND VGND VPWR VPWR _237_ sky130_fd_sc_hd__or4_1
XFILLER_202_851 VPWR VGND VPWR VGND sky130_ef_sc_hd__decap_12
XFILLER_18_1356 VPWR VGND VPWR VGND sky130_ef_sc_hd__decap_12
XFILLER_105_1304 VPWR VGND VPWR VGND sky130_ef_sc_hd__decap_12
XTAP_TAPCELL_ROW_177_1944 VGND VPWR sky130_fd_sc_hd__tapvpwrvgnd_1
XFILLER_198_390 VPWR VGND VPWR VGND sky130_ef_sc_hd__decap_12
XTAP_TAPCELL_ROW_177_1955 VGND VPWR sky130_fd_sc_hd__tapvpwrvgnd_1
XTAP_TAPCELL_ROW_218_3376 VGND VPWR sky130_fd_sc_hd__tapvpwrvgnd_1
XTAP_TAPCELL_ROW_177_1966 VGND VPWR sky130_fd_sc_hd__tapvpwrvgnd_1
XTAP_TAPCELL_ROW_218_3387 VGND VPWR sky130_fd_sc_hd__tapvpwrvgnd_1
XTAP_TAPCELL_ROW_173_1808 VGND VPWR sky130_fd_sc_hd__tapvpwrvgnd_1
XFILLER_174_703 VGND VGND VPWR VPWR sky130_fd_sc_hd__decap_6
XTAP_TAPCELL_ROW_214_3229 VGND VPWR sky130_fd_sc_hd__tapvpwrvgnd_1
XTAP_TAPCELL_ROW_218_3398 VGND VPWR sky130_fd_sc_hd__tapvpwrvgnd_1
X_379_ net592 net580 net554 VGND VGND VPWR VPWR _168_ sky130_fd_sc_hd__a21oi_1
XFILLER_186_574 VGND VGND VPWR VPWR sky130_fd_sc_hd__decap_6
XFILLER_9_253 VPWR VGND VPWR VGND sky130_ef_sc_hd__decap_12
XTAP_TAPCELL_ROW_173_1819 VGND VPWR sky130_fd_sc_hd__tapvpwrvgnd_1
XFILLER_105_1359 VPWR VGND VPWR VGND sky130_ef_sc_hd__decap_12
XFILLER_140_1239 VPWR VGND VPWR VGND sky130_ef_sc_hd__decap_12
XTAP_TAPCELL_ROW_135_2_5743 VGND VPWR sky130_fd_sc_hd__tapvpwrvgnd_1
XTAP_TAPCELL_ROW_104_2_5490 VGND VPWR sky130_fd_sc_hd__tapvpwrvgnd_1
XFILLER_255_1315 VGND VGND VPWR VPWR sky130_fd_sc_hd__decap_8
XFILLER_55_3 VPWR VGND VPWR VGND sky130_ef_sc_hd__decap_12
XFILLER_177_1162 VPWR VGND VPWR VGND sky130_ef_sc_hd__decap_12
XFILLER_173_1026 VGND VGND VPWR VPWR sky130_fd_sc_hd__decap_6
XFILLER_9_1513 VGND VGND VPWR VPWR sky130_fd_sc_hd__fill_2
XFILLER_116_1411 VPWR VGND VPWR VGND sky130_ef_sc_hd__decap_12
XFILLER_25_1316 VPWR VGND VPWR VGND sky130_ef_sc_hd__decap_12
XFILLER_214_1023 VPWR VGND VPWR VGND sky130_ef_sc_hd__decap_12
XTAP_TAPCELL_ROW_53_2_5087 VGND VPWR sky130_fd_sc_hd__tapvpwrvgnd_1
XTAP_TAPCELL_ROW_73_1_1339 VGND VPWR sky130_fd_sc_hd__tapvpwrvgnd_1
XPHY_EDGE_ROW_224_Right_69 VGND VGND VPWR VPWR sky130_fd_sc_hd__decap_3
XFILLER_151_1335 VPWR VGND VPWR VGND sky130_ef_sc_hd__decap_12
XFILLER_116_1466 VPWR VGND VPWR VGND sky130_ef_sc_hd__decap_12
XFILLER_214_1078 VPWR VGND VPWR VGND sky130_ef_sc_hd__decap_12
XFILLER_205_87 VPWR VGND VPWR VGND sky130_ef_sc_hd__decap_12
XFILLER_3_1112 VGND VGND VPWR VPWR sky130_fd_sc_hd__decap_6
XFILLER_231_1370 VGND VGND VPWR VPWR sky130_fd_sc_hd__decap_6
XFILLER_249_1119 VPWR VGND VPWR VGND sky130_ef_sc_hd__decap_12
XFILLER_216_409 VPWR VGND VPWR VGND sky130_ef_sc_hd__decap_12
XFILLER_243_228 VPWR VGND VPWR VGND sky130_ef_sc_hd__decap_12
XTAP_TAPCELL_ROW_255_4701 VGND VPWR sky130_fd_sc_hd__tapvpwrvgnd_1
XFILLER_236_280 VPWR VGND VPWR VGND sky130_ef_sc_hd__decap_12
XTAP_TAPCELL_ROW_255_4712 VGND VPWR sky130_fd_sc_hd__tapvpwrvgnd_1
XTAP_TAPCELL_ROW_255_4723 VGND VPWR sky130_fd_sc_hd__tapvpwrvgnd_1
XFILLER_149_1242 VGND VGND VPWR VPWR sky130_fd_sc_hd__decap_6
XTAP_TAPCELL_ROW_255_4734 VGND VPWR sky130_fd_sc_hd__tapvpwrvgnd_1
XTAP_TAPCELL_ROW_31_2_4913 VGND VPWR sky130_fd_sc_hd__tapvpwrvgnd_1
XFILLER_184_1133 VGND VGND VPWR VPWR sky130_fd_sc_hd__decap_6
XFILLER_224_464 VPWR VGND VPWR VGND sky130_ef_sc_hd__decap_12
XFILLER_251_283 VPWR VGND VPWR VGND sky130_ef_sc_hd__decap_12
XFILLER_196_316 VGND VGND VPWR VPWR sky130_fd_sc_hd__decap_6
XFILLER_212_648 VPWR VGND VPWR VGND sky130_ef_sc_hd__decap_12
XFILLER_240_968 VPWR VGND VPWR VGND sky130_ef_sc_hd__decap_12
XFILLER_36_1423 VPWR VGND VPWR VGND sky130_ef_sc_hd__decap_12
XPHY_EDGE_ROW_134_2_Right_225 VGND VGND VPWR VPWR sky130_fd_sc_hd__decap_3
XFILLER_162_1442 VPWR VGND VPWR VGND sky130_ef_sc_hd__decap_12
XPHY_EDGE_ROW_233_Right_78 VGND VGND VPWR VPWR sky130_fd_sc_hd__decap_3
XFILLER_177_541 VPWR VGND VPWR VGND sky130_ef_sc_hd__decap_12
XFILLER_225_1174 VPWR VGND VPWR VGND sky130_ef_sc_hd__decap_12
XFILLER_71_1347 VPWR VGND VPWR VGND sky130_ef_sc_hd__decap_12
XFILLER_36_1478 VGND VGND VPWR VPWR sky130_fd_sc_hd__decap_6
Xclkload6 clknet_3_7__leaf_clk VGND VGND VPWR VPWR clkload6/Y sky130_fd_sc_hd__inv_8
XFILLER_162_1497 VPWR VGND VPWR VGND sky130_ef_sc_hd__decap_12
XFILLER_165_736 VPWR VGND VPWR VGND sky130_ef_sc_hd__decap_12
XFILLER_177_596 VGND VGND VPWR VPWR sky130_fd_sc_hd__decap_6
XFILLER_165_769 VGND VGND VPWR VPWR sky130_fd_sc_hd__decap_8
XFILLER_3_429 VGND VGND VPWR VPWR sky130_fd_sc_hd__fill_1
XFILLER_59_15 VPWR VGND VPWR VGND sky130_ef_sc_hd__decap_12
XFILLER_195_1284 VGND VGND VPWR VPWR sky130_fd_sc_hd__decap_6
XPHY_EDGE_ROW_242_Right_87 VGND VGND VPWR VPWR sky130_fd_sc_hd__decap_3
XFILLER_82_1454 VPWR VGND VPWR VGND sky130_ef_sc_hd__decap_12
XTAP_TAPCELL_ROW_187_2284 VGND VPWR sky130_fd_sc_hd__tapvpwrvgnd_1
XFILLER_236_1281 VPWR VGND VPWR VGND sky130_ef_sc_hd__decap_12
XFILLER_8_1023 VPWR VGND VPWR VGND sky130_ef_sc_hd__decap_12
XTAP_TAPCELL_ROW_187_2295 VGND VPWR sky130_fd_sc_hd__tapvpwrvgnd_1
XTAP_TAPCELL_ROW_183_2148 VGND VPWR sky130_fd_sc_hd__tapvpwrvgnd_1
XTAP_TAPCELL_ROW_183_2159 VGND VPWR sky130_fd_sc_hd__tapvpwrvgnd_1
XFILLER_8_1078 VPWR VGND VPWR VGND sky130_ef_sc_hd__decap_12
XFILLER_210_1410 VPWR VGND VPWR VGND sky130_ef_sc_hd__decap_12
XFILLER_189_1033 VPWR VGND VPWR VGND sky130_ef_sc_hd__decap_12
XFILLER_234_206 VPWR VGND VPWR VGND sky130_ef_sc_hd__decap_12
XTAP_TAPCELL_ROW_3_974 VGND VPWR sky130_fd_sc_hd__tapvpwrvgnd_1
XFILLER_210_1465 VPWR VGND VPWR VGND sky130_ef_sc_hd__decap_12
XTAP_TAPCELL_ROW_3_985 VGND VPWR sky130_fd_sc_hd__tapvpwrvgnd_1
XFILLER_189_1088 VPWR VGND VPWR VGND sky130_ef_sc_hd__decap_12
XTAP_TAPCELL_ROW_3_996 VGND VPWR sky130_fd_sc_hd__tapvpwrvgnd_1
XFILLER_215_431 VPWR VGND VPWR VGND sky130_ef_sc_hd__decap_12
XFILLER_245_1506 VGND VGND VPWR VPWR sky130_fd_sc_hd__decap_8
XFILLER_242_261 VPWR VGND VPWR VGND sky130_ef_sc_hd__decap_12
XFILLER_163_1206 VPWR VGND VPWR VGND sky130_ef_sc_hd__decap_12
XFILLER_203_615 VPWR VGND VPWR VGND sky130_ef_sc_hd__decap_12
XFILLER_128_1337 VPWR VGND VPWR VGND sky130_ef_sc_hd__decap_12
XFILLER_199_154 VPWR VGND VPWR VGND sky130_ef_sc_hd__decap_12
XFILLER_215_486 VPWR VGND VPWR VGND sky130_ef_sc_hd__decap_12
XPHY_EDGE_ROW_251_Right_96 VGND VGND VPWR VPWR sky130_fd_sc_hd__decap_3
XTAP_TAPCELL_ROW_141_2_5786 VGND VPWR sky130_fd_sc_hd__tapvpwrvgnd_1
XFILLER_188_839 VPWR VGND VPWR VGND sky130_ef_sc_hd__decap_12
X_302_ net596 dout0_q\[29\] net527 VGND VGND VPWR VPWR _091_ sky130_fd_sc_hd__and3_1
XFILLER_91_68 VGND VGND VPWR VPWR sky130_fd_sc_hd__decap_3
XFILLER_187_338 VGND VGND VPWR VPWR sky130_fd_sc_hd__decap_6
XFILLER_230_445 VGND VGND VPWR VPWR sky130_fd_sc_hd__decap_6
XFILLER_243_1241 VGND VGND VPWR VPWR sky130_fd_sc_hd__decap_6
XFILLER_15_1507 VGND VGND VPWR VPWR sky130_fd_sc_hd__decap_8
XFILLER_211_670 VPWR VGND VPWR VGND sky130_ef_sc_hd__decap_12
Xwire600 net601 VGND VGND VPWR VPWR net600 sky130_fd_sc_hd__clkbuf_1
XFILLER_168_574 VGND VGND VPWR VPWR sky130_fd_sc_hd__decap_6
XFILLER_196_894 VPWR VGND VPWR VGND sky130_ef_sc_hd__decap_12
Xwire622 net623 VGND VGND VPWR VPWR net622 sky130_fd_sc_hd__buf_1
XFILLER_204_1269 VPWR VGND VPWR VGND sky130_ef_sc_hd__decap_12
Xwire633 net36 VGND VGND VPWR VPWR net633 sky130_fd_sc_hd__buf_1
Xwire644 net27 VGND VGND VPWR VPWR net644 sky130_fd_sc_hd__buf_1
XFILLER_196_1004 VGND VGND VPWR VPWR sky130_fd_sc_hd__decap_6
Xwire655 net18 VGND VGND VPWR VPWR net655 sky130_fd_sc_hd__buf_1
XTAP_TAPCELL_ROW_232_3863 VGND VPWR sky130_fd_sc_hd__tapvpwrvgnd_1
XFILLER_13_1242 VGND VGND VPWR VPWR sky130_fd_sc_hd__decap_6
XTAP_TAPCELL_ROW_232_3874 VGND VPWR sky130_fd_sc_hd__tapvpwrvgnd_1
XTAP_TAPCELL_ROW_232_3885 VGND VPWR sky130_fd_sc_hd__tapvpwrvgnd_1
XFILLER_104_1392 VGND VGND VPWR VPWR sky130_fd_sc_hd__decap_6
XFILLER_139_1433 VPWR VGND VPWR VGND sky130_ef_sc_hd__decap_12
XFILLER_170_249 VPWR VGND VPWR VGND sky130_ef_sc_hd__decap_12
XFILLER_174_1324 VPWR VGND VPWR VGND sky130_ef_sc_hd__decap_12
XFILLER_83_1218 VPWR VGND VPWR VGND sky130_ef_sc_hd__decap_12
XFILLER_237_1045 VPWR VGND VPWR VGND sky130_ef_sc_hd__decap_12
XFILLER_48_1349 VGND VGND VPWR VPWR sky130_fd_sc_hd__decap_6
XFILLER_139_1488 VPWR VGND VPWR VGND sky130_ef_sc_hd__decap_12
XFILLER_174_1379 VPWR VGND VPWR VGND sky130_ef_sc_hd__decap_12
XTAP_TAPCELL_ROW_207_3000 VGND VPWR sky130_fd_sc_hd__tapvpwrvgnd_1
XTAP_TAPCELL_ROW_207_3011 VGND VPWR sky130_fd_sc_hd__tapvpwrvgnd_1
XTAP_TAPCELL_ROW_226_3656 VGND VPWR sky130_fd_sc_hd__tapvpwrvgnd_1
XTAP_TAPCELL_ROW_226_3667 VGND VPWR sky130_fd_sc_hd__tapvpwrvgnd_1
XTAP_TAPCELL_ROW_222_3509 VGND VPWR sky130_fd_sc_hd__tapvpwrvgnd_1
XTAP_TAPCELL_ROW_226_3678 VGND VPWR sky130_fd_sc_hd__tapvpwrvgnd_1
XFILLER_1_11 VPWR VGND VPWR VGND sky130_ef_sc_hd__decap_12
XFILLER_211_1229 VPWR VGND VPWR VGND sky130_ef_sc_hd__decap_12
XFILLER_4_1410 VPWR VGND VPWR VGND sky130_ef_sc_hd__decap_12
XFILLER_1_44 VPWR VGND VPWR VGND sky130_ef_sc_hd__decap_12
XFILLER_225_228 VPWR VGND VPWR VGND sky130_ef_sc_hd__decap_12
XFILLER_4_1465 VPWR VGND VPWR VGND sky130_ef_sc_hd__decap_12
XFILLER_218_280 VPWR VGND VPWR VGND sky130_ef_sc_hd__decap_12
XFILLER_185_1420 VPWR VGND VPWR VGND sky130_ef_sc_hd__decap_12
XFILLER_248_1152 VPWR VGND VPWR VGND sky130_ef_sc_hd__decap_12
XFILLER_59_1445 VPWR VGND VPWR VGND sky130_ef_sc_hd__decap_12
XFILLER_94_1325 VPWR VGND VPWR VGND sky130_ef_sc_hd__decap_12
XFILLER_206_464 VPWR VGND VPWR VGND sky130_ef_sc_hd__decap_12
XFILLER_185_1475 VPWR VGND VPWR VGND sky130_ef_sc_hd__decap_12
XFILLER_221_412 VPWR VGND VPWR VGND sky130_ef_sc_hd__decap_12
XFILLER_178_316 VGND VGND VPWR VPWR sky130_fd_sc_hd__decap_6
XFILLER_233_283 VPWR VGND VPWR VGND sky130_ef_sc_hd__decap_12
XFILLER_222_968 VPWR VGND VPWR VGND sky130_ef_sc_hd__decap_12
XFILLER_221_467 VGND VGND VPWR VPWR sky130_fd_sc_hd__decap_6
XFILLER_187_861 VPWR VGND VPWR VGND sky130_ef_sc_hd__decap_12
XFILLER_222_1336 VPWR VGND VPWR VGND sky130_ef_sc_hd__decap_12
XFILLER_109_1292 VPWR VGND VPWR VGND sky130_ef_sc_hd__decap_12
XFILLER_70_1380 VPWR VGND VPWR VGND sky130_ef_sc_hd__decap_12
XFILLER_105_1189 VPWR VGND VPWR VGND sky130_ef_sc_hd__decap_12
XFILLER_157_1500 VGND VGND VPWR VPWR sky130_fd_sc_hd__decap_6
XFILLER_255_1156 VPWR VGND VPWR VGND sky130_ef_sc_hd__decap_12
XFILLER_255_1189 VGND VGND VPWR VPWR sky130_fd_sc_hd__decap_8
XFILLER_233_1432 VPWR VGND VPWR VGND sky130_ef_sc_hd__decap_12
XFILLER_64_1184 VPWR VGND VPWR VGND sky130_ef_sc_hd__decap_12
XFILLER_9_1387 VPWR VGND VPWR VGND sky130_ef_sc_hd__decap_12
XFILLER_116_1263 VGND VGND VPWR VPWR sky130_fd_sc_hd__decap_6
XFILLER_5_1229 VPWR VGND VPWR VGND sky130_ef_sc_hd__decap_12
XFILLER_233_1487 VPWR VGND VPWR VGND sky130_ef_sc_hd__decap_12
XFILLER_151_1165 VPWR VGND VPWR VGND sky130_ef_sc_hd__decap_12
XFILLER_216_206 VPWR VGND VPWR VGND sky130_ef_sc_hd__decap_12
XTAP_TAPCELL_ROW_157_2_5919 VGND VPWR sky130_fd_sc_hd__tapvpwrvgnd_1
XFILLER_45_39 VGND VGND VPWR VPWR sky130_fd_sc_hd__decap_4
XTAP_TAPCELL_ROW_126_2_5666 VGND VPWR sky130_fd_sc_hd__tapvpwrvgnd_1
XTAP_TAPCELL_ROW_94_2_5411 VGND VPWR sky130_fd_sc_hd__tapvpwrvgnd_1
XFILLER_231_209 VGND VGND VPWR VPWR sky130_fd_sc_hd__decap_6
XFILLER_197_603 VPWR VGND VPWR VGND sky130_ef_sc_hd__decap_12
XFILLER_224_261 VPWR VGND VPWR VGND sky130_ef_sc_hd__decap_12
XFILLER_240_710 VPWR VGND VPWR VGND sky130_ef_sc_hd__decap_12
XFILLER_252_581 VPWR VGND VPWR VGND sky130_ef_sc_hd__decap_12
XFILLER_36_1220 VGND VGND VPWR VPWR sky130_fd_sc_hd__decap_6
XFILLER_101_56 VPWR VGND VPWR VGND sky130_ef_sc_hd__decap_12
XFILLER_169_338 VGND VGND VPWR VPWR sky130_fd_sc_hd__decap_6
XFILLER_212_445 VGND VGND VPWR VPWR sky130_fd_sc_hd__decap_6
XFILLER_240_765 VPWR VGND VPWR VGND sky130_ef_sc_hd__decap_12
XFILLER_197_658 VPWR VGND VPWR VGND sky130_ef_sc_hd__decap_12
XFILLER_61_27 VPWR VGND VPWR VGND sky130_ef_sc_hd__decap_12
XTAP_TAPCELL_ROW_195_2564 VGND VPWR sky130_fd_sc_hd__tapvpwrvgnd_1
XTAP_TAPCELL_ROW_195_2575 VGND VPWR sky130_fd_sc_hd__tapvpwrvgnd_1
XFILLER_123_1201 VGND VGND VPWR VPWR sky130_fd_sc_hd__decap_4
XTAP_TAPCELL_ROW_195_2586 VGND VPWR sky130_fd_sc_hd__tapvpwrvgnd_1
XPHY_EDGE_ROW_135_2_Right_226 VGND VGND VPWR VPWR sky130_fd_sc_hd__decap_3
XTAP_TAPCELL_ROW_191_2428 VGND VPWR sky130_fd_sc_hd__tapvpwrvgnd_1
XFILLER_177_27 VPWR VGND VPWR VGND sky130_ef_sc_hd__decap_12
XTAP_TAPCELL_ROW_195_2597 VGND VPWR sky130_fd_sc_hd__tapvpwrvgnd_1
XFILLER_221_990 VPWR VGND VPWR VGND sky130_ef_sc_hd__decap_12
XTAP_TAPCELL_ROW_191_2439 VGND VPWR sky130_fd_sc_hd__tapvpwrvgnd_1
XFILLER_178_894 VPWR VGND VPWR VGND sky130_ef_sc_hd__decap_12
XFILLER_71_1177 VPWR VGND VPWR VGND sky130_ef_sc_hd__decap_12
XTAP_TAPCELL_ROW_29_2_4893 VGND VPWR sky130_fd_sc_hd__tapvpwrvgnd_1
XFILLER_162_1294 VPWR VGND VPWR VGND sky130_ef_sc_hd__decap_12
XFILLER_193_842 VPWR VGND VPWR VGND sky130_ef_sc_hd__decap_12
XFILLER_197_1346 VPWR VGND VPWR VGND sky130_ef_sc_hd__decap_12
XFILLER_193_897 VGND VGND VPWR VPWR sky130_fd_sc_hd__decap_6
XFILLER_203_1291 VPWR VGND VPWR VGND sky130_ef_sc_hd__decap_12
XFILLER_193_15 VPWR VGND VPWR VGND sky130_ef_sc_hd__decap_12
XFILLER_3_237 VGND VGND VPWR VPWR sky130_fd_sc_hd__decap_8
XPHY_EDGE_ROW_116_2_Left_618 VGND VGND VPWR VPWR sky130_fd_sc_hd__decap_3
XTAP_TAPCELL_ROW_189_2357 VGND VPWR sky130_fd_sc_hd__tapvpwrvgnd_1
XFILLER_3_259 VGND VGND VPWR VPWR sky130_fd_sc_hd__fill_2
XTAP_TAPCELL_ROW_189_2368 VGND VPWR sky130_fd_sc_hd__tapvpwrvgnd_1
XFILLER_234_1207 VPWR VGND VPWR VGND sky130_ef_sc_hd__decap_12
XTAP_TAPCELL_ROW_189_2379 VGND VPWR sky130_fd_sc_hd__tapvpwrvgnd_1
XTAP_TAPCELL_ROW_22_2_4836 VGND VPWR sky130_fd_sc_hd__tapvpwrvgnd_1
XFILLER_238_1398 VPWR VGND VPWR VGND sky130_ef_sc_hd__decap_12
XFILLER_0_922 VGND VGND VPWR VPWR sky130_fd_sc_hd__fill_2
XFILLER_47_1371 VGND VGND VPWR VPWR sky130_fd_sc_hd__decap_6
XFILLER_82_1251 VPWR VGND VPWR VGND sky130_ef_sc_hd__decap_12
XFILLER_248_832 VGND VGND VPWR VPWR sky130_fd_sc_hd__decap_6
XFILLER_86_46 VPWR VGND VPWR VGND sky130_ef_sc_hd__decap_12
XTAP_TAPCELL_ROW_43_1_1294 VGND VPWR sky130_fd_sc_hd__tapvpwrvgnd_1
XFILLER_0_988 VPWR VGND VPWR VGND sky130_ef_sc_hd__decap_12
XFILLER_21_1500 VGND VGND VPWR VPWR sky130_fd_sc_hd__decap_6
XFILLER_130_1227 VPWR VGND VPWR VGND sky130_ef_sc_hd__decap_12
XFILLER_207_228 VPWR VGND VPWR VGND sky130_ef_sc_hd__decap_12
XFILLER_210_1262 VGND VGND VPWR VPWR sky130_fd_sc_hd__decap_6
XTAP_TAPCELL_ROW_131_1_1426 VGND VPWR sky130_fd_sc_hd__tapvpwrvgnd_1
XFILLER_250_507 VPWR VGND VPWR VGND sky130_ef_sc_hd__decap_12
XFILLER_245_1303 VPWR VGND VPWR VGND sky130_ef_sc_hd__decap_12
XFILLER_203_412 VPWR VGND VPWR VGND sky130_ef_sc_hd__decap_12
XFILLER_231_732 VPWR VGND VPWR VGND sky130_ef_sc_hd__decap_12
XFILLER_215_283 VPWR VGND VPWR VGND sky130_ef_sc_hd__decap_12
XFILLER_245_1358 VPWR VGND VPWR VGND sky130_ef_sc_hd__decap_12
XFILLER_188_636 VPWR VGND VPWR VGND sky130_ef_sc_hd__decap_12
XFILLER_204_968 VPWR VGND VPWR VGND sky130_ef_sc_hd__decap_12
XFILLER_203_467 VGND VGND VPWR VPWR sky130_fd_sc_hd__decap_6
XFILLER_169_861 VPWR VGND VPWR VGND sky130_ef_sc_hd__decap_12
XFILLER_231_787 VPWR VGND VPWR VGND sky130_ef_sc_hd__decap_12
XPHY_EDGE_ROW_239_Left_494 VGND VGND VPWR VPWR sky130_fd_sc_hd__decap_3
XFILLER_15_1304 VPWR VGND VPWR VGND sky130_ef_sc_hd__decap_12
XFILLER_204_1011 VPWR VGND VPWR VGND sky130_ef_sc_hd__decap_12
XTAP_TAPCELL_ROW_234_3936 VGND VPWR sky130_fd_sc_hd__tapvpwrvgnd_1
XTAP_TAPCELL_ROW_234_3947 VGND VPWR sky130_fd_sc_hd__tapvpwrvgnd_1
XFILLER_184_820 VPWR VGND VPWR VGND sky130_ef_sc_hd__decap_12
XTAP_TAPCELL_ROW_234_3958 VGND VPWR sky130_fd_sc_hd__tapvpwrvgnd_1
XFILLER_106_1454 VPWR VGND VPWR VGND sky130_ef_sc_hd__decap_12
XFILLER_196_691 VPWR VGND VPWR VGND sky130_ef_sc_hd__decap_12
XFILLER_50_1239 VPWR VGND VPWR VGND sky130_ef_sc_hd__decap_12
XFILLER_15_1359 VPWR VGND VPWR VGND sky130_ef_sc_hd__decap_12
Xwire430 net431 VGND VGND VPWR VPWR net430 sky130_fd_sc_hd__clkbuf_1
XFILLER_204_1066 VPWR VGND VPWR VGND sky130_ef_sc_hd__decap_12
Xwire441 net442 VGND VGND VPWR VPWR net441 sky130_fd_sc_hd__clkbuf_1
XFILLER_141_1378 VPWR VGND VPWR VGND sky130_ef_sc_hd__decap_12
Xwire452 net453 VGND VGND VPWR VPWR net452 sky130_fd_sc_hd__clkbuf_1
XFILLER_184_875 VGND VGND VPWR VPWR sky130_fd_sc_hd__decap_6
Xwire463 net464 VGND VGND VPWR VPWR net463 sky130_fd_sc_hd__clkbuf_1
Xwire474 net475 VGND VGND VPWR VPWR net474 sky130_fd_sc_hd__clkbuf_1
Xmax_cap207 _183_ VGND VGND VPWR VPWR net207 sky130_fd_sc_hd__clkbuf_1
Xwire485 net486 VGND VGND VPWR VPWR net485 sky130_fd_sc_hd__clkbuf_1
Xmax_cap218 _165_ VGND VGND VPWR VPWR net218 sky130_fd_sc_hd__clkbuf_1
XFILLER_139_1230 VPWR VGND VPWR VGND sky130_ef_sc_hd__decap_12
XFILLER_174_1121 VPWR VGND VPWR VGND sky130_ef_sc_hd__decap_12
XTAP_TAPCELL_ROW_228_3729 VGND VPWR sky130_fd_sc_hd__tapvpwrvgnd_1
XFILLER_3_760 VGND VGND VPWR VPWR sky130_fd_sc_hd__fill_1
XFILLER_139_1285 VGND VGND VPWR VPWR sky130_fd_sc_hd__decap_6
XFILLER_174_1176 VGND VGND VPWR VPWR sky130_fd_sc_hd__decap_6
XFILLER_26_1411 VPWR VGND VPWR VGND sky130_ef_sc_hd__decap_12
XFILLER_2_292 VPWR VGND VPWR VGND sky130_ef_sc_hd__decap_12
XFILLER_61_1335 VPWR VGND VPWR VGND sky130_ef_sc_hd__decap_12
XFILLER_215_1162 VPWR VGND VPWR VGND sky130_ef_sc_hd__decap_12
XFILLER_239_854 VGND VGND VPWR VPWR sky130_fd_sc_hd__decap_6
XFILLER_26_1466 VPWR VGND VPWR VGND sky130_ef_sc_hd__decap_12
XFILLER_113_1414 VGND VGND VPWR VPWR sky130_fd_sc_hd__decap_6
XTAP_TAPCELL_ROW_143_2_5805 VGND VPWR sky130_fd_sc_hd__tapvpwrvgnd_1
XFILLER_211_1026 VGND VGND VPWR VPWR sky130_fd_sc_hd__decap_6
XFILLER_152_1485 VPWR VGND VPWR VGND sky130_ef_sc_hd__decap_12
XFILLER_18_3 VPWR VGND VPWR VGND sky130_ef_sc_hd__decap_12
XFILLER_250_1097 VPWR VGND VPWR VGND sky130_ef_sc_hd__decap_12
XPHY_EDGE_ROW_162_2_Left_664 VGND VGND VPWR VPWR sky130_fd_sc_hd__decap_3
XFILLER_4_1262 VGND VGND VPWR VPWR sky130_fd_sc_hd__decap_6
XFILLER_253_345 VPWR VGND VPWR VGND sky130_ef_sc_hd__decap_12
XFILLER_202_22 VPWR VGND VPWR VGND sky130_ef_sc_hd__decap_12
XFILLER_0_1126 VGND VGND VPWR VPWR sky130_fd_sc_hd__decap_8
XFILLER_59_1242 VGND VGND VPWR VPWR sky130_fd_sc_hd__decap_6
XFILLER_213_209 VGND VGND VPWR VPWR sky130_fd_sc_hd__decap_6
XFILLER_241_529 VPWR VGND VPWR VGND sky130_ef_sc_hd__decap_12
XFILLER_222_710 VPWR VGND VPWR VGND sky130_ef_sc_hd__decap_12
XFILLER_179_603 VPWR VGND VPWR VGND sky130_ef_sc_hd__decap_12
XFILLER_206_261 VPWR VGND VPWR VGND sky130_ef_sc_hd__decap_12
XFILLER_202_77 VPWR VGND VPWR VGND sky130_ef_sc_hd__decap_12
XFILLER_234_581 VPWR VGND VPWR VGND sky130_ef_sc_hd__decap_12
XFILLER_185_1272 VPWR VGND VPWR VGND sky130_ef_sc_hd__decap_12
XFILLER_94_1177 VGND VGND VPWR VPWR sky130_fd_sc_hd__decap_6
XTAP_TAPCELL_ROW_61_2_5149 VGND VPWR sky130_fd_sc_hd__tapvpwrvgnd_1
XFILLER_222_765 VPWR VGND VPWR VGND sky130_ef_sc_hd__decap_12
XFILLER_107_1218 VPWR VGND VPWR VGND sky130_ef_sc_hd__decap_12
XFILLER_179_658 VPWR VGND VPWR VGND sky130_ef_sc_hd__decap_12
XFILLER_72_1442 VPWR VGND VPWR VGND sky130_ef_sc_hd__decap_12
XFILLER_194_617 VGND VGND VPWR VPWR sky130_fd_sc_hd__decap_6
XFILLER_210_949 VPWR VGND VPWR VGND sky130_ef_sc_hd__decap_12
XFILLER_203_990 VPWR VGND VPWR VGND sky130_ef_sc_hd__decap_12
XPHY_EDGE_ROW_114_1_Left_369 VGND VGND VPWR VPWR sky130_fd_sc_hd__decap_3
XFILLER_222_1133 VGND VGND VPWR VPWR sky130_fd_sc_hd__decap_6
XFILLER_72_1497 VPWR VGND VPWR VGND sky130_ef_sc_hd__decap_12
XFILLER_175_842 VPWR VGND VPWR VGND sky130_ef_sc_hd__decap_12
XTAP_TAPCELL_ROW_250_4494 VGND VPWR sky130_fd_sc_hd__tapvpwrvgnd_1
XFILLER_175_897 VGND VGND VPWR VPWR sky130_fd_sc_hd__decap_6
XFILLER_194_1508 VGND VGND VPWR VPWR sky130_fd_sc_hd__decap_6
XPHY_EDGE_ROW_51_1_Left_306 VGND VGND VPWR VPWR sky130_fd_sc_hd__decap_3
XFILLER_200_1453 VPWR VGND VPWR VGND sky130_ef_sc_hd__decap_12
XFILLER_179_1076 VPWR VGND VPWR VGND sky130_ef_sc_hd__decap_12
XFILLER_118_1325 VPWR VGND VPWR VGND sky130_ef_sc_hd__decap_12
XTAP_TAPCELL_ROW_184_2210 VGND VPWR sky130_fd_sc_hd__tapvpwrvgnd_1
XFILLER_153_1249 VPWR VGND VPWR VGND sky130_ef_sc_hd__decap_12
XTAP_TAPCELL_ROW_244_4287 VGND VPWR sky130_fd_sc_hd__tapvpwrvgnd_1
XTAP_TAPCELL_ROW_244_4298 VGND VPWR sky130_fd_sc_hd__tapvpwrvgnd_1
XFILLER_233_1284 VGND VGND VPWR VPWR sky130_fd_sc_hd__decap_6
XFILLER_5_1026 VGND VGND VPWR VPWR sky130_fd_sc_hd__decap_6
XPHY_EDGE_ROW_94_2_Left_596 VGND VGND VPWR VPWR sky130_fd_sc_hd__decap_3
XFILLER_244_323 VPWR VGND VPWR VGND sky130_ef_sc_hd__decap_12
XTAP_TAPCELL_ROW_6_1076 VGND VPWR sky130_fd_sc_hd__tapvpwrvgnd_1
XFILLER_112_22 VPWR VGND VPWR VGND sky130_ef_sc_hd__decap_12
XFILLER_186_1047 VGND VGND VPWR VPWR sky130_fd_sc_hd__decap_6
XTAP_TAPCELL_ROW_6_1087 VGND VPWR sky130_fd_sc_hd__tapvpwrvgnd_1
XFILLER_232_507 VPWR VGND VPWR VGND sky130_ef_sc_hd__decap_12
XFILLER_244_378 VPWR VGND VPWR VGND sky130_ef_sc_hd__decap_12
XTAP_TAPCELL_ROW_6_1098 VGND VPWR sky130_fd_sc_hd__tapvpwrvgnd_1
XTAP_TAPCELL_ROW_178_2003 VGND VPWR sky130_fd_sc_hd__tapvpwrvgnd_1
XFILLER_72_15 VGND VGND VPWR VPWR sky130_fd_sc_hd__decap_6
XFILLER_129_1421 VPWR VGND VPWR VGND sky130_ef_sc_hd__decap_12
XTAP_TAPCELL_ROW_197_2637 VGND VPWR sky130_fd_sc_hd__tapvpwrvgnd_1
XTAP_TAPCELL_ROW_197_2648 VGND VPWR sky130_fd_sc_hd__tapvpwrvgnd_1
XTAP_TAPCELL_ROW_238_4069 VGND VPWR sky130_fd_sc_hd__tapvpwrvgnd_1
XFILLER_73_1206 VPWR VGND VPWR VGND sky130_ef_sc_hd__decap_12
XFILLER_197_400 VPWR VGND VPWR VGND sky130_ef_sc_hd__decap_12
XFILLER_213_732 VPWR VGND VPWR VGND sky130_ef_sc_hd__decap_12
XFILLER_227_1033 VPWR VGND VPWR VGND sky130_ef_sc_hd__decap_12
XTAP_TAPCELL_ROW_197_2659 VGND VPWR sky130_fd_sc_hd__tapvpwrvgnd_1
XFILLER_38_1337 VPWR VGND VPWR VGND sky130_ef_sc_hd__decap_12
XFILLER_188_15 VGND VGND VPWR VPWR sky130_fd_sc_hd__decap_6
XFILLER_129_1476 VPWR VGND VPWR VGND sky130_ef_sc_hd__decap_12
XFILLER_164_1356 VPWR VGND VPWR VGND sky130_ef_sc_hd__decap_12
XFILLER_201_916 VPWR VGND VPWR VGND sky130_ef_sc_hd__decap_12
XFILLER_240_562 VPWR VGND VPWR VGND sky130_ef_sc_hd__decap_12
XFILLER_197_455 VPWR VGND VPWR VGND sky130_ef_sc_hd__decap_12
XFILLER_213_787 VPWR VGND VPWR VGND sky130_ef_sc_hd__decap_12
XFILLER_227_1088 VPWR VGND VPWR VGND sky130_ef_sc_hd__decap_12
XFILLER_244_1391 VGND VGND VPWR VPWR sky130_fd_sc_hd__decap_6
XFILLER_8_307 VGND VGND VPWR VPWR sky130_fd_sc_hd__fill_1
XFILLER_185_639 VGND VGND VPWR VPWR sky130_fd_sc_hd__decap_6
XFILLER_166_820 VPWR VGND VPWR VGND sky130_ef_sc_hd__decap_12
XFILLER_178_691 VPWR VGND VPWR VGND sky130_ef_sc_hd__decap_12
XPHY_EDGE_ROW_136_2_Right_227 VGND VGND VPWR VPWR sky130_fd_sc_hd__decap_3
XFILLER_201_1217 VPWR VGND VPWR VGND sky130_ef_sc_hd__decap_12
XFILLER_122_3 VPWR VGND VPWR VGND sky130_ef_sc_hd__decap_12
XFILLER_166_875 VGND VGND VPWR VPWR sky130_fd_sc_hd__decap_6
XFILLER_197_1143 VPWR VGND VPWR VGND sky130_ef_sc_hd__decap_12
XFILLER_14_1392 VGND VGND VPWR VPWR sky130_fd_sc_hd__decap_6
XFILLER_197_1198 VGND VGND VPWR VPWR sky130_fd_sc_hd__decap_6
XFILLER_49_1433 VPWR VGND VPWR VGND sky130_ef_sc_hd__decap_12
XFILLER_84_1313 VPWR VGND VPWR VGND sky130_ef_sc_hd__decap_12
XFILLER_238_1140 VPWR VGND VPWR VGND sky130_ef_sc_hd__decap_12
XFILLER_180_366 VPWR VGND VPWR VGND sky130_ef_sc_hd__decap_12
XFILLER_234_1004 VGND VGND VPWR VPWR sky130_fd_sc_hd__decap_6
XFILLER_175_1463 VPWR VGND VPWR VGND sky130_ef_sc_hd__decap_12
XFILLER_97_56 VPWR VGND VPWR VGND sky130_ef_sc_hd__decap_12
XFILLER_49_1488 VPWR VGND VPWR VGND sky130_ef_sc_hd__decap_12
XFILLER_84_1368 VPWR VGND VPWR VGND sky130_ef_sc_hd__decap_12
XTAP_TAPCELL_ROW_85_2_5345 VGND VPWR sky130_fd_sc_hd__tapvpwrvgnd_1
XFILLER_238_1195 VPWR VGND VPWR VGND sky130_ef_sc_hd__decap_12
XFILLER_171_1327 VGND VGND VPWR VPWR sky130_fd_sc_hd__decap_6
XTAP_TAPCELL_ROW_54_2_5092 VGND VPWR sky130_fd_sc_hd__tapvpwrvgnd_1
XFILLER_212_1324 VPWR VGND VPWR VGND sky130_ef_sc_hd__decap_12
XFILLER_212_1379 VPWR VGND VPWR VGND sky130_ef_sc_hd__decap_12
XTAP_TAPCELL_ROW_149_1_1453 VGND VPWR sky130_fd_sc_hd__tapvpwrvgnd_1
XFILLER_1_1413 VGND VGND VPWR VPWR sky130_fd_sc_hd__decap_6
XFILLER_235_345 VPWR VGND VPWR VGND sky130_ef_sc_hd__decap_12
XFILLER_250_304 VPWR VGND VPWR VGND sky130_ef_sc_hd__decap_12
XFILLER_245_1100 VPWR VGND VPWR VGND sky130_ef_sc_hd__decap_12
XFILLER_223_529 VPWR VGND VPWR VGND sky130_ef_sc_hd__decap_12
XTAP_TAPCELL_ROW_46_2_5029 VGND VPWR sky130_fd_sc_hd__tapvpwrvgnd_1
XFILLER_204_710 VPWR VGND VPWR VGND sky130_ef_sc_hd__decap_12
XFILLER_216_581 VPWR VGND VPWR VGND sky130_ef_sc_hd__decap_12
XFILLER_249_1291 VPWR VGND VPWR VGND sky130_ef_sc_hd__decap_12
XFILLER_95_1464 VPWR VGND VPWR VGND sky130_ef_sc_hd__decap_12
XPHY_EDGE_ROW_247_Left_502 VGND VGND VPWR VPWR sky130_fd_sc_hd__decap_3
Xmax_cap94 net95 VGND VGND VPWR VPWR net94 sky130_fd_sc_hd__clkbuf_1
XFILLER_182_1434 VGND VGND VPWR VPWR sky130_fd_sc_hd__decap_6
XFILLER_250_359 VGND VGND VPWR VPWR sky130_fd_sc_hd__decap_6
XFILLER_245_1155 VGND VGND VPWR VPWR sky130_fd_sc_hd__decap_6
XFILLER_91_1328 VGND VGND VPWR VPWR sky130_fd_sc_hd__decap_6
XFILLER_188_433 VPWR VGND VPWR VGND sky130_ef_sc_hd__decap_12
XFILLER_204_765 VPWR VGND VPWR VGND sky130_ef_sc_hd__decap_12
XFILLER_176_617 VGND VGND VPWR VPWR sky130_fd_sc_hd__decap_6
XFILLER_223_1420 VPWR VGND VPWR VGND sky130_ef_sc_hd__decap_12
XFILLER_231_584 VPWR VGND VPWR VGND sky130_ef_sc_hd__decap_12
XFILLER_188_488 VGND VGND VPWR VPWR sky130_fd_sc_hd__decap_6
XFILLER_19_1292 VPWR VGND VPWR VGND sky130_ef_sc_hd__decap_12
XFILLER_106_1251 VPWR VGND VPWR VGND sky130_ef_sc_hd__decap_12
XFILLER_223_1475 VPWR VGND VPWR VGND sky130_ef_sc_hd__decap_12
XFILLER_190_108 VPWR VGND VPWR VGND sky130_ef_sc_hd__decap_12
XFILLER_15_1189 VPWR VGND VPWR VGND sky130_ef_sc_hd__decap_12
XFILLER_8_874 VGND VGND VPWR VPWR sky130_fd_sc_hd__decap_6
Xwire260 net261 VGND VGND VPWR VPWR net260 sky130_fd_sc_hd__clkbuf_1
Xwire271 net272 VGND VGND VPWR VPWR net271 sky130_fd_sc_hd__clkbuf_1
XFILLER_7_87 VGND VGND VPWR VPWR sky130_fd_sc_hd__decap_8
Xwire282 net283 VGND VGND VPWR VPWR net282 sky130_fd_sc_hd__clkbuf_1
XFILLER_67_1500 VGND VGND VPWR VPWR sky130_fd_sc_hd__decap_6
Xwire293 net294 VGND VGND VPWR VPWR net293 sky130_fd_sc_hd__clkbuf_1
XFILLER_7_98 VPWR VGND VPWR VGND sky130_ef_sc_hd__decap_12
XFILLER_176_1238 VPWR VGND VPWR VGND sky130_ef_sc_hd__decap_12
XFILLER_171_388 VPWR VGND VPWR VGND sky130_ef_sc_hd__decap_12
XFILLER_6_1324 VPWR VGND VPWR VGND sky130_ef_sc_hd__decap_12
XFILLER_26_1263 VGND VGND VPWR VPWR sky130_fd_sc_hd__decap_6
XFILLER_61_1165 VPWR VGND VPWR VGND sky130_ef_sc_hd__decap_12
XFILLER_152_1282 VPWR VGND VPWR VGND sky130_ef_sc_hd__decap_12
XFILLER_6_1379 VPWR VGND VPWR VGND sky130_ef_sc_hd__decap_12
XFILLER_226_323 VPWR VGND VPWR VGND sky130_ef_sc_hd__decap_12
XFILLER_238_194 VPWR VGND VPWR VGND sky130_ef_sc_hd__decap_12
XFILLER_187_1334 VPWR VGND VPWR VGND sky130_ef_sc_hd__decap_12
XFILLER_253_142 VPWR VGND VPWR VGND sky130_ef_sc_hd__decap_12
XFILLER_96_1239 VPWR VGND VPWR VGND sky130_ef_sc_hd__decap_12
XFILLER_213_87 VPWR VGND VPWR VGND sky130_ef_sc_hd__decap_12
XFILLER_214_507 VPWR VGND VPWR VGND sky130_ef_sc_hd__decap_12
XTAP_TAPCELL_ROW_101_1_1381 VGND VPWR sky130_fd_sc_hd__tapvpwrvgnd_1
XFILLER_226_378 VPWR VGND VPWR VGND sky130_ef_sc_hd__decap_12
XFILLER_241_326 VPWR VGND VPWR VGND sky130_ef_sc_hd__decap_12
XFILLER_187_1389 VPWR VGND VPWR VGND sky130_ef_sc_hd__decap_12
XTAP_TAPCELL_ROW_204_2880 VGND VPWR sky130_fd_sc_hd__tapvpwrvgnd_1
XFILLER_179_400 VPWR VGND VPWR VGND sky130_ef_sc_hd__decap_12
XFILLER_253_197 VPWR VGND VPWR VGND sky130_ef_sc_hd__decap_12
XTAP_TAPCELL_ROW_204_2891 VGND VPWR sky130_fd_sc_hd__tapvpwrvgnd_1
XPHY_EDGE_ROW_174_Right_19 VGND VGND VPWR VPWR sky130_fd_sc_hd__decap_3
XPHY_EDGE_ROW_124_1_Right_780 VGND VGND VPWR VPWR sky130_fd_sc_hd__decap_3
XTAP_TAPCELL_ROW_200_2744 VGND VPWR sky130_fd_sc_hd__tapvpwrvgnd_1
XTAP_TAPCELL_ROW_200_2755 VGND VPWR sky130_fd_sc_hd__tapvpwrvgnd_1
XTAP_TAPCELL_ROW_200_2766 VGND VPWR sky130_fd_sc_hd__tapvpwrvgnd_1
XFILLER_161_1507 VGND VGND VPWR VPWR sky130_fd_sc_hd__decap_8
XFILLER_179_455 VPWR VGND VPWR VGND sky130_ef_sc_hd__decap_12
XFILLER_195_904 VPWR VGND VPWR VGND sky130_ef_sc_hd__decap_12
XFILLER_222_562 VPWR VGND VPWR VGND sky130_ef_sc_hd__decap_12
XFILLER_250_882 VPWR VGND VPWR VGND sky130_ef_sc_hd__decap_12
XTAP_TAPCELL_ROW_252_4567 VGND VPWR sky130_fd_sc_hd__tapvpwrvgnd_1
XFILLER_33_1201 VGND VGND VPWR VPWR sky130_fd_sc_hd__decap_4
XTAP_TAPCELL_ROW_252_4578 VGND VPWR sky130_fd_sc_hd__tapvpwrvgnd_1
XFILLER_167_639 VGND VGND VPWR VPWR sky130_fd_sc_hd__decap_6
XFILLER_210_746 VGND VGND VPWR VPWR sky130_fd_sc_hd__decap_6
XTAP_TAPCELL_ROW_252_4589 VGND VPWR sky130_fd_sc_hd__tapvpwrvgnd_1
XFILLER_195_959 VPWR VGND VPWR VGND sky130_ef_sc_hd__decap_12
XFILLER_72_1294 VPWR VGND VPWR VGND sky130_ef_sc_hd__decap_12
XTAP_TAPCELL_ROW_91_2_5388 VGND VPWR sky130_fd_sc_hd__tapvpwrvgnd_1
XFILLER_198_1441 VPWR VGND VPWR VGND sky130_ef_sc_hd__decap_12
XTAP_TAPCELL_ROW_79_1_1348 VGND VPWR sky130_fd_sc_hd__tapvpwrvgnd_1
XFILLER_159_1414 VGND VGND VPWR VPWR sky130_fd_sc_hd__decap_6
XFILLER_194_1305 VGND VGND VPWR VPWR sky130_fd_sc_hd__decap_6
XFILLER_200_1250 VPWR VGND VPWR VGND sky130_ef_sc_hd__decap_12
XPHY_EDGE_ROW_60_2_Right_151 VGND VGND VPWR VPWR sky130_fd_sc_hd__decap_3
XFILLER_198_1496 VPWR VGND VPWR VGND sky130_ef_sc_hd__decap_12
XTAP_TAPCELL_ROW_103_2_5486 VGND VPWR sky130_fd_sc_hd__tapvpwrvgnd_1
XTAP_TAPCELL_ROW_71_2_5231 VGND VPWR sky130_fd_sc_hd__tapvpwrvgnd_1
XPHY_EDGE_ROW_183_Right_28 VGND VGND VPWR VPWR sky130_fd_sc_hd__decap_3
XTAP_TAPCELL_ROW_246_4349 VGND VPWR sky130_fd_sc_hd__tapvpwrvgnd_1
Xmax_cap571 net43 VGND VGND VPWR VPWR net571 sky130_fd_sc_hd__clkbuf_1
XFILLER_107_44 VPWR VGND VPWR VGND sky130_ef_sc_hd__decap_12
XFILLER_235_1346 VPWR VGND VPWR VGND sky130_ef_sc_hd__decap_12
XFILLER_67_15 VPWR VGND VPWR VGND sky130_ef_sc_hd__decap_12
XFILLER_118_1177 VGND VGND VPWR VPWR sky130_fd_sc_hd__decap_6
XTAP_TAPCELL_ROW_37_2_4955 VGND VPWR sky130_fd_sc_hd__tapvpwrvgnd_1
XFILLER_83_1390 VPWR VGND VPWR VGND sky130_ef_sc_hd__decap_12
XFILLER_188_1109 VPWR VGND VPWR VGND sky130_ef_sc_hd__decap_12
XTAP_TAPCELL_ROW_8_1149 VGND VPWR sky130_fd_sc_hd__tapvpwrvgnd_1
XFILLER_40_1227 VPWR VGND VPWR VGND sky130_ef_sc_hd__decap_12
XFILLER_244_120 VPWR VGND VPWR VGND sky130_ef_sc_hd__decap_12
XFILLER_217_345 VPWR VGND VPWR VGND sky130_ef_sc_hd__decap_12
X_550_ net670 VGND VGND VPWR VPWR _032_ sky130_fd_sc_hd__inv_2
XFILLER_232_304 VPWR VGND VPWR VGND sky130_ef_sc_hd__decap_12
XPHY_EDGE_ROW_192_Right_37 VGND VGND VPWR VPWR sky130_fd_sc_hd__decap_3
XFILLER_205_529 VPWR VGND VPWR VGND sky130_ef_sc_hd__decap_12
XFILLER_244_175 VPWR VGND VPWR VGND sky130_ef_sc_hd__decap_12
X_481_ net165 net93 VGND VGND VPWR VPWR acc_core.adder.cla_blocks\[3\].block.sum\[2\]
+ sky130_fd_sc_hd__xnor2_1
XFILLER_246_1453 VPWR VGND VPWR VGND sky130_ef_sc_hd__decap_12
XFILLER_232_359 VGND VGND VPWR VPWR sky130_fd_sc_hd__decap_6
XFILLER_198_753 VPWR VGND VPWR VGND sky130_ef_sc_hd__decap_12
XFILLER_129_1273 VPWR VGND VPWR VGND sky130_ef_sc_hd__decap_12
XFILLER_201_713 VPWR VGND VPWR VGND sky130_ef_sc_hd__decap_12
XFILLER_197_252 VGND VGND VPWR VPWR sky130_fd_sc_hd__decap_6
XFILLER_213_584 VPWR VGND VPWR VGND sky130_ef_sc_hd__decap_12
XFILLER_186_937 VPWR VGND VPWR VGND sky130_ef_sc_hd__decap_12
XFILLER_199_1205 VPWR VGND VPWR VGND sky130_ef_sc_hd__decap_12
XFILLER_201_768 VGND VGND VPWR VPWR sky130_fd_sc_hd__decap_6
XFILLER_16_1454 VPWR VGND VPWR VGND sky130_ef_sc_hd__decap_12
XFILLER_103_1402 VPWR VGND VPWR VGND sky130_ef_sc_hd__decap_12
XFILLER_201_1014 VPWR VGND VPWR VGND sky130_ef_sc_hd__decap_12
XPHY_EDGE_ROW_137_2_Right_228 VGND VGND VPWR VPWR sky130_fd_sc_hd__decap_3
XFILLER_172_108 VPWR VGND VPWR VGND sky130_ef_sc_hd__decap_12
XFILLER_51_1378 VPWR VGND VPWR VGND sky130_ef_sc_hd__decap_12
XFILLER_103_1457 VGND VGND VPWR VPWR sky130_fd_sc_hd__decap_6
XFILLER_165_160 VGND VGND VPWR VPWR sky130_fd_sc_hd__decap_8
XFILLER_177_1514 VGND VGND VPWR VPWR sky130_fd_sc_hd__fill_1
XFILLER_194_992 VPWR VGND VPWR VGND sky130_ef_sc_hd__decap_12
XFILLER_201_1069 VGND VGND VPWR VPWR sky130_fd_sc_hd__decap_6
XTAP_TAPCELL_ROW_31_1_1276 VGND VPWR sky130_fd_sc_hd__tapvpwrvgnd_1
XFILLER_4_310 VGND VGND VPWR VPWR sky130_fd_sc_hd__fill_1
XFILLER_138_1509 VGND VGND VPWR VPWR sky130_fd_sc_hd__decap_6
XFILLER_49_1230 VPWR VGND VPWR VGND sky130_ef_sc_hd__decap_12
XFILLER_253_1413 VGND VGND VPWR VPWR sky130_fd_sc_hd__decap_6
XFILLER_180_163 VPWR VGND VPWR VGND sky130_ef_sc_hd__decap_12
XFILLER_175_1260 VPWR VGND VPWR VGND sky130_ef_sc_hd__decap_12
XTAP_TAPCELL_ROW_210_3095 VGND VPWR sky130_fd_sc_hd__tapvpwrvgnd_1
XFILLER_49_1285 VGND VGND VPWR VPWR sky130_fd_sc_hd__decap_6
XFILLER_84_1165 VPWR VGND VPWR VGND sky130_ef_sc_hd__decap_12
XFILLER_0_560 VGND VGND VPWR VPWR sky130_fd_sc_hd__fill_1
XFILLER_249_971 VPWR VGND VPWR VGND sky130_ef_sc_hd__decap_12
XFILLER_212_1121 VPWR VGND VPWR VGND sky130_ef_sc_hd__decap_12
XFILLER_23_1414 VGND VGND VPWR VPWR sky130_fd_sc_hd__decap_6
XFILLER_62_1485 VPWR VGND VPWR VGND sky130_ef_sc_hd__decap_12
XFILLER_208_323 VPWR VGND VPWR VGND sky130_ef_sc_hd__decap_12
XTAP_TAPCELL_ROW_167_1592 VGND VPWR sky130_fd_sc_hd__tapvpwrvgnd_1
XFILLER_212_1176 VGND VGND VPWR VPWR sky130_fd_sc_hd__decap_6
XTAP_TAPCELL_ROW_158_2_5924 VGND VPWR sky130_fd_sc_hd__tapvpwrvgnd_1
XFILLER_235_142 VPWR VGND VPWR VGND sky130_ef_sc_hd__decap_12
XFILLER_247_1217 VPWR VGND VPWR VGND sky130_ef_sc_hd__decap_12
XFILLER_208_378 VPWR VGND VPWR VGND sky130_ef_sc_hd__decap_12
XFILLER_250_101 VGND VGND VPWR VPWR sky130_fd_sc_hd__decap_6
XFILLER_223_326 VPWR VGND VPWR VGND sky130_ef_sc_hd__decap_12
XFILLER_251_646 VPWR VGND VPWR VGND sky130_ef_sc_hd__decap_12
XFILLER_235_197 VPWR VGND VPWR VGND sky130_ef_sc_hd__decap_12
XFILLER_95_1261 VPWR VGND VPWR VGND sky130_ef_sc_hd__decap_12
XFILLER_108_1313 VPWR VGND VPWR VGND sky130_ef_sc_hd__decap_12
XFILLER_188_230 VGND VGND VPWR VPWR sky130_fd_sc_hd__decap_6
XFILLER_177_904 VPWR VGND VPWR VGND sky130_ef_sc_hd__decap_12
XFILLER_204_562 VPWR VGND VPWR VGND sky130_ef_sc_hd__decap_12
XFILLER_189_775 VPWR VGND VPWR VGND sky130_ef_sc_hd__decap_12
XFILLER_232_882 VPWR VGND VPWR VGND sky130_ef_sc_hd__decap_12
XFILLER_17_1218 VPWR VGND VPWR VGND sky130_ef_sc_hd__decap_12
XFILLER_189_80 VGND VGND VPWR VPWR sky130_fd_sc_hd__decap_6
XFILLER_231_381 VGND VGND VPWR VPWR sky130_fd_sc_hd__decap_6
XTAP_TAPCELL_ROW_76_2_5268 VGND VPWR sky130_fd_sc_hd__tapvpwrvgnd_1
XFILLER_108_1368 VPWR VGND VPWR VGND sky130_ef_sc_hd__decap_12
XFILLER_85_3 VPWR VGND VPWR VGND sky130_ef_sc_hd__decap_12
XFILLER_177_959 VPWR VGND VPWR VGND sky130_ef_sc_hd__decap_12
XTAP_TAPCELL_ROW_120_2_5625 VGND VPWR sky130_fd_sc_hd__tapvpwrvgnd_1
XFILLER_192_918 VGND VGND VPWR VPWR sky130_fd_sc_hd__decap_6
XFILLER_223_1272 VPWR VGND VPWR VGND sky130_ef_sc_hd__decap_12
XFILLER_8_660 VGND VGND VPWR VPWR sky130_fd_sc_hd__decap_6
XTAP_TAPCELL_ROW_56_2_5111 VGND VPWR sky130_fd_sc_hd__tapvpwrvgnd_1
XFILLER_171_130 VPWR VGND VPWR VGND sky130_ef_sc_hd__decap_12
XFILLER_176_1035 VPWR VGND VPWR VGND sky130_ef_sc_hd__decap_12
XFILLER_208_65 VPWR VGND VPWR VGND sky130_ef_sc_hd__decap_12
XFILLER_171_185 VPWR VGND VPWR VGND sky130_ef_sc_hd__decap_12
XFILLER_28_1325 VPWR VGND VPWR VGND sky130_ef_sc_hd__decap_12
XTAP_TAPCELL_ROW_241_4202 VGND VPWR sky130_fd_sc_hd__tapvpwrvgnd_1
XFILLER_232_1508 VGND VGND VPWR VPWR sky130_fd_sc_hd__decap_6
XFILLER_119_1464 VPWR VGND VPWR VGND sky130_ef_sc_hd__decap_12
XFILLER_63_1249 VPWR VGND VPWR VGND sky130_ef_sc_hd__decap_12
XFILLER_217_1076 VPWR VGND VPWR VGND sky130_ef_sc_hd__decap_12
XFILLER_115_1328 VGND VGND VPWR VPWR sky130_fd_sc_hd__decap_6
XFILLER_150_1208 VPWR VGND VPWR VGND sky130_ef_sc_hd__decap_12
XFILLER_6_1121 VPWR VGND VPWR VGND sky130_ef_sc_hd__decap_12
XFILLER_154_1399 VPWR VGND VPWR VGND sky130_ef_sc_hd__decap_12
XFILLER_6_1176 VGND VGND VPWR VPWR sky130_fd_sc_hd__decap_6
XFILLER_226_120 VPWR VGND VPWR VGND sky130_ef_sc_hd__decap_12
XTAP_TAPCELL_ROW_206_2953 VGND VPWR sky130_fd_sc_hd__tapvpwrvgnd_1
XFILLER_187_1131 VPWR VGND VPWR VGND sky130_ef_sc_hd__decap_12
XTAP_TAPCELL_ROW_206_2964 VGND VPWR sky130_fd_sc_hd__tapvpwrvgnd_1
XTAP_TAPCELL_ROW_206_2975 VGND VPWR sky130_fd_sc_hd__tapvpwrvgnd_1
XTAP_TAPCELL_ROW_202_2817 VGND VPWR sky130_fd_sc_hd__tapvpwrvgnd_1
XTAP_TAPCELL_ROW_239_4120 VGND VPWR sky130_fd_sc_hd__tapvpwrvgnd_1
XTAP_TAPCELL_ROW_239_4131 VGND VPWR sky130_fd_sc_hd__tapvpwrvgnd_1
XTAP_TAPCELL_ROW_202_2828 VGND VPWR sky130_fd_sc_hd__tapvpwrvgnd_1
XFILLER_214_304 VPWR VGND VPWR VGND sky130_ef_sc_hd__decap_12
XFILLER_242_624 VPWR VGND VPWR VGND sky130_ef_sc_hd__decap_12
XFILLER_199_517 VPWR VGND VPWR VGND sky130_ef_sc_hd__decap_12
XTAP_TAPCELL_ROW_202_2839 VGND VPWR sky130_fd_sc_hd__tapvpwrvgnd_1
XFILLER_226_175 VPWR VGND VPWR VGND sky130_ef_sc_hd__decap_12
XFILLER_254_495 VPWR VGND VPWR VGND sky130_ef_sc_hd__decap_12
XFILLER_187_1186 VPWR VGND VPWR VGND sky130_ef_sc_hd__decap_12
XFILLER_241_123 VGND VGND VPWR VPWR sky130_fd_sc_hd__decap_6
XFILLER_39_1421 VPWR VGND VPWR VGND sky130_ef_sc_hd__decap_12
XTAP_TAPCELL_ROW_254_4629 VGND VPWR sky130_fd_sc_hd__tapvpwrvgnd_1
XFILLER_214_359 VGND VGND VPWR VPWR sky130_fd_sc_hd__decap_6
XFILLER_230_808 VPWR VGND VPWR VGND sky130_ef_sc_hd__decap_12
XFILLER_242_679 VPWR VGND VPWR VGND sky130_ef_sc_hd__decap_12
XFILLER_53_39 VGND VGND VPWR VPWR sky130_fd_sc_hd__decap_4
XPHY_EDGE_ROW_125_2_Left_627 VGND VGND VPWR VPWR sky130_fd_sc_hd__decap_3
XFILLER_165_1462 VGND VGND VPWR VPWR sky130_fd_sc_hd__decap_8
XFILLER_39_1476 VPWR VGND VPWR VGND sky130_ef_sc_hd__decap_12
XFILLER_74_1356 VPWR VGND VPWR VGND sky130_ef_sc_hd__decap_12
XFILLER_161_1304 VPWR VGND VPWR VGND sky130_ef_sc_hd__decap_12
XFILLER_228_1183 VPWR VGND VPWR VGND sky130_ef_sc_hd__decap_12
XPHY_EDGE_ROW_125_1_Right_781 VGND VGND VPWR VPWR sky130_fd_sc_hd__decap_3
XFILLER_169_39 VGND VGND VPWR VPWR sky130_fd_sc_hd__decap_4
XFILLER_179_252 VGND VGND VPWR VPWR sky130_fd_sc_hd__decap_6
XFILLER_195_701 VPWR VGND VPWR VGND sky130_ef_sc_hd__decap_12
XFILLER_126_1435 VGND VGND VPWR VPWR sky130_fd_sc_hd__decap_6
XFILLER_168_937 VPWR VGND VPWR VGND sky130_ef_sc_hd__decap_12
XFILLER_224_1047 VGND VGND VPWR VPWR sky130_fd_sc_hd__decap_6
XFILLER_161_1359 VPWR VGND VPWR VGND sky130_ef_sc_hd__decap_12
XFILLER_195_756 VPWR VGND VPWR VGND sky130_ef_sc_hd__decap_12
XFILLER_202_1312 VPWR VGND VPWR VGND sky130_ef_sc_hd__decap_12
XFILLER_176_992 VPWR VGND VPWR VGND sky130_ef_sc_hd__decap_12
XFILLER_185_27 VPWR VGND VPWR VGND sky130_ef_sc_hd__decap_12
XFILLER_202_1367 VPWR VGND VPWR VGND sky130_ef_sc_hd__decap_12
XFILLER_191_940 VGND VGND VPWR VPWR sky130_fd_sc_hd__decap_6
XFILLER_198_1293 VPWR VGND VPWR VGND sky130_ef_sc_hd__decap_12
XPHY_EDGE_ROW_61_2_Right_152 VGND VGND VPWR VPWR sky130_fd_sc_hd__decap_3
XFILLER_118_65 VGND VGND VPWR VPWR sky130_fd_sc_hd__decap_6
XFILLER_1_302 VGND VGND VPWR VPWR sky130_fd_sc_hd__decap_8
XFILLER_78_58 VGND VGND VPWR VPWR sky130_fd_sc_hd__decap_6
XFILLER_172_1422 VPWR VGND VPWR VGND sky130_ef_sc_hd__decap_12
XFILLER_81_1316 VPWR VGND VPWR VGND sky130_ef_sc_hd__decap_12
XFILLER_235_1143 VPWR VGND VPWR VGND sky130_ef_sc_hd__decap_12
XFILLER_172_1477 VGND VGND VPWR VPWR sky130_fd_sc_hd__decap_6
XFILLER_235_1198 VGND VGND VPWR VPWR sky130_fd_sc_hd__decap_6
XTAP_TAPCELL_ROW_144_2_5810 VGND VPWR sky130_fd_sc_hd__tapvpwrvgnd_1
XFILLER_213_1463 VPWR VGND VPWR VGND sky130_ef_sc_hd__decap_12
XFILLER_79_1201 VGND VGND VPWR VPWR sky130_fd_sc_hd__decap_4
XFILLER_94_46 VPWR VGND VPWR VGND sky130_ef_sc_hd__decap_12
X_602_ clknet_3_0__leaf_clk dout0\[0\] _010_ VGND VGND VPWR VPWR dout0_q\[0\] sky130_fd_sc_hd__dfrtp_1
XFILLER_217_142 VPWR VGND VPWR VGND sky130_ef_sc_hd__decap_12
XFILLER_232_101 VGND VGND VPWR VPWR sky130_fd_sc_hd__decap_6
X_533_ net666 VGND VGND VPWR VPWR _015_ sky130_fd_sc_hd__inv_2
XFILLER_166_1226 VPWR VGND VPWR VGND sky130_ef_sc_hd__decap_12
XFILLER_205_326 VPWR VGND VPWR VGND sky130_ef_sc_hd__decap_12
XPHY_EDGE_ROW_57_2_Left_559 VGND VGND VPWR VPWR sky130_fd_sc_hd__decap_3
XFILLER_217_197 VPWR VGND VPWR VGND sky130_ef_sc_hd__decap_12
XFILLER_233_646 VPWR VGND VPWR VGND sky130_ef_sc_hd__decap_12
XTAP_TAPCELL_ROW_93_2_5407 VGND VPWR sky130_fd_sc_hd__tapvpwrvgnd_1
XFILLER_246_1250 VPWR VGND VPWR VGND sky130_ef_sc_hd__decap_12
XFILLER_92_1423 VPWR VGND VPWR VGND sky130_ef_sc_hd__decap_12
XTAP_TAPCELL_ROW_62_2_5154 VGND VPWR sky130_fd_sc_hd__tapvpwrvgnd_1
X_464_ net198 _194_ VGND VGND VPWR VPWR acc_core.adder.cla_blocks\[0\].block.sum\[1\]
+ sky130_fd_sc_hd__xnor2_1
XFILLER_198_550 VPWR VGND VPWR VGND sky130_ef_sc_hd__decap_12
XFILLER_214_882 VPWR VGND VPWR VGND sky130_ef_sc_hd__decap_12
XTAP_TAPCELL_ROW_105_2_5505 VGND VPWR sky130_fd_sc_hd__tapvpwrvgnd_1
XFILLER_201_510 VGND VGND VPWR VPWR sky130_fd_sc_hd__decap_6
XFILLER_92_1478 VGND VGND VPWR VPWR sky130_fd_sc_hd__decap_6
XFILLER_213_381 VGND VGND VPWR VPWR sky130_fd_sc_hd__decap_6
X_395_ net592 net585 net561 VGND VGND VPWR VPWR _184_ sky130_fd_sc_hd__a21o_1
XFILLER_186_734 VPWR VGND VPWR VGND sky130_ef_sc_hd__decap_12
XFILLER_199_1002 VPWR VGND VPWR VGND sky130_ef_sc_hd__decap_12
XFILLER_16_1251 VPWR VGND VPWR VGND sky130_ef_sc_hd__decap_12
XFILLER_174_918 VGND VGND VPWR VPWR sky130_fd_sc_hd__decap_6
XFILLER_186_789 VGND VGND VPWR VPWR sky130_fd_sc_hd__decap_6
XTAP_TAPCELL_ROW_28_2_4889 VGND VPWR sky130_fd_sc_hd__tapvpwrvgnd_1
XFILLER_107_1390 VPWR VGND VPWR VGND sky130_ef_sc_hd__decap_12
XFILLER_142_1270 VPWR VGND VPWR VGND sky130_ef_sc_hd__decap_12
XFILLER_199_1057 VPWR VGND VPWR VGND sky130_ef_sc_hd__decap_12
XFILLER_220_1434 VGND VGND VPWR VPWR sky130_fd_sc_hd__decap_6
XTAP_TAPCELL_ROW_175_1872 VGND VPWR sky130_fd_sc_hd__tapvpwrvgnd_1
XTAP_TAPCELL_ROW_175_1883 VGND VPWR sky130_fd_sc_hd__tapvpwrvgnd_1
XTAP_TAPCELL_ROW_171_1725 VGND VPWR sky130_fd_sc_hd__tapvpwrvgnd_1
XTAP_TAPCELL_ROW_175_1894 VGND VPWR sky130_fd_sc_hd__tapvpwrvgnd_1
XPHY_EDGE_ROW_138_2_Right_229 VGND VGND VPWR VPWR sky130_fd_sc_hd__decap_3
XTAP_TAPCELL_ROW_171_1736 VGND VPWR sky130_fd_sc_hd__tapvpwrvgnd_1
XTAP_TAPCELL_ROW_171_1747 VGND VPWR sky130_fd_sc_hd__tapvpwrvgnd_1
XTAP_TAPCELL_ROW_212_3168 VGND VPWR sky130_fd_sc_hd__tapvpwrvgnd_1
XFILLER_86_1227 VPWR VGND VPWR VGND sky130_ef_sc_hd__decap_12
XTAP_TAPCELL_ROW_171_1758 VGND VPWR sky130_fd_sc_hd__tapvpwrvgnd_1
XTAP_TAPCELL_ROW_212_3179 VGND VPWR sky130_fd_sc_hd__tapvpwrvgnd_1
XFILLER_138_1306 VGND VGND VPWR VPWR sky130_fd_sc_hd__decap_6
XFILLER_4_151 VGND VGND VPWR VPWR sky130_fd_sc_hd__decap_8
XFILLER_177_1377 VPWR VGND VPWR VGND sky130_ef_sc_hd__decap_12
XPHY_EDGE_ROW_189_Left_444 VGND VGND VPWR VPWR sky130_fd_sc_hd__decap_3
XFILLER_4_22 VPWR VGND VPWR VGND sky130_ef_sc_hd__decap_12
XTAP_TAPCELL_ROW_137_1_1435 VGND VPWR sky130_fd_sc_hd__tapvpwrvgnd_1
XFILLER_4_77 VPWR VGND VPWR VGND sky130_ef_sc_hd__decap_12
XTAP_TAPCELL_ROW_169_1654 VGND VPWR sky130_fd_sc_hd__tapvpwrvgnd_1
XFILLER_214_1238 VPWR VGND VPWR VGND sky130_ef_sc_hd__decap_12
XTAP_TAPCELL_ROW_169_1665 VGND VPWR sky130_fd_sc_hd__tapvpwrvgnd_1
XTAP_TAPCELL_ROW_165_1507 VGND VPWR sky130_fd_sc_hd__tapvpwrvgnd_1
XTAP_TAPCELL_ROW_169_1676 VGND VPWR sky130_fd_sc_hd__tapvpwrvgnd_1
XTAP_TAPCELL_ROW_165_1518 VGND VPWR sky130_fd_sc_hd__tapvpwrvgnd_1
XTAP_TAPCELL_ROW_169_1687 VGND VPWR sky130_fd_sc_hd__tapvpwrvgnd_1
XTAP_TAPCELL_ROW_165_1529 VGND VPWR sky130_fd_sc_hd__tapvpwrvgnd_1
XFILLER_7_1463 VPWR VGND VPWR VGND sky130_ef_sc_hd__decap_12
XFILLER_62_1282 VPWR VGND VPWR VGND sky130_ef_sc_hd__decap_12
XPHY_EDGE_ROW_123_1_Left_378 VGND VGND VPWR VPWR sky130_fd_sc_hd__decap_3
XFILLER_3_1327 VGND VGND VPWR VPWR sky130_fd_sc_hd__decap_6
XFILLER_208_120 VPWR VGND VPWR VGND sky130_ef_sc_hd__decap_12
XFILLER_149_1402 VPWR VGND VPWR VGND sky130_ef_sc_hd__decap_12
XFILLER_247_1014 VPWR VGND VPWR VGND sky130_ef_sc_hd__decap_12
XFILLER_208_175 VPWR VGND VPWR VGND sky130_ef_sc_hd__decap_12
XFILLER_224_624 VPWR VGND VPWR VGND sky130_ef_sc_hd__decap_12
XFILLER_188_1484 VPWR VGND VPWR VGND sky130_ef_sc_hd__decap_12
XFILLER_236_495 VPWR VGND VPWR VGND sky130_ef_sc_hd__decap_12
XFILLER_97_1378 VPWR VGND VPWR VGND sky130_ef_sc_hd__decap_12
XPHY_EDGE_ROW_198_Left_453 VGND VGND VPWR VPWR sky130_fd_sc_hd__decap_3
XFILLER_223_123 VGND VGND VPWR VPWR sky130_fd_sc_hd__decap_6
XPHY_EDGE_ROW_60_1_Left_315 VGND VGND VPWR VPWR sky130_fd_sc_hd__decap_3
XFILLER_149_1457 VGND VGND VPWR VPWR sky130_fd_sc_hd__decap_6
XFILLER_251_443 VPWR VGND VPWR VGND sky130_ef_sc_hd__decap_12
XFILLER_184_1348 VGND VGND VPWR VPWR sky130_fd_sc_hd__decap_6
XFILLER_212_808 VPWR VGND VPWR VGND sky130_ef_sc_hd__decap_12
XFILLER_247_1069 VGND VGND VPWR VPWR sky130_fd_sc_hd__decap_6
XFILLER_210_22 VPWR VGND VPWR VGND sky130_ef_sc_hd__decap_12
XFILLER_224_679 VPWR VGND VPWR VGND sky130_ef_sc_hd__decap_12
XFILLER_177_701 VPWR VGND VPWR VGND sky130_ef_sc_hd__decap_12
XFILLER_251_498 VPWR VGND VPWR VGND sky130_ef_sc_hd__decap_12
XFILLER_71_1507 VGND VGND VPWR VPWR sky130_fd_sc_hd__decap_8
XFILLER_225_1334 VPWR VGND VPWR VGND sky130_ef_sc_hd__decap_12
XFILLER_189_572 VPWR VGND VPWR VGND sky130_ef_sc_hd__decap_12
XFILLER_210_77 VPWR VGND VPWR VGND sky130_ef_sc_hd__decap_12
XFILLER_108_1165 VPWR VGND VPWR VGND sky130_ef_sc_hd__decap_12
XFILLER_177_756 VPWR VGND VPWR VGND sky130_ef_sc_hd__decap_12
XFILLER_220_863 VPWR VGND VPWR VGND sky130_ef_sc_hd__decap_12
XFILLER_225_1389 VPWR VGND VPWR VGND sky130_ef_sc_hd__decap_12
Xclkbuf_3_2__f_clk clknet_0_clk VGND VGND VPWR VPWR clknet_3_2__leaf_clk sky130_fd_sc_hd__clkbuf_16
XFILLER_160_1392 VGND VGND VPWR VPWR sky130_fd_sc_hd__decap_6
XFILLER_69_1414 VGND VGND VPWR VPWR sky130_fd_sc_hd__decap_6
XFILLER_173_940 VGND VGND VPWR VPWR sky130_fd_sc_hd__decap_6
XTAP_TAPCELL_ROW_247_4400 VGND VPWR sky130_fd_sc_hd__tapvpwrvgnd_1
XTAP_TAPCELL_ROW_247_4411 VGND VPWR sky130_fd_sc_hd__tapvpwrvgnd_1
XFILLER_195_1444 VPWR VGND VPWR VGND sky130_ef_sc_hd__decap_12
XTAP_TAPCELL_ROW_150_2_5864 VGND VPWR sky130_fd_sc_hd__tapvpwrvgnd_1
XFILLER_195_1499 VGND VGND VPWR VPWR sky130_fd_sc_hd__decap_6
XTAP_TAPCELL_ROW_86_2_5350 VGND VPWR sky130_fd_sc_hd__tapvpwrvgnd_1
XFILLER_236_1441 VPWR VGND VPWR VGND sky130_ef_sc_hd__decap_12
XFILLER_119_1261 VPWR VGND VPWR VGND sky130_ef_sc_hd__decap_12
XFILLER_232_1305 VGND VGND VPWR VPWR sky130_fd_sc_hd__decap_6
XTAP_TAPCELL_ROW_9_1200 VGND VPWR sky130_fd_sc_hd__tapvpwrvgnd_1
XFILLER_236_1496 VPWR VGND VPWR VGND sky130_ef_sc_hd__decap_12
XTAP_TAPCELL_ROW_9_1211 VGND VPWR sky130_fd_sc_hd__tapvpwrvgnd_1
XFILLER_8_1238 VPWR VGND VPWR VGND sky130_ef_sc_hd__decap_12
XFILLER_28_1177 VGND VGND VPWR VPWR sky130_fd_sc_hd__decap_6
XTAP_TAPCELL_ROW_9_1222 VGND VPWR sky130_fd_sc_hd__tapvpwrvgnd_1
XTAP_TAPCELL_ROW_9_1233 VGND VPWR sky130_fd_sc_hd__tapvpwrvgnd_1
XFILLER_154_1196 VPWR VGND VPWR VGND sky130_ef_sc_hd__decap_12
XTAP_TAPCELL_ROW_9_1244 VGND VPWR sky130_fd_sc_hd__tapvpwrvgnd_1
XFILLER_246_237 VPWR VGND VPWR VGND sky130_ef_sc_hd__decap_12
XFILLER_104_34 VPWR VGND VPWR VGND sky130_ef_sc_hd__decap_12
XFILLER_189_1248 VPWR VGND VPWR VGND sky130_ef_sc_hd__decap_12
XTAP_TAPCELL_ROW_111_2_5548 VGND VPWR sky130_fd_sc_hd__tapvpwrvgnd_1
XTAP_TAPCELL_ROW_181_2076 VGND VPWR sky130_fd_sc_hd__tapvpwrvgnd_1
XTAP_TAPCELL_ROW_181_2087 VGND VPWR sky130_fd_sc_hd__tapvpwrvgnd_1
XTAP_TAPCELL_ROW_181_2098 VGND VPWR sky130_fd_sc_hd__tapvpwrvgnd_1
XFILLER_214_101 VGND VGND VPWR VPWR sky130_fd_sc_hd__decap_6
XTAP_TAPCELL_ROW_47_2_5034 VGND VPWR sky130_fd_sc_hd__tapvpwrvgnd_1
XFILLER_242_421 VPWR VGND VPWR VGND sky130_ef_sc_hd__decap_12
XFILLER_199_314 VPWR VGND VPWR VGND sky130_ef_sc_hd__decap_12
XFILLER_215_646 VPWR VGND VPWR VGND sky130_ef_sc_hd__decap_12
XFILLER_254_292 VPWR VGND VPWR VGND sky130_ef_sc_hd__decap_12
XFILLER_226_1109 VPWR VGND VPWR VGND sky130_ef_sc_hd__decap_12
XFILLER_230_605 VPWR VGND VPWR VGND sky130_ef_sc_hd__decap_12
XFILLER_243_1401 VPWR VGND VPWR VGND sky130_ef_sc_hd__decap_12
XFILLER_120_22 VPWR VGND VPWR VGND sky130_ef_sc_hd__decap_12
XFILLER_242_476 VPWR VGND VPWR VGND sky130_ef_sc_hd__decap_12
XFILLER_199_369 VPWR VGND VPWR VGND sky130_ef_sc_hd__decap_12
XFILLER_39_1273 VPWR VGND VPWR VGND sky130_ef_sc_hd__decap_12
XFILLER_80_15 VGND VGND VPWR VPWR sky130_fd_sc_hd__decap_6
XFILLER_211_830 VPWR VGND VPWR VGND sky130_ef_sc_hd__decap_12
XFILLER_243_1456 VGND VGND VPWR VPWR sky130_fd_sc_hd__decap_6
XFILLER_168_734 VPWR VGND VPWR VGND sky130_ef_sc_hd__decap_12
XTAP_TAPCELL_ROW_14_2_4775 VGND VPWR sky130_fd_sc_hd__tapvpwrvgnd_1
XPHY_EDGE_ROW_202_Left_457 VGND VGND VPWR VPWR sky130_fd_sc_hd__decap_3
XPHY_EDGE_ROW_126_1_Right_782 VGND VGND VPWR VPWR sky130_fd_sc_hd__decap_3
XFILLER_196_15 VGND VGND VPWR VPWR sky130_fd_sc_hd__decap_6
XFILLER_195_553 VGND VGND VPWR VPWR sky130_fd_sc_hd__decap_6
XFILLER_211_885 VPWR VGND VPWR VGND sky130_ef_sc_hd__decap_12
XFILLER_13_1402 VPWR VGND VPWR VGND sky130_ef_sc_hd__decap_12
XFILLER_168_789 VGND VGND VPWR VPWR sky130_fd_sc_hd__decap_6
XFILLER_161_1189 VPWR VGND VPWR VGND sky130_ef_sc_hd__decap_12
XFILLER_7_928 VPWR VGND VPWR VGND sky130_ef_sc_hd__decap_12
XFILLER_6_416 VGND VGND VPWR VPWR sky130_fd_sc_hd__fill_2
XFILLER_196_1219 VGND VGND VPWR VPWR sky130_fd_sc_hd__decap_6
XFILLER_13_1457 VGND VGND VPWR VPWR sky130_fd_sc_hd__decap_6
XFILLER_202_1164 VPWR VGND VPWR VGND sky130_ef_sc_hd__decap_12
XFILLER_170_409 VPWR VGND VPWR VGND sky130_ef_sc_hd__decap_12
XFILLER_198_1090 VGND VGND VPWR VPWR sky130_fd_sc_hd__decap_6
XFILLER_202_3 VPWR VGND VPWR VGND sky130_ef_sc_hd__decap_12
XFILLER_237_1205 VPWR VGND VPWR VGND sky130_ef_sc_hd__decap_12
XFILLER_48_1509 VGND VGND VPWR VPWR sky130_fd_sc_hd__decap_6
XTAP_TAPCELL_ROW_230_3791 VGND VPWR sky130_fd_sc_hd__tapvpwrvgnd_1
XFILLER_89_68 VGND VGND VPWR VPWR sky130_fd_sc_hd__decap_3
XFILLER_190_280 VPWR VGND VPWR VGND sky130_ef_sc_hd__decap_12
XPHY_EDGE_ROW_62_2_Right_153 VGND VGND VPWR VPWR sky130_fd_sc_hd__decap_3
XFILLER_1_110 VPWR VGND VPWR VGND sky130_ef_sc_hd__decap_12
XFILLER_215_1514 VGND VGND VPWR VPWR sky130_fd_sc_hd__fill_1
XFILLER_1_154 VPWR VGND VPWR VGND sky130_ef_sc_hd__decap_12
XPHY_EDGE_ROW_211_Left_466 VGND VGND VPWR VPWR sky130_fd_sc_hd__decap_3
XFILLER_1_198 VPWR VGND VPWR VGND sky130_ef_sc_hd__decap_12
XFILLER_213_1260 VPWR VGND VPWR VGND sky130_ef_sc_hd__decap_12
XFILLER_237_259 VPWR VGND VPWR VGND sky130_ef_sc_hd__decap_12
XTAP_TAPCELL_ROW_224_3584 VGND VPWR sky130_fd_sc_hd__tapvpwrvgnd_1
XTAP_TAPCELL_ROW_224_3595 VGND VPWR sky130_fd_sc_hd__tapvpwrvgnd_1
XFILLER_248_1312 VPWR VGND VPWR VGND sky130_ef_sc_hd__decap_12
XFILLER_252_218 VPWR VGND VPWR VGND sky130_ef_sc_hd__decap_12
XTAP_TAPCELL_ROW_220_3448 VGND VPWR sky130_fd_sc_hd__tapvpwrvgnd_1
XFILLER_206_624 VPWR VGND VPWR VGND sky130_ef_sc_hd__decap_12
XTAP_TAPCELL_ROW_220_3459 VGND VPWR sky130_fd_sc_hd__tapvpwrvgnd_1
XFILLER_218_495 VPWR VGND VPWR VGND sky130_ef_sc_hd__decap_12
XFILLER_166_1023 VPWR VGND VPWR VGND sky130_ef_sc_hd__decap_12
XFILLER_205_123 VGND VGND VPWR VPWR sky130_fd_sc_hd__decap_6
XFILLER_248_1367 VPWR VGND VPWR VGND sky130_ef_sc_hd__decap_12
XFILLER_233_443 VPWR VGND VPWR VGND sky130_ef_sc_hd__decap_12
XFILLER_206_679 VPWR VGND VPWR VGND sky130_ef_sc_hd__decap_12
X_516_ _260_ _266_ VGND VGND VPWR VPWR acc_core.adder.cla_blocks\[7\].block.sum\[3\]
+ sky130_fd_sc_hd__xnor2_1
XFILLER_92_1220 VGND VGND VPWR VPWR sky130_fd_sc_hd__decap_6
XFILLER_166_1078 VPWR VGND VPWR VGND sky130_ef_sc_hd__decap_12
XFILLER_221_627 VPWR VGND VPWR VGND sky130_ef_sc_hd__decap_12
XPHY_EDGE_ROW_220_Left_475 VGND VGND VPWR VPWR sky130_fd_sc_hd__decap_3
XFILLER_233_498 VPWR VGND VPWR VGND sky130_ef_sc_hd__decap_12
XFILLER_18_1313 VPWR VGND VPWR VGND sky130_ef_sc_hd__decap_12
XFILLER_183_1370 VGND VGND VPWR VPWR sky130_fd_sc_hd__decap_6
X_447_ net128 net502 net88 net117 _095_ VGND VGND VPWR VPWR _236_ sky130_fd_sc_hd__o311a_1
XTAP_TAPCELL_ROW_177_1934 VGND VPWR sky130_fd_sc_hd__tapvpwrvgnd_1
XFILLER_186_531 VGND VGND VPWR VPWR sky130_fd_sc_hd__decap_6
XTAP_TAPCELL_ROW_177_1945 VGND VPWR sky130_fd_sc_hd__tapvpwrvgnd_1
XFILLER_202_863 VPWR VGND VPWR VGND sky130_ef_sc_hd__decap_12
XFILLER_18_1368 VPWR VGND VPWR VGND sky130_ef_sc_hd__decap_12
XFILLER_105_1316 VPWR VGND VPWR VGND sky130_ef_sc_hd__decap_12
XTAP_TAPCELL_ROW_177_1956 VGND VPWR sky130_fd_sc_hd__tapvpwrvgnd_1
XTAP_TAPCELL_ROW_218_3377 VGND VPWR sky130_fd_sc_hd__tapvpwrvgnd_1
XFILLER_9_232 VPWR VGND VPWR VGND sky130_ef_sc_hd__decap_12
XTAP_TAPCELL_ROW_177_1967 VGND VPWR sky130_fd_sc_hd__tapvpwrvgnd_1
XTAP_TAPCELL_ROW_218_3388 VGND VPWR sky130_fd_sc_hd__tapvpwrvgnd_1
X_378_ net592 net580 net554 VGND VGND VPWR VPWR _167_ sky130_fd_sc_hd__and3_1
XTAP_TAPCELL_ROW_173_1809 VGND VPWR sky130_fd_sc_hd__tapvpwrvgnd_1
XTAP_TAPCELL_ROW_218_3399 VGND VPWR sky130_fd_sc_hd__tapvpwrvgnd_1
XFILLER_9_265 VGND VGND VPWR VPWR sky130_fd_sc_hd__decap_8
XTAP_TAPCELL_ROW_135_2_5744 VGND VPWR sky130_fd_sc_hd__tapvpwrvgnd_1
XTAP_TAPCELL_ROW_104_2_5491 VGND VPWR sky130_fd_sc_hd__tapvpwrvgnd_1
XFILLER_6_961 VGND VGND VPWR VPWR sky130_fd_sc_hd__decap_6
XFILLER_177_1174 VPWR VGND VPWR VGND sky130_ef_sc_hd__decap_12
XFILLER_48_3 VPWR VGND VPWR VGND sky130_ef_sc_hd__decap_12
XFILLER_29_1464 VPWR VGND VPWR VGND sky130_ef_sc_hd__decap_12
XFILLER_116_1423 VPWR VGND VPWR VGND sky130_ef_sc_hd__decap_12
XFILLER_60_1208 VPWR VGND VPWR VGND sky130_ef_sc_hd__decap_12
XTAP_TAPCELL_ROW_53_2_5088 VGND VPWR sky130_fd_sc_hd__tapvpwrvgnd_1
XFILLER_25_1328 VGND VGND VPWR VPWR sky130_fd_sc_hd__decap_6
XFILLER_214_1035 VPWR VGND VPWR VGND sky130_ef_sc_hd__decap_12
XFILLER_205_44 VPWR VGND VPWR VGND sky130_ef_sc_hd__decap_12
XFILLER_64_1399 VPWR VGND VPWR VGND sky130_ef_sc_hd__decap_12
XFILLER_151_1347 VPWR VGND VPWR VGND sky130_ef_sc_hd__decap_12
XFILLER_116_1478 VGND VGND VPWR VPWR sky130_fd_sc_hd__decap_6
XFILLER_228_237 VPWR VGND VPWR VGND sky130_ef_sc_hd__decap_12
XFILLER_7_1260 VPWR VGND VPWR VGND sky130_ef_sc_hd__decap_12
XFILLER_205_99 VPWR VGND VPWR VGND sky130_ef_sc_hd__decap_12
XTAP_TAPCELL_ROW_255_4702 VGND VPWR sky130_fd_sc_hd__tapvpwrvgnd_1
XFILLER_224_421 VPWR VGND VPWR VGND sky130_ef_sc_hd__decap_12
XTAP_TAPCELL_ROW_255_4713 VGND VPWR sky130_fd_sc_hd__tapvpwrvgnd_1
XFILLER_188_1281 VPWR VGND VPWR VGND sky130_ef_sc_hd__decap_12
XTAP_TAPCELL_ROW_255_4724 VGND VPWR sky130_fd_sc_hd__tapvpwrvgnd_1
XFILLER_236_292 VPWR VGND VPWR VGND sky130_ef_sc_hd__decap_12
XTAP_TAPCELL_ROW_255_4735 VGND VPWR sky130_fd_sc_hd__tapvpwrvgnd_1
XFILLER_251_240 VPWR VGND VPWR VGND sky130_ef_sc_hd__decap_12
XFILLER_212_605 VPWR VGND VPWR VGND sky130_ef_sc_hd__decap_12
XFILLER_240_925 VPWR VGND VPWR VGND sky130_ef_sc_hd__decap_12
XFILLER_197_818 VPWR VGND VPWR VGND sky130_ef_sc_hd__decap_12
XFILLER_224_476 VPWR VGND VPWR VGND sky130_ef_sc_hd__decap_12
XFILLER_252_796 VPWR VGND VPWR VGND sky130_ef_sc_hd__decap_12
XFILLER_221_87 VPWR VGND VPWR VGND sky130_ef_sc_hd__decap_12
XFILLER_251_295 VGND VGND VPWR VPWR sky130_fd_sc_hd__decap_6
XFILLER_71_1304 VPWR VGND VPWR VGND sky130_ef_sc_hd__decap_12
XFILLER_225_1131 VPWR VGND VPWR VGND sky130_ef_sc_hd__decap_12
XFILLER_36_1435 VGND VGND VPWR VPWR sky130_fd_sc_hd__decap_6
XFILLER_162_1454 VPWR VGND VPWR VGND sky130_ef_sc_hd__decap_12
XFILLER_71_1359 VPWR VGND VPWR VGND sky130_ef_sc_hd__decap_12
XFILLER_177_553 VGND VGND VPWR VPWR sky130_fd_sc_hd__decap_6
XFILLER_220_660 VGND VGND VPWR VPWR sky130_fd_sc_hd__decap_6
XFILLER_225_1186 VPWR VGND VPWR VGND sky130_ef_sc_hd__decap_12
XFILLER_165_715 VPWR VGND VPWR VGND sky130_ef_sc_hd__decap_12
XFILLER_197_1506 VGND VGND VPWR VPWR sky130_fd_sc_hd__decap_8
XFILLER_165_748 VGND VGND VPWR VPWR sky130_fd_sc_hd__decap_8
XFILLER_238_1514 VGND VGND VPWR VPWR sky130_fd_sc_hd__fill_1
XFILLER_195_1241 VGND VGND VPWR VPWR sky130_fd_sc_hd__decap_6
XFILLER_172_280 VPWR VGND VPWR VGND sky130_ef_sc_hd__decap_12
XFILLER_59_27 VPWR VGND VPWR VGND sky130_ef_sc_hd__decap_12
XFILLER_82_1411 VPWR VGND VPWR VGND sky130_ef_sc_hd__decap_12
XTAP_TAPCELL_ROW_107_1_1390 VGND VPWR sky130_fd_sc_hd__tapvpwrvgnd_1
XTAP_TAPCELL_ROW_187_2285 VGND VPWR sky130_fd_sc_hd__tapvpwrvgnd_1
XFILLER_8_1035 VPWR VGND VPWR VGND sky130_ef_sc_hd__decap_12
XFILLER_82_1466 VPWR VGND VPWR VGND sky130_ef_sc_hd__decap_12
XTAP_TAPCELL_ROW_187_2296 VGND VPWR sky130_fd_sc_hd__tapvpwrvgnd_1
XFILLER_236_1293 VPWR VGND VPWR VGND sky130_ef_sc_hd__decap_12
XFILLER_115_44 VPWR VGND VPWR VGND sky130_ef_sc_hd__decap_12
XTAP_TAPCELL_ROW_183_2149 VGND VPWR sky130_fd_sc_hd__tapvpwrvgnd_1
XFILLER_75_15 VPWR VGND VPWR VGND sky130_ef_sc_hd__decap_12
XFILLER_210_1422 VPWR VGND VPWR VGND sky130_ef_sc_hd__decap_12
XFILLER_219_259 VPWR VGND VPWR VGND sky130_ef_sc_hd__decap_12
XFILLER_189_1045 VPWR VGND VPWR VGND sky130_ef_sc_hd__decap_12
XTAP_TAPCELL_ROW_3_964 VGND VPWR sky130_fd_sc_hd__tapvpwrvgnd_1
XFILLER_234_218 VPWR VGND VPWR VGND sky130_ef_sc_hd__decap_12
XTAP_TAPCELL_ROW_3_975 VGND VPWR sky130_fd_sc_hd__tapvpwrvgnd_1
XTAP_TAPCELL_ROW_3_986 VGND VPWR sky130_fd_sc_hd__tapvpwrvgnd_1
XTAP_TAPCELL_ROW_3_997 VGND VPWR sky130_fd_sc_hd__tapvpwrvgnd_1
XFILLER_210_1477 VGND VGND VPWR VPWR sky130_fd_sc_hd__decap_6
XFILLER_199_111 VPWR VGND VPWR VGND sky130_ef_sc_hd__decap_12
XFILLER_215_443 VPWR VGND VPWR VGND sky130_ef_sc_hd__decap_12
XFILLER_230_402 VGND VGND VPWR VPWR sky130_fd_sc_hd__decap_6
XFILLER_242_273 VGND VGND VPWR VPWR sky130_fd_sc_hd__decap_6
XFILLER_163_1218 VPWR VGND VPWR VGND sky130_ef_sc_hd__decap_12
XFILLER_199_166 VGND VGND VPWR VPWR sky130_fd_sc_hd__decap_6
XFILLER_203_627 VPWR VGND VPWR VGND sky130_ef_sc_hd__decap_12
XFILLER_128_1349 VGND VGND VPWR VPWR sky130_fd_sc_hd__decap_6
XTAP_TAPCELL_ROW_141_2_5787 VGND VPWR sky130_fd_sc_hd__tapvpwrvgnd_1
XFILLER_152_3 VPWR VGND VPWR VGND sky130_ef_sc_hd__decap_12
XFILLER_215_498 VPWR VGND VPWR VGND sky130_ef_sc_hd__decap_12
XFILLER_231_947 VPWR VGND VPWR VGND sky130_ef_sc_hd__decap_12
X_301_ net519 VGND VGND VPWR VPWR _090_ sky130_fd_sc_hd__inv_2
XFILLER_168_531 VGND VGND VPWR VPWR sky130_fd_sc_hd__decap_6
XFILLER_196_851 VPWR VGND VPWR VGND sky130_ef_sc_hd__decap_12
XFILLER_204_1226 VPWR VGND VPWR VGND sky130_ef_sc_hd__decap_12
XTAP_TAPCELL_ROW_121_2_5630 VGND VPWR sky130_fd_sc_hd__tapvpwrvgnd_1
Xwire601 net602 VGND VGND VPWR VPWR net601 sky130_fd_sc_hd__clkbuf_1
XPHY_EDGE_ROW_127_1_Right_783 VGND VGND VPWR VPWR sky130_fd_sc_hd__decap_3
XFILLER_211_682 VGND VGND VPWR VPWR sky130_fd_sc_hd__decap_6
Xwire623 net5 VGND VGND VPWR VPWR net623 sky130_fd_sc_hd__clkbuf_1
Xwire634 net35 VGND VGND VPWR VPWR net634 sky130_fd_sc_hd__buf_1
XFILLER_52_1270 VPWR VGND VPWR VGND sky130_ef_sc_hd__decap_12
XFILLER_17_1390 VPWR VGND VPWR VGND sky130_ef_sc_hd__decap_12
Xwire645 net26 VGND VGND VPWR VPWR net645 sky130_fd_sc_hd__buf_1
XTAP_TAPCELL_ROW_232_3864 VGND VPWR sky130_fd_sc_hd__tapvpwrvgnd_1
Xwire656 net17 VGND VGND VPWR VPWR net656 sky130_fd_sc_hd__buf_1
XTAP_TAPCELL_ROW_232_3875 VGND VPWR sky130_fd_sc_hd__tapvpwrvgnd_1
XTAP_TAPCELL_ROW_232_3886 VGND VPWR sky130_fd_sc_hd__tapvpwrvgnd_1
XFILLER_170_206 VPWR VGND VPWR VGND sky130_ef_sc_hd__decap_12
XFILLER_237_1002 VPWR VGND VPWR VGND sky130_ef_sc_hd__decap_12
XFILLER_48_1306 VGND VGND VPWR VPWR sky130_fd_sc_hd__decap_6
XFILLER_139_1445 VPWR VGND VPWR VGND sky130_ef_sc_hd__decap_12
XFILLER_174_1336 VPWR VGND VPWR VGND sky130_ef_sc_hd__decap_12
XFILLER_237_1057 VPWR VGND VPWR VGND sky130_ef_sc_hd__decap_12
XFILLER_2_452 VGND VGND VPWR VPWR sky130_fd_sc_hd__fill_1
XPHY_EDGE_ROW_63_2_Right_154 VGND VGND VPWR VPWR sky130_fd_sc_hd__decap_3
XTAP_TAPCELL_ROW_207_3001 VGND VPWR sky130_fd_sc_hd__tapvpwrvgnd_1
XTAP_TAPCELL_ROW_207_3012 VGND VPWR sky130_fd_sc_hd__tapvpwrvgnd_1
XFILLER_49_60 VGND VGND VPWR VPWR sky130_fd_sc_hd__decap_8
XTAP_TAPCELL_ROW_226_3657 VGND VPWR sky130_fd_sc_hd__tapvpwrvgnd_1
XTAP_TAPCELL_ROW_226_3668 VGND VPWR sky130_fd_sc_hd__tapvpwrvgnd_1
XFILLER_215_1377 VPWR VGND VPWR VGND sky130_ef_sc_hd__decap_12
XTAP_TAPCELL_ROW_226_3679 VGND VPWR sky130_fd_sc_hd__tapvpwrvgnd_1
XFILLER_1_23 VPWR VGND VPWR VGND sky130_ef_sc_hd__decap_12
XFILLER_4_1422 VPWR VGND VPWR VGND sky130_ef_sc_hd__decap_12
XFILLER_1_56 VPWR VGND VPWR VGND sky130_ef_sc_hd__decap_12
XFILLER_150_1380 VPWR VGND VPWR VGND sky130_ef_sc_hd__decap_12
XFILLER_59_1402 VPWR VGND VPWR VGND sky130_ef_sc_hd__decap_12
XFILLER_4_1477 VGND VGND VPWR VPWR sky130_fd_sc_hd__decap_6
XFILLER_206_421 VPWR VGND VPWR VGND sky130_ef_sc_hd__decap_12
XFILLER_218_292 VPWR VGND VPWR VGND sky130_ef_sc_hd__decap_12
XFILLER_185_1432 VPWR VGND VPWR VGND sky130_ef_sc_hd__decap_12
XFILLER_248_1164 VPWR VGND VPWR VGND sky130_ef_sc_hd__decap_12
XFILLER_59_1457 VGND VGND VPWR VPWR sky130_fd_sc_hd__decap_6
XFILLER_94_1337 VPWR VGND VPWR VGND sky130_ef_sc_hd__decap_12
XFILLER_233_240 VPWR VGND VPWR VGND sky130_ef_sc_hd__decap_12
XFILLER_179_818 VPWR VGND VPWR VGND sky130_ef_sc_hd__decap_12
XFILLER_206_476 VPWR VGND VPWR VGND sky130_ef_sc_hd__decap_12
XFILLER_222_925 VPWR VGND VPWR VGND sky130_ef_sc_hd__decap_12
XTAP_TAPCELL_ROW_37_1_1285 VGND VPWR sky130_fd_sc_hd__tapvpwrvgnd_1
XFILLER_234_796 VPWR VGND VPWR VGND sky130_ef_sc_hd__decap_12
XFILLER_185_1487 VPWR VGND VPWR VGND sky130_ef_sc_hd__decap_12
XFILLER_221_424 VGND VGND VPWR VPWR sky130_fd_sc_hd__decap_6
XFILLER_233_295 VGND VGND VPWR VPWR sky130_fd_sc_hd__decap_6
XFILLER_202_660 VGND VGND VPWR VPWR sky130_fd_sc_hd__decap_6
XFILLER_226_1484 VPWR VGND VPWR VGND sky130_ef_sc_hd__decap_12
XFILLER_18_1165 VPWR VGND VPWR VGND sky130_ef_sc_hd__decap_12
XFILLER_230_980 VPWR VGND VPWR VGND sky130_ef_sc_hd__decap_12
XFILLER_187_873 VPWR VGND VPWR VGND sky130_ef_sc_hd__decap_12
XFILLER_222_1348 VGND VGND VPWR VPWR sky130_fd_sc_hd__decap_6
XFILLER_144_1184 VPWR VGND VPWR VGND sky130_ef_sc_hd__decap_12
XTAP_TAPCELL_ROW_125_1_1417 VGND VPWR sky130_fd_sc_hd__tapvpwrvgnd_1
XFILLER_197_80 VGND VGND VPWR VPWR sky130_fd_sc_hd__decap_6
XFILLER_70_1392 VGND VGND VPWR VPWR sky130_fd_sc_hd__decap_6
XFILLER_6_791 VGND VGND VPWR VPWR sky130_fd_sc_hd__fill_1
XFILLER_255_1135 VPWR VGND VPWR VGND sky130_ef_sc_hd__decap_12
XFILLER_255_1168 VGND VGND VPWR VPWR sky130_fd_sc_hd__decap_8
XFILLER_29_1261 VPWR VGND VPWR VGND sky130_ef_sc_hd__decap_12
XFILLER_216_65 VPWR VGND VPWR VGND sky130_ef_sc_hd__decap_12
XPHY_EDGE_ROW_134_2_Left_636 VGND VGND VPWR VPWR sky130_fd_sc_hd__decap_3
XFILLER_116_1220 VGND VGND VPWR VPWR sky130_fd_sc_hd__decap_6
XFILLER_233_1444 VPWR VGND VPWR VGND sky130_ef_sc_hd__decap_12
XFILLER_9_1366 VPWR VGND VPWR VGND sky130_ef_sc_hd__decap_12
XFILLER_64_1196 VPWR VGND VPWR VGND sky130_ef_sc_hd__decap_12
XFILLER_9_1399 VGND VGND VPWR VPWR sky130_fd_sc_hd__decap_8
XFILLER_233_1499 VGND VGND VPWR VPWR sky130_fd_sc_hd__decap_6
XFILLER_151_1177 VPWR VGND VPWR VGND sky130_ef_sc_hd__decap_12
XFILLER_186_1207 VPWR VGND VPWR VGND sky130_ef_sc_hd__decap_12
XFILLER_216_218 VPWR VGND VPWR VGND sky130_ef_sc_hd__decap_12
XFILLER_244_538 VPWR VGND VPWR VGND sky130_ef_sc_hd__decap_12
XTAP_TAPCELL_ROW_126_2_5667 VGND VPWR sky130_fd_sc_hd__tapvpwrvgnd_1
XTAP_TAPCELL_ROW_94_2_5412 VGND VPWR sky130_fd_sc_hd__tapvpwrvgnd_1
XFILLER_212_402 VGND VGND VPWR VPWR sky130_fd_sc_hd__decap_6
XFILLER_197_615 VPWR VGND VPWR VGND sky130_ef_sc_hd__decap_12
XFILLER_213_947 VPWR VGND VPWR VGND sky130_ef_sc_hd__decap_12
XFILLER_224_273 VGND VGND VPWR VPWR sky130_fd_sc_hd__decap_6
XFILLER_227_1248 VPWR VGND VPWR VGND sky130_ef_sc_hd__decap_12
XFILLER_240_722 VPWR VGND VPWR VGND sky130_ef_sc_hd__decap_12
XFILLER_252_593 VPWR VGND VPWR VGND sky130_ef_sc_hd__decap_12
XTAP_TAPCELL_ROW_106_2_5510 VGND VPWR sky130_fd_sc_hd__tapvpwrvgnd_1
XFILLER_101_68 VGND VGND VPWR VPWR sky130_fd_sc_hd__decap_3
XFILLER_240_777 VPWR VGND VPWR VGND sky130_ef_sc_hd__decap_12
XTAP_TAPCELL_ROW_195_2565 VGND VPWR sky130_fd_sc_hd__tapvpwrvgnd_1
XFILLER_61_39 VGND VGND VPWR VPWR sky130_fd_sc_hd__decap_4
XFILLER_75_1292 VPWR VGND VPWR VGND sky130_ef_sc_hd__decap_12
XFILLER_178_851 VPWR VGND VPWR VGND sky130_ef_sc_hd__decap_12
XTAP_TAPCELL_ROW_195_2576 VGND VPWR sky130_fd_sc_hd__tapvpwrvgnd_1
XFILLER_127_1371 VGND VGND VPWR VPWR sky130_fd_sc_hd__decap_6
XFILLER_162_1251 VPWR VGND VPWR VGND sky130_ef_sc_hd__decap_12
XTAP_TAPCELL_ROW_195_2587 VGND VPWR sky130_fd_sc_hd__tapvpwrvgnd_1
XTAP_TAPCELL_ROW_191_2429 VGND VPWR sky130_fd_sc_hd__tapvpwrvgnd_1
XTAP_TAPCELL_ROW_195_2598 VGND VPWR sky130_fd_sc_hd__tapvpwrvgnd_1
XTAP_TAPCELL_ROW_160_1_1469 VGND VPWR sky130_fd_sc_hd__tapvpwrvgnd_1
XFILLER_177_39 VGND VGND VPWR VPWR sky130_fd_sc_hd__decap_4
XTAP_TAPCELL_ROW_29_2_4894 VGND VPWR sky130_fd_sc_hd__tapvpwrvgnd_1
XFILLER_197_1303 VPWR VGND VPWR VGND sky130_ef_sc_hd__decap_12
XFILLER_71_1189 VPWR VGND VPWR VGND sky130_ef_sc_hd__decap_12
XFILLER_193_854 VGND VGND VPWR VPWR sky130_fd_sc_hd__decap_6
XFILLER_101_1500 VGND VGND VPWR VPWR sky130_fd_sc_hd__decap_6
XPHY_EDGE_ROW_148_1_Left_403 VGND VGND VPWR VPWR sky130_fd_sc_hd__decap_3
XFILLER_197_1358 VPWR VGND VPWR VGND sky130_ef_sc_hd__decap_12
XFILLER_165_589 VPWR VGND VPWR VGND sky130_ef_sc_hd__decap_12
XFILLER_4_739 VGND VGND VPWR VPWR sky130_fd_sc_hd__decap_3
XFILLER_193_27 VPWR VGND VPWR VGND sky130_ef_sc_hd__decap_12
XTAP_TAPCELL_ROW_189_2358 VGND VPWR sky130_fd_sc_hd__tapvpwrvgnd_1
XFILLER_238_1355 VPWR VGND VPWR VGND sky130_ef_sc_hd__decap_12
XTAP_TAPCELL_ROW_189_2369 VGND VPWR sky130_fd_sc_hd__tapvpwrvgnd_1
XPHY_EDGE_ROW_66_2_Left_568 VGND VGND VPWR VPWR sky130_fd_sc_hd__decap_3
XFILLER_10_65 VGND VGND VPWR VPWR sky130_fd_sc_hd__decap_6
XFILLER_234_1219 VGND VGND VPWR VPWR sky130_fd_sc_hd__decap_6
XTAP_TAPCELL_ROW_22_2_4837 VGND VPWR sky130_fd_sc_hd__tapvpwrvgnd_1
XFILLER_126_65 VGND VGND VPWR VPWR sky130_fd_sc_hd__decap_6
XFILLER_82_1263 VGND VGND VPWR VPWR sky130_fd_sc_hd__decap_6
XFILLER_236_1090 VGND VGND VPWR VPWR sky130_fd_sc_hd__decap_6
XFILLER_0_967 VPWR VGND VPWR VGND sky130_ef_sc_hd__decap_12
XFILLER_86_58 VGND VGND VPWR VPWR sky130_fd_sc_hd__decap_6
XFILLER_130_1239 VPWR VGND VPWR VGND sky130_ef_sc_hd__decap_12
XFILLER_215_240 VPWR VGND VPWR VGND sky130_ef_sc_hd__decap_12
XFILLER_250_519 VPWR VGND VPWR VGND sky130_ef_sc_hd__decap_12
XFILLER_245_1315 VPWR VGND VPWR VGND sky130_ef_sc_hd__decap_12
XFILLER_243_560 VPWR VGND VPWR VGND sky130_ef_sc_hd__decap_12
XFILLER_204_925 VPWR VGND VPWR VGND sky130_ef_sc_hd__decap_12
XFILLER_167_1162 VPWR VGND VPWR VGND sky130_ef_sc_hd__decap_12
XFILLER_216_796 VPWR VGND VPWR VGND sky130_ef_sc_hd__decap_12
XFILLER_203_424 VGND VGND VPWR VPWR sky130_fd_sc_hd__decap_6
XFILLER_231_744 VPWR VGND VPWR VGND sky130_ef_sc_hd__decap_12
XFILLER_215_295 VGND VGND VPWR VPWR sky130_fd_sc_hd__decap_6
XFILLER_188_648 VPWR VGND VPWR VGND sky130_ef_sc_hd__decap_12
XFILLER_106_1411 VPWR VGND VPWR VGND sky130_ef_sc_hd__decap_12
XFILLER_231_799 VPWR VGND VPWR VGND sky130_ef_sc_hd__decap_12
XFILLER_169_873 VPWR VGND VPWR VGND sky130_ef_sc_hd__decap_12
XFILLER_204_1023 VPWR VGND VPWR VGND sky130_ef_sc_hd__decap_12
XFILLER_212_980 VPWR VGND VPWR VGND sky130_ef_sc_hd__decap_12
XTAP_TAPCELL_ROW_234_3937 VGND VPWR sky130_fd_sc_hd__tapvpwrvgnd_1
XFILLER_15_1316 VPWR VGND VPWR VGND sky130_ef_sc_hd__decap_12
XTAP_TAPCELL_ROW_234_3948 VGND VPWR sky130_fd_sc_hd__tapvpwrvgnd_1
XTAP_TAPCELL_ROW_234_3959 VGND VPWR sky130_fd_sc_hd__tapvpwrvgnd_1
XFILLER_141_1335 VPWR VGND VPWR VGND sky130_ef_sc_hd__decap_12
XFILLER_184_832 VGND VGND VPWR VPWR sky130_fd_sc_hd__decap_6
Xwire420 net421 VGND VGND VPWR VPWR net420 sky130_fd_sc_hd__clkbuf_1
XFILLER_106_1466 VPWR VGND VPWR VGND sky130_ef_sc_hd__decap_12
Xwire431 net432 VGND VGND VPWR VPWR net431 sky130_fd_sc_hd__clkbuf_1
XPHY_EDGE_ROW_128_1_Right_784 VGND VGND VPWR VPWR sky130_fd_sc_hd__decap_3
Xwire442 net443 VGND VGND VPWR VPWR net442 sky130_fd_sc_hd__clkbuf_1
XFILLER_204_1078 VPWR VGND VPWR VGND sky130_ef_sc_hd__decap_12
Xwire453 net454 VGND VGND VPWR VPWR net453 sky130_fd_sc_hd__clkbuf_1
XFILLER_221_1370 VGND VGND VPWR VPWR sky130_fd_sc_hd__decap_6
XFILLER_239_1119 VPWR VGND VPWR VGND sky130_ef_sc_hd__decap_12
Xwire464 net465 VGND VGND VPWR VPWR net464 sky130_fd_sc_hd__clkbuf_1
XPHY_EDGE_ROW_132_1_Left_387 VGND VGND VPWR VPWR sky130_fd_sc_hd__decap_3
Xmax_cap208 _179_ VGND VGND VPWR VPWR net208 sky130_fd_sc_hd__clkbuf_1
Xwire475 net476 VGND VGND VPWR VPWR net475 sky130_fd_sc_hd__clkbuf_1
Xwire486 net487 VGND VGND VPWR VPWR net486 sky130_fd_sc_hd__clkbuf_1
Xmax_cap219 _164_ VGND VGND VPWR VPWR net219 sky130_fd_sc_hd__clkbuf_1
Xwire497 _123_ VGND VGND VPWR VPWR net497 sky130_fd_sc_hd__clkbuf_1
XFILLER_139_1242 VGND VGND VPWR VPWR sky130_fd_sc_hd__decap_6
XFILLER_174_1133 VGND VGND VPWR VPWR sky130_fd_sc_hd__decap_6
XTAP_TAPCELL_ROW_228_3719 VGND VPWR sky130_fd_sc_hd__tapvpwrvgnd_1
XFILLER_3_783 VGND VGND VPWR VPWR sky130_fd_sc_hd__decap_3
XFILLER_3_794 VGND VGND VPWR VPWR sky130_fd_sc_hd__fill_2
XFILLER_239_811 VGND VGND VPWR VPWR sky130_fd_sc_hd__decap_6
XFILLER_26_1423 VPWR VGND VPWR VGND sky130_ef_sc_hd__decap_12
XPHY_EDGE_ROW_64_2_Right_155 VGND VGND VPWR VPWR sky130_fd_sc_hd__decap_3
XFILLER_152_1442 VPWR VGND VPWR VGND sky130_ef_sc_hd__decap_12
XFILLER_250_1054 VPWR VGND VPWR VGND sky130_ef_sc_hd__decap_12
XFILLER_61_1347 VPWR VGND VPWR VGND sky130_ef_sc_hd__decap_12
XFILLER_215_1174 VPWR VGND VPWR VGND sky130_ef_sc_hd__decap_12
XFILLER_26_1478 VGND VGND VPWR VPWR sky130_fd_sc_hd__decap_6
XTAP_TAPCELL_ROW_143_2_5806 VGND VPWR sky130_fd_sc_hd__tapvpwrvgnd_1
XFILLER_152_1497 VPWR VGND VPWR VGND sky130_ef_sc_hd__decap_12
XFILLER_253_302 VPWR VGND VPWR VGND sky130_ef_sc_hd__decap_12
XFILLER_226_538 VPWR VGND VPWR VGND sky130_ef_sc_hd__decap_12
XFILLER_0_1105 VGND VGND VPWR VPWR sky130_fd_sc_hd__decap_8
XFILLER_253_357 VPWR VGND VPWR VGND sky130_ef_sc_hd__decap_12
XFILLER_98_1270 VPWR VGND VPWR VGND sky130_ef_sc_hd__decap_12
XFILLER_202_34 VPWR VGND VPWR VGND sky130_ef_sc_hd__decap_12
XFILLER_179_615 VPWR VGND VPWR VGND sky130_ef_sc_hd__decap_12
XFILLER_206_273 VGND VGND VPWR VPWR sky130_fd_sc_hd__decap_6
XFILLER_222_722 VPWR VGND VPWR VGND sky130_ef_sc_hd__decap_12
XFILLER_185_1284 VGND VGND VPWR VPWR sky130_fd_sc_hd__decap_6
XFILLER_202_89 VPWR VGND VPWR VGND sky130_ef_sc_hd__decap_12
XFILLER_234_593 VPWR VGND VPWR VGND sky130_ef_sc_hd__decap_12
XFILLER_210_906 VPWR VGND VPWR VGND sky130_ef_sc_hd__decap_12
XTAP_TAPCELL_ROW_15_2_4780 VGND VPWR sky130_fd_sc_hd__tapvpwrvgnd_1
XFILLER_222_777 VPWR VGND VPWR VGND sky130_ef_sc_hd__decap_12
XFILLER_72_1454 VPWR VGND VPWR VGND sky130_ef_sc_hd__decap_12
XFILLER_226_1281 VPWR VGND VPWR VGND sky130_ef_sc_hd__decap_12
XFILLER_187_670 VPWR VGND VPWR VGND sky130_ef_sc_hd__decap_12
XFILLER_175_854 VGND VGND VPWR VPWR sky130_fd_sc_hd__decap_6
XTAP_TAPCELL_ROW_250_4495 VGND VPWR sky130_fd_sc_hd__tapvpwrvgnd_1
XFILLER_200_1410 VPWR VGND VPWR VGND sky130_ef_sc_hd__decap_12
XFILLER_179_1033 VPWR VGND VPWR VGND sky130_ef_sc_hd__decap_12
XFILLER_179_1088 VPWR VGND VPWR VGND sky130_ef_sc_hd__decap_12
XFILLER_200_1465 VPWR VGND VPWR VGND sky130_ef_sc_hd__decap_12
XFILLER_235_1506 VGND VGND VPWR VPWR sky130_fd_sc_hd__decap_8
XFILLER_196_1391 VGND VGND VPWR VPWR sky130_fd_sc_hd__decap_6
XFILLER_153_1206 VPWR VGND VPWR VGND sky130_ef_sc_hd__decap_12
XFILLER_118_1337 VPWR VGND VPWR VGND sky130_ef_sc_hd__decap_12
XFILLER_170_581 VPWR VGND VPWR VGND sky130_ef_sc_hd__decap_12
XTAP_TAPCELL_ROW_184_2200 VGND VPWR sky130_fd_sc_hd__tapvpwrvgnd_1
XTAP_TAPCELL_ROW_184_2211 VGND VPWR sky130_fd_sc_hd__tapvpwrvgnd_1
XFILLER_233_1241 VGND VGND VPWR VPWR sky130_fd_sc_hd__decap_6
XTAP_TAPCELL_ROW_244_4288 VGND VPWR sky130_fd_sc_hd__tapvpwrvgnd_1
XTAP_TAPCELL_ROW_244_4299 VGND VPWR sky130_fd_sc_hd__tapvpwrvgnd_1
XFILLER_186_1004 VGND VGND VPWR VPWR sky130_fd_sc_hd__decap_6
XFILLER_244_335 VPWR VGND VPWR VGND sky130_ef_sc_hd__decap_12
XTAP_TAPCELL_ROW_6_1077 VGND VPWR sky130_fd_sc_hd__tapvpwrvgnd_1
XTAP_TAPCELL_ROW_6_1088 VGND VPWR sky130_fd_sc_hd__tapvpwrvgnd_1
XFILLER_112_34 VPWR VGND VPWR VGND sky130_ef_sc_hd__decap_12
XFILLER_232_519 VPWR VGND VPWR VGND sky130_ef_sc_hd__decap_12
XTAP_TAPCELL_ROW_6_1099 VGND VPWR sky130_fd_sc_hd__tapvpwrvgnd_1
XFILLER_225_560 VPWR VGND VPWR VGND sky130_ef_sc_hd__decap_12
XTAP_TAPCELL_ROW_197_2638 VGND VPWR sky130_fd_sc_hd__tapvpwrvgnd_1
XFILLER_129_1433 VPWR VGND VPWR VGND sky130_ef_sc_hd__decap_12
XFILLER_164_1313 VPWR VGND VPWR VGND sky130_ef_sc_hd__decap_12
XTAP_TAPCELL_ROW_197_2649 VGND VPWR sky130_fd_sc_hd__tapvpwrvgnd_1
XFILLER_197_412 VPWR VGND VPWR VGND sky130_ef_sc_hd__decap_12
XFILLER_73_1218 VPWR VGND VPWR VGND sky130_ef_sc_hd__decap_12
XFILLER_213_744 VPWR VGND VPWR VGND sky130_ef_sc_hd__decap_12
XFILLER_227_1045 VPWR VGND VPWR VGND sky130_ef_sc_hd__decap_12
XFILLER_252_390 VPWR VGND VPWR VGND sky130_ef_sc_hd__decap_12
XFILLER_38_1349 VGND VGND VPWR VPWR sky130_fd_sc_hd__decap_6
XFILLER_198_968 VPWR VGND VPWR VGND sky130_ef_sc_hd__decap_12
XFILLER_129_1488 VPWR VGND VPWR VGND sky130_ef_sc_hd__decap_12
XFILLER_164_1368 VPWR VGND VPWR VGND sky130_ef_sc_hd__decap_12
XFILLER_197_467 VGND VGND VPWR VPWR sky130_fd_sc_hd__decap_6
XFILLER_201_928 VPWR VGND VPWR VGND sky130_ef_sc_hd__decap_12
XFILLER_240_574 VGND VGND VPWR VPWR sky130_fd_sc_hd__decap_6
XFILLER_213_799 VPWR VGND VPWR VGND sky130_ef_sc_hd__decap_12
XFILLER_8_319 VGND VGND VPWR VPWR sky130_fd_sc_hd__decap_3
XFILLER_166_832 VGND VGND VPWR VPWR sky130_fd_sc_hd__decap_6
XFILLER_197_1100 VPWR VGND VPWR VGND sky130_ef_sc_hd__decap_12
XFILLER_201_1229 VPWR VGND VPWR VGND sky130_ef_sc_hd__decap_12
XFILLER_115_3 VPWR VGND VPWR VGND sky130_ef_sc_hd__decap_12
XFILLER_197_1155 VGND VGND VPWR VPWR sky130_fd_sc_hd__decap_6
XFILLER_180_323 VPWR VGND VPWR VGND sky130_ef_sc_hd__decap_12
XFILLER_192_194 VPWR VGND VPWR VGND sky130_ef_sc_hd__decap_12
XFILLER_175_1420 VPWR VGND VPWR VGND sky130_ef_sc_hd__decap_12
XFILLER_238_1152 VPWR VGND VPWR VGND sky130_ef_sc_hd__decap_12
XFILLER_49_1445 VPWR VGND VPWR VGND sky130_ef_sc_hd__decap_12
XFILLER_4_569 VGND VGND VPWR VPWR sky130_fd_sc_hd__fill_2
XFILLER_84_1325 VPWR VGND VPWR VGND sky130_ef_sc_hd__decap_12
XFILLER_180_378 VPWR VGND VPWR VGND sky130_ef_sc_hd__decap_12
XFILLER_175_1475 VPWR VGND VPWR VGND sky130_ef_sc_hd__decap_12
XFILLER_97_68 VGND VGND VPWR VPWR sky130_fd_sc_hd__decap_3
XTAP_TAPCELL_ROW_54_2_5093 VGND VPWR sky130_fd_sc_hd__tapvpwrvgnd_1
XFILLER_212_1336 VPWR VGND VPWR VGND sky130_ef_sc_hd__decap_12
XFILLER_235_302 VPWR VGND VPWR VGND sky130_ef_sc_hd__decap_12
XFILLER_247_173 VPWR VGND VPWR VGND sky130_ef_sc_hd__decap_12
XFILLER_208_538 VPWR VGND VPWR VGND sky130_ef_sc_hd__decap_12
XFILLER_60_1380 VPWR VGND VPWR VGND sky130_ef_sc_hd__decap_12
XFILLER_235_357 VPWR VGND VPWR VGND sky130_ef_sc_hd__decap_12
XFILLER_95_1421 VPWR VGND VPWR VGND sky130_ef_sc_hd__decap_12
XFILLER_147_1500 VGND VGND VPWR VPWR sky130_fd_sc_hd__decap_6
XFILLER_250_316 VGND VGND VPWR VPWR sky130_fd_sc_hd__decap_6
XFILLER_245_1112 VGND VGND VPWR VPWR sky130_fd_sc_hd__decap_6
XFILLER_204_722 VPWR VGND VPWR VGND sky130_ef_sc_hd__decap_12
Xmax_cap84 net85 VGND VGND VPWR VPWR net84 sky130_fd_sc_hd__clkbuf_1
XFILLER_216_593 VPWR VGND VPWR VGND sky130_ef_sc_hd__decap_12
XFILLER_95_1476 VPWR VGND VPWR VGND sky130_ef_sc_hd__decap_12
XFILLER_231_541 VPWR VGND VPWR VGND sky130_ef_sc_hd__decap_12
XFILLER_188_445 VGND VGND VPWR VPWR sky130_fd_sc_hd__decap_6
XFILLER_204_777 VPWR VGND VPWR VGND sky130_ef_sc_hd__decap_12
XFILLER_223_1432 VPWR VGND VPWR VGND sky130_ef_sc_hd__decap_12
XFILLER_231_596 VGND VGND VPWR VPWR sky130_fd_sc_hd__decap_6
XFILLER_169_670 VPWR VGND VPWR VGND sky130_ef_sc_hd__decap_12
XFILLER_197_990 VPWR VGND VPWR VGND sky130_ef_sc_hd__decap_12
XFILLER_8_820 VPWR VGND VPWR VGND sky130_ef_sc_hd__decap_12
XFILLER_54_1184 VPWR VGND VPWR VGND sky130_ef_sc_hd__decap_12
XFILLER_106_1263 VGND VGND VPWR VPWR sky130_fd_sc_hd__decap_6
XFILLER_200_961 VGND VGND VPWR VPWR sky130_fd_sc_hd__decap_6
XFILLER_223_1487 VPWR VGND VPWR VGND sky130_ef_sc_hd__decap_12
XFILLER_141_1165 VPWR VGND VPWR VGND sky130_ef_sc_hd__decap_12
XFILLER_7_44 VPWR VGND VPWR VGND sky130_ef_sc_hd__decap_12
Xwire250 net251 VGND VGND VPWR VPWR net250 sky130_fd_sc_hd__clkbuf_1
Xwire261 net262 VGND VGND VPWR VPWR net261 sky130_fd_sc_hd__clkbuf_1
XPHY_EDGE_ROW_129_1_Right_785 VGND VGND VPWR VPWR sky130_fd_sc_hd__decap_3
Xwire272 net273 VGND VGND VPWR VPWR net272 sky130_fd_sc_hd__clkbuf_1
Xwire283 net284 VGND VGND VPWR VPWR net283 sky130_fd_sc_hd__clkbuf_1
XPHY_EDGE_ROW_170_Left_425 VGND VGND VPWR VPWR sky130_fd_sc_hd__decap_3
Xwire294 net295 VGND VGND VPWR VPWR net294 sky130_fd_sc_hd__clkbuf_1
XFILLER_171_345 VPWR VGND VPWR VGND sky130_ef_sc_hd__decap_12
XFILLER_30_3 VPWR VGND VPWR VGND sky130_ef_sc_hd__decap_12
XFILLER_26_1220 VGND VGND VPWR VPWR sky130_fd_sc_hd__decap_6
XFILLER_113_1201 VGND VGND VPWR VPWR sky130_fd_sc_hd__decap_4
XPHY_EDGE_ROW_65_2_Right_156 VGND VGND VPWR VPWR sky130_fd_sc_hd__decap_3
XTAP_TAPCELL_ROW_25_1_1267 VGND VPWR sky130_fd_sc_hd__tapvpwrvgnd_1
XFILLER_6_1336 VPWR VGND VPWR VGND sky130_ef_sc_hd__decap_12
XFILLER_238_151 VPWR VGND VPWR VGND sky130_ef_sc_hd__decap_12
XFILLER_61_1177 VPWR VGND VPWR VGND sky130_ef_sc_hd__decap_12
XFILLER_152_1294 VPWR VGND VPWR VGND sky130_ef_sc_hd__decap_12
XFILLER_213_44 VPWR VGND VPWR VGND sky130_ef_sc_hd__decap_12
XFILLER_226_335 VPWR VGND VPWR VGND sky130_ef_sc_hd__decap_12
XFILLER_187_1346 VPWR VGND VPWR VGND sky130_ef_sc_hd__decap_12
XFILLER_253_154 VPWR VGND VPWR VGND sky130_ef_sc_hd__decap_12
XFILLER_213_99 VPWR VGND VPWR VGND sky130_ef_sc_hd__decap_12
XFILLER_214_519 VPWR VGND VPWR VGND sky130_ef_sc_hd__decap_12
XFILLER_242_839 VPWR VGND VPWR VGND sky130_ef_sc_hd__decap_12
XFILLER_207_560 VPWR VGND VPWR VGND sky130_ef_sc_hd__decap_12
XTAP_TAPCELL_ROW_204_2881 VGND VPWR sky130_fd_sc_hd__tapvpwrvgnd_1
XFILLER_241_338 VGND VGND VPWR VPWR sky130_fd_sc_hd__decap_6
XTAP_TAPCELL_ROW_204_2892 VGND VPWR sky130_fd_sc_hd__tapvpwrvgnd_1
XFILLER_179_412 VPWR VGND VPWR VGND sky130_ef_sc_hd__decap_12
XTAP_TAPCELL_ROW_200_2745 VGND VPWR sky130_fd_sc_hd__tapvpwrvgnd_1
XFILLER_234_390 VPWR VGND VPWR VGND sky130_ef_sc_hd__decap_12
XTAP_TAPCELL_ROW_200_2756 VGND VPWR sky130_fd_sc_hd__tapvpwrvgnd_1
XFILLER_224_1207 VPWR VGND VPWR VGND sky130_ef_sc_hd__decap_12
XTAP_TAPCELL_ROW_200_2767 VGND VPWR sky130_fd_sc_hd__tapvpwrvgnd_1
XFILLER_210_703 VGND VGND VPWR VPWR sky130_fd_sc_hd__decap_6
XFILLER_228_1398 VPWR VGND VPWR VGND sky130_ef_sc_hd__decap_12
XFILLER_179_467 VGND VGND VPWR VPWR sky130_fd_sc_hd__decap_6
XFILLER_195_916 VPWR VGND VPWR VGND sky130_ef_sc_hd__decap_12
XFILLER_222_574 VGND VGND VPWR VPWR sky130_fd_sc_hd__decap_6
XFILLER_250_894 VPWR VGND VPWR VGND sky130_ef_sc_hd__decap_12
XTAP_TAPCELL_ROW_252_4568 VGND VPWR sky130_fd_sc_hd__tapvpwrvgnd_1
XTAP_TAPCELL_ROW_252_4579 VGND VPWR sky130_fd_sc_hd__tapvpwrvgnd_1
XFILLER_37_1371 VGND VGND VPWR VPWR sky130_fd_sc_hd__decap_6
XFILLER_72_1251 VPWR VGND VPWR VGND sky130_ef_sc_hd__decap_12
XFILLER_163_1390 VPWR VGND VPWR VGND sky130_ef_sc_hd__decap_12
XTAP_TAPCELL_ROW_91_2_5389 VGND VPWR sky130_fd_sc_hd__tapvpwrvgnd_1
XFILLER_11_1500 VGND VGND VPWR VPWR sky130_fd_sc_hd__decap_6
XFILLER_120_1227 VPWR VGND VPWR VGND sky130_ef_sc_hd__decap_12
XFILLER_198_1453 VPWR VGND VPWR VGND sky130_ef_sc_hd__decap_12
XTAP_TAPCELL_ROW_103_2_5487 VGND VPWR sky130_fd_sc_hd__tapvpwrvgnd_1
XFILLER_174_194 VPWR VGND VPWR VGND sky130_ef_sc_hd__decap_12
XFILLER_200_1262 VGND VGND VPWR VPWR sky130_fd_sc_hd__decap_6
XTAP_TAPCELL_ROW_71_2_5232 VGND VPWR sky130_fd_sc_hd__tapvpwrvgnd_1
XFILLER_235_1303 VPWR VGND VPWR VGND sky130_ef_sc_hd__decap_12
Xmax_cap561 net69 VGND VGND VPWR VPWR net561 sky130_fd_sc_hd__clkbuf_1
XFILLER_107_56 VPWR VGND VPWR VGND sky130_ef_sc_hd__decap_12
XFILLER_235_1358 VPWR VGND VPWR VGND sky130_ef_sc_hd__decap_12
XFILLER_67_27 VPWR VGND VPWR VGND sky130_ef_sc_hd__decap_12
XTAP_TAPCELL_ROW_37_2_4956 VGND VPWR sky130_fd_sc_hd__tapvpwrvgnd_1
XTAP_TAPCELL_ROW_8_1139 VGND VPWR sky130_fd_sc_hd__tapvpwrvgnd_1
XFILLER_217_302 VPWR VGND VPWR VGND sky130_ef_sc_hd__decap_12
XFILLER_40_1239 VPWR VGND VPWR VGND sky130_ef_sc_hd__decap_12
XFILLER_123_44 VPWR VGND VPWR VGND sky130_ef_sc_hd__decap_12
XFILLER_229_173 VPWR VGND VPWR VGND sky130_ef_sc_hd__decap_12
XFILLER_244_132 VPWR VGND VPWR VGND sky130_ef_sc_hd__decap_12
XFILLER_83_15 VPWR VGND VPWR VGND sky130_ef_sc_hd__decap_12
XFILLER_131_1378 VPWR VGND VPWR VGND sky130_ef_sc_hd__decap_12
XFILLER_217_357 VPWR VGND VPWR VGND sky130_ef_sc_hd__decap_12
XFILLER_199_15 VPWR VGND VPWR VGND sky130_ef_sc_hd__decap_12
XFILLER_246_1410 VPWR VGND VPWR VGND sky130_ef_sc_hd__decap_12
XFILLER_189_209 VGND VGND VPWR VPWR sky130_fd_sc_hd__decap_6
XFILLER_232_316 VGND VGND VPWR VPWR sky130_fd_sc_hd__decap_6
XFILLER_244_187 VGND VGND VPWR VPWR sky130_fd_sc_hd__decap_6
X_480_ net167 _246_ VGND VGND VPWR VPWR acc_core.adder.cla_blocks\[3\].block.sum\[3\]
+ sky130_fd_sc_hd__xnor2_1
XFILLER_198_710 VPWR VGND VPWR VGND sky130_ef_sc_hd__decap_12
XFILLER_129_1230 VPWR VGND VPWR VGND sky130_ef_sc_hd__decap_12
XFILLER_213_541 VPWR VGND VPWR VGND sky130_ef_sc_hd__decap_12
XFILLER_246_1465 VPWR VGND VPWR VGND sky130_ef_sc_hd__decap_12
XFILLER_241_861 VPWR VGND VPWR VGND sky130_ef_sc_hd__decap_12
XFILLER_198_765 VPWR VGND VPWR VGND sky130_ef_sc_hd__decap_12
XFILLER_164_1165 VPWR VGND VPWR VGND sky130_ef_sc_hd__decap_12
XFILLER_129_1285 VGND VGND VPWR VPWR sky130_fd_sc_hd__decap_6
XFILLER_201_725 VGND VGND VPWR VPWR sky130_fd_sc_hd__decap_6
XFILLER_16_1411 VPWR VGND VPWR VGND sky130_ef_sc_hd__decap_12
XFILLER_213_596 VGND VGND VPWR VPWR sky130_fd_sc_hd__decap_6
XFILLER_186_949 VPWR VGND VPWR VGND sky130_ef_sc_hd__decap_12
XFILLER_232_3 VPWR VGND VPWR VGND sky130_ef_sc_hd__decap_12
XFILLER_179_990 VPWR VGND VPWR VGND sky130_ef_sc_hd__decap_12
XFILLER_199_1217 VPWR VGND VPWR VGND sky130_ef_sc_hd__decap_12
XFILLER_51_1335 VPWR VGND VPWR VGND sky130_ef_sc_hd__decap_12
XFILLER_205_1162 VPWR VGND VPWR VGND sky130_ef_sc_hd__decap_12
XFILLER_16_1466 VPWR VGND VPWR VGND sky130_ef_sc_hd__decap_12
XFILLER_103_1414 VGND VGND VPWR VPWR sky130_fd_sc_hd__decap_6
XFILLER_142_1485 VPWR VGND VPWR VGND sky130_ef_sc_hd__decap_12
XFILLER_201_1026 VGND VGND VPWR VPWR sky130_fd_sc_hd__decap_6
XFILLER_240_1097 VPWR VGND VPWR VGND sky130_ef_sc_hd__decap_12
XFILLER_180_120 VPWR VGND VPWR VGND sky130_ef_sc_hd__decap_12
XFILLER_49_1242 VGND VGND VPWR VPWR sky130_fd_sc_hd__decap_6
XFILLER_180_175 VPWR VGND VPWR VGND sky130_ef_sc_hd__decap_12
XTAP_TAPCELL_ROW_210_3096 VGND VPWR sky130_fd_sc_hd__tapvpwrvgnd_1
XFILLER_175_1272 VPWR VGND VPWR VGND sky130_ef_sc_hd__decap_12
XFILLER_84_1177 VGND VGND VPWR VPWR sky130_fd_sc_hd__decap_6
XFILLER_62_1442 VPWR VGND VPWR VGND sky130_ef_sc_hd__decap_12
XFILLER_249_983 VGND VGND VPWR VPWR sky130_fd_sc_hd__decap_6
XFILLER_212_1133 VGND VGND VPWR VPWR sky130_fd_sc_hd__decap_6
XFILLER_62_1497 VPWR VGND VPWR VGND sky130_ef_sc_hd__decap_12
XTAP_TAPCELL_ROW_167_1593 VGND VPWR sky130_fd_sc_hd__tapvpwrvgnd_1
XFILLER_208_335 VPWR VGND VPWR VGND sky130_ef_sc_hd__decap_12
XTAP_TAPCELL_ROW_158_2_5925 VGND VPWR sky130_fd_sc_hd__tapvpwrvgnd_1
XFILLER_251_603 VPWR VGND VPWR VGND sky130_ef_sc_hd__decap_12
XFILLER_184_1508 VGND VGND VPWR VPWR sky130_fd_sc_hd__decap_6
XFILLER_235_154 VPWR VGND VPWR VGND sky130_ef_sc_hd__decap_12
XFILLER_247_1229 VPWR VGND VPWR VGND sky130_ef_sc_hd__decap_12
XFILLER_224_839 VPWR VGND VPWR VGND sky130_ef_sc_hd__decap_12
XFILLER_169_1076 VPWR VGND VPWR VGND sky130_ef_sc_hd__decap_12
XFILLER_223_338 VGND VGND VPWR VPWR sky130_fd_sc_hd__decap_6
XFILLER_251_658 VPWR VGND VPWR VGND sky130_ef_sc_hd__decap_12
XFILLER_95_1273 VPWR VGND VPWR VGND sky130_ef_sc_hd__decap_12
XFILLER_189_732 VPWR VGND VPWR VGND sky130_ef_sc_hd__decap_12
XFILLER_216_390 VPWR VGND VPWR VGND sky130_ef_sc_hd__decap_12
XFILLER_108_1325 VPWR VGND VPWR VGND sky130_ef_sc_hd__decap_12
XFILLER_204_574 VGND VGND VPWR VPWR sky130_fd_sc_hd__decap_6
XFILLER_177_916 VPWR VGND VPWR VGND sky130_ef_sc_hd__decap_12
XFILLER_189_787 VPWR VGND VPWR VGND sky130_ef_sc_hd__decap_12
XFILLER_232_894 VPWR VGND VPWR VGND sky130_ef_sc_hd__decap_12
XTAP_TAPCELL_ROW_76_2_5269 VGND VPWR sky130_fd_sc_hd__tapvpwrvgnd_1
XFILLER_143_1249 VPWR VGND VPWR VGND sky130_ef_sc_hd__decap_12
XPHY_EDGE_ROW_143_2_Left_645 VGND VGND VPWR VPWR sky130_fd_sc_hd__decap_3
XFILLER_78_3 VPWR VGND VPWR VGND sky130_ef_sc_hd__decap_12
XFILLER_185_971 VPWR VGND VPWR VGND sky130_ef_sc_hd__decap_12
XFILLER_223_1284 VGND VGND VPWR VPWR sky130_fd_sc_hd__decap_6
XTAP_TAPCELL_ROW_56_2_5112 VGND VPWR sky130_fd_sc_hd__tapvpwrvgnd_1
XFILLER_208_22 VPWR VGND VPWR VGND sky130_ef_sc_hd__decap_12
XFILLER_171_142 VPWR VGND VPWR VGND sky130_ef_sc_hd__decap_12
XFILLER_176_1047 VGND VGND VPWR VPWR sky130_fd_sc_hd__decap_6
XFILLER_119_1421 VPWR VGND VPWR VGND sky130_ef_sc_hd__decap_12
XFILLER_208_77 VPWR VGND VPWR VGND sky130_ef_sc_hd__decap_12
XTAP_TAPCELL_ROW_23_2_4842 VGND VPWR sky130_fd_sc_hd__tapvpwrvgnd_1
XFILLER_63_1206 VPWR VGND VPWR VGND sky130_ef_sc_hd__decap_12
XFILLER_171_197 VPWR VGND VPWR VGND sky130_ef_sc_hd__decap_12
XFILLER_217_1033 VPWR VGND VPWR VGND sky130_ef_sc_hd__decap_12
XFILLER_28_1337 VPWR VGND VPWR VGND sky130_ef_sc_hd__decap_12
XTAP_TAPCELL_ROW_241_4203 VGND VPWR sky130_fd_sc_hd__tapvpwrvgnd_1
XFILLER_154_1356 VPWR VGND VPWR VGND sky130_ef_sc_hd__decap_12
XFILLER_119_1476 VPWR VGND VPWR VGND sky130_ef_sc_hd__decap_12
XFILLER_217_1088 VPWR VGND VPWR VGND sky130_ef_sc_hd__decap_12
XFILLER_234_1391 VGND VGND VPWR VPWR sky130_fd_sc_hd__decap_6
XFILLER_6_1133 VGND VGND VPWR VPWR sky130_fd_sc_hd__decap_6
XFILLER_224_65 VPWR VGND VPWR VGND sky130_ef_sc_hd__decap_12
XPHY_EDGE_ROW_66_2_Right_157 VGND VGND VPWR VPWR sky130_fd_sc_hd__decap_3
XTAP_TAPCELL_ROW_206_2954 VGND VPWR sky130_fd_sc_hd__tapvpwrvgnd_1
XTAP_TAPCELL_ROW_206_2965 VGND VPWR sky130_fd_sc_hd__tapvpwrvgnd_1
XFILLER_226_132 VPWR VGND VPWR VGND sky130_ef_sc_hd__decap_12
XFILLER_254_452 VPWR VGND VPWR VGND sky130_ef_sc_hd__decap_12
XTAP_TAPCELL_ROW_239_4110 VGND VPWR sky130_fd_sc_hd__tapvpwrvgnd_1
XTAP_TAPCELL_ROW_239_4121 VGND VPWR sky130_fd_sc_hd__tapvpwrvgnd_1
XFILLER_187_1143 VPWR VGND VPWR VGND sky130_ef_sc_hd__decap_12
XTAP_TAPCELL_ROW_198_2700 VGND VPWR sky130_fd_sc_hd__tapvpwrvgnd_1
XTAP_TAPCELL_ROW_206_2976 VGND VPWR sky130_fd_sc_hd__tapvpwrvgnd_1
XTAP_TAPCELL_ROW_239_4132 VGND VPWR sky130_fd_sc_hd__tapvpwrvgnd_1
XPHY_EDGE_ROW_157_1_Left_412 VGND VGND VPWR VPWR sky130_fd_sc_hd__decap_3
XTAP_TAPCELL_ROW_202_2818 VGND VPWR sky130_fd_sc_hd__tapvpwrvgnd_1
XTAP_TAPCELL_ROW_202_2829 VGND VPWR sky130_fd_sc_hd__tapvpwrvgnd_1
XFILLER_214_316 VGND VGND VPWR VPWR sky130_fd_sc_hd__decap_6
XFILLER_242_636 VPWR VGND VPWR VGND sky130_ef_sc_hd__decap_12
XFILLER_199_529 VPWR VGND VPWR VGND sky130_ef_sc_hd__decap_12
XFILLER_226_187 VGND VGND VPWR VPWR sky130_fd_sc_hd__decap_6
XFILLER_187_1198 VGND VGND VPWR VPWR sky130_fd_sc_hd__decap_6
XFILLER_39_1433 VPWR VGND VPWR VGND sky130_ef_sc_hd__decap_12
XFILLER_74_1313 VPWR VGND VPWR VGND sky130_ef_sc_hd__decap_12
XFILLER_228_1140 VPWR VGND VPWR VGND sky130_ef_sc_hd__decap_12
XFILLER_165_1441 VGND VGND VPWR VPWR sky130_fd_sc_hd__decap_8
XFILLER_223_861 VPWR VGND VPWR VGND sky130_ef_sc_hd__decap_12
XFILLER_224_1004 VGND VGND VPWR VPWR sky130_fd_sc_hd__decap_6
XFILLER_39_1488 VPWR VGND VPWR VGND sky130_ef_sc_hd__decap_12
XFILLER_74_1368 VPWR VGND VPWR VGND sky130_ef_sc_hd__decap_12
XPHY_EDGE_ROW_75_2_Left_577 VGND VGND VPWR VPWR sky130_fd_sc_hd__decap_3
XFILLER_161_1316 VPWR VGND VPWR VGND sky130_ef_sc_hd__decap_12
XFILLER_195_713 VPWR VGND VPWR VGND sky130_ef_sc_hd__decap_12
XFILLER_228_1195 VPWR VGND VPWR VGND sky130_ef_sc_hd__decap_12
XFILLER_250_691 VPWR VGND VPWR VGND sky130_ef_sc_hd__decap_12
XFILLER_168_949 VPWR VGND VPWR VGND sky130_ef_sc_hd__decap_12
XFILLER_195_768 VGND VGND VPWR VPWR sky130_fd_sc_hd__decap_6
XFILLER_202_1324 VPWR VGND VPWR VGND sky130_ef_sc_hd__decap_12
XFILLER_159_1201 VGND VGND VPWR VPWR sky130_fd_sc_hd__decap_4
XFILLER_198_1250 VPWR VGND VPWR VGND sky130_ef_sc_hd__decap_12
XFILLER_185_39 VGND VGND VPWR VPWR sky130_fd_sc_hd__decap_4
XFILLER_202_1379 VPWR VGND VPWR VGND sky130_ef_sc_hd__decap_12
XFILLER_118_22 VPWR VGND VPWR VGND sky130_ef_sc_hd__decap_12
XFILLER_78_15 VGND VGND VPWR VPWR sky130_fd_sc_hd__decap_6
XFILLER_235_1100 VPWR VGND VPWR VGND sky130_ef_sc_hd__decap_12
XFILLER_2_837 VGND VGND VPWR VPWR sky130_fd_sc_hd__fill_1
XFILLER_190_495 VPWR VGND VPWR VGND sky130_ef_sc_hd__decap_12
XFILLER_239_1291 VPWR VGND VPWR VGND sky130_ef_sc_hd__decap_12
XFILLER_85_1464 VPWR VGND VPWR VGND sky130_ef_sc_hd__decap_12
XFILLER_172_1434 VGND VGND VPWR VPWR sky130_fd_sc_hd__decap_6
XFILLER_81_1328 VGND VGND VPWR VPWR sky130_fd_sc_hd__decap_6
XFILLER_235_1155 VGND VGND VPWR VPWR sky130_fd_sc_hd__decap_6
XFILLER_213_1420 VPWR VGND VPWR VGND sky130_ef_sc_hd__decap_12
XTAP_TAPCELL_ROW_144_2_5811 VGND VPWR sky130_fd_sc_hd__tapvpwrvgnd_1
XFILLER_134_65 VGND VGND VPWR VPWR sky130_fd_sc_hd__decap_6
XFILLER_213_1475 VPWR VGND VPWR VGND sky130_ef_sc_hd__decap_12
XPHY_EDGE_ROW_89_1_Left_344 VGND VGND VPWR VPWR sky130_fd_sc_hd__decap_3
XFILLER_182_3 VPWR VGND VPWR VGND sky130_ef_sc_hd__decap_12
X_601_ clknet_3_3__leaf_clk net689 _009_ VGND VGND VPWR VPWR valid_d2 sky130_fd_sc_hd__dfrtp_1
XFILLER_94_58 VGND VGND VPWR VPWR sky130_fd_sc_hd__decap_6
XFILLER_217_154 VPWR VGND VPWR VGND sky130_ef_sc_hd__decap_12
XFILLER_233_603 VPWR VGND VPWR VGND sky130_ef_sc_hd__decap_12
XFILLER_245_474 VPWR VGND VPWR VGND sky130_ef_sc_hd__decap_12
X_532_ net666 VGND VGND VPWR VPWR _014_ sky130_fd_sc_hd__inv_2
XPHY_EDGE_ROW_141_1_Left_396 VGND VGND VPWR VPWR sky130_fd_sc_hd__decap_3
XFILLER_206_839 VPWR VGND VPWR VGND sky130_ef_sc_hd__decap_12
XFILLER_57_1500 VGND VGND VPWR VPWR sky130_fd_sc_hd__decap_6
XFILLER_205_338 VGND VGND VPWR VPWR sky130_fd_sc_hd__decap_6
XFILLER_166_1238 VPWR VGND VPWR VGND sky130_ef_sc_hd__decap_12
XTAP_TAPCELL_ROW_93_2_5408 VGND VPWR sky130_fd_sc_hd__tapvpwrvgnd_1
XFILLER_233_658 VPWR VGND VPWR VGND sky130_ef_sc_hd__decap_12
X_463_ net148 net147 VGND VGND VPWR VPWR acc_core.adder.cla_blocks\[0\].block.sum\[2\]
+ sky130_fd_sc_hd__xnor2_1
XFILLER_246_1262 VGND VGND VPWR VPWR sky130_fd_sc_hd__decap_6
XTAP_TAPCELL_ROW_62_2_5155 VGND VPWR sky130_fd_sc_hd__tapvpwrvgnd_1
XFILLER_92_1435 VGND VGND VPWR VPWR sky130_fd_sc_hd__decap_6
XFILLER_198_562 VPWR VGND VPWR VGND sky130_ef_sc_hd__decap_12
XFILLER_214_894 VPWR VGND VPWR VGND sky130_ef_sc_hd__decap_12
X_394_ net592 net585 net561 VGND VGND VPWR VPWR _183_ sky130_fd_sc_hd__and3_1
XFILLER_186_746 VGND VGND VPWR VPWR sky130_fd_sc_hd__decap_6
XFILLER_199_1014 VPWR VGND VPWR VGND sky130_ef_sc_hd__decap_12
XFILLER_16_1263 VGND VGND VPWR VPWR sky130_fd_sc_hd__decap_6
XFILLER_167_971 VPWR VGND VPWR VGND sky130_ef_sc_hd__decap_12
XFILLER_51_1165 VPWR VGND VPWR VGND sky130_ef_sc_hd__decap_12
XFILLER_142_1282 VPWR VGND VPWR VGND sky130_ef_sc_hd__decap_12
XTAP_TAPCELL_ROW_175_1873 VGND VPWR sky130_fd_sc_hd__tapvpwrvgnd_1
XFILLER_199_1069 VGND VGND VPWR VPWR sky130_fd_sc_hd__decap_6
XTAP_TAPCELL_ROW_175_1884 VGND VPWR sky130_fd_sc_hd__tapvpwrvgnd_1
XTAP_TAPCELL_ROW_171_1726 VGND VPWR sky130_fd_sc_hd__tapvpwrvgnd_1
XTAP_TAPCELL_ROW_175_1895 VGND VPWR sky130_fd_sc_hd__tapvpwrvgnd_1
XTAP_TAPCELL_ROW_171_1737 VGND VPWR sky130_fd_sc_hd__tapvpwrvgnd_1
XTAP_TAPCELL_ROW_212_3169 VGND VPWR sky130_fd_sc_hd__tapvpwrvgnd_1
XTAP_TAPCELL_ROW_171_1748 VGND VPWR sky130_fd_sc_hd__tapvpwrvgnd_1
XFILLER_177_1334 VPWR VGND VPWR VGND sky130_ef_sc_hd__decap_12
XFILLER_86_1239 VPWR VGND VPWR VGND sky130_ef_sc_hd__decap_12
XFILLER_177_1389 VPWR VGND VPWR VGND sky130_ef_sc_hd__decap_12
XFILLER_4_34 VPWR VGND VPWR VGND sky130_ef_sc_hd__decap_12
XFILLER_151_1507 VGND VGND VPWR VPWR sky130_fd_sc_hd__decap_8
XTAP_TAPCELL_ROW_169_1655 VGND VPWR sky130_fd_sc_hd__tapvpwrvgnd_1
XFILLER_7_1420 VPWR VGND VPWR VGND sky130_ef_sc_hd__decap_12
XTAP_TAPCELL_ROW_169_1666 VGND VPWR sky130_fd_sc_hd__tapvpwrvgnd_1
XTAP_TAPCELL_ROW_165_1508 VGND VPWR sky130_fd_sc_hd__tapvpwrvgnd_1
XTAP_TAPCELL_ROW_169_1677 VGND VPWR sky130_fd_sc_hd__tapvpwrvgnd_1
XFILLER_23_1201 VGND VGND VPWR VPWR sky130_fd_sc_hd__decap_4
XTAP_TAPCELL_ROW_165_1519 VGND VPWR sky130_fd_sc_hd__tapvpwrvgnd_1
XTAP_TAPCELL_ROW_169_1688 VGND VPWR sky130_fd_sc_hd__tapvpwrvgnd_1
XFILLER_62_1294 VPWR VGND VPWR VGND sky130_ef_sc_hd__decap_12
XFILLER_7_1475 VPWR VGND VPWR VGND sky130_ef_sc_hd__decap_12
XFILLER_188_1441 VPWR VGND VPWR VGND sky130_ef_sc_hd__decap_12
XFILLER_208_132 VPWR VGND VPWR VGND sky130_ef_sc_hd__decap_12
XFILLER_97_1335 VPWR VGND VPWR VGND sky130_ef_sc_hd__decap_12
XFILLER_236_452 VPWR VGND VPWR VGND sky130_ef_sc_hd__decap_12
XFILLER_251_400 VPWR VGND VPWR VGND sky130_ef_sc_hd__decap_12
XFILLER_149_1414 VGND VGND VPWR VPWR sky130_fd_sc_hd__decap_6
XFILLER_184_1305 VGND VGND VPWR VPWR sky130_fd_sc_hd__decap_6
XFILLER_247_1026 VGND VGND VPWR VPWR sky130_fd_sc_hd__decap_6
XFILLER_224_636 VPWR VGND VPWR VGND sky130_ef_sc_hd__decap_12
XFILLER_188_1496 VPWR VGND VPWR VGND sky130_ef_sc_hd__decap_12
XFILLER_208_187 VGND VGND VPWR VPWR sky130_fd_sc_hd__decap_6
XFILLER_251_455 VPWR VGND VPWR VGND sky130_ef_sc_hd__decap_12
XFILLER_205_861 VPWR VGND VPWR VGND sky130_ef_sc_hd__decap_12
XFILLER_210_34 VPWR VGND VPWR VGND sky130_ef_sc_hd__decap_12
XFILLER_177_713 VPWR VGND VPWR VGND sky130_ef_sc_hd__decap_12
XFILLER_220_820 VPWR VGND VPWR VGND sky130_ef_sc_hd__decap_12
XFILLER_189_584 VPWR VGND VPWR VGND sky130_ef_sc_hd__decap_12
XFILLER_225_1346 VPWR VGND VPWR VGND sky130_ef_sc_hd__decap_12
XFILLER_232_691 VPWR VGND VPWR VGND sky130_ef_sc_hd__decap_12
XFILLER_210_89 VPWR VGND VPWR VGND sky130_ef_sc_hd__decap_12
XFILLER_108_1177 VGND VGND VPWR VPWR sky130_fd_sc_hd__decap_6
XFILLER_177_768 VGND VGND VPWR VPWR sky130_fd_sc_hd__decap_6
XFILLER_220_875 VGND VGND VPWR VPWR sky130_fd_sc_hd__decap_6
XFILLER_73_1390 VPWR VGND VPWR VGND sky130_ef_sc_hd__decap_12
XFILLER_178_1109 VPWR VGND VPWR VGND sky130_ef_sc_hd__decap_12
XFILLER_30_1227 VPWR VGND VPWR VGND sky130_ef_sc_hd__decap_12
XFILLER_195_1401 VPWR VGND VPWR VGND sky130_ef_sc_hd__decap_12
XTAP_TAPCELL_ROW_247_4401 VGND VPWR sky130_fd_sc_hd__tapvpwrvgnd_1
XFILLER_191_259 VPWR VGND VPWR VGND sky130_ef_sc_hd__decap_12
XTAP_TAPCELL_ROW_247_4412 VGND VPWR sky130_fd_sc_hd__tapvpwrvgnd_1
XFILLER_219_87 VPWR VGND VPWR VGND sky130_ef_sc_hd__decap_12
XTAP_TAPCELL_ROW_13_1_1249 VGND VPWR sky130_fd_sc_hd__tapvpwrvgnd_1
XFILLER_195_1456 VGND VGND VPWR VPWR sky130_fd_sc_hd__decap_6
XTAP_TAPCELL_ROW_150_2_5865 VGND VPWR sky130_fd_sc_hd__tapvpwrvgnd_1
XFILLER_172_495 VPWR VGND VPWR VGND sky130_ef_sc_hd__decap_12
XTAP_TAPCELL_ROW_86_2_5351 VGND VPWR sky130_fd_sc_hd__tapvpwrvgnd_1
XFILLER_236_1453 VPWR VGND VPWR VGND sky130_ef_sc_hd__decap_12
XTAP_TAPCELL_ROW_9_1201 VGND VPWR sky130_fd_sc_hd__tapvpwrvgnd_1
XFILLER_119_1273 VPWR VGND VPWR VGND sky130_ef_sc_hd__decap_12
XTAP_TAPCELL_ROW_9_1212 VGND VPWR sky130_fd_sc_hd__tapvpwrvgnd_1
XTAP_TAPCELL_ROW_9_1223 VGND VPWR sky130_fd_sc_hd__tapvpwrvgnd_1
XTAP_TAPCELL_ROW_9_1234 VGND VPWR sky130_fd_sc_hd__tapvpwrvgnd_1
XTAP_TAPCELL_ROW_9_1245 VGND VPWR sky130_fd_sc_hd__tapvpwrvgnd_1
XFILLER_189_1205 VPWR VGND VPWR VGND sky130_ef_sc_hd__decap_12
XFILLER_246_249 VPWR VGND VPWR VGND sky130_ef_sc_hd__decap_12
XFILLER_104_46 VPWR VGND VPWR VGND sky130_ef_sc_hd__decap_12
XPHY_EDGE_ROW_67_2_Right_158 VGND VGND VPWR VPWR sky130_fd_sc_hd__decap_3
XTAP_TAPCELL_ROW_111_2_5549 VGND VPWR sky130_fd_sc_hd__tapvpwrvgnd_1
XTAP_TAPCELL_ROW_181_2077 VGND VPWR sky130_fd_sc_hd__tapvpwrvgnd_1
XFILLER_41_1378 VPWR VGND VPWR VGND sky130_ef_sc_hd__decap_12
XTAP_TAPCELL_ROW_181_2088 VGND VPWR sky130_fd_sc_hd__tapvpwrvgnd_1
XFILLER_215_603 VPWR VGND VPWR VGND sky130_ef_sc_hd__decap_12
XTAP_TAPCELL_ROW_181_2099 VGND VPWR sky130_fd_sc_hd__tapvpwrvgnd_1
XFILLER_167_1514 VGND VGND VPWR VPWR sky130_fd_sc_hd__fill_1
XFILLER_227_474 VPWR VGND VPWR VGND sky130_ef_sc_hd__decap_12
XTAP_TAPCELL_ROW_47_2_5035 VGND VPWR sky130_fd_sc_hd__tapvpwrvgnd_1
XFILLER_242_433 VPWR VGND VPWR VGND sky130_ef_sc_hd__decap_12
XFILLER_128_1509 VGND VGND VPWR VPWR sky130_fd_sc_hd__decap_6
XFILLER_199_326 VPWR VGND VPWR VGND sky130_ef_sc_hd__decap_12
XFILLER_215_658 VPWR VGND VPWR VGND sky130_ef_sc_hd__decap_12
XFILLER_39_1230 VPWR VGND VPWR VGND sky130_ef_sc_hd__decap_12
XFILLER_120_34 VPWR VGND VPWR VGND sky130_ef_sc_hd__decap_12
XFILLER_230_617 VGND VGND VPWR VPWR sky130_fd_sc_hd__decap_6
XFILLER_243_1413 VGND VGND VPWR VPWR sky130_fd_sc_hd__decap_6
XFILLER_242_488 VGND VGND VPWR VPWR sky130_fd_sc_hd__decap_6
XFILLER_39_1285 VGND VGND VPWR VPWR sky130_fd_sc_hd__decap_6
XFILLER_74_1165 VPWR VGND VPWR VGND sky130_ef_sc_hd__decap_12
XFILLER_165_1282 VPWR VGND VPWR VGND sky130_ef_sc_hd__decap_12
XFILLER_195_510 VGND VGND VPWR VPWR sky130_fd_sc_hd__decap_6
XFILLER_211_842 VPWR VGND VPWR VGND sky130_ef_sc_hd__decap_12
XTAP_TAPCELL_ROW_14_2_4776 VGND VPWR sky130_fd_sc_hd__tapvpwrvgnd_1
XFILLER_168_746 VGND VGND VPWR VPWR sky130_fd_sc_hd__decap_6
XFILLER_211_897 VGND VGND VPWR VPWR sky130_fd_sc_hd__decap_6
XFILLER_13_1414 VGND VGND VPWR VPWR sky130_fd_sc_hd__decap_6
XFILLER_202_1121 VPWR VGND VPWR VGND sky130_ef_sc_hd__decap_12
XFILLER_52_1485 VPWR VGND VPWR VGND sky130_ef_sc_hd__decap_12
XFILLER_182_237 VPWR VGND VPWR VGND sky130_ef_sc_hd__decap_12
XFILLER_202_1176 VGND VGND VPWR VPWR sky130_fd_sc_hd__decap_6
XFILLER_237_1217 VPWR VGND VPWR VGND sky130_ef_sc_hd__decap_12
XTAP_TAPCELL_ROW_230_3792 VGND VPWR sky130_fd_sc_hd__tapvpwrvgnd_1
XFILLER_8_3 VPWR VGND VPWR VGND sky130_ef_sc_hd__decap_12
XFILLER_190_292 VPWR VGND VPWR VGND sky130_ef_sc_hd__decap_12
XFILLER_1_122 VGND VGND VPWR VPWR sky130_fd_sc_hd__decap_6
XFILLER_85_1261 VPWR VGND VPWR VGND sky130_ef_sc_hd__decap_12
XFILLER_2_667 VGND VGND VPWR VPWR sky130_fd_sc_hd__fill_1
XFILLER_1_166 VGND VGND VPWR VPWR sky130_fd_sc_hd__decap_6
XFILLER_237_216 VPWR VGND VPWR VGND sky130_ef_sc_hd__decap_12
XFILLER_213_1272 VPWR VGND VPWR VGND sky130_ef_sc_hd__decap_12
XFILLER_218_452 VPWR VGND VPWR VGND sky130_ef_sc_hd__decap_12
XTAP_TAPCELL_ROW_224_3585 VGND VPWR sky130_fd_sc_hd__tapvpwrvgnd_1
XTAP_TAPCELL_ROW_224_3596 VGND VPWR sky130_fd_sc_hd__tapvpwrvgnd_1
XFILLER_248_1324 VPWR VGND VPWR VGND sky130_ef_sc_hd__decap_12
XTAP_TAPCELL_ROW_220_3449 VGND VPWR sky130_fd_sc_hd__tapvpwrvgnd_1
XFILLER_233_400 VPWR VGND VPWR VGND sky130_ef_sc_hd__decap_12
XFILLER_245_271 VPWR VGND VPWR VGND sky130_ef_sc_hd__decap_12
XFILLER_206_636 VPWR VGND VPWR VGND sky130_ef_sc_hd__decap_12
XFILLER_166_1035 VPWR VGND VPWR VGND sky130_ef_sc_hd__decap_12
XFILLER_248_1379 VPWR VGND VPWR VGND sky130_ef_sc_hd__decap_12
X_515_ net518 net185 _264_ net79 net187 VGND VGND VPWR VPWR _266_ sky130_fd_sc_hd__o221a_1
XFILLER_233_455 VPWR VGND VPWR VGND sky130_ef_sc_hd__decap_12
XFILLER_202_820 VPWR VGND VPWR VGND sky130_ef_sc_hd__decap_12
XFILLER_221_639 VGND VGND VPWR VPWR sky130_fd_sc_hd__decap_6
XFILLER_18_1325 VPWR VGND VPWR VGND sky130_ef_sc_hd__decap_12
X_446_ net128 net503 net88 _111_ VGND VGND VPWR VPWR _235_ sky130_fd_sc_hd__o31a_1
XFILLER_214_691 VPWR VGND VPWR VGND sky130_ef_sc_hd__decap_12
XFILLER_222_1508 VGND VGND VPWR VPWR sky130_fd_sc_hd__decap_6
XFILLER_109_1464 VPWR VGND VPWR VGND sky130_ef_sc_hd__decap_12
XTAP_TAPCELL_ROW_177_1935 VGND VPWR sky130_fd_sc_hd__tapvpwrvgnd_1
XFILLER_9_211 VPWR VGND VPWR VGND sky130_ef_sc_hd__decap_12
XTAP_TAPCELL_ROW_177_1946 VGND VPWR sky130_fd_sc_hd__tapvpwrvgnd_1
XFILLER_53_1249 VPWR VGND VPWR VGND sky130_ef_sc_hd__decap_12
XTAP_TAPCELL_ROW_177_1957 VGND VPWR sky130_fd_sc_hd__tapvpwrvgnd_1
XFILLER_202_875 VGND VGND VPWR VPWR sky130_fd_sc_hd__decap_6
XFILLER_207_1076 VPWR VGND VPWR VGND sky130_ef_sc_hd__decap_12
XTAP_TAPCELL_ROW_218_3378 VGND VPWR sky130_fd_sc_hd__tapvpwrvgnd_1
X_377_ net219 _165_ VGND VGND VPWR VPWR _166_ sky130_fd_sc_hd__or2_1
XFILLER_105_1328 VGND VGND VPWR VPWR sky130_fd_sc_hd__decap_6
XFILLER_140_1208 VPWR VGND VPWR VGND sky130_ef_sc_hd__decap_12
XTAP_TAPCELL_ROW_218_3389 VGND VPWR sky130_fd_sc_hd__tapvpwrvgnd_1
XPHY_EDGE_ROW_29_2_Right_120 VGND VGND VPWR VPWR sky130_fd_sc_hd__decap_3
XTAP_TAPCELL_ROW_177_1968 VGND VPWR sky130_fd_sc_hd__tapvpwrvgnd_1
XFILLER_9_244 VGND VGND VPWR VPWR sky130_fd_sc_hd__decap_8
XTAP_TAPCELL_ROW_92_2_5394 VGND VPWR sky130_fd_sc_hd__tapvpwrvgnd_1
XFILLER_144_1399 VPWR VGND VPWR VGND sky130_ef_sc_hd__decap_12
XTAP_TAPCELL_ROW_135_2_5745 VGND VPWR sky130_fd_sc_hd__tapvpwrvgnd_1
XFILLER_62_6 VPWR VGND VPWR VGND sky130_ef_sc_hd__decap_12
XTAP_TAPCELL_ROW_104_2_5492 VGND VPWR sky130_fd_sc_hd__tapvpwrvgnd_1
XFILLER_173_259 VPWR VGND VPWR VGND sky130_ef_sc_hd__decap_12
XFILLER_177_1131 VPWR VGND VPWR VGND sky130_ef_sc_hd__decap_12
XFILLER_177_1186 VPWR VGND VPWR VGND sky130_ef_sc_hd__decap_12
XFILLER_29_1421 VPWR VGND VPWR VGND sky130_ef_sc_hd__decap_12
XFILLER_9_1504 VGND VGND VPWR VPWR sky130_fd_sc_hd__decap_8
XFILLER_64_1356 VPWR VGND VPWR VGND sky130_ef_sc_hd__decap_12
XFILLER_151_1304 VPWR VGND VPWR VGND sky130_ef_sc_hd__decap_12
XFILLER_218_1183 VPWR VGND VPWR VGND sky130_ef_sc_hd__decap_12
XFILLER_29_1476 VPWR VGND VPWR VGND sky130_ef_sc_hd__decap_12
XFILLER_116_1435 VGND VGND VPWR VPWR sky130_fd_sc_hd__decap_6
XTAP_TAPCELL_ROW_53_2_5089 VGND VPWR sky130_fd_sc_hd__tapvpwrvgnd_1
XFILLER_214_1047 VGND VGND VPWR VPWR sky130_fd_sc_hd__decap_6
XFILLER_205_56 VPWR VGND VPWR VGND sky130_ef_sc_hd__decap_12
XFILLER_151_1359 VPWR VGND VPWR VGND sky130_ef_sc_hd__decap_12
XFILLER_7_1272 VPWR VGND VPWR VGND sky130_ef_sc_hd__decap_12
XFILLER_228_249 VPWR VGND VPWR VGND sky130_ef_sc_hd__decap_12
XFILLER_209_474 VPWR VGND VPWR VGND sky130_ef_sc_hd__decap_12
XTAP_TAPCELL_ROW_255_4703 VGND VPWR sky130_fd_sc_hd__tapvpwrvgnd_1
XTAP_TAPCELL_ROW_255_4714 VGND VPWR sky130_fd_sc_hd__tapvpwrvgnd_1
XFILLER_97_1165 VPWR VGND VPWR VGND sky130_ef_sc_hd__decap_12
XFILLER_221_44 VPWR VGND VPWR VGND sky130_ef_sc_hd__decap_12
XFILLER_224_433 VPWR VGND VPWR VGND sky130_ef_sc_hd__decap_12
XTAP_TAPCELL_ROW_255_4725 VGND VPWR sky130_fd_sc_hd__tapvpwrvgnd_1
XFILLER_252_753 VPWR VGND VPWR VGND sky130_ef_sc_hd__decap_12
XFILLER_188_1293 VPWR VGND VPWR VGND sky130_ef_sc_hd__decap_12
XFILLER_251_252 VGND VGND VPWR VPWR sky130_fd_sc_hd__decap_6
XFILLER_212_617 VGND VGND VPWR VPWR sky130_fd_sc_hd__decap_6
XFILLER_240_937 VPWR VGND VPWR VGND sky130_ef_sc_hd__decap_12
XFILLER_221_99 VPWR VGND VPWR VGND sky130_ef_sc_hd__decap_12
XFILLER_224_488 VGND VGND VPWR VPWR sky130_fd_sc_hd__decap_6
XFILLER_162_1411 VPWR VGND VPWR VGND sky130_ef_sc_hd__decap_12
XFILLER_71_1316 VPWR VGND VPWR VGND sky130_ef_sc_hd__decap_12
XFILLER_177_510 VGND VGND VPWR VPWR sky130_fd_sc_hd__decap_6
XFILLER_225_1143 VPWR VGND VPWR VGND sky130_ef_sc_hd__decap_12
XFILLER_189_381 VGND VGND VPWR VPWR sky130_fd_sc_hd__decap_6
XFILLER_162_1466 VPWR VGND VPWR VGND sky130_ef_sc_hd__decap_12
XFILLER_225_1198 VGND VGND VPWR VPWR sky130_fd_sc_hd__decap_6
XFILLER_165_727 VGND VGND VPWR VPWR sky130_fd_sc_hd__decap_8
XFILLER_203_1463 VPWR VGND VPWR VGND sky130_ef_sc_hd__decap_12
XFILLER_69_1201 VGND VGND VPWR VPWR sky130_fd_sc_hd__decap_4
XPHY_EDGE_ROW_106_2_Left_608 VGND VGND VPWR VPWR sky130_fd_sc_hd__decap_3
XFILLER_172_292 VPWR VGND VPWR VGND sky130_ef_sc_hd__decap_12
XFILLER_59_39 VGND VGND VPWR VPWR sky130_fd_sc_hd__decap_4
XFILLER_82_1423 VPWR VGND VPWR VGND sky130_ef_sc_hd__decap_12
XFILLER_236_1250 VPWR VGND VPWR VGND sky130_ef_sc_hd__decap_12
XTAP_TAPCELL_ROW_119_1_1408 VGND VPWR sky130_fd_sc_hd__tapvpwrvgnd_1
XTAP_TAPCELL_ROW_187_2286 VGND VPWR sky130_fd_sc_hd__tapvpwrvgnd_1
XTAP_TAPCELL_ROW_187_2297 VGND VPWR sky130_fd_sc_hd__tapvpwrvgnd_1
XFILLER_8_1047 VGND VGND VPWR VPWR sky130_fd_sc_hd__decap_6
XFILLER_82_1478 VGND VGND VPWR VPWR sky130_fd_sc_hd__decap_6
XFILLER_219_216 VPWR VGND VPWR VGND sky130_ef_sc_hd__decap_12
XFILLER_115_56 VPWR VGND VPWR VGND sky130_ef_sc_hd__decap_12
XFILLER_189_1002 VPWR VGND VPWR VGND sky130_ef_sc_hd__decap_12
XFILLER_75_27 VPWR VGND VPWR VGND sky130_ef_sc_hd__decap_12
XTAP_TAPCELL_ROW_159_2_5930 VGND VPWR sky130_fd_sc_hd__tapvpwrvgnd_1
XFILLER_132_1270 VPWR VGND VPWR VGND sky130_ef_sc_hd__decap_12
XFILLER_210_1434 VGND VGND VPWR VPWR sky130_fd_sc_hd__decap_6
XTAP_TAPCELL_ROW_3_965 VGND VPWR sky130_fd_sc_hd__tapvpwrvgnd_1
XFILLER_189_1057 VPWR VGND VPWR VGND sky130_ef_sc_hd__decap_12
XTAP_TAPCELL_ROW_3_976 VGND VPWR sky130_fd_sc_hd__tapvpwrvgnd_1
XFILLER_215_400 VPWR VGND VPWR VGND sky130_ef_sc_hd__decap_12
XFILLER_255_580 VGND VGND VPWR VPWR sky130_fd_sc_hd__decap_8
XTAP_TAPCELL_ROW_3_987 VGND VPWR sky130_fd_sc_hd__tapvpwrvgnd_1
XFILLER_227_271 VPWR VGND VPWR VGND sky130_ef_sc_hd__decap_12
XPHY_EDGE_ROW_68_2_Right_159 VGND VGND VPWR VPWR sky130_fd_sc_hd__decap_3
XTAP_TAPCELL_ROW_3_998 VGND VPWR sky130_fd_sc_hd__tapvpwrvgnd_1
XFILLER_131_44 VPWR VGND VPWR VGND sky130_ef_sc_hd__decap_12
XFILLER_242_230 VGND VGND VPWR VPWR sky130_fd_sc_hd__decap_6
XFILLER_76_1227 VPWR VGND VPWR VGND sky130_ef_sc_hd__decap_12
XFILLER_199_123 VGND VGND VPWR VPWR sky130_fd_sc_hd__decap_6
XFILLER_91_15 VPWR VGND VPWR VGND sky130_ef_sc_hd__decap_12
XFILLER_128_1306 VGND VGND VPWR VPWR sky130_fd_sc_hd__decap_6
XFILLER_215_455 VPWR VGND VPWR VGND sky130_ef_sc_hd__decap_12
XFILLER_231_904 VPWR VGND VPWR VGND sky130_ef_sc_hd__decap_12
XFILLER_243_775 VPWR VGND VPWR VGND sky130_ef_sc_hd__decap_12
XFILLER_188_808 VPWR VGND VPWR VGND sky130_ef_sc_hd__decap_12
XFILLER_167_1377 VPWR VGND VPWR VGND sky130_ef_sc_hd__decap_12
X_300_ net596 dout0_q\[29\] net527 VGND VGND VPWR VPWR _089_ sky130_fd_sc_hd__a21o_1
XTAP_TAPCELL_ROW_141_2_5788 VGND VPWR sky130_fd_sc_hd__tapvpwrvgnd_1
XFILLER_203_639 VGND VGND VPWR VPWR sky130_fd_sc_hd__decap_6
XFILLER_231_959 VPWR VGND VPWR VGND sky130_ef_sc_hd__decap_12
XFILLER_24_42 VGND VGND VPWR VPWR sky130_fd_sc_hd__fill_2
XTAP_TAPCELL_ROW_77_2_5274 VGND VPWR sky130_fd_sc_hd__tapvpwrvgnd_1
XFILLER_145_3 VPWR VGND VPWR VGND sky130_ef_sc_hd__decap_12
XTAP_TAPCELL_ROW_121_2_5631 VGND VPWR sky130_fd_sc_hd__tapvpwrvgnd_1
XFILLER_196_863 VPWR VGND VPWR VGND sky130_ef_sc_hd__decap_12
Xwire602 net603 VGND VGND VPWR VPWR net602 sky130_fd_sc_hd__clkbuf_1
XFILLER_204_1238 VPWR VGND VPWR VGND sky130_ef_sc_hd__decap_12
Xwire635 net34 VGND VGND VPWR VPWR net635 sky130_fd_sc_hd__buf_1
XTAP_TAPCELL_ROW_213_3220 VGND VPWR sky130_fd_sc_hd__tapvpwrvgnd_1
Xwire646 net25 VGND VGND VPWR VPWR net646 sky130_fd_sc_hd__buf_1
XFILLER_52_1282 VPWR VGND VPWR VGND sky130_ef_sc_hd__decap_12
Xwire657 net16 VGND VGND VPWR VPWR net657 sky130_fd_sc_hd__buf_1
XTAP_TAPCELL_ROW_232_3865 VGND VPWR sky130_fd_sc_hd__tapvpwrvgnd_1
XTAP_TAPCELL_ROW_232_3876 VGND VPWR sky130_fd_sc_hd__tapvpwrvgnd_1
XTAP_TAPCELL_ROW_232_3887 VGND VPWR sky130_fd_sc_hd__tapvpwrvgnd_1
XFILLER_139_1402 VPWR VGND VPWR VGND sky130_ef_sc_hd__decap_12
XFILLER_170_218 VPWR VGND VPWR VGND sky130_ef_sc_hd__decap_12
XFILLER_237_1014 VPWR VGND VPWR VGND sky130_ef_sc_hd__decap_12
XFILLER_178_1484 VPWR VGND VPWR VGND sky130_ef_sc_hd__decap_12
XFILLER_87_1378 VPWR VGND VPWR VGND sky130_ef_sc_hd__decap_12
XFILLER_139_1457 VGND VGND VPWR VPWR sky130_fd_sc_hd__decap_6
XFILLER_174_1348 VGND VGND VPWR VPWR sky130_fd_sc_hd__decap_6
XFILLER_237_1069 VGND VGND VPWR VPWR sky130_fd_sc_hd__decap_6
XTAP_TAPCELL_ROW_207_3002 VGND VPWR sky130_fd_sc_hd__tapvpwrvgnd_1
XFILLER_61_1507 VGND VGND VPWR VPWR sky130_fd_sc_hd__decap_8
XTAP_TAPCELL_ROW_207_3013 VGND VPWR sky130_fd_sc_hd__tapvpwrvgnd_1
XFILLER_215_1334 VPWR VGND VPWR VGND sky130_ef_sc_hd__decap_12
XTAP_TAPCELL_ROW_226_3658 VGND VPWR sky130_fd_sc_hd__tapvpwrvgnd_1
XTAP_TAPCELL_ROW_226_3669 VGND VPWR sky130_fd_sc_hd__tapvpwrvgnd_1
XFILLER_250_1269 VPWR VGND VPWR VGND sky130_ef_sc_hd__decap_12
XFILLER_215_1389 VPWR VGND VPWR VGND sky130_ef_sc_hd__decap_12
XPHY_EDGE_ROW_152_2_Left_654 VGND VGND VPWR VPWR sky130_fd_sc_hd__decap_3
XFILLER_1_35 VGND VGND VPWR VPWR sky130_fd_sc_hd__decap_8
XFILLER_4_1434 VGND VGND VPWR VPWR sky130_fd_sc_hd__decap_6
XFILLER_253_517 VPWR VGND VPWR VGND sky130_ef_sc_hd__decap_12
XFILLER_1_68 VPWR VGND VPWR VGND sky130_ef_sc_hd__decap_12
XFILLER_150_1392 VGND VGND VPWR VPWR sky130_fd_sc_hd__decap_6
XFILLER_248_1121 VPWR VGND VPWR VGND sky130_ef_sc_hd__decap_12
XFILLER_59_1414 VGND VGND VPWR VPWR sky130_fd_sc_hd__decap_6
XFILLER_98_1485 VPWR VGND VPWR VGND sky130_ef_sc_hd__decap_12
XFILLER_206_433 VPWR VGND VPWR VGND sky130_ef_sc_hd__decap_12
XFILLER_234_753 VPWR VGND VPWR VGND sky130_ef_sc_hd__decap_12
XFILLER_185_1444 VPWR VGND VPWR VGND sky130_ef_sc_hd__decap_12
XFILLER_248_1176 VGND VGND VPWR VPWR sky130_fd_sc_hd__decap_6
XFILLER_94_1349 VGND VGND VPWR VPWR sky130_fd_sc_hd__decap_6
XFILLER_233_252 VGND VGND VPWR VPWR sky130_fd_sc_hd__decap_6
XFILLER_222_937 VPWR VGND VPWR VGND sky130_ef_sc_hd__decap_12
XFILLER_206_488 VGND VGND VPWR VPWR sky130_fd_sc_hd__decap_6
XFILLER_185_1499 VGND VGND VPWR VPWR sky130_fd_sc_hd__decap_6
XFILLER_226_1441 VPWR VGND VPWR VGND sky130_ef_sc_hd__decap_12
XFILLER_187_830 VPWR VGND VPWR VGND sky130_ef_sc_hd__decap_12
XPHY_EDGE_ROW_104_1_Left_359 VGND VGND VPWR VPWR sky130_fd_sc_hd__decap_3
XFILLER_222_1305 VGND VGND VPWR VPWR sky130_fd_sc_hd__decap_6
X_429_ net194 net192 VGND VGND VPWR VPWR _218_ sky130_fd_sc_hd__nor2_1
XFILLER_109_1261 VPWR VGND VPWR VGND sky130_ef_sc_hd__decap_12
XFILLER_226_1496 VPWR VGND VPWR VGND sky130_ef_sc_hd__decap_12
XFILLER_18_1177 VGND VGND VPWR VPWR sky130_fd_sc_hd__decap_6
XFILLER_187_885 VPWR VGND VPWR VGND sky130_ef_sc_hd__decap_12
XFILLER_230_992 VPWR VGND VPWR VGND sky130_ef_sc_hd__decap_12
XFILLER_144_1196 VPWR VGND VPWR VGND sky130_ef_sc_hd__decap_12
XFILLER_179_1248 VPWR VGND VPWR VGND sky130_ef_sc_hd__decap_12
XFILLER_255_1114 VPWR VGND VPWR VGND sky130_ef_sc_hd__decap_12
XFILLER_255_1147 VGND VGND VPWR VPWR sky130_fd_sc_hd__decap_8
XFILLER_5_280 VGND VGND VPWR VPWR sky130_fd_sc_hd__decap_3
XFILLER_216_22 VPWR VGND VPWR VGND sky130_ef_sc_hd__decap_12
XFILLER_216_1109 VPWR VGND VPWR VGND sky130_ef_sc_hd__decap_12
XFILLER_233_1401 VPWR VGND VPWR VGND sky130_ef_sc_hd__decap_12
XFILLER_170_796 VPWR VGND VPWR VGND sky130_ef_sc_hd__decap_12
XFILLER_29_1273 VPWR VGND VPWR VGND sky130_ef_sc_hd__decap_12
XFILLER_216_77 VPWR VGND VPWR VGND sky130_ef_sc_hd__decap_12
XFILLER_9_1345 VPWR VGND VPWR VGND sky130_ef_sc_hd__decap_12
XFILLER_233_1456 VGND VGND VPWR VPWR sky130_fd_sc_hd__decap_6
XPHY_EDGE_ROW_84_2_Left_586 VGND VGND VPWR VPWR sky130_fd_sc_hd__decap_3
XFILLER_155_1292 VPWR VGND VPWR VGND sky130_ef_sc_hd__decap_12
XFILLER_9_1378 VGND VGND VPWR VPWR sky130_fd_sc_hd__decap_8
XFILLER_190_1183 VPWR VGND VPWR VGND sky130_ef_sc_hd__decap_12
Xinput1 rst VGND VGND VPWR VPWR net1 sky130_fd_sc_hd__clkbuf_1
XFILLER_99_1249 VPWR VGND VPWR VGND sky130_ef_sc_hd__decap_12
XFILLER_151_1189 VPWR VGND VPWR VGND sky130_ef_sc_hd__decap_12
XFILLER_186_1219 VGND VGND VPWR VPWR sky130_fd_sc_hd__decap_6
XFILLER_232_65 VPWR VGND VPWR VGND sky130_ef_sc_hd__decap_12
XFILLER_209_271 VPWR VGND VPWR VGND sky130_ef_sc_hd__decap_12
XTAP_TAPCELL_ROW_126_2_5668 VGND VPWR sky130_fd_sc_hd__tapvpwrvgnd_1
XTAP_TAPCELL_ROW_94_2_5413 VGND VPWR sky130_fd_sc_hd__tapvpwrvgnd_1
XFILLER_213_904 VPWR VGND VPWR VGND sky130_ef_sc_hd__decap_12
XFILLER_224_230 VGND VGND VPWR VPWR sky130_fd_sc_hd__decap_6
XFILLER_227_1205 VPWR VGND VPWR VGND sky130_ef_sc_hd__decap_12
XFILLER_252_550 VPWR VGND VPWR VGND sky130_ef_sc_hd__decap_12
XFILLER_188_1090 VGND VGND VPWR VPWR sky130_fd_sc_hd__decap_6
XFILLER_38_1509 VGND VGND VPWR VPWR sky130_fd_sc_hd__decap_6
XFILLER_225_775 VPWR VGND VPWR VGND sky130_ef_sc_hd__decap_12
XFILLER_240_734 VPWR VGND VPWR VGND sky130_ef_sc_hd__decap_12
XFILLER_197_627 VPWR VGND VPWR VGND sky130_ef_sc_hd__decap_12
XFILLER_213_959 VPWR VGND VPWR VGND sky130_ef_sc_hd__decap_12
XTAP_TAPCELL_ROW_106_2_5511 VGND VPWR sky130_fd_sc_hd__tapvpwrvgnd_1
XTAP_TAPCELL_ROW_195_2566 VGND VPWR sky130_fd_sc_hd__tapvpwrvgnd_1
XFILLER_205_1514 VGND VGND VPWR VPWR sky130_fd_sc_hd__fill_1
XFILLER_240_789 VGND VGND VPWR VPWR sky130_fd_sc_hd__decap_6
XTAP_TAPCELL_ROW_195_2577 VGND VPWR sky130_fd_sc_hd__tapvpwrvgnd_1
XFILLER_178_863 VPWR VGND VPWR VGND sky130_ef_sc_hd__decap_12
XTAP_TAPCELL_ROW_195_2588 VGND VPWR sky130_fd_sc_hd__tapvpwrvgnd_1
XFILLER_162_1263 VGND VGND VPWR VPWR sky130_fd_sc_hd__decap_6
XFILLER_193_811 VGND VGND VPWR VPWR sky130_fd_sc_hd__decap_6
XTAP_TAPCELL_ROW_29_2_4895 VGND VPWR sky130_fd_sc_hd__tapvpwrvgnd_1
XFILLER_197_1315 VPWR VGND VPWR VGND sky130_ef_sc_hd__decap_12
XFILLER_203_1260 VPWR VGND VPWR VGND sky130_ef_sc_hd__decap_12
XFILLER_165_568 VPWR VGND VPWR VGND sky130_ef_sc_hd__decap_12
XPHY_EDGE_ROW_98_1_Left_353 VGND VGND VPWR VPWR sky130_fd_sc_hd__decap_3
XFILLER_4_729 VGND VGND VPWR VPWR sky130_fd_sc_hd__decap_4
XFILLER_238_1312 VPWR VGND VPWR VGND sky130_ef_sc_hd__decap_12
XFILLER_180_538 VPWR VGND VPWR VGND sky130_ef_sc_hd__decap_12
XFILLER_10_22 VPWR VGND VPWR VGND sky130_ef_sc_hd__decap_12
XFILLER_193_39 VGND VGND VPWR VPWR sky130_fd_sc_hd__decap_4
XTAP_TAPCELL_ROW_189_2359 VGND VPWR sky130_fd_sc_hd__tapvpwrvgnd_1
XFILLER_126_22 VPWR VGND VPWR VGND sky130_ef_sc_hd__decap_12
XFILLER_238_1367 VPWR VGND VPWR VGND sky130_ef_sc_hd__decap_12
XFILLER_0_902 VGND VGND VPWR VPWR sky130_fd_sc_hd__fill_1
XTAP_TAPCELL_ROW_22_2_4838 VGND VPWR sky130_fd_sc_hd__tapvpwrvgnd_1
XFILLER_82_1220 VGND VGND VPWR VPWR sky130_fd_sc_hd__decap_6
XFILLER_86_15 VGND VGND VPWR VPWR sky130_fd_sc_hd__decap_6
XFILLER_0_946 VPWR VGND VPWR VGND sky130_ef_sc_hd__decap_12
XFILLER_173_1370 VGND VGND VPWR VPWR sky130_fd_sc_hd__decap_6
XFILLER_0_979 VGND VGND VPWR VPWR sky130_fd_sc_hd__decap_8
XTAP_TAPCELL_ROW_221_3500 VGND VPWR sky130_fd_sc_hd__tapvpwrvgnd_1
XFILLER_235_517 VPWR VGND VPWR VGND sky130_ef_sc_hd__decap_12
XFILLER_247_388 VPWR VGND VPWR VGND sky130_ef_sc_hd__decap_12
XFILLER_142_65 VGND VGND VPWR VPWR sky130_fd_sc_hd__decap_6
XFILLER_216_753 VPWR VGND VPWR VGND sky130_ef_sc_hd__decap_12
XFILLER_249_1463 VPWR VGND VPWR VGND sky130_ef_sc_hd__decap_12
XFILLER_215_252 VGND VGND VPWR VPWR sky130_fd_sc_hd__decap_6
XFILLER_231_701 VPWR VGND VPWR VGND sky130_ef_sc_hd__decap_12
XFILLER_245_1327 VGND VGND VPWR VPWR sky130_fd_sc_hd__decap_6
XFILLER_243_572 VPWR VGND VPWR VGND sky130_ef_sc_hd__decap_12
XFILLER_188_605 VPWR VGND VPWR VGND sky130_ef_sc_hd__decap_12
XFILLER_204_937 VPWR VGND VPWR VGND sky130_ef_sc_hd__decap_12
XFILLER_167_1174 VPWR VGND VPWR VGND sky130_ef_sc_hd__decap_12
XFILLER_231_756 VPWR VGND VPWR VGND sky130_ef_sc_hd__decap_12
XFILLER_169_830 VPWR VGND VPWR VGND sky130_ef_sc_hd__decap_12
XFILLER_93_1371 VGND VGND VPWR VPWR sky130_fd_sc_hd__decap_6
XFILLER_19_1464 VPWR VGND VPWR VGND sky130_ef_sc_hd__decap_12
XFILLER_106_1423 VPWR VGND VPWR VGND sky130_ef_sc_hd__decap_12
XTAP_TAPCELL_ROW_234_3938 VGND VPWR sky130_fd_sc_hd__tapvpwrvgnd_1
XFILLER_196_660 VGND VGND VPWR VPWR sky130_fd_sc_hd__decap_6
XFILLER_50_1208 VPWR VGND VPWR VGND sky130_ef_sc_hd__decap_12
XFILLER_169_885 VPWR VGND VPWR VGND sky130_ef_sc_hd__decap_12
XFILLER_204_1035 VPWR VGND VPWR VGND sky130_ef_sc_hd__decap_12
XFILLER_212_992 VPWR VGND VPWR VGND sky130_ef_sc_hd__decap_12
XTAP_TAPCELL_ROW_234_3949 VGND VPWR sky130_fd_sc_hd__tapvpwrvgnd_1
XFILLER_15_1328 VGND VGND VPWR VPWR sky130_fd_sc_hd__decap_6
Xwire410 net411 VGND VGND VPWR VPWR net410 sky130_fd_sc_hd__clkbuf_1
XFILLER_54_1399 VPWR VGND VPWR VGND sky130_ef_sc_hd__decap_12
Xwire421 net422 VGND VGND VPWR VPWR net421 sky130_fd_sc_hd__clkbuf_1
XFILLER_141_1347 VPWR VGND VPWR VGND sky130_ef_sc_hd__decap_12
XFILLER_51_62 VGND VGND VPWR VPWR sky130_fd_sc_hd__decap_6
XFILLER_106_1478 VGND VGND VPWR VPWR sky130_fd_sc_hd__decap_6
Xwire432 net433 VGND VGND VPWR VPWR net432 sky130_fd_sc_hd__clkbuf_1
Xwire443 net444 VGND VGND VPWR VPWR net443 sky130_fd_sc_hd__clkbuf_1
Xwire454 net455 VGND VGND VPWR VPWR net454 sky130_fd_sc_hd__clkbuf_1
Xwire465 net466 VGND VGND VPWR VPWR net465 sky130_fd_sc_hd__clkbuf_1
Xwire476 net477 VGND VGND VPWR VPWR net476 sky130_fd_sc_hd__clkbuf_1
Xmax_cap209 net210 VGND VGND VPWR VPWR net209 sky130_fd_sc_hd__clkbuf_1
Xwire487 net488 VGND VGND VPWR VPWR net487 sky130_fd_sc_hd__clkbuf_1
XTAP_TAPCELL_ROW_151_2_5870 VGND VPWR sky130_fd_sc_hd__tapvpwrvgnd_1
XFILLER_178_1281 VPWR VGND VPWR VGND sky130_ef_sc_hd__decap_12
XFILLER_250_1011 VPWR VGND VPWR VGND sky130_ef_sc_hd__decap_12
XFILLER_61_1304 VPWR VGND VPWR VGND sky130_ef_sc_hd__decap_12
XFILLER_215_1131 VPWR VGND VPWR VGND sky130_ef_sc_hd__decap_12
XFILLER_26_1435 VGND VGND VPWR VPWR sky130_fd_sc_hd__decap_6
XFILLER_152_1454 VPWR VGND VPWR VGND sky130_ef_sc_hd__decap_12
XFILLER_250_1066 VPWR VGND VPWR VGND sky130_ef_sc_hd__decap_12
XFILLER_61_1359 VPWR VGND VPWR VGND sky130_ef_sc_hd__decap_12
XTAP_TAPCELL_ROW_143_2_5807 VGND VPWR sky130_fd_sc_hd__tapvpwrvgnd_1
XFILLER_215_1186 VPWR VGND VPWR VGND sky130_ef_sc_hd__decap_12
XFILLER_238_366 VPWR VGND VPWR VGND sky130_ef_sc_hd__decap_12
XTAP_TAPCELL_ROW_112_2_5554 VGND VPWR sky130_fd_sc_hd__tapvpwrvgnd_1
XFILLER_187_1506 VGND VGND VPWR VPWR sky130_fd_sc_hd__decap_8
XFILLER_253_314 VPWR VGND VPWR VGND sky130_ef_sc_hd__decap_12
XFILLER_206_230 VGND VGND VPWR VPWR sky130_fd_sc_hd__decap_6
XFILLER_253_369 VPWR VGND VPWR VGND sky130_ef_sc_hd__decap_12
XFILLER_98_1282 VPWR VGND VPWR VGND sky130_ef_sc_hd__decap_12
XFILLER_228_1514 VGND VGND VPWR VPWR sky130_fd_sc_hd__fill_1
XFILLER_234_550 VPWR VGND VPWR VGND sky130_ef_sc_hd__decap_12
XFILLER_185_1241 VGND VGND VPWR VPWR sky130_fd_sc_hd__decap_6
XFILLER_202_46 VPWR VGND VPWR VGND sky130_ef_sc_hd__decap_12
XFILLER_207_775 VPWR VGND VPWR VGND sky130_ef_sc_hd__decap_12
XFILLER_179_627 VPWR VGND VPWR VGND sky130_ef_sc_hd__decap_12
XFILLER_222_734 VPWR VGND VPWR VGND sky130_ef_sc_hd__decap_12
XFILLER_72_1411 VPWR VGND VPWR VGND sky130_ef_sc_hd__decap_12
XTAP_TAPCELL_ROW_15_2_4781 VGND VPWR sky130_fd_sc_hd__tapvpwrvgnd_1
XFILLER_210_918 VGND VGND VPWR VPWR sky130_fd_sc_hd__decap_6
XFILLER_222_789 VGND VGND VPWR VPWR sky130_fd_sc_hd__decap_6
XFILLER_72_1466 VPWR VGND VPWR VGND sky130_ef_sc_hd__decap_12
XFILLER_226_1293 VPWR VGND VPWR VGND sky130_ef_sc_hd__decap_12
XFILLER_175_811 VGND VGND VPWR VPWR sky130_fd_sc_hd__decap_6
XFILLER_187_682 VGND VGND VPWR VPWR sky130_fd_sc_hd__decap_6
XTAP_TAPCELL_ROW_250_4496 VGND VPWR sky130_fd_sc_hd__tapvpwrvgnd_1
XFILLER_200_1422 VPWR VGND VPWR VGND sky130_ef_sc_hd__decap_12
XFILLER_179_1045 VPWR VGND VPWR VGND sky130_ef_sc_hd__decap_12
XFILLER_200_1477 VGND VGND VPWR VPWR sky130_fd_sc_hd__decap_6
XFILLER_227_87 VPWR VGND VPWR VGND sky130_ef_sc_hd__decap_12
XFILLER_153_1218 VPWR VGND VPWR VGND sky130_ef_sc_hd__decap_12
XTAP_TAPCELL_ROW_184_2201 VGND VPWR sky130_fd_sc_hd__tapvpwrvgnd_1
XTAP_TAPCELL_ROW_184_2212 VGND VPWR sky130_fd_sc_hd__tapvpwrvgnd_1
XFILLER_248_108 VPWR VGND VPWR VGND sky130_ef_sc_hd__decap_12
XFILLER_118_1349 VGND VGND VPWR VPWR sky130_fd_sc_hd__decap_6
XFILLER_170_593 VPWR VGND VPWR VGND sky130_ef_sc_hd__decap_12
XTAP_TAPCELL_ROW_244_4289 VGND VPWR sky130_fd_sc_hd__tapvpwrvgnd_1
XFILLER_217_517 VPWR VGND VPWR VGND sky130_ef_sc_hd__decap_12
XFILLER_42_1270 VPWR VGND VPWR VGND sky130_ef_sc_hd__decap_12
XFILLER_229_388 VPWR VGND VPWR VGND sky130_ef_sc_hd__decap_12
XFILLER_244_347 VPWR VGND VPWR VGND sky130_ef_sc_hd__decap_12
XTAP_TAPCELL_ROW_6_1078 VGND VPWR sky130_fd_sc_hd__tapvpwrvgnd_1
XTAP_TAPCELL_ROW_6_1089 VGND VPWR sky130_fd_sc_hd__tapvpwrvgnd_1
XFILLER_112_46 VPWR VGND VPWR VGND sky130_ef_sc_hd__decap_12
XFILLER_213_701 VPWR VGND VPWR VGND sky130_ef_sc_hd__decap_12
XFILLER_227_1002 VPWR VGND VPWR VGND sky130_ef_sc_hd__decap_12
XFILLER_38_1306 VGND VGND VPWR VPWR sky130_fd_sc_hd__decap_6
XFILLER_225_572 VPWR VGND VPWR VGND sky130_ef_sc_hd__decap_12
XTAP_TAPCELL_ROW_197_2639 VGND VPWR sky130_fd_sc_hd__tapvpwrvgnd_1
XFILLER_198_925 VPWR VGND VPWR VGND sky130_ef_sc_hd__decap_12
XFILLER_129_1445 VPWR VGND VPWR VGND sky130_ef_sc_hd__decap_12
XFILLER_164_1325 VPWR VGND VPWR VGND sky130_ef_sc_hd__decap_12
XFILLER_197_424 VGND VGND VPWR VPWR sky130_fd_sc_hd__decap_6
XFILLER_240_531 VGND VGND VPWR VPWR sky130_fd_sc_hd__decap_6
XPHY_EDGE_ROW_50_1_Right_706 VGND VGND VPWR VPWR sky130_fd_sc_hd__decap_3
XFILLER_213_756 VPWR VGND VPWR VGND sky130_ef_sc_hd__decap_12
XFILLER_227_1057 VPWR VGND VPWR VGND sky130_ef_sc_hd__decap_12
XTAP_TAPCELL_ROW_19_1_1258 VGND VPWR sky130_fd_sc_hd__tapvpwrvgnd_1
XFILLER_178_660 VGND VGND VPWR VPWR sky130_fd_sc_hd__decap_6
XFILLER_205_1377 VPWR VGND VPWR VGND sky130_ef_sc_hd__decap_12
XFILLER_197_1112 VGND VGND VPWR VPWR sky130_fd_sc_hd__decap_6
XTAP_TAPCELL_ROW_136_2_5750 VGND VPWR sky130_fd_sc_hd__tapvpwrvgnd_1
XPHY_EDGE_ROW_239_Right_84 VGND VGND VPWR VPWR sky130_fd_sc_hd__decap_3
XFILLER_192_151 VPWR VGND VPWR VGND sky130_ef_sc_hd__decap_12
XFILLER_4_504 VGND VGND VPWR VPWR sky130_fd_sc_hd__fill_2
XFILLER_140_1380 VPWR VGND VPWR VGND sky130_ef_sc_hd__decap_12
XFILLER_49_1402 VPWR VGND VPWR VGND sky130_ef_sc_hd__decap_12
XFILLER_180_335 VPWR VGND VPWR VGND sky130_ef_sc_hd__decap_12
XFILLER_4_559 VGND VGND VPWR VPWR sky130_fd_sc_hd__fill_1
XFILLER_108_3 VPWR VGND VPWR VGND sky130_ef_sc_hd__decap_12
XFILLER_175_1432 VPWR VGND VPWR VGND sky130_ef_sc_hd__decap_12
XFILLER_84_1337 VPWR VGND VPWR VGND sky130_ef_sc_hd__decap_12
XFILLER_238_1164 VPWR VGND VPWR VGND sky130_ef_sc_hd__decap_12
XFILLER_49_1457 VGND VGND VPWR VPWR sky130_fd_sc_hd__decap_6
XFILLER_175_1487 VPWR VGND VPWR VGND sky130_ef_sc_hd__decap_12
XTAP_TAPCELL_ROW_54_2_5094 VGND VPWR sky130_fd_sc_hd__tapvpwrvgnd_1
XFILLER_0_765 VGND VGND VPWR VPWR sky130_fd_sc_hd__fill_1
XFILLER_0_776 VGND VGND VPWR VPWR sky130_fd_sc_hd__fill_1
XFILLER_216_1484 VPWR VGND VPWR VGND sky130_ef_sc_hd__decap_12
XFILLER_247_130 VPWR VGND VPWR VGND sky130_ef_sc_hd__decap_12
XFILLER_212_1348 VGND VGND VPWR VPWR sky130_fd_sc_hd__decap_6
XFILLER_134_1184 VPWR VGND VPWR VGND sky130_ef_sc_hd__decap_12
XPHY_EDGE_ROW_248_Right_93 VGND VGND VPWR VPWR sky130_fd_sc_hd__decap_3
XFILLER_235_314 VPWR VGND VPWR VGND sky130_ef_sc_hd__decap_12
XFILLER_247_185 VPWR VGND VPWR VGND sky130_ef_sc_hd__decap_12
XFILLER_60_1392 VGND VGND VPWR VPWR sky130_fd_sc_hd__decap_6
XFILLER_251_818 VPWR VGND VPWR VGND sky130_ef_sc_hd__decap_12
XFILLER_235_369 VPWR VGND VPWR VGND sky130_ef_sc_hd__decap_12
XFILLER_249_1260 VPWR VGND VPWR VGND sky130_ef_sc_hd__decap_12
XTAP_TAPCELL_ROW_32_2_4920 VGND VPWR sky130_fd_sc_hd__tapvpwrvgnd_1
XFILLER_216_550 VPWR VGND VPWR VGND sky130_ef_sc_hd__decap_12
XFILLER_95_1433 VPWR VGND VPWR VGND sky130_ef_sc_hd__decap_12
XFILLER_188_402 VGND VGND VPWR VPWR sky130_fd_sc_hd__decap_6
Xmax_cap96 net97 VGND VGND VPWR VPWR net96 sky130_fd_sc_hd__clkbuf_1
XFILLER_204_734 VPWR VGND VPWR VGND sky130_ef_sc_hd__decap_12
XFILLER_189_947 VPWR VGND VPWR VGND sky130_ef_sc_hd__decap_12
XFILLER_95_1488 VPWR VGND VPWR VGND sky130_ef_sc_hd__decap_12
XFILLER_231_553 VGND VGND VPWR VPWR sky130_fd_sc_hd__decap_6
XFILLER_204_789 VGND VGND VPWR VPWR sky130_fd_sc_hd__decap_6
XFILLER_19_1261 VPWR VGND VPWR VGND sky130_ef_sc_hd__decap_12
XFILLER_106_1220 VGND VGND VPWR VPWR sky130_fd_sc_hd__decap_6
XFILLER_223_1444 VPWR VGND VPWR VGND sky130_ef_sc_hd__decap_12
XFILLER_169_682 VGND VGND VPWR VPWR sky130_fd_sc_hd__decap_6
XFILLER_8_832 VGND VGND VPWR VPWR sky130_fd_sc_hd__decap_6
XFILLER_54_1196 VPWR VGND VPWR VGND sky130_ef_sc_hd__decap_12
Xwire240 net241 VGND VGND VPWR VPWR net240 sky130_fd_sc_hd__clkbuf_1
XFILLER_223_1499 VGND VGND VPWR VPWR sky130_fd_sc_hd__decap_6
XFILLER_141_1177 VPWR VGND VPWR VGND sky130_ef_sc_hd__decap_12
XFILLER_7_56 VPWR VGND VPWR VGND sky130_ef_sc_hd__decap_12
Xwire251 net252 VGND VGND VPWR VPWR net251 sky130_fd_sc_hd__clkbuf_1
Xwire262 net263 VGND VGND VPWR VPWR net262 sky130_fd_sc_hd__clkbuf_1
Xwire273 net274 VGND VGND VPWR VPWR net273 sky130_fd_sc_hd__clkbuf_1
XFILLER_171_302 VPWR VGND VPWR VGND sky130_ef_sc_hd__decap_12
XFILLER_176_1207 VPWR VGND VPWR VGND sky130_ef_sc_hd__decap_12
Xwire284 net285 VGND VGND VPWR VPWR net284 sky130_fd_sc_hd__clkbuf_1
XFILLER_183_173 VPWR VGND VPWR VGND sky130_ef_sc_hd__decap_12
Xwire295 net296 VGND VGND VPWR VPWR net295 sky130_fd_sc_hd__clkbuf_1
XFILLER_171_357 VPWR VGND VPWR VGND sky130_ef_sc_hd__decap_12
XFILLER_217_1248 VPWR VGND VPWR VGND sky130_ef_sc_hd__decap_12
XFILLER_65_1292 VPWR VGND VPWR VGND sky130_ef_sc_hd__decap_12
XFILLER_23_3 VPWR VGND VPWR VGND sky130_ef_sc_hd__decap_12
XFILLER_117_1371 VGND VGND VPWR VPWR sky130_fd_sc_hd__decap_6
XFILLER_152_1251 VPWR VGND VPWR VGND sky130_ef_sc_hd__decap_12
XFILLER_6_1348 VGND VGND VPWR VPWR sky130_fd_sc_hd__decap_6
XFILLER_187_1303 VPWR VGND VPWR VGND sky130_ef_sc_hd__decap_12
XFILLER_238_163 VPWR VGND VPWR VGND sky130_ef_sc_hd__decap_12
XFILLER_61_1189 VPWR VGND VPWR VGND sky130_ef_sc_hd__decap_12
XFILLER_253_111 VPWR VGND VPWR VGND sky130_ef_sc_hd__decap_12
XFILLER_96_1208 VPWR VGND VPWR VGND sky130_ef_sc_hd__decap_12
XFILLER_213_56 VPWR VGND VPWR VGND sky130_ef_sc_hd__decap_12
XFILLER_226_347 VPWR VGND VPWR VGND sky130_ef_sc_hd__decap_12
XFILLER_254_667 VPWR VGND VPWR VGND sky130_ef_sc_hd__decap_12
XFILLER_187_1358 VPWR VGND VPWR VGND sky130_ef_sc_hd__decap_12
XFILLER_253_166 VGND VGND VPWR VPWR sky130_fd_sc_hd__decap_6
XPHY_EDGE_ROW_115_2_Left_617 VGND VGND VPWR VPWR sky130_fd_sc_hd__decap_3
XFILLER_207_572 VPWR VGND VPWR VGND sky130_ef_sc_hd__decap_12
XTAP_TAPCELL_ROW_204_2882 VGND VPWR sky130_fd_sc_hd__tapvpwrvgnd_1
XTAP_TAPCELL_ROW_204_2893 VGND VPWR sky130_fd_sc_hd__tapvpwrvgnd_1
XFILLER_228_1355 VPWR VGND VPWR VGND sky130_ef_sc_hd__decap_12
XFILLER_179_424 VGND VGND VPWR VPWR sky130_fd_sc_hd__decap_6
XTAP_TAPCELL_ROW_200_2746 VGND VPWR sky130_fd_sc_hd__tapvpwrvgnd_1
XFILLER_222_531 VGND VGND VPWR VPWR sky130_fd_sc_hd__decap_6
XFILLER_250_851 VPWR VGND VPWR VGND sky130_ef_sc_hd__decap_12
XTAP_TAPCELL_ROW_200_2757 VGND VPWR sky130_fd_sc_hd__tapvpwrvgnd_1
XTAP_TAPCELL_ROW_237_4060 VGND VPWR sky130_fd_sc_hd__tapvpwrvgnd_1
XTAP_TAPCELL_ROW_200_2768 VGND VPWR sky130_fd_sc_hd__tapvpwrvgnd_1
XFILLER_224_1219 VGND VGND VPWR VPWR sky130_fd_sc_hd__decap_6
XFILLER_195_928 VPWR VGND VPWR VGND sky130_ef_sc_hd__decap_12
XTAP_TAPCELL_ROW_252_4569 VGND VPWR sky130_fd_sc_hd__tapvpwrvgnd_1
XFILLER_188_980 VPWR VGND VPWR VGND sky130_ef_sc_hd__decap_12
XFILLER_72_1263 VGND VGND VPWR VPWR sky130_fd_sc_hd__decap_6
XFILLER_226_1090 VGND VGND VPWR VPWR sky130_fd_sc_hd__decap_6
XFILLER_198_1410 VPWR VGND VPWR VGND sky130_ef_sc_hd__decap_12
XFILLER_120_1239 VPWR VGND VPWR VGND sky130_ef_sc_hd__decap_12
XFILLER_174_151 VPWR VGND VPWR VGND sky130_ef_sc_hd__decap_12
XFILLER_198_1465 VPWR VGND VPWR VGND sky130_ef_sc_hd__decap_12
XTAP_TAPCELL_ROW_103_2_5488 VGND VPWR sky130_fd_sc_hd__tapvpwrvgnd_1
XTAP_TAPCELL_ROW_71_2_5233 VGND VPWR sky130_fd_sc_hd__tapvpwrvgnd_1
Xmax_cap551 net74 VGND VGND VPWR VPWR net551 sky130_fd_sc_hd__clkbuf_1
XFILLER_235_1315 VPWR VGND VPWR VGND sky130_ef_sc_hd__decap_12
XFILLER_170_390 VPWR VGND VPWR VGND sky130_ef_sc_hd__decap_12
XFILLER_107_68 VGND VGND VPWR VPWR sky130_fd_sc_hd__decap_3
XFILLER_192_1097 VPWR VGND VPWR VGND sky130_ef_sc_hd__decap_12
XFILLER_67_39 VGND VGND VPWR VPWR sky130_fd_sc_hd__decap_4
XTAP_TAPCELL_ROW_37_2_4957 VGND VPWR sky130_fd_sc_hd__tapvpwrvgnd_1
XFILLER_229_130 VPWR VGND VPWR VGND sky130_ef_sc_hd__decap_12
XFILLER_131_1335 VPWR VGND VPWR VGND sky130_ef_sc_hd__decap_12
XFILLER_217_314 VPWR VGND VPWR VGND sky130_ef_sc_hd__decap_12
XTAP_TAPCELL_ROW_17_2_4800 VGND VPWR sky130_fd_sc_hd__tapvpwrvgnd_1
XFILLER_229_185 VPWR VGND VPWR VGND sky130_ef_sc_hd__decap_12
XFILLER_123_56 VPWR VGND VPWR VGND sky130_ef_sc_hd__decap_12
XFILLER_211_1370 VGND VGND VPWR VPWR sky130_fd_sc_hd__decap_6
XFILLER_244_144 VGND VGND VPWR VPWR sky130_fd_sc_hd__decap_6
XPHY_EDGE_ROW_47_2_Left_549 VGND VGND VPWR VPWR sky130_fd_sc_hd__decap_3
XFILLER_83_27 VPWR VGND VPWR VGND sky130_ef_sc_hd__decap_12
XFILLER_217_369 VPWR VGND VPWR VGND sky130_ef_sc_hd__decap_12
XFILLER_229_1119 VPWR VGND VPWR VGND sky130_ef_sc_hd__decap_12
XFILLER_233_818 VPWR VGND VPWR VGND sky130_ef_sc_hd__decap_12
XFILLER_245_689 VPWR VGND VPWR VGND sky130_ef_sc_hd__decap_12
XFILLER_246_1422 VPWR VGND VPWR VGND sky130_ef_sc_hd__decap_12
XFILLER_199_27 VPWR VGND VPWR VGND sky130_ef_sc_hd__decap_12
XFILLER_198_722 VPWR VGND VPWR VGND sky130_ef_sc_hd__decap_12
XFILLER_129_1242 VGND VGND VPWR VPWR sky130_fd_sc_hd__decap_6
XFILLER_16_65 VGND VGND VPWR VPWR sky130_fd_sc_hd__decap_6
XFILLER_246_1477 VGND VGND VPWR VPWR sky130_fd_sc_hd__decap_6
XFILLER_213_553 VGND VGND VPWR VPWR sky130_fd_sc_hd__decap_6
XFILLER_241_873 VPWR VGND VPWR VGND sky130_ef_sc_hd__decap_12
XFILLER_0_1492 VPWR VGND VPWR VGND sky130_ef_sc_hd__decap_12
XFILLER_186_906 VPWR VGND VPWR VGND sky130_ef_sc_hd__decap_12
XFILLER_198_777 VPWR VGND VPWR VGND sky130_ef_sc_hd__decap_12
XPHY_EDGE_ROW_51_1_Right_707 VGND VGND VPWR VPWR sky130_fd_sc_hd__decap_3
XFILLER_9_607 VGND VGND VPWR VPWR sky130_fd_sc_hd__fill_2
XFILLER_164_1177 VGND VGND VPWR VPWR sky130_fd_sc_hd__decap_6
XFILLER_16_1423 VPWR VGND VPWR VGND sky130_ef_sc_hd__decap_12
XFILLER_142_1442 VPWR VGND VPWR VGND sky130_ef_sc_hd__decap_12
XFILLER_199_1229 VPWR VGND VPWR VGND sky130_ef_sc_hd__decap_12
XFILLER_240_1054 VPWR VGND VPWR VGND sky130_ef_sc_hd__decap_12
XFILLER_51_1347 VPWR VGND VPWR VGND sky130_ef_sc_hd__decap_12
XFILLER_205_1174 VPWR VGND VPWR VGND sky130_ef_sc_hd__decap_12
XFILLER_225_3 VPWR VGND VPWR VGND sky130_ef_sc_hd__decap_12
XFILLER_194_961 VGND VGND VPWR VPWR sky130_fd_sc_hd__decap_6
XFILLER_16_1478 VGND VGND VPWR VPWR sky130_fd_sc_hd__decap_6
XFILLER_142_1497 VPWR VGND VPWR VGND sky130_ef_sc_hd__decap_12
XPHY_EDGE_ROW_161_2_Left_663 VGND VGND VPWR VPWR sky130_fd_sc_hd__decap_3
XFILLER_5_835 VGND VGND VPWR VPWR sky130_fd_sc_hd__fill_1
XFILLER_4_323 VGND VGND VPWR VPWR sky130_fd_sc_hd__fill_2
XFILLER_180_132 VPWR VGND VPWR VGND sky130_ef_sc_hd__decap_12
XFILLER_88_1270 VPWR VGND VPWR VGND sky130_ef_sc_hd__decap_12
XFILLER_180_187 VGND VGND VPWR VPWR sky130_fd_sc_hd__decap_6
XTAP_TAPCELL_ROW_210_3097 VGND VPWR sky130_fd_sc_hd__tapvpwrvgnd_1
XFILLER_175_1284 VGND VGND VPWR VPWR sky130_fd_sc_hd__decap_6
XFILLER_249_940 VGND VGND VPWR VPWR sky130_fd_sc_hd__decap_6
XPHY_EDGE_ROW_113_1_Left_368 VGND VGND VPWR VPWR sky130_fd_sc_hd__decap_3
XFILLER_62_1454 VPWR VGND VPWR VGND sky130_ef_sc_hd__decap_12
XFILLER_216_1281 VPWR VGND VPWR VGND sky130_ef_sc_hd__decap_12
XFILLER_0_595 VGND VGND VPWR VPWR sky130_fd_sc_hd__fill_1
XTAP_TAPCELL_ROW_167_1594 VGND VPWR sky130_fd_sc_hd__tapvpwrvgnd_1
XFILLER_235_111 VPWR VGND VPWR VGND sky130_ef_sc_hd__decap_12
XTAP_TAPCELL_ROW_158_2_5926 VGND VPWR sky130_fd_sc_hd__tapvpwrvgnd_1
XFILLER_208_347 VPWR VGND VPWR VGND sky130_ef_sc_hd__decap_12
XFILLER_5_1370 VGND VGND VPWR VPWR sky130_fd_sc_hd__decap_6
XFILLER_169_1033 VPWR VGND VPWR VGND sky130_ef_sc_hd__decap_12
XFILLER_236_667 VPWR VGND VPWR VGND sky130_ef_sc_hd__decap_12
XPHY_EDGE_ROW_50_1_Left_305 VGND VGND VPWR VPWR sky130_fd_sc_hd__decap_3
XFILLER_251_615 VPWR VGND VPWR VGND sky130_ef_sc_hd__decap_12
XFILLER_235_166 VGND VGND VPWR VPWR sky130_fd_sc_hd__decap_6
XFILLER_95_1230 VPWR VGND VPWR VGND sky130_ef_sc_hd__decap_12
XFILLER_169_1088 VPWR VGND VPWR VGND sky130_ef_sc_hd__decap_12
XFILLER_204_531 VGND VGND VPWR VPWR sky130_fd_sc_hd__decap_6
XFILLER_186_1391 VGND VGND VPWR VPWR sky130_fd_sc_hd__decap_6
XFILLER_225_1506 VGND VGND VPWR VPWR sky130_fd_sc_hd__decap_8
XFILLER_232_851 VPWR VGND VPWR VGND sky130_ef_sc_hd__decap_12
XFILLER_95_1285 VGND VGND VPWR VPWR sky130_fd_sc_hd__decap_6
XFILLER_189_744 VPWR VGND VPWR VGND sky130_ef_sc_hd__decap_12
XFILLER_143_1206 VPWR VGND VPWR VGND sky130_ef_sc_hd__decap_12
XFILLER_108_1337 VPWR VGND VPWR VGND sky130_ef_sc_hd__decap_12
XFILLER_177_928 VPWR VGND VPWR VGND sky130_ef_sc_hd__decap_12
XFILLER_189_799 VPWR VGND VPWR VGND sky130_ef_sc_hd__decap_12
XFILLER_223_1241 VGND VGND VPWR VPWR sky130_fd_sc_hd__decap_6
XPHY_EDGE_ROW_93_2_Left_595 VGND VGND VPWR VPWR sky130_fd_sc_hd__decap_3
XFILLER_185_983 VGND VGND VPWR VPWR sky130_fd_sc_hd__decap_6
XTAP_TAPCELL_ROW_56_2_5113 VGND VPWR sky130_fd_sc_hd__tapvpwrvgnd_1
XPHY_EDGE_ROW_159_2_Right_250 VGND VGND VPWR VPWR sky130_fd_sc_hd__decap_3
XFILLER_176_1004 VGND VGND VPWR VPWR sky130_fd_sc_hd__decap_6
XPHY_EDGE_ROW_9_Right_9 VGND VGND VPWR VPWR sky130_fd_sc_hd__decap_3
XFILLER_208_34 VPWR VGND VPWR VGND sky130_ef_sc_hd__decap_12
XFILLER_171_154 VPWR VGND VPWR VGND sky130_ef_sc_hd__decap_12
XTAP_TAPCELL_ROW_245_4340 VGND VPWR sky130_fd_sc_hd__tapvpwrvgnd_1
XTAP_TAPCELL_ROW_23_2_4843 VGND VPWR sky130_fd_sc_hd__tapvpwrvgnd_1
XFILLER_119_1433 VPWR VGND VPWR VGND sky130_ef_sc_hd__decap_12
XFILLER_154_1313 VPWR VGND VPWR VGND sky130_ef_sc_hd__decap_12
XFILLER_208_89 VPWR VGND VPWR VGND sky130_ef_sc_hd__decap_12
XFILLER_63_1218 VPWR VGND VPWR VGND sky130_ef_sc_hd__decap_12
XFILLER_217_1045 VPWR VGND VPWR VGND sky130_ef_sc_hd__decap_12
XTAP_TAPCELL_ROW_241_4204 VGND VPWR sky130_fd_sc_hd__tapvpwrvgnd_1
XFILLER_28_1349 VGND VGND VPWR VPWR sky130_fd_sc_hd__decap_6
XFILLER_119_1488 VPWR VGND VPWR VGND sky130_ef_sc_hd__decap_12
XFILLER_154_1368 VPWR VGND VPWR VGND sky130_ef_sc_hd__decap_12
XFILLER_224_22 VPWR VGND VPWR VGND sky130_ef_sc_hd__decap_12
XFILLER_246_409 VPWR VGND VPWR VGND sky130_ef_sc_hd__decap_12
XFILLER_224_77 VPWR VGND VPWR VGND sky130_ef_sc_hd__decap_12
XFILLER_187_1100 VPWR VGND VPWR VGND sky130_ef_sc_hd__decap_12
XTAP_TAPCELL_ROW_206_2955 VGND VPWR sky130_fd_sc_hd__tapvpwrvgnd_1
XTAP_TAPCELL_ROW_206_2966 VGND VPWR sky130_fd_sc_hd__tapvpwrvgnd_1
XTAP_TAPCELL_ROW_206_2977 VGND VPWR sky130_fd_sc_hd__tapvpwrvgnd_1
XFILLER_215_818 VPWR VGND VPWR VGND sky130_ef_sc_hd__decap_12
XFILLER_226_144 VGND VGND VPWR VPWR sky130_fd_sc_hd__decap_6
XTAP_TAPCELL_ROW_239_4111 VGND VPWR sky130_fd_sc_hd__tapvpwrvgnd_1
XFILLER_254_464 VPWR VGND VPWR VGND sky130_ef_sc_hd__decap_12
XTAP_TAPCELL_ROW_239_4122 VGND VPWR sky130_fd_sc_hd__tapvpwrvgnd_1
XTAP_TAPCELL_ROW_198_2701 VGND VPWR sky130_fd_sc_hd__tapvpwrvgnd_1
XTAP_TAPCELL_ROW_202_2819 VGND VPWR sky130_fd_sc_hd__tapvpwrvgnd_1
XTAP_TAPCELL_ROW_239_4133 VGND VPWR sky130_fd_sc_hd__tapvpwrvgnd_1
XFILLER_187_1155 VGND VGND VPWR VPWR sky130_fd_sc_hd__decap_6
XFILLER_227_689 VPWR VGND VPWR VGND sky130_ef_sc_hd__decap_12
XFILLER_242_648 VPWR VGND VPWR VGND sky130_ef_sc_hd__decap_12
XFILLER_240_65 VPWR VGND VPWR VGND sky130_ef_sc_hd__decap_12
XFILLER_165_1420 VGND VGND VPWR VPWR sky130_fd_sc_hd__decap_8
XFILLER_39_1445 VPWR VGND VPWR VGND sky130_ef_sc_hd__decap_12
XFILLER_74_1325 VPWR VGND VPWR VGND sky130_ef_sc_hd__decap_12
XFILLER_228_1152 VPWR VGND VPWR VGND sky130_ef_sc_hd__decap_12
XFILLER_168_906 VPWR VGND VPWR VGND sky130_ef_sc_hd__decap_12
XFILLER_223_873 VPWR VGND VPWR VGND sky130_ef_sc_hd__decap_12
XFILLER_161_1328 VGND VGND VPWR VPWR sky130_fd_sc_hd__decap_6
XFILLER_195_725 VGND VGND VPWR VPWR sky130_fd_sc_hd__decap_6
XTAP_TAPCELL_ROW_112_1_1397 VGND VPWR sky130_fd_sc_hd__tapvpwrvgnd_1
XFILLER_176_961 VGND VGND VPWR VPWR sky130_fd_sc_hd__decap_6
XFILLER_202_1336 VPWR VGND VPWR VGND sky130_ef_sc_hd__decap_12
XFILLER_198_1262 VGND VGND VPWR VPWR sky130_fd_sc_hd__decap_6
XFILLER_50_1380 VPWR VGND VPWR VGND sky130_ef_sc_hd__decap_12
XFILLER_118_34 VPWR VGND VPWR VGND sky130_ef_sc_hd__decap_12
XFILLER_190_452 VPWR VGND VPWR VGND sky130_ef_sc_hd__decap_12
XFILLER_85_1421 VPWR VGND VPWR VGND sky130_ef_sc_hd__decap_12
XFILLER_137_1500 VGND VGND VPWR VPWR sky130_fd_sc_hd__decap_6
XFILLER_235_1112 VGND VGND VPWR VPWR sky130_fd_sc_hd__decap_6
XFILLER_1_315 VGND VGND VPWR VPWR sky130_fd_sc_hd__fill_2
XFILLER_85_1476 VPWR VGND VPWR VGND sky130_ef_sc_hd__decap_12
XFILLER_134_22 VPWR VGND VPWR VGND sky130_ef_sc_hd__decap_12
XTAP_TAPCELL_ROW_144_2_5812 VGND VPWR sky130_fd_sc_hd__tapvpwrvgnd_1
XFILLER_213_1432 VPWR VGND VPWR VGND sky130_ef_sc_hd__decap_12
XFILLER_94_15 VGND VGND VPWR VPWR sky130_fd_sc_hd__decap_6
XFILLER_44_1184 VPWR VGND VPWR VGND sky130_ef_sc_hd__decap_12
XFILLER_217_111 VPWR VGND VPWR VGND sky130_ef_sc_hd__decap_12
X_600_ clknet_3_3__leaf_clk net620 _008_ VGND VGND VPWR VPWR valid_d1 sky130_fd_sc_hd__dfrtp_1
XFILLER_213_1487 VPWR VGND VPWR VGND sky130_ef_sc_hd__decap_12
XFILLER_245_431 VPWR VGND VPWR VGND sky130_ef_sc_hd__decap_12
XFILLER_131_1165 VPWR VGND VPWR VGND sky130_ef_sc_hd__decap_12
XFILLER_218_667 VPWR VGND VPWR VGND sky130_ef_sc_hd__decap_12
XFILLER_175_3 VPWR VGND VPWR VGND sky130_ef_sc_hd__decap_12
X_531_ net666 VGND VGND VPWR VPWR _013_ sky130_fd_sc_hd__inv_2
XFILLER_233_615 VPWR VGND VPWR VGND sky130_ef_sc_hd__decap_12
XFILLER_217_166 VGND VGND VPWR VPWR sky130_fd_sc_hd__decap_6
XFILLER_245_486 VPWR VGND VPWR VGND sky130_ef_sc_hd__decap_12
XFILLER_150_65 VGND VGND VPWR VPWR sky130_fd_sc_hd__decap_6
X_462_ _196_ _197_ VGND VGND VPWR VPWR acc_core.adder.cla_blocks\[0\].block.sum\[3\]
+ sky130_fd_sc_hd__xnor2_1
XTAP_TAPCELL_ROW_93_2_5409 VGND VPWR sky130_fd_sc_hd__tapvpwrvgnd_1
XFILLER_214_851 VPWR VGND VPWR VGND sky130_ef_sc_hd__decap_12
XTAP_TAPCELL_ROW_62_2_5156 VGND VPWR sky130_fd_sc_hd__tapvpwrvgnd_1
XFILLER_241_670 VPWR VGND VPWR VGND sky130_ef_sc_hd__decap_12
XFILLER_186_703 VGND VGND VPWR VPWR sky130_fd_sc_hd__decap_6
X_393_ net152 net151 VGND VGND VPWR VPWR _182_ sky130_fd_sc_hd__or2_1
XFILLER_198_574 VGND VGND VPWR VPWR sky130_fd_sc_hd__decap_6
XFILLER_16_1220 VGND VGND VPWR VPWR sky130_fd_sc_hd__decap_6
XPHY_EDGE_ROW_52_1_Right_708 VGND VGND VPWR VPWR sky130_fd_sc_hd__decap_3
XFILLER_199_1026 VGND VGND VPWR VPWR sky130_fd_sc_hd__decap_6
XFILLER_103_1201 VGND VGND VPWR VPWR sky130_fd_sc_hd__decap_4
XFILLER_167_983 VGND VGND VPWR VPWR sky130_fd_sc_hd__decap_6
XTAP_TAPCELL_ROW_175_1874 VGND VPWR sky130_fd_sc_hd__tapvpwrvgnd_1
XFILLER_51_1177 VPWR VGND VPWR VGND sky130_ef_sc_hd__decap_12
XFILLER_142_1294 VPWR VGND VPWR VGND sky130_ef_sc_hd__decap_12
XTAP_TAPCELL_ROW_175_1885 VGND VPWR sky130_fd_sc_hd__tapvpwrvgnd_1
XTAP_TAPCELL_ROW_171_1727 VGND VPWR sky130_fd_sc_hd__tapvpwrvgnd_1
XTAP_TAPCELL_ROW_175_1896 VGND VPWR sky130_fd_sc_hd__tapvpwrvgnd_1
XTAP_TAPCELL_ROW_171_1738 VGND VPWR sky130_fd_sc_hd__tapvpwrvgnd_1
XTAP_TAPCELL_ROW_212_3159 VGND VPWR sky130_fd_sc_hd__tapvpwrvgnd_1
XTAP_TAPCELL_ROW_171_1749 VGND VPWR sky130_fd_sc_hd__tapvpwrvgnd_1
XFILLER_5_643 VGND VGND VPWR VPWR sky130_fd_sc_hd__fill_2
XFILLER_4_120 VPWR VGND VPWR VGND sky130_ef_sc_hd__decap_12
XFILLER_177_1346 VPWR VGND VPWR VGND sky130_ef_sc_hd__decap_12
XFILLER_5_665 VGND VGND VPWR VPWR sky130_fd_sc_hd__fill_1
XFILLER_181_474 VPWR VGND VPWR VGND sky130_ef_sc_hd__decap_12
XFILLER_4_46 VPWR VGND VPWR VGND sky130_ef_sc_hd__decap_12
XFILLER_214_1207 VPWR VGND VPWR VGND sky130_ef_sc_hd__decap_12
XTAP_TAPCELL_ROW_169_1656 VGND VPWR sky130_fd_sc_hd__tapvpwrvgnd_1
XFILLER_218_1398 VPWR VGND VPWR VGND sky130_ef_sc_hd__decap_12
XTAP_TAPCELL_ROW_169_1667 VGND VPWR sky130_fd_sc_hd__tapvpwrvgnd_1
XTAP_TAPCELL_ROW_165_1509 VGND VPWR sky130_fd_sc_hd__tapvpwrvgnd_1
XTAP_TAPCELL_ROW_169_1678 VGND VPWR sky130_fd_sc_hd__tapvpwrvgnd_1
XFILLER_228_409 VPWR VGND VPWR VGND sky130_ef_sc_hd__decap_12
XFILLER_62_1251 VPWR VGND VPWR VGND sky130_ef_sc_hd__decap_12
XFILLER_27_1371 VGND VGND VPWR VPWR sky130_fd_sc_hd__decap_6
XFILLER_7_1432 VPWR VGND VPWR VGND sky130_ef_sc_hd__decap_12
XFILLER_0_392 VGND VGND VPWR VPWR sky130_fd_sc_hd__fill_1
XFILLER_153_1390 VPWR VGND VPWR VGND sky130_ef_sc_hd__decap_12
XFILLER_248_280 VPWR VGND VPWR VGND sky130_ef_sc_hd__decap_12
XFILLER_7_1487 VPWR VGND VPWR VGND sky130_ef_sc_hd__decap_12
XFILLER_208_144 VGND VGND VPWR VPWR sky130_fd_sc_hd__decap_6
XFILLER_110_1227 VPWR VGND VPWR VGND sky130_ef_sc_hd__decap_12
XFILLER_188_1453 VPWR VGND VPWR VGND sky130_ef_sc_hd__decap_12
XFILLER_97_1347 VPWR VGND VPWR VGND sky130_ef_sc_hd__decap_12
XFILLER_209_689 VPWR VGND VPWR VGND sky130_ef_sc_hd__decap_12
XFILLER_236_464 VPWR VGND VPWR VGND sky130_ef_sc_hd__decap_12
XFILLER_251_412 VPWR VGND VPWR VGND sky130_ef_sc_hd__decap_12
XFILLER_224_648 VPWR VGND VPWR VGND sky130_ef_sc_hd__decap_12
XFILLER_252_968 VPWR VGND VPWR VGND sky130_ef_sc_hd__decap_12
XFILLER_251_467 VGND VGND VPWR VPWR sky130_fd_sc_hd__decap_6
XFILLER_225_1303 VPWR VGND VPWR VGND sky130_ef_sc_hd__decap_12
XTAP_TAPCELL_ROW_253_4620 VGND VPWR sky130_fd_sc_hd__tapvpwrvgnd_1
XFILLER_189_541 VPWR VGND VPWR VGND sky130_ef_sc_hd__decap_12
XFILLER_205_873 VPWR VGND VPWR VGND sky130_ef_sc_hd__decap_12
XFILLER_210_46 VPWR VGND VPWR VGND sky130_ef_sc_hd__decap_12
XFILLER_90_3 VPWR VGND VPWR VGND sky130_ef_sc_hd__decap_12
XFILLER_177_725 VGND VGND VPWR VPWR sky130_fd_sc_hd__decap_6
XFILLER_220_832 VGND VGND VPWR VPWR sky130_fd_sc_hd__decap_6
XFILLER_225_1358 VPWR VGND VPWR VGND sky130_ef_sc_hd__decap_12
XFILLER_189_596 VGND VGND VPWR VPWR sky130_fd_sc_hd__decap_6
XFILLER_191_216 VPWR VGND VPWR VGND sky130_ef_sc_hd__decap_12
XFILLER_219_44 VPWR VGND VPWR VGND sky130_ef_sc_hd__decap_12
XFILLER_30_1239 VPWR VGND VPWR VGND sky130_ef_sc_hd__decap_12
XFILLER_8_481 VGND VGND VPWR VPWR sky130_fd_sc_hd__fill_1
XFILLER_195_1413 VGND VGND VPWR VPWR sky130_fd_sc_hd__decap_6
XTAP_TAPCELL_ROW_247_4402 VGND VPWR sky130_fd_sc_hd__tapvpwrvgnd_1
XFILLER_121_1378 VPWR VGND VPWR VGND sky130_ef_sc_hd__decap_12
XTAP_TAPCELL_ROW_247_4413 VGND VPWR sky130_fd_sc_hd__tapvpwrvgnd_1
XFILLER_172_452 VPWR VGND VPWR VGND sky130_ef_sc_hd__decap_12
XFILLER_219_99 VPWR VGND VPWR VGND sky130_ef_sc_hd__decap_12
XFILLER_236_1410 VPWR VGND VPWR VGND sky130_ef_sc_hd__decap_12
XTAP_TAPCELL_ROW_86_2_5352 VGND VPWR sky130_fd_sc_hd__tapvpwrvgnd_1
XFILLER_119_1230 VPWR VGND VPWR VGND sky130_ef_sc_hd__decap_12
XFILLER_8_1207 VPWR VGND VPWR VGND sky130_ef_sc_hd__decap_12
XFILLER_236_1465 VPWR VGND VPWR VGND sky130_ef_sc_hd__decap_12
XTAP_TAPCELL_ROW_9_1202 VGND VPWR sky130_fd_sc_hd__tapvpwrvgnd_1
XTAP_TAPCELL_ROW_9_1213 VGND VPWR sky130_fd_sc_hd__tapvpwrvgnd_1
XFILLER_119_1285 VGND VGND VPWR VPWR sky130_fd_sc_hd__decap_6
XFILLER_154_1165 VPWR VGND VPWR VGND sky130_ef_sc_hd__decap_12
XFILLER_235_87 VPWR VGND VPWR VGND sky130_ef_sc_hd__decap_12
XTAP_TAPCELL_ROW_9_1224 VGND VPWR sky130_fd_sc_hd__tapvpwrvgnd_1
XFILLER_246_206 VPWR VGND VPWR VGND sky130_ef_sc_hd__decap_12
XTAP_TAPCELL_ROW_9_1235 VGND VPWR sky130_fd_sc_hd__tapvpwrvgnd_1
XFILLER_189_1217 VPWR VGND VPWR VGND sky130_ef_sc_hd__decap_12
XFILLER_41_1335 VPWR VGND VPWR VGND sky130_ef_sc_hd__decap_12
XFILLER_227_431 VPWR VGND VPWR VGND sky130_ef_sc_hd__decap_12
XFILLER_132_1485 VPWR VGND VPWR VGND sky130_ef_sc_hd__decap_12
XTAP_TAPCELL_ROW_181_2078 VGND VPWR sky130_fd_sc_hd__tapvpwrvgnd_1
XFILLER_104_58 VGND VGND VPWR VPWR sky130_fd_sc_hd__decap_6
XFILLER_64_18 VGND VGND VPWR VPWR sky130_fd_sc_hd__decap_3
XTAP_TAPCELL_ROW_181_2089 VGND VPWR sky130_fd_sc_hd__tapvpwrvgnd_1
XFILLER_230_1097 VPWR VGND VPWR VGND sky130_ef_sc_hd__decap_12
XFILLER_215_615 VPWR VGND VPWR VGND sky130_ef_sc_hd__decap_12
XFILLER_254_261 VPWR VGND VPWR VGND sky130_ef_sc_hd__decap_12
XFILLER_227_486 VPWR VGND VPWR VGND sky130_ef_sc_hd__decap_12
XTAP_TAPCELL_ROW_47_2_5036 VGND VPWR sky130_fd_sc_hd__tapvpwrvgnd_1
XFILLER_242_445 VGND VGND VPWR VPWR sky130_fd_sc_hd__decap_6
XFILLER_199_338 VGND VGND VPWR VPWR sky130_fd_sc_hd__decap_6
XFILLER_39_1242 VGND VGND VPWR VPWR sky130_fd_sc_hd__decap_6
XFILLER_120_46 VPWR VGND VPWR VGND sky130_ef_sc_hd__decap_12
XFILLER_165_1261 VPWR VGND VPWR VGND sky130_ef_sc_hd__decap_12
XFILLER_168_703 VGND VGND VPWR VPWR sky130_fd_sc_hd__decap_6
XFILLER_223_670 VPWR VGND VPWR VGND sky130_ef_sc_hd__decap_12
XFILLER_251_990 VPWR VGND VPWR VGND sky130_ef_sc_hd__decap_12
XFILLER_74_1177 VGND VGND VPWR VPWR sky130_fd_sc_hd__decap_6
XTAP_TAPCELL_ROW_14_2_4777 VGND VPWR sky130_fd_sc_hd__tapvpwrvgnd_1
XFILLER_165_1294 VGND VGND VPWR VPWR sky130_fd_sc_hd__decap_8
XFILLER_211_854 VGND VGND VPWR VPWR sky130_fd_sc_hd__decap_6
XFILLER_52_1442 VPWR VGND VPWR VGND sky130_ef_sc_hd__decap_12
XFILLER_13_44 VPWR VGND VPWR VGND sky130_ef_sc_hd__decap_12
XFILLER_202_1133 VGND VGND VPWR VPWR sky130_fd_sc_hd__decap_6
XFILLER_129_44 VPWR VGND VPWR VGND sky130_ef_sc_hd__decap_12
XFILLER_52_1497 VPWR VGND VPWR VGND sky130_ef_sc_hd__decap_12
XFILLER_89_15 VPWR VGND VPWR VGND sky130_ef_sc_hd__decap_12
XFILLER_182_249 VPWR VGND VPWR VGND sky130_ef_sc_hd__decap_12
XFILLER_174_1508 VGND VGND VPWR VPWR sky130_fd_sc_hd__decap_6
XTAP_TAPCELL_ROW_230_3793 VGND VPWR sky130_fd_sc_hd__tapvpwrvgnd_1
XFILLER_237_1229 VPWR VGND VPWR VGND sky130_ef_sc_hd__decap_12
XFILLER_2_646 VGND VGND VPWR VPWR sky130_fd_sc_hd__decap_3
XFILLER_2_657 VGND VGND VPWR VPWR sky130_fd_sc_hd__decap_6
XFILLER_85_1273 VPWR VGND VPWR VGND sky130_ef_sc_hd__decap_12
XPHY_EDGE_ROW_189_Right_34 VGND VGND VPWR VPWR sky130_fd_sc_hd__decap_3
XFILLER_133_1249 VPWR VGND VPWR VGND sky130_ef_sc_hd__decap_12
XFILLER_237_228 VPWR VGND VPWR VGND sky130_ef_sc_hd__decap_12
XFILLER_213_1284 VGND VGND VPWR VPWR sky130_fd_sc_hd__decap_6
XTAP_TAPCELL_ROW_224_3586 VGND VPWR sky130_fd_sc_hd__tapvpwrvgnd_1
XTAP_TAPCELL_ROW_224_3597 VGND VPWR sky130_fd_sc_hd__tapvpwrvgnd_1
XFILLER_218_464 VPWR VGND VPWR VGND sky130_ef_sc_hd__decap_12
XTAP_TAPCELL_ROW_220_3439 VGND VPWR sky130_fd_sc_hd__tapvpwrvgnd_1
XFILLER_248_1336 VPWR VGND VPWR VGND sky130_ef_sc_hd__decap_12
XFILLER_94_1509 VGND VGND VPWR VPWR sky130_fd_sc_hd__decap_6
XFILLER_233_412 VPWR VGND VPWR VGND sky130_ef_sc_hd__decap_12
XFILLER_245_283 VPWR VGND VPWR VGND sky130_ef_sc_hd__decap_12
XFILLER_206_648 VPWR VGND VPWR VGND sky130_ef_sc_hd__decap_12
XFILLER_234_968 VPWR VGND VPWR VGND sky130_ef_sc_hd__decap_12
X_514_ _261_ _263_ VGND VGND VPWR VPWR _265_ sky130_fd_sc_hd__nand2_1
XFILLER_166_1047 VGND VGND VPWR VPWR sky130_fd_sc_hd__decap_6
XFILLER_96_1380 VPWR VGND VPWR VGND sky130_ef_sc_hd__decap_12
XFILLER_233_467 VGND VGND VPWR VPWR sky130_fd_sc_hd__decap_6
XFILLER_199_861 VPWR VGND VPWR VGND sky130_ef_sc_hd__decap_12
XFILLER_109_1421 VPWR VGND VPWR VGND sky130_ef_sc_hd__decap_12
X_445_ net94 _232_ _114_ VGND VGND VPWR VPWR _234_ sky130_fd_sc_hd__o21ba_1
XFILLER_53_1206 VPWR VGND VPWR VGND sky130_ef_sc_hd__decap_12
XFILLER_202_832 VGND VGND VPWR VPWR sky130_fd_sc_hd__decap_6
XFILLER_207_1033 VPWR VGND VPWR VGND sky130_ef_sc_hd__decap_12
XFILLER_18_1337 VPWR VGND VPWR VGND sky130_ef_sc_hd__decap_12
XPHY_EDGE_ROW_198_Right_43 VGND VGND VPWR VPWR sky130_fd_sc_hd__decap_3
XTAP_TAPCELL_ROW_177_1936 VGND VPWR sky130_fd_sc_hd__tapvpwrvgnd_1
X_376_ net593 net579 net552 VGND VGND VPWR VPWR _165_ sky130_fd_sc_hd__a21oi_1
XFILLER_109_1476 VPWR VGND VPWR VGND sky130_ef_sc_hd__decap_12
XFILLER_144_1356 VPWR VGND VPWR VGND sky130_ef_sc_hd__decap_12
XTAP_TAPCELL_ROW_177_1947 VGND VPWR sky130_fd_sc_hd__tapvpwrvgnd_1
XFILLER_9_223 VGND VGND VPWR VPWR sky130_fd_sc_hd__decap_8
XTAP_TAPCELL_ROW_177_1958 VGND VPWR sky130_fd_sc_hd__tapvpwrvgnd_1
XTAP_TAPCELL_ROW_218_3379 VGND VPWR sky130_fd_sc_hd__tapvpwrvgnd_1
XFILLER_207_1088 VPWR VGND VPWR VGND sky130_ef_sc_hd__decap_12
XPHY_EDGE_ROW_53_1_Right_709 VGND VGND VPWR VPWR sky130_fd_sc_hd__decap_3
XTAP_TAPCELL_ROW_92_2_5395 VGND VPWR sky130_fd_sc_hd__tapvpwrvgnd_1
XFILLER_224_1391 VGND VGND VPWR VPWR sky130_fd_sc_hd__decap_6
XFILLER_9_278 VGND VGND VPWR VPWR sky130_fd_sc_hd__fill_1
XFILLER_173_216 VPWR VGND VPWR VGND sky130_ef_sc_hd__decap_12
XTAP_TAPCELL_ROW_104_2_5493 VGND VPWR sky130_fd_sc_hd__tapvpwrvgnd_1
XFILLER_177_1143 VPWR VGND VPWR VGND sky130_ef_sc_hd__decap_12
XFILLER_181_271 VPWR VGND VPWR VGND sky130_ef_sc_hd__decap_12
XFILLER_177_1198 VGND VGND VPWR VPWR sky130_fd_sc_hd__decap_6
XFILLER_64_1313 VPWR VGND VPWR VGND sky130_ef_sc_hd__decap_12
XFILLER_29_1433 VPWR VGND VPWR VGND sky130_ef_sc_hd__decap_12
XPHY_EDGE_ROW_124_2_Left_626 VGND VGND VPWR VPWR sky130_fd_sc_hd__decap_3
XFILLER_218_1140 VPWR VGND VPWR VGND sky130_ef_sc_hd__decap_12
XFILLER_214_1004 VGND VGND VPWR VPWR sky130_fd_sc_hd__decap_6
XTAP_TAPCELL_ROW_38_2_4962 VGND VPWR sky130_fd_sc_hd__tapvpwrvgnd_1
XFILLER_64_1368 VPWR VGND VPWR VGND sky130_ef_sc_hd__decap_12
XFILLER_151_1316 VPWR VGND VPWR VGND sky130_ef_sc_hd__decap_12
XFILLER_218_1195 VPWR VGND VPWR VGND sky130_ef_sc_hd__decap_12
XFILLER_29_1488 VPWR VGND VPWR VGND sky130_ef_sc_hd__decap_12
XFILLER_228_206 VPWR VGND VPWR VGND sky130_ef_sc_hd__decap_12
XFILLER_190_1398 VPWR VGND VPWR VGND sky130_ef_sc_hd__decap_12
XFILLER_205_68 VPWR VGND VPWR VGND sky130_ef_sc_hd__decap_12
XFILLER_209_431 VPWR VGND VPWR VGND sky130_ef_sc_hd__decap_12
XFILLER_7_1284 VGND VGND VPWR VPWR sky130_fd_sc_hd__decap_6
XFILLER_243_209 VGND VGND VPWR VPWR sky130_fd_sc_hd__decap_6
XFILLER_252_710 VPWR VGND VPWR VGND sky130_ef_sc_hd__decap_12
XFILLER_149_1201 VGND VGND VPWR VPWR sky130_fd_sc_hd__decap_4
XFILLER_188_1250 VPWR VGND VPWR VGND sky130_ef_sc_hd__decap_12
XFILLER_236_261 VPWR VGND VPWR VGND sky130_ef_sc_hd__decap_12
XFILLER_209_486 VPWR VGND VPWR VGND sky130_ef_sc_hd__decap_12
XTAP_TAPCELL_ROW_255_4704 VGND VPWR sky130_fd_sc_hd__tapvpwrvgnd_1
XTAP_TAPCELL_ROW_255_4715 VGND VPWR sky130_fd_sc_hd__tapvpwrvgnd_1
XFILLER_97_1177 VPWR VGND VPWR VGND sky130_ef_sc_hd__decap_12
XTAP_TAPCELL_ROW_255_4726 VGND VPWR sky130_fd_sc_hd__tapvpwrvgnd_1
XFILLER_221_56 VPWR VGND VPWR VGND sky130_ef_sc_hd__decap_12
XFILLER_224_445 VGND VGND VPWR VPWR sky130_fd_sc_hd__decap_6
XFILLER_252_765 VPWR VGND VPWR VGND sky130_ef_sc_hd__decap_12
XFILLER_225_1100 VPWR VGND VPWR VGND sky130_ef_sc_hd__decap_12
XFILLER_205_670 VPWR VGND VPWR VGND sky130_ef_sc_hd__decap_12
XFILLER_240_949 VPWR VGND VPWR VGND sky130_ef_sc_hd__decap_12
XFILLER_229_1291 VPWR VGND VPWR VGND sky130_ef_sc_hd__decap_12
XFILLER_75_1464 VPWR VGND VPWR VGND sky130_ef_sc_hd__decap_12
XFILLER_233_990 VPWR VGND VPWR VGND sky130_ef_sc_hd__decap_12
XFILLER_162_1423 VPWR VGND VPWR VGND sky130_ef_sc_hd__decap_12
XFILLER_71_1328 VGND VGND VPWR VPWR sky130_fd_sc_hd__decap_6
XFILLER_225_1155 VGND VGND VPWR VPWR sky130_fd_sc_hd__decap_6
XFILLER_162_1478 VGND VGND VPWR VPWR sky130_fd_sc_hd__decap_6
XFILLER_165_706 VGND VGND VPWR VPWR sky130_fd_sc_hd__decap_8
XFILLER_203_1420 VPWR VGND VPWR VGND sky130_ef_sc_hd__decap_12
XTAP_TAPCELL_ROW_193_2494 VGND VPWR sky130_fd_sc_hd__tapvpwrvgnd_1
XFILLER_9_790 VGND VGND VPWR VPWR sky130_fd_sc_hd__decap_8
XPHY_EDGE_ROW_202_Right_47 VGND VGND VPWR VPWR sky130_fd_sc_hd__decap_3
XFILLER_203_1475 VPWR VGND VPWR VGND sky130_ef_sc_hd__decap_12
XPHY_EDGE_ROW_56_2_Left_558 VGND VGND VPWR VPWR sky130_fd_sc_hd__decap_3
XFILLER_47_1500 VGND VGND VPWR VPWR sky130_fd_sc_hd__decap_6
XFILLER_156_1227 VPWR VGND VPWR VGND sky130_ef_sc_hd__decap_12
XFILLER_236_1262 VGND VGND VPWR VPWR sky130_fd_sc_hd__decap_6
XFILLER_8_1004 VGND VGND VPWR VPWR sky130_fd_sc_hd__decap_6
XFILLER_82_1435 VGND VGND VPWR VPWR sky130_fd_sc_hd__decap_6
XTAP_TAPCELL_ROW_187_2287 VGND VPWR sky130_fd_sc_hd__tapvpwrvgnd_1
XTAP_TAPCELL_ROW_187_2298 VGND VPWR sky130_fd_sc_hd__tapvpwrvgnd_1
XFILLER_219_228 VPWR VGND VPWR VGND sky130_ef_sc_hd__decap_12
XFILLER_115_68 VGND VGND VPWR VPWR sky130_fd_sc_hd__decap_3
XFILLER_189_1014 VPWR VGND VPWR VGND sky130_ef_sc_hd__decap_12
XFILLER_75_39 VGND VGND VPWR VPWR sky130_fd_sc_hd__decap_4
XPHY_EDGE_ROW_211_Right_56 VGND VGND VPWR VPWR sky130_fd_sc_hd__decap_3
XTAP_TAPCELL_ROW_159_2_5931 VGND VPWR sky130_fd_sc_hd__tapvpwrvgnd_1
XFILLER_41_1165 VPWR VGND VPWR VGND sky130_ef_sc_hd__decap_12
XTAP_TAPCELL_ROW_3_966 VGND VPWR sky130_fd_sc_hd__tapvpwrvgnd_1
XFILLER_132_1282 VPWR VGND VPWR VGND sky130_ef_sc_hd__decap_12
XFILLER_189_1069 VGND VGND VPWR VPWR sky130_fd_sc_hd__decap_6
XTAP_TAPCELL_ROW_3_977 VGND VPWR sky130_fd_sc_hd__tapvpwrvgnd_1
XTAP_TAPCELL_ROW_3_988 VGND VPWR sky130_fd_sc_hd__tapvpwrvgnd_1
XFILLER_215_412 VPWR VGND VPWR VGND sky130_ef_sc_hd__decap_12
XFILLER_243_732 VPWR VGND VPWR VGND sky130_ef_sc_hd__decap_12
XFILLER_227_283 VPWR VGND VPWR VGND sky130_ef_sc_hd__decap_12
XFILLER_167_1334 VPWR VGND VPWR VGND sky130_ef_sc_hd__decap_12
XFILLER_131_56 VPWR VGND VPWR VGND sky130_ef_sc_hd__decap_12
XFILLER_216_968 VPWR VGND VPWR VGND sky130_ef_sc_hd__decap_12
XFILLER_76_1239 VPWR VGND VPWR VGND sky130_ef_sc_hd__decap_12
XTAP_TAPCELL_ROW_100_1_1379 VGND VPWR sky130_fd_sc_hd__tapvpwrvgnd_1
XFILLER_231_916 VPWR VGND VPWR VGND sky130_ef_sc_hd__decap_12
XFILLER_91_27 VPWR VGND VPWR VGND sky130_ef_sc_hd__decap_12
XFILLER_215_467 VGND VGND VPWR VPWR sky130_fd_sc_hd__decap_6
XFILLER_243_787 VPWR VGND VPWR VGND sky130_ef_sc_hd__decap_12
XFILLER_167_1389 VPWR VGND VPWR VGND sky130_ef_sc_hd__decap_12
XTAP_TAPCELL_ROW_141_2_5789 VGND VPWR sky130_fd_sc_hd__tapvpwrvgnd_1
XFILLER_196_820 VPWR VGND VPWR VGND sky130_ef_sc_hd__decap_12
XTAP_TAPCELL_ROW_77_2_5275 VGND VPWR sky130_fd_sc_hd__tapvpwrvgnd_1
XFILLER_165_1091 VGND VGND VPWR VPWR sky130_fd_sc_hd__fill_1
XFILLER_141_1507 VGND VGND VPWR VPWR sky130_fd_sc_hd__decap_8
XTAP_TAPCELL_ROW_121_2_5632 VGND VPWR sky130_fd_sc_hd__tapvpwrvgnd_1
XFILLER_138_3 VPWR VGND VPWR VGND sky130_ef_sc_hd__decap_12
XFILLER_196_875 VGND VGND VPWR VPWR sky130_fd_sc_hd__decap_6
XFILLER_13_1201 VGND VGND VPWR VPWR sky130_fd_sc_hd__decap_4
XTAP_TAPCELL_ROW_213_3210 VGND VPWR sky130_fd_sc_hd__tapvpwrvgnd_1
XPHY_EDGE_ROW_220_Right_65 VGND VGND VPWR VPWR sky130_fd_sc_hd__decap_3
XPHY_EDGE_ROW_122_1_Left_377 VGND VGND VPWR VPWR sky130_fd_sc_hd__decap_3
XTAP_TAPCELL_ROW_213_3221 VGND VPWR sky130_fd_sc_hd__tapvpwrvgnd_1
Xwire636 net33 VGND VGND VPWR VPWR net636 sky130_fd_sc_hd__buf_1
Xwire647 net24 VGND VGND VPWR VPWR net647 sky130_fd_sc_hd__buf_1
XFILLER_210_194 VPWR VGND VPWR VGND sky130_ef_sc_hd__decap_12
Xwire658 net15 VGND VGND VPWR VPWR net658 sky130_fd_sc_hd__buf_1
XTAP_TAPCELL_ROW_232_3866 VGND VPWR sky130_fd_sc_hd__tapvpwrvgnd_1
XFILLER_52_1294 VPWR VGND VPWR VGND sky130_ef_sc_hd__decap_12
XFILLER_6_237 VGND VGND VPWR VPWR sky130_fd_sc_hd__fill_2
XTAP_TAPCELL_ROW_232_3877 VGND VPWR sky130_fd_sc_hd__tapvpwrvgnd_1
XTAP_TAPCELL_ROW_232_3888 VGND VPWR sky130_fd_sc_hd__tapvpwrvgnd_1
XFILLER_178_1441 VPWR VGND VPWR VGND sky130_ef_sc_hd__decap_12
XFILLER_87_1335 VPWR VGND VPWR VGND sky130_ef_sc_hd__decap_12
XFILLER_139_1414 VGND VGND VPWR VPWR sky130_fd_sc_hd__decap_6
XFILLER_174_1305 VGND VGND VPWR VPWR sky130_fd_sc_hd__decap_6
XTAP_TAPCELL_ROW_70_2_5218 VGND VPWR sky130_fd_sc_hd__tapvpwrvgnd_1
XFILLER_237_1026 VGND VGND VPWR VPWR sky130_fd_sc_hd__decap_6
XFILLER_178_1496 VPWR VGND VPWR VGND sky130_ef_sc_hd__decap_12
XTAP_TAPCELL_ROW_207_3003 VGND VPWR sky130_fd_sc_hd__tapvpwrvgnd_1
XTAP_TAPCELL_ROW_207_3014 VGND VPWR sky130_fd_sc_hd__tapvpwrvgnd_1
XFILLER_250_1226 VPWR VGND VPWR VGND sky130_ef_sc_hd__decap_12
XFILLER_215_1346 VPWR VGND VPWR VGND sky130_ef_sc_hd__decap_12
XTAP_TAPCELL_ROW_226_3659 VGND VPWR sky130_fd_sc_hd__tapvpwrvgnd_1
XFILLER_63_1390 VPWR VGND VPWR VGND sky130_ef_sc_hd__decap_12
XFILLER_168_1109 VPWR VGND VPWR VGND sky130_ef_sc_hd__decap_12
XFILLER_225_209 VGND VGND VPWR VPWR sky130_fd_sc_hd__decap_6
XFILLER_253_529 VPWR VGND VPWR VGND sky130_ef_sc_hd__decap_12
XFILLER_98_1442 VPWR VGND VPWR VGND sky130_ef_sc_hd__decap_12
XFILLER_20_1227 VPWR VGND VPWR VGND sky130_ef_sc_hd__decap_12
XFILLER_185_1401 VPWR VGND VPWR VGND sky130_ef_sc_hd__decap_12
XFILLER_218_261 VPWR VGND VPWR VGND sky130_ef_sc_hd__decap_12
XFILLER_234_710 VPWR VGND VPWR VGND sky130_ef_sc_hd__decap_12
XFILLER_246_581 VPWR VGND VPWR VGND sky130_ef_sc_hd__decap_12
XFILLER_248_1133 VGND VGND VPWR VPWR sky130_fd_sc_hd__decap_6
XFILLER_94_1306 VGND VGND VPWR VPWR sky130_fd_sc_hd__decap_6
XFILLER_206_445 VGND VGND VPWR VPWR sky130_fd_sc_hd__decap_6
XFILLER_98_1497 VPWR VGND VPWR VGND sky130_ef_sc_hd__decap_12
XFILLER_185_1456 VGND VGND VPWR VPWR sky130_fd_sc_hd__decap_6
XFILLER_234_765 VPWR VGND VPWR VGND sky130_ef_sc_hd__decap_12
XFILLER_222_949 VPWR VGND VPWR VGND sky130_ef_sc_hd__decap_12
XFILLER_215_990 VPWR VGND VPWR VGND sky130_ef_sc_hd__decap_12
XFILLER_226_1453 VPWR VGND VPWR VGND sky130_ef_sc_hd__decap_12
XFILLER_187_842 VPWR VGND VPWR VGND sky130_ef_sc_hd__decap_12
X_428_ net595 dout0_q\[22\] net534 VGND VGND VPWR VPWR _217_ sky130_fd_sc_hd__and3_1
XFILLER_109_1273 VPWR VGND VPWR VGND sky130_ef_sc_hd__decap_12
XFILLER_187_897 VGND VGND VPWR VPWR sky130_fd_sc_hd__decap_6
X_359_ net594 net546 net575 VGND VGND VPWR VPWR _148_ sky130_fd_sc_hd__nand3_1
XFILLER_179_1205 VPWR VGND VPWR VGND sky130_ef_sc_hd__decap_12
XFILLER_31_1378 VPWR VGND VPWR VGND sky130_ef_sc_hd__decap_12
XFILLER_53_3 VPWR VGND VPWR VGND sky130_ef_sc_hd__decap_12
XFILLER_255_1126 VGND VGND VPWR VPWR sky130_fd_sc_hd__decap_8
XFILLER_118_1509 VGND VGND VPWR VPWR sky130_fd_sc_hd__decap_6
XFILLER_170_753 VPWR VGND VPWR VGND sky130_ef_sc_hd__decap_12
XFILLER_29_1230 VPWR VGND VPWR VGND sky130_ef_sc_hd__decap_12
XFILLER_216_34 VPWR VGND VPWR VGND sky130_ef_sc_hd__decap_12
XFILLER_233_1413 VGND VGND VPWR VPWR sky130_fd_sc_hd__decap_6
XFILLER_9_1324 VPWR VGND VPWR VGND sky130_ef_sc_hd__decap_12
XFILLER_190_1140 VPWR VGND VPWR VGND sky130_ef_sc_hd__decap_12
XFILLER_64_1165 VPWR VGND VPWR VGND sky130_ef_sc_hd__decap_12
XFILLER_29_1285 VGND VGND VPWR VPWR sky130_fd_sc_hd__decap_6
XFILLER_9_1357 VGND VGND VPWR VPWR sky130_fd_sc_hd__decap_8
XFILLER_216_89 VPWR VGND VPWR VGND sky130_ef_sc_hd__decap_12
XFILLER_99_1206 VPWR VGND VPWR VGND sky130_ef_sc_hd__decap_12
XFILLER_190_1195 VPWR VGND VPWR VGND sky130_ef_sc_hd__decap_12
XTAP_TAPCELL_ROW_182_2140 VGND VPWR sky130_fd_sc_hd__tapvpwrvgnd_1
XFILLER_232_22 VPWR VGND VPWR VGND sky130_ef_sc_hd__decap_12
XFILLER_244_507 VPWR VGND VPWR VGND sky130_ef_sc_hd__decap_12
Xinput2 wr_addr[0] VGND VGND VPWR VPWR net2 sky130_fd_sc_hd__clkbuf_1
XFILLER_42_1485 VPWR VGND VPWR VGND sky130_ef_sc_hd__decap_12
XFILLER_225_732 VPWR VGND VPWR VGND sky130_ef_sc_hd__decap_12
XFILLER_232_77 VPWR VGND VPWR VGND sky130_ef_sc_hd__decap_12
XFILLER_209_283 VPWR VGND VPWR VGND sky130_ef_sc_hd__decap_12
XTAP_TAPCELL_ROW_126_2_5669 VGND VPWR sky130_fd_sc_hd__tapvpwrvgnd_1
XTAP_TAPCELL_ROW_94_2_5414 VGND VPWR sky130_fd_sc_hd__tapvpwrvgnd_1
XFILLER_213_916 VPWR VGND VPWR VGND sky130_ef_sc_hd__decap_12
XFILLER_227_1217 VPWR VGND VPWR VGND sky130_ef_sc_hd__decap_12
XFILLER_252_562 VPWR VGND VPWR VGND sky130_ef_sc_hd__decap_12
XFILLER_225_787 VPWR VGND VPWR VGND sky130_ef_sc_hd__decap_12
XFILLER_101_15 VPWR VGND VPWR VGND sky130_ef_sc_hd__decap_12
XFILLER_240_746 VGND VGND VPWR VPWR sky130_fd_sc_hd__decap_6
XFILLER_75_1261 VPWR VGND VPWR VGND sky130_ef_sc_hd__decap_12
XTAP_TAPCELL_ROW_106_2_5512 VGND VPWR sky130_fd_sc_hd__tapvpwrvgnd_1
XFILLER_178_820 VPWR VGND VPWR VGND sky130_ef_sc_hd__decap_12
XFILLER_197_639 VGND VGND VPWR VPWR sky130_fd_sc_hd__decap_6
XFILLER_162_1220 VGND VGND VPWR VPWR sky130_fd_sc_hd__decap_6
XTAP_TAPCELL_ROW_195_2567 VGND VPWR sky130_fd_sc_hd__tapvpwrvgnd_1
XTAP_TAPCELL_ROW_195_2578 VGND VPWR sky130_fd_sc_hd__tapvpwrvgnd_1
XTAP_TAPCELL_ROW_195_2589 VGND VPWR sky130_fd_sc_hd__tapvpwrvgnd_1
XFILLER_221_971 VPWR VGND VPWR VGND sky130_ef_sc_hd__decap_12
XFILLER_178_875 VGND VGND VPWR VPWR sky130_fd_sc_hd__decap_6
XTAP_TAPCELL_ROW_29_2_4896 VGND VPWR sky130_fd_sc_hd__tapvpwrvgnd_1
XFILLER_165_547 VPWR VGND VPWR VGND sky130_ef_sc_hd__decap_12
XFILLER_197_1327 VGND VGND VPWR VPWR sky130_fd_sc_hd__decap_6
XFILLER_203_1272 VPWR VGND VPWR VGND sky130_ef_sc_hd__decap_12
XFILLER_192_366 VPWR VGND VPWR VGND sky130_ef_sc_hd__decap_12
XFILLER_238_1324 VPWR VGND VPWR VGND sky130_ef_sc_hd__decap_12
XFILLER_10_34 VPWR VGND VPWR VGND sky130_ef_sc_hd__decap_12
XFILLER_238_1379 VPWR VGND VPWR VGND sky130_ef_sc_hd__decap_12
XFILLER_126_34 VPWR VGND VPWR VGND sky130_ef_sc_hd__decap_12
XTAP_TAPCELL_ROW_22_2_4839 VGND VPWR sky130_fd_sc_hd__tapvpwrvgnd_1
XFILLER_0_925 VPWR VGND VPWR VGND sky130_ef_sc_hd__decap_12
XFILLER_0_958 VGND VGND VPWR VPWR sky130_fd_sc_hd__decap_8
XFILLER_212_1508 VGND VGND VPWR VPWR sky130_fd_sc_hd__decap_6
XFILLER_43_1249 VPWR VGND VPWR VGND sky130_ef_sc_hd__decap_12
XFILLER_247_345 VPWR VGND VPWR VGND sky130_ef_sc_hd__decap_12
XFILLER_130_1208 VPWR VGND VPWR VGND sky130_ef_sc_hd__decap_12
XFILLER_142_22 VPWR VGND VPWR VGND sky130_ef_sc_hd__decap_12
XTAP_TAPCELL_ROW_221_3501 VGND VPWR sky130_fd_sc_hd__tapvpwrvgnd_1
XFILLER_134_1399 VPWR VGND VPWR VGND sky130_ef_sc_hd__decap_12
XFILLER_207_209 VGND VGND VPWR VPWR sky130_fd_sc_hd__decap_6
XFILLER_216_710 VPWR VGND VPWR VGND sky130_ef_sc_hd__decap_12
XFILLER_235_529 VPWR VGND VPWR VGND sky130_ef_sc_hd__decap_12
XFILLER_249_1420 VPWR VGND VPWR VGND sky130_ef_sc_hd__decap_12
XFILLER_228_581 VPWR VGND VPWR VGND sky130_ef_sc_hd__decap_12
XFILLER_167_1131 VPWR VGND VPWR VGND sky130_ef_sc_hd__decap_12
XFILLER_216_765 VPWR VGND VPWR VGND sky130_ef_sc_hd__decap_12
XFILLER_249_1475 VPWR VGND VPWR VGND sky130_ef_sc_hd__decap_12
XFILLER_255_3 VPWR VGND VPWR VGND sky130_ef_sc_hd__decap_12
XFILLER_231_713 VPWR VGND VPWR VGND sky130_ef_sc_hd__decap_12
XFILLER_243_584 VPWR VGND VPWR VGND sky130_ef_sc_hd__decap_12
XFILLER_188_617 VGND VGND VPWR VPWR sky130_fd_sc_hd__decap_6
XFILLER_204_949 VPWR VGND VPWR VGND sky130_ef_sc_hd__decap_12
XFILLER_167_1186 VPWR VGND VPWR VGND sky130_ef_sc_hd__decap_12
XFILLER_19_1421 VPWR VGND VPWR VGND sky130_ef_sc_hd__decap_12
XTAP_TAPCELL_ROW_219_3430 VGND VPWR sky130_fd_sc_hd__tapvpwrvgnd_1
XFILLER_231_768 VGND VGND VPWR VPWR sky130_fd_sc_hd__decap_6
XFILLER_169_842 VPWR VGND VPWR VGND sky130_ef_sc_hd__decap_12
XFILLER_54_1356 VPWR VGND VPWR VGND sky130_ef_sc_hd__decap_12
XFILLER_19_1476 VPWR VGND VPWR VGND sky130_ef_sc_hd__decap_12
XFILLER_141_1304 VPWR VGND VPWR VGND sky130_ef_sc_hd__decap_12
XFILLER_208_1183 VPWR VGND VPWR VGND sky130_ef_sc_hd__decap_12
XTAP_TAPCELL_ROW_234_3939 VGND VPWR sky130_fd_sc_hd__tapvpwrvgnd_1
XFILLER_106_1435 VGND VGND VPWR VPWR sky130_fd_sc_hd__decap_6
Xwire400 net401 VGND VGND VPWR VPWR net400 sky130_fd_sc_hd__clkbuf_1
XFILLER_169_897 VGND VGND VPWR VPWR sky130_fd_sc_hd__decap_6
XFILLER_204_1047 VGND VGND VPWR VPWR sky130_fd_sc_hd__decap_6
Xwire411 net412 VGND VGND VPWR VPWR net411 sky130_fd_sc_hd__clkbuf_1
Xwire422 net423 VGND VGND VPWR VPWR net422 sky130_fd_sc_hd__clkbuf_1
Xwire433 net434 VGND VGND VPWR VPWR net433 sky130_fd_sc_hd__clkbuf_1
XFILLER_141_1359 VPWR VGND VPWR VGND sky130_ef_sc_hd__decap_12
Xwire444 net445 VGND VGND VPWR VPWR net444 sky130_fd_sc_hd__clkbuf_1
Xwire455 net456 VGND VGND VPWR VPWR net455 sky130_fd_sc_hd__clkbuf_1
Xwire466 net467 VGND VGND VPWR VPWR net466 sky130_fd_sc_hd__clkbuf_1
XPHY_EDGE_ROW_208_Left_463 VGND VGND VPWR VPWR sky130_fd_sc_hd__decap_3
Xwire477 net478 VGND VGND VPWR VPWR net477 sky130_fd_sc_hd__clkbuf_1
Xwire488 net489 VGND VGND VPWR VPWR net488 sky130_fd_sc_hd__clkbuf_1
XFILLER_171_517 VPWR VGND VPWR VGND sky130_ef_sc_hd__decap_12
XFILLER_183_388 VPWR VGND VPWR VGND sky130_ef_sc_hd__decap_12
XTAP_TAPCELL_ROW_151_2_5871 VGND VPWR sky130_fd_sc_hd__tapvpwrvgnd_1
XFILLER_87_1165 VPWR VGND VPWR VGND sky130_ef_sc_hd__decap_12
XFILLER_178_1293 VPWR VGND VPWR VGND sky130_ef_sc_hd__decap_12
XFILLER_152_1411 VPWR VGND VPWR VGND sky130_ef_sc_hd__decap_12
XFILLER_250_1023 VPWR VGND VPWR VGND sky130_ef_sc_hd__decap_12
XFILLER_61_1316 VPWR VGND VPWR VGND sky130_ef_sc_hd__decap_12
XFILLER_215_1143 VPWR VGND VPWR VGND sky130_ef_sc_hd__decap_12
XFILLER_6_1508 VGND VGND VPWR VPWR sky130_fd_sc_hd__decap_6
XFILLER_238_323 VPWR VGND VPWR VGND sky130_ef_sc_hd__decap_12
XFILLER_152_1466 VPWR VGND VPWR VGND sky130_ef_sc_hd__decap_12
XFILLER_250_1078 VPWR VGND VPWR VGND sky130_ef_sc_hd__decap_12
XTAP_TAPCELL_ROW_143_2_5808 VGND VPWR sky130_fd_sc_hd__tapvpwrvgnd_1
XFILLER_215_1198 VGND VGND VPWR VPWR sky130_fd_sc_hd__decap_6
XFILLER_226_507 VPWR VGND VPWR VGND sky130_ef_sc_hd__decap_12
XTAP_TAPCELL_ROW_112_2_5555 VGND VPWR sky130_fd_sc_hd__tapvpwrvgnd_1
XPHY_EDGE_ROW_217_Left_472 VGND VGND VPWR VPWR sky130_fd_sc_hd__decap_3
XFILLER_238_378 VPWR VGND VPWR VGND sky130_ef_sc_hd__decap_12
XTAP_TAPCELL_ROW_80_2_5300 VGND VPWR sky130_fd_sc_hd__tapvpwrvgnd_1
XFILLER_253_326 VPWR VGND VPWR VGND sky130_ef_sc_hd__decap_12
XFILLER_59_1201 VGND VGND VPWR VPWR sky130_fd_sc_hd__decap_4
XFILLER_207_732 VPWR VGND VPWR VGND sky130_ef_sc_hd__decap_12
XFILLER_98_1294 VPWR VGND VPWR VGND sky130_ef_sc_hd__decap_12
XFILLER_202_58 VGND VGND VPWR VPWR sky130_fd_sc_hd__decap_6
XFILLER_234_562 VPWR VGND VPWR VGND sky130_ef_sc_hd__decap_12
XFILLER_207_787 VPWR VGND VPWR VGND sky130_ef_sc_hd__decap_12
XFILLER_179_639 VGND VGND VPWR VPWR sky130_fd_sc_hd__decap_6
XFILLER_222_746 VGND VGND VPWR VPWR sky130_fd_sc_hd__decap_6
XFILLER_72_1423 VPWR VGND VPWR VGND sky130_ef_sc_hd__decap_12
XFILLER_226_1250 VPWR VGND VPWR VGND sky130_ef_sc_hd__decap_12
XTAP_TAPCELL_ROW_15_2_4782 VGND VPWR sky130_fd_sc_hd__tapvpwrvgnd_1
XFILLER_203_971 VPWR VGND VPWR VGND sky130_ef_sc_hd__decap_12
XFILLER_72_1478 VGND VGND VPWR VPWR sky130_fd_sc_hd__decap_6
XTAP_TAPCELL_ROW_190_2420 VGND VPWR sky130_fd_sc_hd__tapvpwrvgnd_1
XFILLER_179_1002 VPWR VGND VPWR VGND sky130_ef_sc_hd__decap_12
XPHY_EDGE_ROW_226_Left_481 VGND VGND VPWR VPWR sky130_fd_sc_hd__decap_3
XTAP_TAPCELL_ROW_250_4497 VGND VPWR sky130_fd_sc_hd__tapvpwrvgnd_1
XFILLER_122_1270 VPWR VGND VPWR VGND sky130_ef_sc_hd__decap_12
XFILLER_174_366 VPWR VGND VPWR VGND sky130_ef_sc_hd__decap_12
XFILLER_200_1434 VGND VGND VPWR VPWR sky130_fd_sc_hd__decap_6
XFILLER_179_1057 VPWR VGND VPWR VGND sky130_ef_sc_hd__decap_12
XFILLER_227_44 VPWR VGND VPWR VGND sky130_ef_sc_hd__decap_12
XFILLER_66_1227 VPWR VGND VPWR VGND sky130_ef_sc_hd__decap_12
XFILLER_118_1306 VGND VGND VPWR VPWR sky130_fd_sc_hd__decap_6
XFILLER_170_550 VPWR VGND VPWR VGND sky130_ef_sc_hd__decap_12
XFILLER_227_99 VPWR VGND VPWR VGND sky130_ef_sc_hd__decap_12
XTAP_TAPCELL_ROW_184_2202 VGND VPWR sky130_fd_sc_hd__tapvpwrvgnd_1
XTAP_TAPCELL_ROW_184_2213 VGND VPWR sky130_fd_sc_hd__tapvpwrvgnd_1
XTAP_TAPCELL_ROW_244_4279 VGND VPWR sky130_fd_sc_hd__tapvpwrvgnd_1
XPHY_EDGE_ROW_235_Left_490 VGND VGND VPWR VPWR sky130_fd_sc_hd__decap_3
XFILLER_229_345 VPWR VGND VPWR VGND sky130_ef_sc_hd__decap_12
XFILLER_9_1198 VPWR VGND VPWR VGND sky130_ef_sc_hd__decap_12
XFILLER_243_87 VPWR VGND VPWR VGND sky130_ef_sc_hd__decap_12
XFILLER_244_304 VPWR VGND VPWR VGND sky130_ef_sc_hd__decap_12
XFILLER_217_529 VPWR VGND VPWR VGND sky130_ef_sc_hd__decap_12
XFILLER_42_1282 VPWR VGND VPWR VGND sky130_ef_sc_hd__decap_12
XFILLER_244_359 VGND VGND VPWR VPWR sky130_fd_sc_hd__decap_6
XTAP_TAPCELL_ROW_6_1079 VGND VPWR sky130_fd_sc_hd__tapvpwrvgnd_1
XFILLER_129_1402 VPWR VGND VPWR VGND sky130_ef_sc_hd__decap_12
XFILLER_112_58 VGND VGND VPWR VPWR sky130_fd_sc_hd__decap_6
XFILLER_227_1014 VPWR VGND VPWR VGND sky130_ef_sc_hd__decap_12
XFILLER_213_713 VPWR VGND VPWR VGND sky130_ef_sc_hd__decap_12
XFILLER_168_1484 VPWR VGND VPWR VGND sky130_ef_sc_hd__decap_12
XFILLER_225_584 VPWR VGND VPWR VGND sky130_ef_sc_hd__decap_12
XFILLER_77_1378 VPWR VGND VPWR VGND sky130_ef_sc_hd__decap_12
XFILLER_198_937 VPWR VGND VPWR VGND sky130_ef_sc_hd__decap_12
XFILLER_164_1337 VPWR VGND VPWR VGND sky130_ef_sc_hd__decap_12
XFILLER_129_1457 VGND VGND VPWR VPWR sky130_fd_sc_hd__decap_6
XFILLER_213_768 VGND VGND VPWR VPWR sky130_fd_sc_hd__decap_6
XFILLER_227_1069 VGND VGND VPWR VPWR sky130_fd_sc_hd__decap_6
XFILLER_51_1507 VGND VGND VPWR VPWR sky130_fd_sc_hd__decap_8
XFILLER_205_1334 VPWR VGND VPWR VGND sky130_ef_sc_hd__decap_12
XFILLER_184_108 VPWR VGND VPWR VGND sky130_ef_sc_hd__decap_12
XFILLER_240_1269 VPWR VGND VPWR VGND sky130_ef_sc_hd__decap_12
XFILLER_205_1389 VPWR VGND VPWR VGND sky130_ef_sc_hd__decap_12
XTAP_TAPCELL_ROW_136_2_5751 VGND VPWR sky130_fd_sc_hd__tapvpwrvgnd_1
XFILLER_21_44 VPWR VGND VPWR VGND sky130_ef_sc_hd__decap_12
XFILLER_192_163 VPWR VGND VPWR VGND sky130_ef_sc_hd__decap_12
XFILLER_140_1392 VGND VGND VPWR VPWR sky130_fd_sc_hd__decap_6
XFILLER_49_1414 VGND VGND VPWR VPWR sky130_fd_sc_hd__decap_6
XFILLER_4_538 VGND VGND VPWR VPWR sky130_fd_sc_hd__fill_2
XFILLER_238_1121 VPWR VGND VPWR VGND sky130_ef_sc_hd__decap_12
XFILLER_137_44 VPWR VGND VPWR VGND sky130_ef_sc_hd__decap_12
XFILLER_180_347 VPWR VGND VPWR VGND sky130_ef_sc_hd__decap_12
XFILLER_88_1485 VPWR VGND VPWR VGND sky130_ef_sc_hd__decap_12
XFILLER_97_15 VPWR VGND VPWR VGND sky130_ef_sc_hd__decap_12
XFILLER_175_1444 VPWR VGND VPWR VGND sky130_ef_sc_hd__decap_12
XFILLER_84_1349 VGND VGND VPWR VPWR sky130_fd_sc_hd__decap_6
XFILLER_238_1176 VGND VGND VPWR VPWR sky130_fd_sc_hd__decap_6
XTAP_TAPCELL_ROW_227_3710 VGND VPWR sky130_fd_sc_hd__tapvpwrvgnd_1
XFILLER_175_1499 VGND VGND VPWR VPWR sky130_fd_sc_hd__decap_6
XFILLER_216_1441 VPWR VGND VPWR VGND sky130_ef_sc_hd__decap_12
XTAP_TAPCELL_ROW_54_2_5095 VGND VPWR sky130_fd_sc_hd__tapvpwrvgnd_1
XFILLER_212_1305 VGND VGND VPWR VPWR sky130_fd_sc_hd__decap_6
XFILLER_216_1496 VPWR VGND VPWR VGND sky130_ef_sc_hd__decap_12
XFILLER_247_142 VPWR VGND VPWR VGND sky130_ef_sc_hd__decap_12
XFILLER_0_799 VGND VGND VPWR VPWR sky130_fd_sc_hd__fill_2
XFILLER_208_507 VPWR VGND VPWR VGND sky130_ef_sc_hd__decap_12
XFILLER_134_1196 VPWR VGND VPWR VGND sky130_ef_sc_hd__decap_12
XFILLER_235_326 VPWR VGND VPWR VGND sky130_ef_sc_hd__decap_12
XFILLER_247_197 VPWR VGND VPWR VGND sky130_ef_sc_hd__decap_12
XFILLER_169_1248 VPWR VGND VPWR VGND sky130_ef_sc_hd__decap_12
XTAP_TAPCELL_ROW_32_2_4921 VGND VPWR sky130_fd_sc_hd__tapvpwrvgnd_1
XFILLER_249_1272 VPWR VGND VPWR VGND sky130_ef_sc_hd__decap_12
XFILLER_95_1445 VPWR VGND VPWR VGND sky130_ef_sc_hd__decap_12
XFILLER_189_904 VPWR VGND VPWR VGND sky130_ef_sc_hd__decap_12
XFILLER_216_562 VPWR VGND VPWR VGND sky130_ef_sc_hd__decap_12
XFILLER_244_882 VPWR VGND VPWR VGND sky130_ef_sc_hd__decap_12
XFILLER_231_510 VGND VGND VPWR VPWR sky130_fd_sc_hd__decap_6
XFILLER_243_381 VGND VGND VPWR VPWR sky130_fd_sc_hd__decap_6
XFILLER_204_746 VGND VGND VPWR VPWR sky130_fd_sc_hd__decap_6
XFILLER_189_959 VPWR VGND VPWR VGND sky130_ef_sc_hd__decap_12
XFILLER_206_1109 VPWR VGND VPWR VGND sky130_ef_sc_hd__decap_12
XFILLER_223_1401 VPWR VGND VPWR VGND sky130_ef_sc_hd__decap_12
XPHY_EDGE_ROW_133_2_Left_635 VGND VGND VPWR VPWR sky130_fd_sc_hd__decap_3
XFILLER_19_1273 VPWR VGND VPWR VGND sky130_ef_sc_hd__decap_12
XFILLER_145_1292 VPWR VGND VPWR VGND sky130_ef_sc_hd__decap_12
XFILLER_223_1456 VGND VGND VPWR VPWR sky130_fd_sc_hd__decap_6
XFILLER_180_1183 VPWR VGND VPWR VGND sky130_ef_sc_hd__decap_12
Xwire230 net231 VGND VGND VPWR VPWR net230 sky130_fd_sc_hd__clkbuf_1
Xwire241 net242 VGND VGND VPWR VPWR net241 sky130_fd_sc_hd__clkbuf_1
XFILLER_183_130 VPWR VGND VPWR VGND sky130_ef_sc_hd__decap_12
Xwire252 net253 VGND VGND VPWR VPWR net252 sky130_fd_sc_hd__clkbuf_1
XFILLER_7_343 VGND VGND VPWR VPWR sky130_fd_sc_hd__fill_1
Xwire263 net264 VGND VGND VPWR VPWR net263 sky130_fd_sc_hd__clkbuf_1
XFILLER_89_1249 VPWR VGND VPWR VGND sky130_ef_sc_hd__decap_12
XFILLER_141_1189 VPWR VGND VPWR VGND sky130_ef_sc_hd__decap_12
XFILLER_7_68 VPWR VGND VPWR VGND sky130_ef_sc_hd__decap_12
Xwire274 net275 VGND VGND VPWR VPWR net274 sky130_fd_sc_hd__clkbuf_1
XFILLER_171_314 VPWR VGND VPWR VGND sky130_ef_sc_hd__decap_12
Xwire285 net286 VGND VGND VPWR VPWR net285 sky130_fd_sc_hd__clkbuf_1
XFILLER_176_1219 VGND VGND VPWR VPWR sky130_fd_sc_hd__decap_6
Xwire296 net297 VGND VGND VPWR VPWR net296 sky130_fd_sc_hd__clkbuf_1
XFILLER_183_185 VPWR VGND VPWR VGND sky130_ef_sc_hd__decap_12
XFILLER_171_369 VPWR VGND VPWR VGND sky130_ef_sc_hd__decap_12
XFILLER_217_1205 VPWR VGND VPWR VGND sky130_ef_sc_hd__decap_12
XFILLER_178_1090 VGND VGND VPWR VPWR sky130_fd_sc_hd__decap_6
XFILLER_28_1509 VGND VGND VPWR VPWR sky130_fd_sc_hd__decap_6
XFILLER_6_1305 VGND VGND VPWR VPWR sky130_fd_sc_hd__decap_6
XFILLER_238_120 VPWR VGND VPWR VGND sky130_ef_sc_hd__decap_12
XFILLER_152_1263 VGND VGND VPWR VPWR sky130_fd_sc_hd__decap_6
XFILLER_16_3 VPWR VGND VPWR VGND sky130_ef_sc_hd__decap_12
XFILLER_226_304 VPWR VGND VPWR VGND sky130_ef_sc_hd__decap_12
XFILLER_254_624 VPWR VGND VPWR VGND sky130_ef_sc_hd__decap_12
XFILLER_238_175 VPWR VGND VPWR VGND sky130_ef_sc_hd__decap_12
XPHY_EDGE_ROW_147_1_Left_402 VGND VGND VPWR VPWR sky130_fd_sc_hd__decap_3
XFILLER_187_1315 VPWR VGND VPWR VGND sky130_ef_sc_hd__decap_12
XFILLER_253_123 VGND VGND VPWR VPWR sky130_fd_sc_hd__decap_6
XFILLER_213_68 VPWR VGND VPWR VGND sky130_ef_sc_hd__decap_12
XFILLER_242_808 VPWR VGND VPWR VGND sky130_ef_sc_hd__decap_12
XFILLER_226_359 VGND VGND VPWR VPWR sky130_fd_sc_hd__decap_6
XFILLER_254_679 VPWR VGND VPWR VGND sky130_ef_sc_hd__decap_12
XFILLER_228_1312 VPWR VGND VPWR VGND sky130_ef_sc_hd__decap_12
XTAP_TAPCELL_ROW_204_2883 VGND VPWR sky130_fd_sc_hd__tapvpwrvgnd_1
XTAP_TAPCELL_ROW_204_2894 VGND VPWR sky130_fd_sc_hd__tapvpwrvgnd_1
XFILLER_207_584 VPWR VGND VPWR VGND sky130_ef_sc_hd__decap_12
XTAP_TAPCELL_ROW_142_2_5794 VGND VPWR sky130_fd_sc_hd__tapvpwrvgnd_1
XPHY_EDGE_ROW_65_2_Left_567 VGND VGND VPWR VPWR sky130_fd_sc_hd__decap_3
XTAP_TAPCELL_ROW_237_4050 VGND VPWR sky130_fd_sc_hd__tapvpwrvgnd_1
XTAP_TAPCELL_ROW_200_2747 VGND VPWR sky130_fd_sc_hd__tapvpwrvgnd_1
XFILLER_228_1367 VPWR VGND VPWR VGND sky130_ef_sc_hd__decap_12
XTAP_TAPCELL_ROW_237_4061 VGND VPWR sky130_fd_sc_hd__tapvpwrvgnd_1
XTAP_TAPCELL_ROW_200_2758 VGND VPWR sky130_fd_sc_hd__tapvpwrvgnd_1
XFILLER_250_863 VPWR VGND VPWR VGND sky130_ef_sc_hd__decap_12
XTAP_TAPCELL_ROW_200_2769 VGND VPWR sky130_fd_sc_hd__tapvpwrvgnd_1
XFILLER_72_1220 VGND VGND VPWR VPWR sky130_fd_sc_hd__decap_6
XTAP_TAPCELL_ROW_252_4559 VGND VPWR sky130_fd_sc_hd__tapvpwrvgnd_1
XFILLER_166_108 VPWR VGND VPWR VGND sky130_ef_sc_hd__decap_12
XFILLER_188_992 VPWR VGND VPWR VGND sky130_ef_sc_hd__decap_12
XFILLER_198_1422 VPWR VGND VPWR VGND sky130_ef_sc_hd__decap_12
XFILLER_174_163 VPWR VGND VPWR VGND sky130_ef_sc_hd__decap_12
XFILLER_238_65 VPWR VGND VPWR VGND sky130_ef_sc_hd__decap_12
XFILLER_198_1477 VGND VGND VPWR VPWR sky130_fd_sc_hd__decap_6
XTAP_TAPCELL_ROW_103_2_5489 VGND VPWR sky130_fd_sc_hd__tapvpwrvgnd_1
Xmax_cap530 net61 VGND VGND VPWR VPWR net530 sky130_fd_sc_hd__clkbuf_1
XFILLER_239_1463 VPWR VGND VPWR VGND sky130_ef_sc_hd__decap_12
Xmax_cap541 net49 VGND VGND VPWR VPWR net541 sky130_fd_sc_hd__clkbuf_1
XFILLER_190_667 VPWR VGND VPWR VGND sky130_ef_sc_hd__decap_12
Xmax_cap552 net73 VGND VGND VPWR VPWR net552 sky130_fd_sc_hd__clkbuf_1
Xmax_cap563 net68 VGND VGND VPWR VPWR net563 sky130_fd_sc_hd__clkbuf_1
XFILLER_235_1327 VGND VGND VPWR VPWR sky130_fd_sc_hd__decap_6
XFILLER_192_1054 VPWR VGND VPWR VGND sky130_ef_sc_hd__decap_12
XFILLER_83_1371 VGND VGND VPWR VPWR sky130_fd_sc_hd__decap_6
XTAP_TAPCELL_ROW_37_2_4958 VGND VPWR sky130_fd_sc_hd__tapvpwrvgnd_1
XPHY_EDGE_ROW_79_1_Left_334 VGND VGND VPWR VPWR sky130_fd_sc_hd__decap_3
XPHY_EDGE_ROW_144_1_Right_800 VGND VGND VPWR VPWR sky130_fd_sc_hd__decap_3
XFILLER_229_142 VPWR VGND VPWR VGND sky130_ef_sc_hd__decap_12
XFILLER_40_1208 VPWR VGND VPWR VGND sky130_ef_sc_hd__decap_12
XFILLER_44_1399 VPWR VGND VPWR VGND sky130_ef_sc_hd__decap_12
XFILLER_131_1347 VPWR VGND VPWR VGND sky130_ef_sc_hd__decap_12
XFILLER_244_101 VGND VGND VPWR VPWR sky130_fd_sc_hd__decap_6
XTAP_TAPCELL_ROW_17_2_4801 VGND VPWR sky130_fd_sc_hd__tapvpwrvgnd_1
XFILLER_217_326 VPWR VGND VPWR VGND sky130_ef_sc_hd__decap_12
XFILLER_245_646 VPWR VGND VPWR VGND sky130_ef_sc_hd__decap_12
XPHY_EDGE_ROW_131_1_Left_386 VGND VGND VPWR VPWR sky130_fd_sc_hd__decap_3
XFILLER_229_197 VPWR VGND VPWR VGND sky130_ef_sc_hd__decap_12
XFILLER_123_68 VGND VGND VPWR VPWR sky130_fd_sc_hd__decap_3
XFILLER_83_39 VGND VGND VPWR VPWR sky130_fd_sc_hd__decap_4
XFILLER_16_22 VPWR VGND VPWR VGND sky130_ef_sc_hd__decap_12
XFILLER_199_39 VGND VGND VPWR VPWR sky130_fd_sc_hd__decap_4
XFILLER_226_882 VPWR VGND VPWR VGND sky130_ef_sc_hd__decap_12
XFILLER_246_1434 VGND VGND VPWR VPWR sky130_fd_sc_hd__decap_6
XFILLER_213_510 VGND VGND VPWR VPWR sky130_fd_sc_hd__decap_6
XFILLER_241_830 VPWR VGND VPWR VGND sky130_ef_sc_hd__decap_12
XFILLER_225_381 VGND VGND VPWR VPWR sky130_fd_sc_hd__decap_6
XFILLER_168_1281 VPWR VGND VPWR VGND sky130_ef_sc_hd__decap_12
XFILLER_198_734 VPWR VGND VPWR VGND sky130_ef_sc_hd__decap_12
XFILLER_0_1471 VPWR VGND VPWR VGND sky130_ef_sc_hd__decap_12
XFILLER_241_885 VPWR VGND VPWR VGND sky130_ef_sc_hd__decap_12
XFILLER_186_918 VGND VGND VPWR VPWR sky130_fd_sc_hd__decap_6
XFILLER_198_789 VGND VGND VPWR VPWR sky130_fd_sc_hd__decap_6
XFILLER_240_1011 VPWR VGND VPWR VGND sky130_ef_sc_hd__decap_12
XFILLER_51_1304 VPWR VGND VPWR VGND sky130_ef_sc_hd__decap_12
XFILLER_205_1131 VPWR VGND VPWR VGND sky130_ef_sc_hd__decap_12
XFILLER_16_1435 VGND VGND VPWR VPWR sky130_fd_sc_hd__decap_6
XFILLER_200_237 VPWR VGND VPWR VGND sky130_ef_sc_hd__decap_12
XFILLER_142_1454 VPWR VGND VPWR VGND sky130_ef_sc_hd__decap_12
XFILLER_32_54 VGND VGND VPWR VPWR sky130_fd_sc_hd__fill_1
XFILLER_240_1066 VPWR VGND VPWR VGND sky130_ef_sc_hd__decap_12
XFILLER_51_1359 VPWR VGND VPWR VGND sky130_ef_sc_hd__decap_12
XFILLER_32_65 VGND VGND VPWR VPWR sky130_fd_sc_hd__fill_2
XFILLER_205_1186 VPWR VGND VPWR VGND sky130_ef_sc_hd__decap_12
XFILLER_120_3 VPWR VGND VPWR VGND sky130_ef_sc_hd__decap_12
XFILLER_177_1506 VGND VGND VPWR VPWR sky130_fd_sc_hd__decap_8
XFILLER_218_3 VPWR VGND VPWR VGND sky130_ef_sc_hd__decap_12
XFILLER_148_65 VGND VGND VPWR VPWR sky130_fd_sc_hd__decap_6
XFILLER_5_825 VGND VGND VPWR VPWR sky130_fd_sc_hd__fill_1
XFILLER_180_144 VGND VGND VPWR VPWR sky130_fd_sc_hd__decap_6
XFILLER_88_1282 VPWR VGND VPWR VGND sky130_ef_sc_hd__decap_12
XFILLER_218_1514 VGND VGND VPWR VPWR sky130_fd_sc_hd__fill_1
XFILLER_175_1241 VGND VGND VPWR VPWR sky130_fd_sc_hd__decap_6
XFILLER_181_689 VPWR VGND VPWR VGND sky130_ef_sc_hd__decap_12
XTAP_TAPCELL_ROW_210_3098 VGND VPWR sky130_fd_sc_hd__tapvpwrvgnd_1
XPHY_EDGE_ROW_170_Right_15 VGND VGND VPWR VPWR sky130_fd_sc_hd__decap_3
XTAP_TAPCELL_ROW_106_1_1388 VGND VPWR sky130_fd_sc_hd__tapvpwrvgnd_1
XFILLER_62_1411 VPWR VGND VPWR VGND sky130_ef_sc_hd__decap_12
XFILLER_251_1162 VPWR VGND VPWR VGND sky130_ef_sc_hd__decap_12
XFILLER_216_1293 VPWR VGND VPWR VGND sky130_ef_sc_hd__decap_12
XFILLER_62_1466 VPWR VGND VPWR VGND sky130_ef_sc_hd__decap_12
XFILLER_208_304 VPWR VGND VPWR VGND sky130_ef_sc_hd__decap_12
XFILLER_97_1507 VGND VGND VPWR VPWR sky130_fd_sc_hd__decap_8
XTAP_TAPCELL_ROW_167_1584 VGND VPWR sky130_fd_sc_hd__tapvpwrvgnd_1
XFILLER_236_624 VPWR VGND VPWR VGND sky130_ef_sc_hd__decap_12
XFILLER_248_495 VPWR VGND VPWR VGND sky130_ef_sc_hd__decap_12
XTAP_TAPCELL_ROW_167_1595 VGND VPWR sky130_fd_sc_hd__tapvpwrvgnd_1
XTAP_TAPCELL_ROW_158_2_5927 VGND VPWR sky130_fd_sc_hd__tapvpwrvgnd_1
XFILLER_235_123 VGND VGND VPWR VPWR sky130_fd_sc_hd__decap_6
XFILLER_169_1045 VPWR VGND VPWR VGND sky130_ef_sc_hd__decap_12
XFILLER_208_359 VGND VGND VPWR VPWR sky130_fd_sc_hd__decap_6
XFILLER_224_808 VPWR VGND VPWR VGND sky130_ef_sc_hd__decap_12
XTAP_TAPCELL_ROW_127_2_5674 VGND VPWR sky130_fd_sc_hd__tapvpwrvgnd_1
XFILLER_236_679 VPWR VGND VPWR VGND sky130_ef_sc_hd__decap_12
XFILLER_251_627 VPWR VGND VPWR VGND sky130_ef_sc_hd__decap_12
XFILLER_189_701 VPWR VGND VPWR VGND sky130_ef_sc_hd__decap_12
XFILLER_95_1242 VGND VGND VPWR VPWR sky130_fd_sc_hd__decap_6
XFILLER_232_863 VPWR VGND VPWR VGND sky130_ef_sc_hd__decap_12
XFILLER_189_756 VPWR VGND VPWR VGND sky130_ef_sc_hd__decap_12
XFILLER_143_1218 VPWR VGND VPWR VGND sky130_ef_sc_hd__decap_12
XFILLER_108_1349 VGND VGND VPWR VPWR sky130_fd_sc_hd__decap_6
XFILLER_185_940 VGND VGND VPWR VPWR sky130_fd_sc_hd__decap_6
XFILLER_32_1270 VPWR VGND VPWR VGND sky130_ef_sc_hd__decap_12
XFILLER_171_111 VPWR VGND VPWR VGND sky130_ef_sc_hd__decap_12
XFILLER_172_667 VPWR VGND VPWR VGND sky130_ef_sc_hd__decap_12
XFILLER_208_46 VPWR VGND VPWR VGND sky130_ef_sc_hd__decap_12
XFILLER_171_166 VGND VGND VPWR VPWR sky130_fd_sc_hd__decap_6
XFILLER_217_1002 VPWR VGND VPWR VGND sky130_ef_sc_hd__decap_12
XFILLER_28_1306 VGND VGND VPWR VPWR sky130_fd_sc_hd__decap_6
XTAP_TAPCELL_ROW_245_4330 VGND VPWR sky130_fd_sc_hd__tapvpwrvgnd_1
XTAP_TAPCELL_ROW_23_2_4844 VGND VPWR sky130_fd_sc_hd__tapvpwrvgnd_1
XTAP_TAPCELL_ROW_245_4341 VGND VPWR sky130_fd_sc_hd__tapvpwrvgnd_1
XFILLER_119_1445 VPWR VGND VPWR VGND sky130_ef_sc_hd__decap_12
XFILLER_154_1325 VPWR VGND VPWR VGND sky130_ef_sc_hd__decap_12
XTAP_TAPCELL_ROW_241_4205 VGND VPWR sky130_fd_sc_hd__tapvpwrvgnd_1
XFILLER_217_1057 VPWR VGND VPWR VGND sky130_ef_sc_hd__decap_12
XFILLER_224_34 VPWR VGND VPWR VGND sky130_ef_sc_hd__decap_12
XTAP_TAPCELL_ROW_7_1130 VGND VPWR sky130_fd_sc_hd__tapvpwrvgnd_1
XFILLER_224_89 VPWR VGND VPWR VGND sky130_ef_sc_hd__decap_12
XFILLER_226_101 VGND VGND VPWR VPWR sky130_fd_sc_hd__decap_6
XFILLER_254_421 VPWR VGND VPWR VGND sky130_ef_sc_hd__decap_12
XFILLER_187_1112 VGND VGND VPWR VPWR sky130_fd_sc_hd__decap_6
XTAP_TAPCELL_ROW_206_2956 VGND VPWR sky130_fd_sc_hd__tapvpwrvgnd_1
XFILLER_227_646 VPWR VGND VPWR VGND sky130_ef_sc_hd__decap_12
XTAP_TAPCELL_ROW_206_2967 VGND VPWR sky130_fd_sc_hd__tapvpwrvgnd_1
XTAP_TAPCELL_ROW_239_4112 VGND VPWR sky130_fd_sc_hd__tapvpwrvgnd_1
XFILLER_255_988 VPWR VGND VPWR VGND sky130_ef_sc_hd__decap_12
XFILLER_242_605 VPWR VGND VPWR VGND sky130_ef_sc_hd__decap_12
XTAP_TAPCELL_ROW_239_4123 VGND VPWR sky130_fd_sc_hd__tapvpwrvgnd_1
XTAP_TAPCELL_ROW_198_2702 VGND VPWR sky130_fd_sc_hd__tapvpwrvgnd_1
XTAP_TAPCELL_ROW_202_2809 VGND VPWR sky130_fd_sc_hd__tapvpwrvgnd_1
XTAP_TAPCELL_ROW_206_2978 VGND VPWR sky130_fd_sc_hd__tapvpwrvgnd_1
XFILLER_240_22 VPWR VGND VPWR VGND sky130_ef_sc_hd__decap_12
XFILLER_254_476 VPWR VGND VPWR VGND sky130_ef_sc_hd__decap_12
XTAP_TAPCELL_ROW_239_4134 VGND VPWR sky130_fd_sc_hd__tapvpwrvgnd_1
XFILLER_130_1380 VPWR VGND VPWR VGND sky130_ef_sc_hd__decap_12
XFILLER_208_882 VPWR VGND VPWR VGND sky130_ef_sc_hd__decap_12
XFILLER_39_1402 VPWR VGND VPWR VGND sky130_ef_sc_hd__decap_12
XFILLER_207_381 VGND VGND VPWR VPWR sky130_fd_sc_hd__decap_6
XFILLER_223_830 VPWR VGND VPWR VGND sky130_ef_sc_hd__decap_12
XFILLER_240_77 VPWR VGND VPWR VGND sky130_ef_sc_hd__decap_12
XFILLER_39_1457 VGND VGND VPWR VPWR sky130_fd_sc_hd__decap_6
XFILLER_74_1337 VPWR VGND VPWR VGND sky130_ef_sc_hd__decap_12
XFILLER_228_1164 VPWR VGND VPWR VGND sky130_ef_sc_hd__decap_12
XFILLER_250_660 VGND VGND VPWR VPWR sky130_fd_sc_hd__decap_6
XFILLER_168_918 VGND VGND VPWR VPWR sky130_fd_sc_hd__decap_6
XFILLER_223_885 VPWR VGND VPWR VGND sky130_ef_sc_hd__decap_12
XFILLER_206_1484 VPWR VGND VPWR VGND sky130_ef_sc_hd__decap_12
XTAP_TAPCELL_ROW_112_1_1398 VGND VPWR sky130_fd_sc_hd__tapvpwrvgnd_1
XFILLER_182_409 VPWR VGND VPWR VGND sky130_ef_sc_hd__decap_12
XFILLER_124_1184 VPWR VGND VPWR VGND sky130_ef_sc_hd__decap_12
XFILLER_202_1348 VGND VGND VPWR VPWR sky130_fd_sc_hd__decap_6
XFILLER_50_1392 VGND VGND VPWR VPWR sky130_fd_sc_hd__decap_6
XFILLER_118_46 VPWR VGND VPWR VGND sky130_ef_sc_hd__decap_12
XFILLER_190_464 VPWR VGND VPWR VGND sky130_ef_sc_hd__decap_12
XFILLER_239_1260 VPWR VGND VPWR VGND sky130_ef_sc_hd__decap_12
XFILLER_85_1433 VPWR VGND VPWR VGND sky130_ef_sc_hd__decap_12
XFILLER_2_839 VPWR VGND VPWR VGND sky130_ef_sc_hd__decap_12
XFILLER_85_1488 VPWR VGND VPWR VGND sky130_ef_sc_hd__decap_12
XFILLER_134_34 VPWR VGND VPWR VGND sky130_ef_sc_hd__decap_12
XFILLER_249_259 VPWR VGND VPWR VGND sky130_ef_sc_hd__decap_12
XTAP_TAPCELL_ROW_144_2_5813 VGND VPWR sky130_fd_sc_hd__tapvpwrvgnd_1
XFILLER_213_1444 VPWR VGND VPWR VGND sky130_ef_sc_hd__decap_12
XPHY_EDGE_ROW_145_1_Right_801 VGND VGND VPWR VPWR sky130_fd_sc_hd__decap_3
XFILLER_218_624 VPWR VGND VPWR VGND sky130_ef_sc_hd__decap_12
XFILLER_44_1196 VPWR VGND VPWR VGND sky130_ef_sc_hd__decap_12
XFILLER_217_123 VGND VGND VPWR VPWR sky130_fd_sc_hd__decap_6
XFILLER_213_1499 VGND VGND VPWR VPWR sky130_fd_sc_hd__decap_6
XFILLER_245_443 VPWR VGND VPWR VGND sky130_ef_sc_hd__decap_12
XFILLER_131_1177 VPWR VGND VPWR VGND sky130_ef_sc_hd__decap_12
XFILLER_206_808 VPWR VGND VPWR VGND sky130_ef_sc_hd__decap_12
X_530_ net666 VGND VGND VPWR VPWR _012_ sky130_fd_sc_hd__inv_2
XFILLER_150_22 VPWR VGND VPWR VGND sky130_ef_sc_hd__decap_12
XFILLER_218_679 VPWR VGND VPWR VGND sky130_ef_sc_hd__decap_12
XFILLER_166_1207 VPWR VGND VPWR VGND sky130_ef_sc_hd__decap_12
XFILLER_233_627 VPWR VGND VPWR VGND sky130_ef_sc_hd__decap_12
XFILLER_245_498 VPWR VGND VPWR VGND sky130_ef_sc_hd__decap_12
XFILLER_168_3 VPWR VGND VPWR VGND sky130_ef_sc_hd__decap_12
X_461_ net606 net9 net42 VGND VGND VPWR VPWR addr0\[7\] sky130_fd_sc_hd__mux2_1
XTAP_TAPCELL_ROW_1_894 VGND VPWR sky130_fd_sc_hd__tapvpwrvgnd_1
XFILLER_198_531 VGND VGND VPWR VPWR sky130_fd_sc_hd__decap_6
XTAP_TAPCELL_ROW_62_2_5157 VGND VPWR sky130_fd_sc_hd__tapvpwrvgnd_1
XFILLER_214_863 VPWR VGND VPWR VGND sky130_ef_sc_hd__decap_12
X_392_ net209 _179_ VGND VGND VPWR VPWR _181_ sky130_fd_sc_hd__or2_1
XFILLER_241_682 VGND VGND VPWR VPWR sky130_fd_sc_hd__decap_6
XFILLER_207_1248 VPWR VGND VPWR VGND sky130_ef_sc_hd__decap_12
XTAP_TAPCELL_ROW_42_2_5000 VGND VPWR sky130_fd_sc_hd__tapvpwrvgnd_1
XFILLER_167_940 VGND VGND VPWR VPWR sky130_fd_sc_hd__decap_6
XFILLER_55_1292 VPWR VGND VPWR VGND sky130_ef_sc_hd__decap_12
XFILLER_142_1251 VPWR VGND VPWR VGND sky130_ef_sc_hd__decap_12
XFILLER_107_1371 VGND VGND VPWR VPWR sky130_fd_sc_hd__decap_6
XTAP_TAPCELL_ROW_175_1864 VGND VPWR sky130_fd_sc_hd__tapvpwrvgnd_1
XTAP_TAPCELL_ROW_175_1875 VGND VPWR sky130_fd_sc_hd__tapvpwrvgnd_1
XFILLER_5_600 VGND VGND VPWR VPWR sky130_fd_sc_hd__fill_2
XTAP_TAPCELL_ROW_175_1886 VGND VPWR sky130_fd_sc_hd__tapvpwrvgnd_1
XFILLER_51_1189 VPWR VGND VPWR VGND sky130_ef_sc_hd__decap_12
XTAP_TAPCELL_ROW_171_1728 VGND VPWR sky130_fd_sc_hd__tapvpwrvgnd_1
XFILLER_177_1303 VPWR VGND VPWR VGND sky130_ef_sc_hd__decap_12
XTAP_TAPCELL_ROW_175_1897 VGND VPWR sky130_fd_sc_hd__tapvpwrvgnd_1
XFILLER_86_1208 VPWR VGND VPWR VGND sky130_ef_sc_hd__decap_12
XTAP_TAPCELL_ROW_171_1739 VGND VPWR sky130_fd_sc_hd__tapvpwrvgnd_1
XFILLER_181_431 VPWR VGND VPWR VGND sky130_ef_sc_hd__decap_12
XFILLER_4_132 VPWR VGND VPWR VGND sky130_ef_sc_hd__decap_12
XFILLER_177_1358 VPWR VGND VPWR VGND sky130_ef_sc_hd__decap_12
XFILLER_181_486 VPWR VGND VPWR VGND sky130_ef_sc_hd__decap_12
XFILLER_190_1514 VGND VGND VPWR VPWR sky130_fd_sc_hd__fill_1
XFILLER_218_1355 VPWR VGND VPWR VGND sky130_ef_sc_hd__decap_12
XFILLER_4_58 VGND VGND VPWR VPWR sky130_fd_sc_hd__decap_6
XFILLER_214_1219 VGND VGND VPWR VPWR sky130_fd_sc_hd__decap_6
XTAP_TAPCELL_ROW_169_1657 VGND VPWR sky130_fd_sc_hd__tapvpwrvgnd_1
XTAP_TAPCELL_ROW_169_1668 VGND VPWR sky130_fd_sc_hd__tapvpwrvgnd_1
XTAP_TAPCELL_ROW_169_1679 VGND VPWR sky130_fd_sc_hd__tapvpwrvgnd_1
XFILLER_7_1444 VPWR VGND VPWR VGND sky130_ef_sc_hd__decap_12
XFILLER_62_1263 VGND VGND VPWR VPWR sky130_fd_sc_hd__decap_6
XFILLER_216_1090 VGND VGND VPWR VPWR sky130_fd_sc_hd__decap_6
XFILLER_208_101 VGND VGND VPWR VPWR sky130_fd_sc_hd__decap_6
XFILLER_188_1410 VPWR VGND VPWR VGND sky130_ef_sc_hd__decap_12
XFILLER_236_421 VPWR VGND VPWR VGND sky130_ef_sc_hd__decap_12
XFILLER_97_1304 VPWR VGND VPWR VGND sky130_ef_sc_hd__decap_12
XFILLER_209_646 VPWR VGND VPWR VGND sky130_ef_sc_hd__decap_12
XFILLER_248_292 VPWR VGND VPWR VGND sky130_ef_sc_hd__decap_12
XFILLER_7_1499 VGND VGND VPWR VPWR sky130_fd_sc_hd__decap_6
XFILLER_110_1239 VPWR VGND VPWR VGND sky130_ef_sc_hd__decap_12
XFILLER_224_605 VPWR VGND VPWR VGND sky130_ef_sc_hd__decap_12
XFILLER_252_925 VPWR VGND VPWR VGND sky130_ef_sc_hd__decap_12
XFILLER_188_1465 VPWR VGND VPWR VGND sky130_ef_sc_hd__decap_12
XFILLER_236_476 VPWR VGND VPWR VGND sky130_ef_sc_hd__decap_12
XFILLER_97_1359 VPWR VGND VPWR VGND sky130_ef_sc_hd__decap_12
XFILLER_251_424 VGND VGND VPWR VPWR sky130_fd_sc_hd__decap_6
XFILLER_205_830 VPWR VGND VPWR VGND sky130_ef_sc_hd__decap_12
X_659_ clknet_3_4__leaf_clk acc_core.adder.cla_blocks\[6\].block.sum\[1\] _067_ VGND
+ VGND VPWR VPWR net60 sky130_fd_sc_hd__dfrtp_1
XTAP_TAPCELL_ROW_253_4610 VGND VPWR sky130_fd_sc_hd__tapvpwrvgnd_1
XFILLER_1_1076 VPWR VGND VPWR VGND sky130_ef_sc_hd__decap_12
XTAP_TAPCELL_ROW_253_4621 VGND VPWR sky130_fd_sc_hd__tapvpwrvgnd_1
XFILLER_225_1315 VPWR VGND VPWR VGND sky130_ef_sc_hd__decap_12
XFILLER_189_553 VGND VGND VPWR VPWR sky130_fd_sc_hd__decap_6
XFILLER_232_660 VGND VGND VPWR VPWR sky130_fd_sc_hd__decap_6
XFILLER_205_885 VPWR VGND VPWR VGND sky130_ef_sc_hd__decap_12
XFILLER_210_58 VGND VGND VPWR VPWR sky130_fd_sc_hd__decap_6
XPHY_EDGE_ROW_167_Left_422 VGND VGND VPWR VPWR sky130_fd_sc_hd__decap_3
XFILLER_182_1097 VPWR VGND VPWR VGND sky130_ef_sc_hd__decap_12
XFILLER_83_3 VPWR VGND VPWR VGND sky130_ef_sc_hd__decap_12
XFILLER_121_1335 VPWR VGND VPWR VGND sky130_ef_sc_hd__decap_12
XFILLER_191_228 VPWR VGND VPWR VGND sky130_ef_sc_hd__decap_12
XFILLER_219_56 VPWR VGND VPWR VGND sky130_ef_sc_hd__decap_12
XFILLER_184_280 VPWR VGND VPWR VGND sky130_ef_sc_hd__decap_12
XTAP_TAPCELL_ROW_247_4403 VGND VPWR sky130_fd_sc_hd__tapvpwrvgnd_1
XTAP_TAPCELL_ROW_247_4414 VGND VPWR sky130_fd_sc_hd__tapvpwrvgnd_1
XFILLER_201_1370 VGND VGND VPWR VPWR sky130_fd_sc_hd__decap_6
XFILLER_219_1119 VPWR VGND VPWR VGND sky130_ef_sc_hd__decap_12
XFILLER_172_464 VPWR VGND VPWR VGND sky130_ef_sc_hd__decap_12
XFILLER_236_1422 VPWR VGND VPWR VGND sky130_ef_sc_hd__decap_12
XTAP_TAPCELL_ROW_86_2_5353 VGND VPWR sky130_fd_sc_hd__tapvpwrvgnd_1
XFILLER_235_44 VPWR VGND VPWR VGND sky130_ef_sc_hd__decap_12
XFILLER_119_1242 VGND VGND VPWR VPWR sky130_fd_sc_hd__decap_6
XPHY_EDGE_ROW_176_Left_431 VGND VGND VPWR VPWR sky130_fd_sc_hd__decap_3
XFILLER_8_1219 VGND VGND VPWR VPWR sky130_fd_sc_hd__decap_6
XFILLER_236_1477 VGND VGND VPWR VPWR sky130_fd_sc_hd__decap_6
XTAP_TAPCELL_ROW_9_1203 VGND VPWR sky130_fd_sc_hd__tapvpwrvgnd_1
XTAP_TAPCELL_ROW_9_1214 VGND VPWR sky130_fd_sc_hd__tapvpwrvgnd_1
XFILLER_235_99 VPWR VGND VPWR VGND sky130_ef_sc_hd__decap_12
XTAP_TAPCELL_ROW_9_1225 VGND VPWR sky130_fd_sc_hd__tapvpwrvgnd_1
XFILLER_154_1177 VGND VGND VPWR VPWR sky130_fd_sc_hd__decap_6
XTAP_TAPCELL_ROW_9_1236 VGND VPWR sky130_fd_sc_hd__tapvpwrvgnd_1
XFILLER_246_218 VPWR VGND VPWR VGND sky130_ef_sc_hd__decap_12
XFILLER_104_15 VGND VGND VPWR VPWR sky130_fd_sc_hd__decap_6
XFILLER_132_1442 VPWR VGND VPWR VGND sky130_ef_sc_hd__decap_12
XFILLER_189_1229 VPWR VGND VPWR VGND sky130_ef_sc_hd__decap_12
XFILLER_41_1347 VPWR VGND VPWR VGND sky130_ef_sc_hd__decap_12
XFILLER_230_1054 VPWR VGND VPWR VGND sky130_ef_sc_hd__decap_12
XFILLER_227_443 VPWR VGND VPWR VGND sky130_ef_sc_hd__decap_12
XTAP_TAPCELL_ROW_181_2079 VGND VPWR sky130_fd_sc_hd__tapvpwrvgnd_1
XFILLER_132_1497 VPWR VGND VPWR VGND sky130_ef_sc_hd__decap_12
XFILLER_251_87 VPWR VGND VPWR VGND sky130_ef_sc_hd__decap_12
XFILLER_242_402 VGND VGND VPWR VPWR sky130_fd_sc_hd__decap_6
XFILLER_254_273 VGND VGND VPWR VPWR sky130_fd_sc_hd__decap_6
XFILLER_215_627 VPWR VGND VPWR VGND sky130_ef_sc_hd__decap_12
XFILLER_243_947 VPWR VGND VPWR VGND sky130_ef_sc_hd__decap_12
XTAP_TAPCELL_ROW_47_2_5037 VGND VPWR sky130_fd_sc_hd__tapvpwrvgnd_1
XFILLER_227_498 VPWR VGND VPWR VGND sky130_ef_sc_hd__decap_12
XFILLER_78_1270 VPWR VGND VPWR VGND sky130_ef_sc_hd__decap_12
XFILLER_165_1240 VPWR VGND VPWR VGND sky130_ef_sc_hd__decap_12
XPHY_EDGE_ROW_185_Left_440 VGND VGND VPWR VPWR sky130_fd_sc_hd__decap_3
XFILLER_211_811 VGND VGND VPWR VPWR sky130_fd_sc_hd__decap_6
XFILLER_120_58 VGND VGND VPWR VPWR sky130_fd_sc_hd__decap_6
XFILLER_223_682 VGND VGND VPWR VPWR sky130_fd_sc_hd__decap_6
XFILLER_165_1273 VGND VGND VPWR VPWR sky130_fd_sc_hd__decap_8
XFILLER_52_1454 VPWR VGND VPWR VGND sky130_ef_sc_hd__decap_12
XFILLER_206_1281 VPWR VGND VPWR VGND sky130_ef_sc_hd__decap_12
XFILLER_13_56 VPWR VGND VPWR VGND sky130_ef_sc_hd__decap_12
XFILLER_182_206 VPWR VGND VPWR VGND sky130_ef_sc_hd__decap_12
XFILLER_129_56 VPWR VGND VPWR VGND sky130_ef_sc_hd__decap_12
XFILLER_89_27 VPWR VGND VPWR VGND sky130_ef_sc_hd__decap_12
XTAP_TAPCELL_ROW_230_3794 VGND VPWR sky130_fd_sc_hd__tapvpwrvgnd_1
XFILLER_85_1230 VPWR VGND VPWR VGND sky130_ef_sc_hd__decap_12
XFILLER_190_261 VPWR VGND VPWR VGND sky130_ef_sc_hd__decap_12
XFILLER_145_44 VPWR VGND VPWR VGND sky130_ef_sc_hd__decap_12
XFILLER_176_1391 VGND VGND VPWR VPWR sky130_fd_sc_hd__decap_6
XFILLER_215_1506 VGND VGND VPWR VPWR sky130_fd_sc_hd__decap_8
Xmax_cap190 _226_ VGND VGND VPWR VPWR net190 sky130_fd_sc_hd__clkbuf_1
XFILLER_85_1285 VGND VGND VPWR VPWR sky130_fd_sc_hd__decap_6
XFILLER_133_1206 VPWR VGND VPWR VGND sky130_ef_sc_hd__decap_12
XPHY_EDGE_ROW_142_2_Left_644 VGND VGND VPWR VPWR sky130_fd_sc_hd__decap_3
XFILLER_213_1241 VGND VGND VPWR VPWR sky130_fd_sc_hd__decap_6
XFILLER_218_421 VPWR VGND VPWR VGND sky130_ef_sc_hd__decap_12
XPHY_EDGE_ROW_146_1_Right_802 VGND VGND VPWR VPWR sky130_fd_sc_hd__decap_3
XTAP_TAPCELL_ROW_224_3587 VGND VPWR sky130_fd_sc_hd__tapvpwrvgnd_1
XFILLER_245_240 VPWR VGND VPWR VGND sky130_ef_sc_hd__decap_12
XTAP_TAPCELL_ROW_224_3598 VGND VPWR sky130_fd_sc_hd__tapvpwrvgnd_1
XFILLER_206_605 VPWR VGND VPWR VGND sky130_ef_sc_hd__decap_12
XPHY_EDGE_ROW_89_2_Right_180 VGND VGND VPWR VPWR sky130_fd_sc_hd__decap_3
XFILLER_218_476 VPWR VGND VPWR VGND sky130_ef_sc_hd__decap_12
XFILLER_234_925 VPWR VGND VPWR VGND sky130_ef_sc_hd__decap_12
XFILLER_246_796 VPWR VGND VPWR VGND sky130_ef_sc_hd__decap_12
XFILLER_166_1004 VGND VGND VPWR VPWR sky130_fd_sc_hd__decap_6
XFILLER_248_1348 VGND VGND VPWR VPWR sky130_fd_sc_hd__decap_6
XFILLER_233_424 VGND VGND VPWR VPWR sky130_fd_sc_hd__decap_6
XFILLER_245_295 VGND VGND VPWR VPWR sky130_fd_sc_hd__decap_6
X_513_ net515 net187 net186 net511 VGND VGND VPWR VPWR _264_ sky130_fd_sc_hd__a211o_1
XFILLER_96_1392 VGND VGND VPWR VPWR sky130_fd_sc_hd__decap_6
XFILLER_214_660 VGND VGND VPWR VPWR sky130_fd_sc_hd__decap_6
X_444_ net95 _232_ VGND VGND VPWR VPWR _233_ sky130_fd_sc_hd__or2_1
XFILLER_242_980 VPWR VGND VPWR VGND sky130_ef_sc_hd__decap_12
XFILLER_144_1313 VPWR VGND VPWR VGND sky130_ef_sc_hd__decap_12
XFILLER_199_873 VPWR VGND VPWR VGND sky130_ef_sc_hd__decap_12
XFILLER_109_1433 VPWR VGND VPWR VGND sky130_ef_sc_hd__decap_12
XFILLER_207_1045 VPWR VGND VPWR VGND sky130_ef_sc_hd__decap_12
XFILLER_53_1218 VPWR VGND VPWR VGND sky130_ef_sc_hd__decap_12
XFILLER_18_1349 VGND VGND VPWR VPWR sky130_fd_sc_hd__decap_6
XTAP_TAPCELL_ROW_177_1937 VGND VPWR sky130_fd_sc_hd__tapvpwrvgnd_1
X_375_ net593 net552 net579 VGND VGND VPWR VPWR _164_ sky130_fd_sc_hd__and3_1
XTAP_TAPCELL_ROW_177_1948 VGND VPWR sky130_fd_sc_hd__tapvpwrvgnd_1
XTAP_TAPCELL_ROW_218_3369 VGND VPWR sky130_fd_sc_hd__tapvpwrvgnd_1
XFILLER_144_1368 VPWR VGND VPWR VGND sky130_ef_sc_hd__decap_12
XFILLER_109_1488 VPWR VGND VPWR VGND sky130_ef_sc_hd__decap_12
XTAP_TAPCELL_ROW_177_1959 VGND VPWR sky130_fd_sc_hd__tapvpwrvgnd_1
XTAP_TAPCELL_ROW_81_1_1351 VGND VPWR sky130_fd_sc_hd__tapvpwrvgnd_1
XTAP_TAPCELL_ROW_92_2_5396 VGND VPWR sky130_fd_sc_hd__tapvpwrvgnd_1
XFILLER_173_228 VPWR VGND VPWR VGND sky130_ef_sc_hd__decap_12
XFILLER_177_1100 VPWR VGND VPWR VGND sky130_ef_sc_hd__decap_12
XFILLER_166_280 VPWR VGND VPWR VGND sky130_ef_sc_hd__decap_12
XTAP_TAPCELL_ROW_104_2_5494 VGND VPWR sky130_fd_sc_hd__tapvpwrvgnd_1
XPHY_EDGE_ROW_156_1_Left_411 VGND VGND VPWR VPWR sky130_fd_sc_hd__decap_3
XFILLER_177_1155 VGND VGND VPWR VPWR sky130_fd_sc_hd__decap_6
XFILLER_181_283 VPWR VGND VPWR VGND sky130_ef_sc_hd__decap_12
XFILLER_170_968 VPWR VGND VPWR VGND sky130_ef_sc_hd__decap_12
XFILLER_64_1325 VPWR VGND VPWR VGND sky130_ef_sc_hd__decap_12
XFILLER_29_1445 VPWR VGND VPWR VGND sky130_ef_sc_hd__decap_12
XFILLER_218_1152 VPWR VGND VPWR VGND sky130_ef_sc_hd__decap_12
XPHY_EDGE_ROW_74_2_Left_576 VGND VGND VPWR VPWR sky130_fd_sc_hd__decap_3
XFILLER_155_1464 VPWR VGND VPWR VGND sky130_ef_sc_hd__decap_12
XTAP_TAPCELL_ROW_38_2_4963 VGND VPWR sky130_fd_sc_hd__tapvpwrvgnd_1
XFILLER_190_1355 VPWR VGND VPWR VGND sky130_ef_sc_hd__decap_12
XFILLER_253_1076 VPWR VGND VPWR VGND sky130_ef_sc_hd__decap_12
XFILLER_151_1328 VGND VGND VPWR VPWR sky130_fd_sc_hd__decap_6
XFILLER_228_218 VPWR VGND VPWR VGND sky130_ef_sc_hd__decap_12
XFILLER_7_1241 VGND VGND VPWR VPWR sky130_fd_sc_hd__decap_6
XFILLER_0_190 VPWR VGND VPWR VGND sky130_ef_sc_hd__decap_12
XFILLER_209_443 VPWR VGND VPWR VGND sky130_ef_sc_hd__decap_12
XFILLER_224_402 VGND VGND VPWR VPWR sky130_fd_sc_hd__decap_6
XFILLER_252_722 VPWR VGND VPWR VGND sky130_ef_sc_hd__decap_12
XFILLER_188_1262 VGND VGND VPWR VPWR sky130_fd_sc_hd__decap_6
XFILLER_236_273 VGND VGND VPWR VPWR sky130_fd_sc_hd__decap_6
XTAP_TAPCELL_ROW_255_4705 VGND VPWR sky130_fd_sc_hd__tapvpwrvgnd_1
XFILLER_40_1380 VPWR VGND VPWR VGND sky130_ef_sc_hd__decap_12
XFILLER_209_498 VPWR VGND VPWR VGND sky130_ef_sc_hd__decap_12
XFILLER_225_947 VPWR VGND VPWR VGND sky130_ef_sc_hd__decap_12
XTAP_TAPCELL_ROW_255_4716 VGND VPWR sky130_fd_sc_hd__tapvpwrvgnd_1
XTAP_TAPCELL_ROW_255_4727 VGND VPWR sky130_fd_sc_hd__tapvpwrvgnd_1
XTAP_TAPCELL_ROW_31_2_4906 VGND VPWR sky130_fd_sc_hd__tapvpwrvgnd_1
XFILLER_240_906 VPWR VGND VPWR VGND sky130_ef_sc_hd__decap_12
XFILLER_97_1189 VPWR VGND VPWR VGND sky130_ef_sc_hd__decap_12
XFILLER_75_1421 VPWR VGND VPWR VGND sky130_ef_sc_hd__decap_12
XFILLER_221_68 VPWR VGND VPWR VGND sky130_ef_sc_hd__decap_12
XFILLER_252_777 VPWR VGND VPWR VGND sky130_ef_sc_hd__decap_12
XFILLER_127_1500 VGND VGND VPWR VPWR sky130_fd_sc_hd__decap_6
XFILLER_225_1112 VGND VGND VPWR VPWR sky130_fd_sc_hd__decap_6
XFILLER_205_682 VGND VGND VPWR VPWR sky130_fd_sc_hd__decap_6
XFILLER_75_1476 VPWR VGND VPWR VGND sky130_ef_sc_hd__decap_12
XFILLER_162_1435 VGND VGND VPWR VPWR sky130_fd_sc_hd__decap_6
XFILLER_203_1432 VPWR VGND VPWR VGND sky130_ef_sc_hd__decap_12
XTAP_TAPCELL_ROW_193_2495 VGND VPWR sky130_fd_sc_hd__tapvpwrvgnd_1
XPHY_EDGE_ROW_88_1_Left_343 VGND VGND VPWR VPWR sky130_fd_sc_hd__decap_3
XFILLER_34_1184 VPWR VGND VPWR VGND sky130_ef_sc_hd__decap_12
XFILLER_203_1487 VPWR VGND VPWR VGND sky130_ef_sc_hd__decap_12
XFILLER_121_1165 VPWR VGND VPWR VGND sky130_ef_sc_hd__decap_12
XPHY_EDGE_ROW_140_1_Left_395 VGND VGND VPWR VPWR sky130_fd_sc_hd__decap_3
XFILLER_172_261 VPWR VGND VPWR VGND sky130_ef_sc_hd__decap_12
XFILLER_246_65 VPWR VGND VPWR VGND sky130_ef_sc_hd__decap_12
XFILLER_191_1119 VPWR VGND VPWR VGND sky130_ef_sc_hd__decap_12
XFILLER_156_1239 VPWR VGND VPWR VGND sky130_ef_sc_hd__decap_12
XTAP_TAPCELL_ROW_187_2288 VGND VPWR sky130_fd_sc_hd__tapvpwrvgnd_1
XTAP_TAPCELL_ROW_187_2299 VGND VPWR sky130_fd_sc_hd__tapvpwrvgnd_1
XFILLER_189_1026 VGND VGND VPWR VPWR sky130_fd_sc_hd__decap_6
XTAP_TAPCELL_ROW_159_2_5932 VGND VPWR sky130_fd_sc_hd__tapvpwrvgnd_1
XFILLER_227_240 VPWR VGND VPWR VGND sky130_ef_sc_hd__decap_12
XTAP_TAPCELL_ROW_3_967 VGND VPWR sky130_fd_sc_hd__tapvpwrvgnd_1
XFILLER_216_925 VPWR VGND VPWR VGND sky130_ef_sc_hd__decap_12
XFILLER_41_1177 VPWR VGND VPWR VGND sky130_ef_sc_hd__decap_12
XTAP_TAPCELL_ROW_3_978 VGND VPWR sky130_fd_sc_hd__tapvpwrvgnd_1
XFILLER_132_1294 VPWR VGND VPWR VGND sky130_ef_sc_hd__decap_12
XTAP_TAPCELL_ROW_3_989 VGND VPWR sky130_fd_sc_hd__tapvpwrvgnd_1
XFILLER_228_796 VPWR VGND VPWR VGND sky130_ef_sc_hd__decap_12
XFILLER_215_424 VGND VGND VPWR VPWR sky130_fd_sc_hd__decap_6
XFILLER_243_744 VPWR VGND VPWR VGND sky130_ef_sc_hd__decap_12
XFILLER_227_295 VGND VGND VPWR VPWR sky130_fd_sc_hd__decap_6
XFILLER_167_1346 VPWR VGND VPWR VGND sky130_ef_sc_hd__decap_12
XFILLER_131_68 VGND VGND VPWR VPWR sky130_fd_sc_hd__decap_3
XFILLER_231_928 VPWR VGND VPWR VGND sky130_ef_sc_hd__decap_12
XFILLER_247_1370 VGND VGND VPWR VPWR sky130_fd_sc_hd__decap_6
XFILLER_91_39 VGND VGND VPWR VPWR sky130_fd_sc_hd__decap_4
XFILLER_243_799 VPWR VGND VPWR VGND sky130_ef_sc_hd__decap_12
XFILLER_224_980 VPWR VGND VPWR VGND sky130_ef_sc_hd__decap_12
XFILLER_24_22 VPWR VGND VPWR VGND sky130_ef_sc_hd__decap_12
XFILLER_196_832 VGND VGND VPWR VPWR sky130_fd_sc_hd__decap_6
XFILLER_204_1207 VPWR VGND VPWR VGND sky130_ef_sc_hd__decap_12
XTAP_TAPCELL_ROW_77_2_5276 VGND VPWR sky130_fd_sc_hd__tapvpwrvgnd_1
XFILLER_208_1398 VPWR VGND VPWR VGND sky130_ef_sc_hd__decap_12
XTAP_TAPCELL_ROW_121_2_5633 VGND VPWR sky130_fd_sc_hd__tapvpwrvgnd_1
XFILLER_210_151 VPWR VGND VPWR VGND sky130_ef_sc_hd__decap_12
XTAP_TAPCELL_ROW_213_3200 VGND VPWR sky130_fd_sc_hd__tapvpwrvgnd_1
XFILLER_52_1251 VPWR VGND VPWR VGND sky130_ef_sc_hd__decap_12
XFILLER_17_1371 VGND VGND VPWR VPWR sky130_fd_sc_hd__decap_6
Xwire626 net41 VGND VGND VPWR VPWR net626 sky130_fd_sc_hd__buf_1
XTAP_TAPCELL_ROW_213_3211 VGND VPWR sky130_fd_sc_hd__tapvpwrvgnd_1
Xwire637 net32 VGND VGND VPWR VPWR net637 sky130_fd_sc_hd__buf_1
XTAP_TAPCELL_ROW_213_3222 VGND VPWR sky130_fd_sc_hd__tapvpwrvgnd_1
Xwire648 net23 VGND VGND VPWR VPWR net648 sky130_fd_sc_hd__buf_1
XFILLER_143_1390 VPWR VGND VPWR VGND sky130_ef_sc_hd__decap_12
XTAP_TAPCELL_ROW_232_3867 VGND VPWR sky130_fd_sc_hd__tapvpwrvgnd_1
Xwire659 net14 VGND VGND VPWR VPWR net659 sky130_fd_sc_hd__buf_1
XTAP_TAPCELL_ROW_232_3878 VGND VPWR sky130_fd_sc_hd__tapvpwrvgnd_1
XTAP_TAPCELL_ROW_232_3889 VGND VPWR sky130_fd_sc_hd__tapvpwrvgnd_1
XFILLER_40_65 VGND VGND VPWR VPWR sky130_fd_sc_hd__decap_3
XFILLER_100_1227 VPWR VGND VPWR VGND sky130_ef_sc_hd__decap_12
XFILLER_3_901 VGND VGND VPWR VPWR sky130_fd_sc_hd__fill_2
XFILLER_178_1453 VPWR VGND VPWR VGND sky130_ef_sc_hd__decap_12
XFILLER_87_1347 VPWR VGND VPWR VGND sky130_ef_sc_hd__decap_12
XFILLER_200_3 VPWR VGND VPWR VGND sky130_ef_sc_hd__decap_12
XTAP_TAPCELL_ROW_70_2_5219 VGND VPWR sky130_fd_sc_hd__tapvpwrvgnd_1
XFILLER_2_400 VGND VGND VPWR VPWR sky130_fd_sc_hd__fill_2
XFILLER_156_65 VGND VGND VPWR VPWR sky130_fd_sc_hd__decap_6
XFILLER_215_1303 VPWR VGND VPWR VGND sky130_ef_sc_hd__decap_12
XFILLER_2_477 VGND VGND VPWR VPWR sky130_fd_sc_hd__fill_1
XTAP_TAPCELL_ROW_207_3004 VGND VPWR sky130_fd_sc_hd__tapvpwrvgnd_1
XFILLER_49_52 VGND VGND VPWR VPWR sky130_fd_sc_hd__fill_2
XTAP_TAPCELL_ROW_207_3015 VGND VPWR sky130_fd_sc_hd__tapvpwrvgnd_1
XFILLER_250_1238 VPWR VGND VPWR VGND sky130_ef_sc_hd__decap_12
XTAP_TAPCELL_ROW_226_3649 VGND VPWR sky130_fd_sc_hd__tapvpwrvgnd_1
XFILLER_215_1358 VPWR VGND VPWR VGND sky130_ef_sc_hd__decap_12
XFILLER_238_538 VPWR VGND VPWR VGND sky130_ef_sc_hd__decap_12
XFILLER_206_402 VGND VGND VPWR VPWR sky130_fd_sc_hd__decap_6
XFILLER_98_1454 VPWR VGND VPWR VGND sky130_ef_sc_hd__decap_12
XFILLER_234_722 VPWR VGND VPWR VGND sky130_ef_sc_hd__decap_12
XFILLER_20_1239 VPWR VGND VPWR VGND sky130_ef_sc_hd__decap_12
XPHY_EDGE_ROW_147_1_Right_803 VGND VGND VPWR VPWR sky130_fd_sc_hd__decap_3
XFILLER_185_1413 VGND VGND VPWR VPWR sky130_fd_sc_hd__decap_6
XFILLER_207_947 VPWR VGND VPWR VGND sky130_ef_sc_hd__decap_12
XFILLER_218_273 VGND VGND VPWR VPWR sky130_fd_sc_hd__decap_6
XFILLER_246_593 VPWR VGND VPWR VGND sky130_ef_sc_hd__decap_12
XFILLER_111_1378 VPWR VGND VPWR VGND sky130_ef_sc_hd__decap_12
XFILLER_222_906 VPWR VGND VPWR VGND sky130_ef_sc_hd__decap_12
XFILLER_234_777 VPWR VGND VPWR VGND sky130_ef_sc_hd__decap_12
XFILLER_226_1410 VPWR VGND VPWR VGND sky130_ef_sc_hd__decap_12
XFILLER_199_670 VPWR VGND VPWR VGND sky130_ef_sc_hd__decap_12
XFILLER_109_1230 VPWR VGND VPWR VGND sky130_ef_sc_hd__decap_12
X_427_ net595 dout0_q\[22\] net534 VGND VGND VPWR VPWR _216_ sky130_fd_sc_hd__a21oi_1
XFILLER_226_1465 VPWR VGND VPWR VGND sky130_ef_sc_hd__decap_12
XFILLER_187_854 VGND VGND VPWR VPWR sky130_fd_sc_hd__decap_6
XFILLER_230_961 VGND VGND VPWR VPWR sky130_fd_sc_hd__decap_6
XFILLER_109_1285 VGND VGND VPWR VPWR sky130_fd_sc_hd__decap_6
XFILLER_144_1165 VPWR VGND VPWR VGND sky130_ef_sc_hd__decap_12
X_358_ net169 _144_ net136 net135 VGND VGND VPWR VPWR _147_ sky130_fd_sc_hd__o211a_1
XFILLER_201_173 VPWR VGND VPWR VGND sky130_ef_sc_hd__decap_12
XFILLER_179_1217 VPWR VGND VPWR VGND sky130_ef_sc_hd__decap_12
XFILLER_31_1335 VPWR VGND VPWR VGND sky130_ef_sc_hd__decap_12
X_289_ net605 net140 VGND VGND VPWR VPWR _081_ sky130_fd_sc_hd__xor2_1
XFILLER_122_1485 VPWR VGND VPWR VGND sky130_ef_sc_hd__decap_12
XFILLER_255_1105 VGND VGND VPWR VPWR sky130_fd_sc_hd__decap_8
XFILLER_220_1097 VPWR VGND VPWR VGND sky130_ef_sc_hd__decap_12
XFILLER_170_710 VPWR VGND VPWR VGND sky130_ef_sc_hd__decap_12
XFILLER_182_581 VPWR VGND VPWR VGND sky130_ef_sc_hd__decap_12
XFILLER_5_293 VGND VGND VPWR VPWR sky130_fd_sc_hd__decap_8
XFILLER_46_3 VPWR VGND VPWR VGND sky130_ef_sc_hd__decap_12
XFILLER_170_765 VPWR VGND VPWR VGND sky130_ef_sc_hd__decap_12
XFILLER_9_1303 VPWR VGND VPWR VGND sky130_ef_sc_hd__decap_12
XFILLER_29_1242 VGND VGND VPWR VPWR sky130_fd_sc_hd__decap_6
XFILLER_216_46 VPWR VGND VPWR VGND sky130_ef_sc_hd__decap_12
XFILLER_155_1261 VPWR VGND VPWR VGND sky130_ef_sc_hd__decap_12
XFILLER_9_1336 VGND VGND VPWR VPWR sky130_fd_sc_hd__decap_8
XFILLER_190_1152 VPWR VGND VPWR VGND sky130_ef_sc_hd__decap_12
XFILLER_64_1177 VGND VGND VPWR VPWR sky130_fd_sc_hd__decap_6
XTAP_TAPCELL_ROW_182_2130 VGND VPWR sky130_fd_sc_hd__tapvpwrvgnd_1
XTAP_TAPCELL_ROW_182_2141 VGND VPWR sky130_fd_sc_hd__tapvpwrvgnd_1
XFILLER_42_1442 VPWR VGND VPWR VGND sky130_ef_sc_hd__decap_12
XFILLER_99_1218 VPWR VGND VPWR VGND sky130_ef_sc_hd__decap_12
XFILLER_232_34 VPWR VGND VPWR VGND sky130_ef_sc_hd__decap_12
Xinput3 wr_addr[1] VGND VGND VPWR VPWR net3 sky130_fd_sc_hd__clkbuf_1
XFILLER_209_240 VPWR VGND VPWR VGND sky130_ef_sc_hd__decap_12
XFILLER_244_519 VPWR VGND VPWR VGND sky130_ef_sc_hd__decap_12
XPHY_EDGE_ROW_3_Left_259 VGND VGND VPWR VPWR sky130_fd_sc_hd__decap_3
XFILLER_237_560 VPWR VGND VPWR VGND sky130_ef_sc_hd__decap_12
XFILLER_42_1497 VPWR VGND VPWR VGND sky130_ef_sc_hd__decap_12
XFILLER_232_89 VPWR VGND VPWR VGND sky130_ef_sc_hd__decap_12
XFILLER_209_295 VGND VGND VPWR VPWR sky130_fd_sc_hd__decap_6
XFILLER_225_744 VPWR VGND VPWR VGND sky130_ef_sc_hd__decap_12
XTAP_TAPCELL_ROW_94_2_5415 VGND VPWR sky130_fd_sc_hd__tapvpwrvgnd_1
XFILLER_240_703 VGND VGND VPWR VPWR sky130_fd_sc_hd__decap_6
XFILLER_252_574 VGND VGND VPWR VPWR sky130_fd_sc_hd__decap_6
XTAP_TAPCELL_ROW_63_2_5162 VGND VPWR sky130_fd_sc_hd__tapvpwrvgnd_1
XFILLER_213_928 VPWR VGND VPWR VGND sky130_ef_sc_hd__decap_12
XFILLER_227_1229 VPWR VGND VPWR VGND sky130_ef_sc_hd__decap_12
XFILLER_225_799 VPWR VGND VPWR VGND sky130_ef_sc_hd__decap_12
XFILLER_101_27 VPWR VGND VPWR VGND sky130_ef_sc_hd__decap_12
XFILLER_206_980 VPWR VGND VPWR VGND sky130_ef_sc_hd__decap_12
XTAP_TAPCELL_ROW_106_2_5513 VGND VPWR sky130_fd_sc_hd__tapvpwrvgnd_1
XFILLER_75_1273 VPWR VGND VPWR VGND sky130_ef_sc_hd__decap_12
XFILLER_178_832 VGND VGND VPWR VPWR sky130_fd_sc_hd__decap_6
XTAP_TAPCELL_ROW_195_2568 VGND VPWR sky130_fd_sc_hd__tapvpwrvgnd_1
XTAP_TAPCELL_ROW_195_2579 VGND VPWR sky130_fd_sc_hd__tapvpwrvgnd_1
XFILLER_221_983 VGND VGND VPWR VPWR sky130_fd_sc_hd__decap_6
XFILLER_123_1249 VPWR VGND VPWR VGND sky130_ef_sc_hd__decap_12
XTAP_TAPCELL_ROW_29_2_4897 VGND VPWR sky130_fd_sc_hd__tapvpwrvgnd_1
XFILLER_165_526 VPWR VGND VPWR VGND sky130_ef_sc_hd__decap_12
XFILLER_192_323 VPWR VGND VPWR VGND sky130_ef_sc_hd__decap_12
XFILLER_165_559 VGND VGND VPWR VPWR sky130_fd_sc_hd__decap_8
XFILLER_203_1284 VGND VGND VPWR VPWR sky130_fd_sc_hd__decap_6
XFILLER_180_507 VPWR VGND VPWR VGND sky130_ef_sc_hd__decap_12
XFILLER_192_378 VPWR VGND VPWR VGND sky130_ef_sc_hd__decap_12
XFILLER_84_1509 VGND VGND VPWR VPWR sky130_fd_sc_hd__decap_6
XFILLER_238_1336 VPWR VGND VPWR VGND sky130_ef_sc_hd__decap_12
XFILLER_10_46 VPWR VGND VPWR VGND sky130_ef_sc_hd__decap_12
XFILLER_0_904 VGND VGND VPWR VPWR sky130_fd_sc_hd__fill_2
XFILLER_86_1380 VPWR VGND VPWR VGND sky130_ef_sc_hd__decap_12
XFILLER_126_46 VPWR VGND VPWR VGND sky130_ef_sc_hd__decap_12
XFILLER_251_1514 VGND VGND VPWR VPWR sky130_fd_sc_hd__fill_1
XFILLER_0_937 VGND VGND VPWR VPWR sky130_fd_sc_hd__decap_8
XFILLER_43_1206 VPWR VGND VPWR VGND sky130_ef_sc_hd__decap_12
XFILLER_247_302 VPWR VGND VPWR VGND sky130_ef_sc_hd__decap_12
XFILLER_134_1356 VPWR VGND VPWR VGND sky130_ef_sc_hd__decap_12
XFILLER_19_44 VPWR VGND VPWR VGND sky130_ef_sc_hd__decap_12
XTAP_TAPCELL_ROW_221_3502 VGND VPWR sky130_fd_sc_hd__tapvpwrvgnd_1
XFILLER_247_357 VPWR VGND VPWR VGND sky130_ef_sc_hd__decap_12
XFILLER_142_34 VPWR VGND VPWR VGND sky130_ef_sc_hd__decap_12
XFILLER_214_1391 VGND VGND VPWR VPWR sky130_fd_sc_hd__decap_6
XFILLER_216_722 VPWR VGND VPWR VGND sky130_ef_sc_hd__decap_12
XFILLER_249_1432 VPWR VGND VPWR VGND sky130_ef_sc_hd__decap_12
XFILLER_228_593 VPWR VGND VPWR VGND sky130_ef_sc_hd__decap_12
XFILLER_243_541 VPWR VGND VPWR VGND sky130_ef_sc_hd__decap_12
XFILLER_204_906 VPWR VGND VPWR VGND sky130_ef_sc_hd__decap_12
XFILLER_167_1143 VPWR VGND VPWR VGND sky130_ef_sc_hd__decap_12
XFILLER_216_777 VPWR VGND VPWR VGND sky130_ef_sc_hd__decap_12
XFILLER_249_1487 VPWR VGND VPWR VGND sky130_ef_sc_hd__decap_12
XFILLER_231_725 VGND VGND VPWR VPWR sky130_fd_sc_hd__decap_6
XFILLER_243_596 VGND VGND VPWR VPWR sky130_fd_sc_hd__decap_6
XTAP_TAPCELL_ROW_219_3420 VGND VPWR sky130_fd_sc_hd__tapvpwrvgnd_1
XFILLER_150_3 VPWR VGND VPWR VGND sky130_ef_sc_hd__decap_12
XFILLER_167_1198 VGND VGND VPWR VPWR sky130_fd_sc_hd__decap_6
XFILLER_208_1140 VPWR VGND VPWR VGND sky130_ef_sc_hd__decap_12
XTAP_TAPCELL_ROW_219_3431 VGND VPWR sky130_fd_sc_hd__tapvpwrvgnd_1
XFILLER_248_3 VPWR VGND VPWR VGND sky130_ef_sc_hd__decap_12
XFILLER_54_1313 VPWR VGND VPWR VGND sky130_ef_sc_hd__decap_12
XFILLER_19_1433 VPWR VGND VPWR VGND sky130_ef_sc_hd__decap_12
XFILLER_212_961 VGND VGND VPWR VPWR sky130_fd_sc_hd__decap_6
XFILLER_169_854 VGND VGND VPWR VPWR sky130_fd_sc_hd__decap_6
XFILLER_204_1004 VGND VGND VPWR VPWR sky130_fd_sc_hd__decap_6
XTAP_TAPCELL_ROW_234_3929 VGND VPWR sky130_fd_sc_hd__tapvpwrvgnd_1
XFILLER_208_1195 VPWR VGND VPWR VGND sky130_ef_sc_hd__decap_12
XFILLER_54_1368 VPWR VGND VPWR VGND sky130_ef_sc_hd__decap_12
XFILLER_19_1488 VPWR VGND VPWR VGND sky130_ef_sc_hd__decap_12
XFILLER_141_1316 VPWR VGND VPWR VGND sky130_ef_sc_hd__decap_12
Xwire401 net402 VGND VGND VPWR VPWR net401 sky130_fd_sc_hd__clkbuf_1
Xwire412 net413 VGND VGND VPWR VPWR net412 sky130_fd_sc_hd__clkbuf_1
XFILLER_180_1398 VPWR VGND VPWR VGND sky130_ef_sc_hd__decap_12
Xwire423 net424 VGND VGND VPWR VPWR net423 sky130_fd_sc_hd__clkbuf_1
Xwire434 net435 VGND VGND VPWR VPWR net434 sky130_fd_sc_hd__clkbuf_1
Xwire445 net446 VGND VGND VPWR VPWR net445 sky130_fd_sc_hd__clkbuf_1
Xwire456 net457 VGND VGND VPWR VPWR net456 sky130_fd_sc_hd__clkbuf_1
XFILLER_183_345 VPWR VGND VPWR VGND sky130_ef_sc_hd__decap_12
Xwire467 net468 VGND VGND VPWR VPWR net467 sky130_fd_sc_hd__clkbuf_1
Xwire478 net479 VGND VGND VPWR VPWR net478 sky130_fd_sc_hd__clkbuf_1
Xwire489 net490 VGND VGND VPWR VPWR net489 sky130_fd_sc_hd__clkbuf_1
XFILLER_139_1201 VGND VGND VPWR VPWR sky130_fd_sc_hd__decap_4
XTAP_TAPCELL_ROW_151_2_5872 VGND VPWR sky130_fd_sc_hd__tapvpwrvgnd_1
XFILLER_171_529 VPWR VGND VPWR VGND sky130_ef_sc_hd__decap_12
XFILLER_178_1250 VPWR VGND VPWR VGND sky130_ef_sc_hd__decap_12
XFILLER_87_1177 VPWR VGND VPWR VGND sky130_ef_sc_hd__decap_12
XFILLER_3_742 VGND VGND VPWR VPWR sky130_fd_sc_hd__fill_2
XFILLER_215_1100 VPWR VGND VPWR VGND sky130_ef_sc_hd__decap_12
XFILLER_2_263 VGND VGND VPWR VPWR sky130_fd_sc_hd__decap_6
XFILLER_65_1464 VPWR VGND VPWR VGND sky130_ef_sc_hd__decap_12
XFILLER_2_274 VGND VGND VPWR VPWR sky130_fd_sc_hd__fill_1
XFILLER_219_1291 VPWR VGND VPWR VGND sky130_ef_sc_hd__decap_12
XFILLER_152_1423 VPWR VGND VPWR VGND sky130_ef_sc_hd__decap_12
XFILLER_250_1035 VPWR VGND VPWR VGND sky130_ef_sc_hd__decap_12
XFILLER_61_1328 VGND VGND VPWR VPWR sky130_fd_sc_hd__decap_6
XFILLER_215_1155 VGND VGND VPWR VPWR sky130_fd_sc_hd__decap_6
XFILLER_238_335 VPWR VGND VPWR VGND sky130_ef_sc_hd__decap_12
XTAP_TAPCELL_ROW_143_2_5809 VGND VPWR sky130_fd_sc_hd__tapvpwrvgnd_1
XFILLER_152_1478 VGND VGND VPWR VPWR sky130_fd_sc_hd__decap_6
XFILLER_8_1391 VGND VGND VPWR VPWR sky130_fd_sc_hd__decap_6
XTAP_TAPCELL_ROW_112_2_5556 VGND VPWR sky130_fd_sc_hd__tapvpwrvgnd_1
XFILLER_226_519 VPWR VGND VPWR VGND sky130_ef_sc_hd__decap_12
XTAP_TAPCELL_ROW_80_2_5301 VGND VPWR sky130_fd_sc_hd__tapvpwrvgnd_1
XFILLER_219_560 VPWR VGND VPWR VGND sky130_ef_sc_hd__decap_12
XFILLER_254_839 VPWR VGND VPWR VGND sky130_ef_sc_hd__decap_12
XFILLER_253_338 VGND VGND VPWR VPWR sky130_fd_sc_hd__decap_6
XTAP_TAPCELL_ROW_48_2_5042 VGND VPWR sky130_fd_sc_hd__tapvpwrvgnd_1
XFILLER_98_1251 VPWR VGND VPWR VGND sky130_ef_sc_hd__decap_12
XPHY_EDGE_ROW_105_2_Left_607 VGND VGND VPWR VPWR sky130_fd_sc_hd__decap_3
XFILLER_202_15 VGND VGND VPWR VPWR sky130_fd_sc_hd__decap_6
XFILLER_246_390 VPWR VGND VPWR VGND sky130_ef_sc_hd__decap_12
XFILLER_207_744 VPWR VGND VPWR VGND sky130_ef_sc_hd__decap_12
XPHY_EDGE_ROW_148_1_Right_804 VGND VGND VPWR VPWR sky130_fd_sc_hd__decap_3
XFILLER_222_703 VGND VGND VPWR VPWR sky130_fd_sc_hd__decap_6
XFILLER_234_574 VGND VGND VPWR VPWR sky130_fd_sc_hd__decap_6
XFILLER_207_799 VPWR VGND VPWR VGND sky130_ef_sc_hd__decap_12
XFILLER_37_1500 VGND VGND VPWR VPWR sky130_fd_sc_hd__decap_6
XFILLER_146_1227 VPWR VGND VPWR VGND sky130_ef_sc_hd__decap_12
XTAP_TAPCELL_ROW_15_2_4783 VGND VPWR sky130_fd_sc_hd__tapvpwrvgnd_1
XFILLER_72_1435 VGND VGND VPWR VPWR sky130_fd_sc_hd__decap_6
XFILLER_226_1262 VGND VGND VPWR VPWR sky130_fd_sc_hd__decap_6
XFILLER_203_983 VGND VGND VPWR VPWR sky130_fd_sc_hd__decap_6
XTAP_TAPCELL_ROW_190_2410 VGND VPWR sky130_fd_sc_hd__tapvpwrvgnd_1
XTAP_TAPCELL_ROW_190_2421 VGND VPWR sky130_fd_sc_hd__tapvpwrvgnd_1
XFILLER_174_323 VPWR VGND VPWR VGND sky130_ef_sc_hd__decap_12
XFILLER_179_1014 VPWR VGND VPWR VGND sky130_ef_sc_hd__decap_12
XFILLER_186_194 VPWR VGND VPWR VGND sky130_ef_sc_hd__decap_12
XTAP_TAPCELL_ROW_250_4498 VGND VPWR sky130_fd_sc_hd__tapvpwrvgnd_1
XFILLER_31_1165 VPWR VGND VPWR VGND sky130_ef_sc_hd__decap_12
XFILLER_122_1282 VPWR VGND VPWR VGND sky130_ef_sc_hd__decap_12
XFILLER_174_378 VPWR VGND VPWR VGND sky130_ef_sc_hd__decap_12
XFILLER_179_1069 VGND VGND VPWR VPWR sky130_fd_sc_hd__decap_6
XFILLER_227_56 VPWR VGND VPWR VGND sky130_ef_sc_hd__decap_12
XFILLER_66_1239 VPWR VGND VPWR VGND sky130_ef_sc_hd__decap_12
XFILLER_170_562 VPWR VGND VPWR VGND sky130_ef_sc_hd__decap_12
XTAP_TAPCELL_ROW_188_2350 VGND VPWR sky130_fd_sc_hd__tapvpwrvgnd_1
XFILLER_157_1378 VPWR VGND VPWR VGND sky130_ef_sc_hd__decap_12
XTAP_TAPCELL_ROW_184_2203 VGND VPWR sky130_fd_sc_hd__tapvpwrvgnd_1
XFILLER_192_1269 VPWR VGND VPWR VGND sky130_ef_sc_hd__decap_12
XFILLER_229_302 VPWR VGND VPWR VGND sky130_ef_sc_hd__decap_12
XFILLER_243_44 VPWR VGND VPWR VGND sky130_ef_sc_hd__decap_12
XFILLER_9_1177 VPWR VGND VPWR VGND sky130_ef_sc_hd__decap_12
XFILLER_131_1507 VGND VGND VPWR VPWR sky130_fd_sc_hd__decap_8
XFILLER_229_357 VPWR VGND VPWR VGND sky130_ef_sc_hd__decap_12
XFILLER_243_99 VPWR VGND VPWR VGND sky130_ef_sc_hd__decap_12
XPHY_EDGE_ROW_37_2_Left_539 VGND VGND VPWR VPWR sky130_fd_sc_hd__decap_3
XFILLER_244_316 VGND VGND VPWR VPWR sky130_fd_sc_hd__decap_6
XFILLER_42_1294 VPWR VGND VPWR VGND sky130_ef_sc_hd__decap_12
XTAP_TAPCELL_ROW_6_1069 VGND VPWR sky130_fd_sc_hd__tapvpwrvgnd_1
XFILLER_112_15 VGND VGND VPWR VPWR sky130_fd_sc_hd__decap_6
XFILLER_168_1441 VPWR VGND VPWR VGND sky130_ef_sc_hd__decap_12
XFILLER_225_541 VPWR VGND VPWR VGND sky130_ef_sc_hd__decap_12
XFILLER_253_861 VPWR VGND VPWR VGND sky130_ef_sc_hd__decap_12
XFILLER_77_1335 VPWR VGND VPWR VGND sky130_ef_sc_hd__decap_12
XFILLER_129_1414 VGND VGND VPWR VPWR sky130_fd_sc_hd__decap_6
XFILLER_213_725 VGND VGND VPWR VPWR sky130_fd_sc_hd__decap_6
XFILLER_227_1026 VGND VGND VPWR VPWR sky130_fd_sc_hd__decap_6
XFILLER_168_1496 VPWR VGND VPWR VGND sky130_ef_sc_hd__decap_12
XFILLER_225_596 VGND VGND VPWR VPWR sky130_fd_sc_hd__decap_6
XFILLER_198_949 VPWR VGND VPWR VGND sky130_ef_sc_hd__decap_12
XFILLER_164_1349 VGND VGND VPWR VPWR sky130_fd_sc_hd__decap_6
XPHY_EDGE_ROW_99_2_Left_601 VGND VGND VPWR VPWR sky130_fd_sc_hd__decap_3
XFILLER_240_1226 VPWR VGND VPWR VGND sky130_ef_sc_hd__decap_12
XFILLER_205_1346 VPWR VGND VPWR VGND sky130_ef_sc_hd__decap_12
XPHY_EDGE_ROW_151_2_Left_653 VGND VGND VPWR VPWR sky130_fd_sc_hd__decap_3
XFILLER_53_1390 VPWR VGND VPWR VGND sky130_ef_sc_hd__decap_12
XTAP_TAPCELL_ROW_136_2_5752 VGND VPWR sky130_fd_sc_hd__tapvpwrvgnd_1
XFILLER_192_120 VPWR VGND VPWR VGND sky130_ef_sc_hd__decap_12
XPHY_EDGE_ROW_110_1_Right_766 VGND VGND VPWR VPWR sky130_fd_sc_hd__decap_3
XFILLER_180_304 VPWR VGND VPWR VGND sky130_ef_sc_hd__decap_12
XFILLER_88_1442 VPWR VGND VPWR VGND sky130_ef_sc_hd__decap_12
XFILLER_21_56 VPWR VGND VPWR VGND sky130_ef_sc_hd__decap_12
XFILLER_10_1227 VPWR VGND VPWR VGND sky130_ef_sc_hd__decap_12
XFILLER_192_175 VPWR VGND VPWR VGND sky130_ef_sc_hd__decap_12
XFILLER_175_1401 VPWR VGND VPWR VGND sky130_ef_sc_hd__decap_12
XFILLER_84_1306 VGND VGND VPWR VPWR sky130_fd_sc_hd__decap_6
XFILLER_137_56 VPWR VGND VPWR VGND sky130_ef_sc_hd__decap_12
XFILLER_238_1133 VGND VGND VPWR VPWR sky130_fd_sc_hd__decap_6
XFILLER_180_359 VGND VGND VPWR VPWR sky130_fd_sc_hd__decap_6
XFILLER_88_1497 VPWR VGND VPWR VGND sky130_ef_sc_hd__decap_12
XFILLER_97_27 VPWR VGND VPWR VGND sky130_ef_sc_hd__decap_12
XFILLER_175_1456 VGND VGND VPWR VPWR sky130_fd_sc_hd__decap_6
XTAP_TAPCELL_ROW_227_3700 VGND VPWR sky130_fd_sc_hd__tapvpwrvgnd_1
XTAP_TAPCELL_ROW_85_2_5338 VGND VPWR sky130_fd_sc_hd__tapvpwrvgnd_1
XTAP_TAPCELL_ROW_227_3711 VGND VPWR sky130_fd_sc_hd__tapvpwrvgnd_1
XPHY_EDGE_ROW_103_1_Left_358 VGND VGND VPWR VPWR sky130_fd_sc_hd__decap_3
XTAP_TAPCELL_ROW_54_2_5096 VGND VPWR sky130_fd_sc_hd__tapvpwrvgnd_1
XFILLER_216_1453 VPWR VGND VPWR VGND sky130_ef_sc_hd__decap_12
XFILLER_153_44 VPWR VGND VPWR VGND sky130_ef_sc_hd__decap_12
XFILLER_0_778 VGND VGND VPWR VPWR sky130_fd_sc_hd__fill_2
XFILLER_251_1377 VPWR VGND VPWR VGND sky130_ef_sc_hd__decap_12
XFILLER_198_3 VPWR VGND VPWR VGND sky130_ef_sc_hd__decap_12
XFILLER_247_154 VPWR VGND VPWR VGND sky130_ef_sc_hd__decap_12
XFILLER_208_519 VPWR VGND VPWR VGND sky130_ef_sc_hd__decap_12
XFILLER_169_1205 VPWR VGND VPWR VGND sky130_ef_sc_hd__decap_12
XFILLER_236_839 VPWR VGND VPWR VGND sky130_ef_sc_hd__decap_12
XFILLER_235_338 VGND VGND VPWR VPWR sky130_fd_sc_hd__decap_6
XFILLER_95_1402 VPWR VGND VPWR VGND sky130_ef_sc_hd__decap_12
XTAP_TAPCELL_ROW_165_1490 VGND VPWR sky130_fd_sc_hd__tapvpwrvgnd_1
XFILLER_228_390 VPWR VGND VPWR VGND sky130_ef_sc_hd__decap_12
XFILLER_21_1378 VPWR VGND VPWR VGND sky130_ef_sc_hd__decap_12
XFILLER_204_703 VGND VGND VPWR VPWR sky130_fd_sc_hd__decap_6
XFILLER_249_1284 VGND VGND VPWR VPWR sky130_fd_sc_hd__decap_6
Xmax_cap76 _255_ VGND VGND VPWR VPWR net76 sky130_fd_sc_hd__clkbuf_1
XFILLER_95_1457 VGND VGND VPWR VPWR sky130_fd_sc_hd__decap_6
XFILLER_189_916 VPWR VGND VPWR VGND sky130_ef_sc_hd__decap_12
XFILLER_216_574 VGND VGND VPWR VPWR sky130_fd_sc_hd__decap_6
XFILLER_244_894 VPWR VGND VPWR VGND sky130_ef_sc_hd__decap_12
Xmax_cap87 _249_ VGND VGND VPWR VPWR net87 sky130_fd_sc_hd__clkbuf_1
Xmax_cap98 _244_ VGND VGND VPWR VPWR net98 sky130_fd_sc_hd__clkbuf_1
XFILLER_108_1509 VGND VGND VPWR VPWR sky130_fd_sc_hd__decap_6
XFILLER_19_1230 VPWR VGND VPWR VGND sky130_ef_sc_hd__decap_12
XFILLER_223_1413 VGND VGND VPWR VPWR sky130_fd_sc_hd__decap_6
XFILLER_62_63 VGND VGND VPWR VPWR sky130_fd_sc_hd__fill_1
XFILLER_180_1140 VPWR VGND VPWR VGND sky130_ef_sc_hd__decap_12
XFILLER_197_971 VPWR VGND VPWR VGND sky130_ef_sc_hd__decap_12
XPHY_EDGE_ROW_83_2_Left_585 VGND VGND VPWR VPWR sky130_fd_sc_hd__decap_3
XFILLER_54_1165 VPWR VGND VPWR VGND sky130_ef_sc_hd__decap_12
XFILLER_19_1285 VGND VGND VPWR VPWR sky130_fd_sc_hd__decap_6
Xwire220 net221 VGND VGND VPWR VPWR net220 sky130_fd_sc_hd__clkbuf_1
XFILLER_89_1206 VPWR VGND VPWR VGND sky130_ef_sc_hd__decap_12
XFILLER_180_1195 VPWR VGND VPWR VGND sky130_ef_sc_hd__decap_12
Xwire231 net232 VGND VGND VPWR VPWR net231 sky130_fd_sc_hd__clkbuf_1
XFILLER_168_194 VPWR VGND VPWR VGND sky130_ef_sc_hd__decap_12
Xwire242 net243 VGND VGND VPWR VPWR net242 sky130_fd_sc_hd__clkbuf_1
Xwire253 net254 VGND VGND VPWR VPWR net253 sky130_fd_sc_hd__clkbuf_1
XFILLER_183_142 VPWR VGND VPWR VGND sky130_ef_sc_hd__decap_12
Xwire264 net265 VGND VGND VPWR VPWR net264 sky130_fd_sc_hd__clkbuf_1
Xwire275 net276 VGND VGND VPWR VPWR net275 sky130_fd_sc_hd__clkbuf_1
XFILLER_32_1485 VPWR VGND VPWR VGND sky130_ef_sc_hd__decap_12
Xwire286 net287 VGND VGND VPWR VPWR net286 sky130_fd_sc_hd__clkbuf_1
XFILLER_7_388 VGND VGND VPWR VPWR sky130_fd_sc_hd__fill_1
XFILLER_171_326 VPWR VGND VPWR VGND sky130_ef_sc_hd__decap_12
Xwire297 net298 VGND VGND VPWR VPWR net297 sky130_fd_sc_hd__clkbuf_1
XFILLER_183_197 VPWR VGND VPWR VGND sky130_ef_sc_hd__decap_12
XFILLER_217_1217 VPWR VGND VPWR VGND sky130_ef_sc_hd__decap_12
XFILLER_180_882 VPWR VGND VPWR VGND sky130_ef_sc_hd__decap_12
XFILLER_65_1261 VPWR VGND VPWR VGND sky130_ef_sc_hd__decap_12
XFILLER_152_1220 VGND VGND VPWR VPWR sky130_fd_sc_hd__decap_6
XFILLER_191_1291 VPWR VGND VPWR VGND sky130_ef_sc_hd__decap_12
XFILLER_238_132 VPWR VGND VPWR VGND sky130_ef_sc_hd__decap_12
XFILLER_226_316 VGND VGND VPWR VPWR sky130_fd_sc_hd__decap_6
XFILLER_254_636 VPWR VGND VPWR VGND sky130_ef_sc_hd__decap_12
XFILLER_238_187 VGND VGND VPWR VPWR sky130_fd_sc_hd__decap_6
XFILLER_187_1327 VGND VGND VPWR VPWR sky130_fd_sc_hd__decap_6
XPHY_EDGE_ROW_97_1_Left_352 VGND VGND VPWR VPWR sky130_fd_sc_hd__decap_3
XTAP_TAPCELL_ROW_87_1_1360 VGND VPWR sky130_fd_sc_hd__tapvpwrvgnd_1
XFILLER_207_541 VPWR VGND VPWR VGND sky130_ef_sc_hd__decap_12
XFILLER_235_861 VPWR VGND VPWR VGND sky130_ef_sc_hd__decap_12
XFILLER_228_1324 VPWR VGND VPWR VGND sky130_ef_sc_hd__decap_12
XFILLER_250_820 VPWR VGND VPWR VGND sky130_ef_sc_hd__decap_12
XTAP_TAPCELL_ROW_204_2884 VGND VPWR sky130_fd_sc_hd__tapvpwrvgnd_1
XTAP_TAPCELL_ROW_204_2895 VGND VPWR sky130_fd_sc_hd__tapvpwrvgnd_1
XFILLER_207_596 VGND VGND VPWR VPWR sky130_fd_sc_hd__decap_6
XTAP_TAPCELL_ROW_142_2_5795 VGND VPWR sky130_fd_sc_hd__tapvpwrvgnd_1
XPHY_EDGE_ROW_149_1_Right_805 VGND VGND VPWR VPWR sky130_fd_sc_hd__decap_3
XTAP_TAPCELL_ROW_237_4040 VGND VPWR sky130_fd_sc_hd__tapvpwrvgnd_1
XTAP_TAPCELL_ROW_196_2630 VGND VPWR sky130_fd_sc_hd__tapvpwrvgnd_1
XTAP_TAPCELL_ROW_200_2748 VGND VPWR sky130_fd_sc_hd__tapvpwrvgnd_1
XTAP_TAPCELL_ROW_237_4051 VGND VPWR sky130_fd_sc_hd__tapvpwrvgnd_1
XTAP_TAPCELL_ROW_200_2759 VGND VPWR sky130_fd_sc_hd__tapvpwrvgnd_1
XTAP_TAPCELL_ROW_237_4062 VGND VPWR sky130_fd_sc_hd__tapvpwrvgnd_1
XFILLER_228_1379 VPWR VGND VPWR VGND sky130_ef_sc_hd__decap_12
XFILLER_250_875 VGND VGND VPWR VPWR sky130_fd_sc_hd__decap_6
XFILLER_163_1371 VGND VGND VPWR VPWR sky130_fd_sc_hd__decap_6
XFILLER_202_1508 VGND VGND VPWR VPWR sky130_fd_sc_hd__decap_6
XFILLER_33_1249 VPWR VGND VPWR VGND sky130_ef_sc_hd__decap_12
XFILLER_174_120 VPWR VGND VPWR VGND sky130_ef_sc_hd__decap_12
XFILLER_238_22 VPWR VGND VPWR VGND sky130_ef_sc_hd__decap_12
XFILLER_120_1208 VPWR VGND VPWR VGND sky130_ef_sc_hd__decap_12
XFILLER_198_1434 VGND VGND VPWR VPWR sky130_fd_sc_hd__decap_6
XFILLER_124_1399 VPWR VGND VPWR VGND sky130_ef_sc_hd__decap_12
XFILLER_174_175 VPWR VGND VPWR VGND sky130_ef_sc_hd__decap_12
XFILLER_190_624 VPWR VGND VPWR VGND sky130_ef_sc_hd__decap_12
XFILLER_239_1420 VPWR VGND VPWR VGND sky130_ef_sc_hd__decap_12
XFILLER_238_77 VPWR VGND VPWR VGND sky130_ef_sc_hd__decap_12
Xmax_cap520 net521 VGND VGND VPWR VPWR net520 sky130_fd_sc_hd__clkbuf_1
Xmax_cap531 net60 VGND VGND VPWR VPWR net531 sky130_fd_sc_hd__clkbuf_1
Xmax_cap542 net543 VGND VGND VPWR VPWR net542 sky130_fd_sc_hd__clkbuf_1
XFILLER_190_679 VPWR VGND VPWR VGND sky130_ef_sc_hd__decap_12
XFILLER_192_1011 VPWR VGND VPWR VGND sky130_ef_sc_hd__decap_12
XFILLER_239_1475 VPWR VGND VPWR VGND sky130_ef_sc_hd__decap_12
XFILLER_107_15 VPWR VGND VPWR VGND sky130_ef_sc_hd__decap_12
XFILLER_192_1066 VPWR VGND VPWR VGND sky130_ef_sc_hd__decap_12
XFILLER_254_65 VPWR VGND VPWR VGND sky130_ef_sc_hd__decap_12
XTAP_TAPCELL_ROW_37_2_4959 VGND VPWR sky130_fd_sc_hd__tapvpwrvgnd_1
XFILLER_44_1356 VPWR VGND VPWR VGND sky130_ef_sc_hd__decap_12
XFILLER_131_1304 VPWR VGND VPWR VGND sky130_ef_sc_hd__decap_12
XFILLER_245_603 VPWR VGND VPWR VGND sky130_ef_sc_hd__decap_12
XFILLER_229_154 VPWR VGND VPWR VGND sky130_ef_sc_hd__decap_12
XFILLER_218_839 VPWR VGND VPWR VGND sky130_ef_sc_hd__decap_12
XFILLER_131_1359 VPWR VGND VPWR VGND sky130_ef_sc_hd__decap_12
XFILLER_217_338 VGND VGND VPWR VPWR sky130_fd_sc_hd__decap_6
XFILLER_245_658 VPWR VGND VPWR VGND sky130_ef_sc_hd__decap_12
XFILLER_16_34 VPWR VGND VPWR VGND sky130_ef_sc_hd__decap_12
XFILLER_203_80 VGND VGND VPWR VPWR sky130_fd_sc_hd__decap_6
XFILLER_226_894 VPWR VGND VPWR VGND sky130_ef_sc_hd__decap_12
XFILLER_0_1450 VPWR VGND VPWR VGND sky130_ef_sc_hd__decap_12
XFILLER_77_1165 VPWR VGND VPWR VGND sky130_ef_sc_hd__decap_12
XFILLER_241_842 VPWR VGND VPWR VGND sky130_ef_sc_hd__decap_12
XFILLER_168_1293 VPWR VGND VPWR VGND sky130_ef_sc_hd__decap_12
XPHY_EDGE_ROW_0_Right_0 VGND VGND VPWR VPWR sky130_fd_sc_hd__decap_3
XFILLER_198_746 VGND VGND VPWR VPWR sky130_fd_sc_hd__decap_6
XFILLER_0_1483 VGND VGND VPWR VPWR sky130_fd_sc_hd__decap_8
XFILLER_241_897 VGND VGND VPWR VPWR sky130_fd_sc_hd__decap_6
XFILLER_179_971 VPWR VGND VPWR VGND sky130_ef_sc_hd__decap_12
XFILLER_142_1411 VPWR VGND VPWR VGND sky130_ef_sc_hd__decap_12
XFILLER_240_1023 VPWR VGND VPWR VGND sky130_ef_sc_hd__decap_12
XFILLER_8_108 VPWR VGND VPWR VGND sky130_ef_sc_hd__decap_12
XFILLER_51_1316 VPWR VGND VPWR VGND sky130_ef_sc_hd__decap_12
XFILLER_32_22 VPWR VGND VPWR VGND sky130_ef_sc_hd__decap_12
XFILLER_205_1143 VPWR VGND VPWR VGND sky130_ef_sc_hd__decap_12
XFILLER_200_249 VPWR VGND VPWR VGND sky130_ef_sc_hd__decap_12
XFILLER_142_1466 VPWR VGND VPWR VGND sky130_ef_sc_hd__decap_12
XFILLER_148_22 VPWR VGND VPWR VGND sky130_ef_sc_hd__decap_12
XFILLER_240_1078 VPWR VGND VPWR VGND sky130_ef_sc_hd__decap_12
XFILLER_205_1198 VGND VGND VPWR VPWR sky130_fd_sc_hd__decap_6
XPHY_EDGE_ROW_111_1_Right_767 VGND VGND VPWR VPWR sky130_fd_sc_hd__decap_3
XFILLER_180_101 VGND VGND VPWR VPWR sky130_fd_sc_hd__decap_6
XFILLER_113_3 VPWR VGND VPWR VGND sky130_ef_sc_hd__decap_12
XFILLER_49_1201 VGND VGND VPWR VPWR sky130_fd_sc_hd__decap_4
XFILLER_181_646 VPWR VGND VPWR VGND sky130_ef_sc_hd__decap_12
XFILLER_4_369 VGND VGND VPWR VPWR sky130_fd_sc_hd__fill_2
XFILLER_88_1294 VPWR VGND VPWR VGND sky130_ef_sc_hd__decap_12
XTAP_TAPCELL_ROW_210_3099 VGND VPWR sky130_fd_sc_hd__tapvpwrvgnd_1
XFILLER_164_65 VGND VGND VPWR VPWR sky130_fd_sc_hd__decap_6
XTAP_TAPCELL_ROW_106_1_1389 VGND VPWR sky130_fd_sc_hd__tapvpwrvgnd_1
XFILLER_62_1423 VPWR VGND VPWR VGND sky130_ef_sc_hd__decap_12
XFILLER_216_1250 VPWR VGND VPWR VGND sky130_ef_sc_hd__decap_12
XFILLER_251_1174 VPWR VGND VPWR VGND sky130_ef_sc_hd__decap_12
XFILLER_248_452 VPWR VGND VPWR VGND sky130_ef_sc_hd__decap_12
XFILLER_62_1478 VGND VGND VPWR VPWR sky130_fd_sc_hd__decap_6
XFILLER_208_316 VGND VGND VPWR VPWR sky130_fd_sc_hd__decap_6
XTAP_TAPCELL_ROW_167_1585 VGND VPWR sky130_fd_sc_hd__tapvpwrvgnd_1
XFILLER_169_1002 VPWR VGND VPWR VGND sky130_ef_sc_hd__decap_12
XTAP_TAPCELL_ROW_167_1596 VGND VPWR sky130_fd_sc_hd__tapvpwrvgnd_1
XFILLER_236_636 VPWR VGND VPWR VGND sky130_ef_sc_hd__decap_12
XTAP_TAPCELL_ROW_158_2_5928 VGND VPWR sky130_fd_sc_hd__tapvpwrvgnd_1
XFILLER_112_1270 VPWR VGND VPWR VGND sky130_ef_sc_hd__decap_12
XTAP_TAPCELL_ROW_127_2_5675 VGND VPWR sky130_fd_sc_hd__tapvpwrvgnd_1
XFILLER_169_1057 VPWR VGND VPWR VGND sky130_ef_sc_hd__decap_12
XFILLER_217_861 VPWR VGND VPWR VGND sky130_ef_sc_hd__decap_12
XTAP_TAPCELL_ROW_95_2_5420 VGND VPWR sky130_fd_sc_hd__tapvpwrvgnd_1
XFILLER_99_1390 VPWR VGND VPWR VGND sky130_ef_sc_hd__decap_12
XFILLER_251_639 VGND VGND VPWR VPWR sky130_fd_sc_hd__decap_6
XFILLER_189_713 VPWR VGND VPWR VGND sky130_ef_sc_hd__decap_12
XFILLER_232_820 VPWR VGND VPWR VGND sky130_ef_sc_hd__decap_12
XFILLER_244_691 VPWR VGND VPWR VGND sky130_ef_sc_hd__decap_12
XFILLER_56_1227 VPWR VGND VPWR VGND sky130_ef_sc_hd__decap_12
XFILLER_108_1306 VGND VGND VPWR VPWR sky130_fd_sc_hd__decap_6
XFILLER_189_768 VGND VGND VPWR VPWR sky130_fd_sc_hd__decap_6
XFILLER_232_875 VGND VGND VPWR VPWR sky130_fd_sc_hd__decap_6
XTAP_TAPCELL_ROW_120_2_5618 VGND VPWR sky130_fd_sc_hd__tapvpwrvgnd_1
XFILLER_7_130 VPWR VGND VPWR VGND sky130_ef_sc_hd__decap_12
XFILLER_172_624 VPWR VGND VPWR VGND sky130_ef_sc_hd__decap_12
XFILLER_184_495 VPWR VGND VPWR VGND sky130_ef_sc_hd__decap_12
XFILLER_32_1282 VPWR VGND VPWR VGND sky130_ef_sc_hd__decap_12
XFILLER_171_123 VGND VGND VPWR VPWR sky130_fd_sc_hd__decap_6
XFILLER_172_679 VPWR VGND VPWR VGND sky130_ef_sc_hd__decap_12
XFILLER_208_58 VGND VGND VPWR VPWR sky130_fd_sc_hd__decap_6
XFILLER_119_1402 VPWR VGND VPWR VGND sky130_ef_sc_hd__decap_12
XTAP_TAPCELL_ROW_245_4320 VGND VPWR sky130_fd_sc_hd__tapvpwrvgnd_1
XTAP_TAPCELL_ROW_245_4331 VGND VPWR sky130_fd_sc_hd__tapvpwrvgnd_1
XFILLER_217_1014 VPWR VGND VPWR VGND sky130_ef_sc_hd__decap_12
XTAP_TAPCELL_ROW_245_4342 VGND VPWR sky130_fd_sc_hd__tapvpwrvgnd_1
XTAP_TAPCELL_ROW_23_2_4845 VGND VPWR sky130_fd_sc_hd__tapvpwrvgnd_1
XFILLER_67_1378 VPWR VGND VPWR VGND sky130_ef_sc_hd__decap_12
XFILLER_119_1457 VGND VGND VPWR VPWR sky130_fd_sc_hd__decap_6
XFILLER_154_1337 VPWR VGND VPWR VGND sky130_ef_sc_hd__decap_12
XTAP_TAPCELL_ROW_241_4206 VGND VPWR sky130_fd_sc_hd__tapvpwrvgnd_1
XFILLER_217_1069 VGND VGND VPWR VPWR sky130_fd_sc_hd__decap_6
XFILLER_224_46 VPWR VGND VPWR VGND sky130_ef_sc_hd__decap_12
XFILLER_41_1507 VGND VGND VPWR VPWR sky130_fd_sc_hd__decap_8
XFILLER_227_603 VPWR VGND VPWR VGND sky130_ef_sc_hd__decap_12
XTAP_TAPCELL_ROW_7_1120 VGND VPWR sky130_fd_sc_hd__tapvpwrvgnd_1
XFILLER_239_474 VPWR VGND VPWR VGND sky130_ef_sc_hd__decap_12
XTAP_TAPCELL_ROW_7_1131 VGND VPWR sky130_fd_sc_hd__tapvpwrvgnd_1
XFILLER_230_1269 VPWR VGND VPWR VGND sky130_ef_sc_hd__decap_12
XFILLER_255_967 VPWR VGND VPWR VGND sky130_ef_sc_hd__decap_12
XFILLER_254_433 VPWR VGND VPWR VGND sky130_ef_sc_hd__decap_12
XTAP_TAPCELL_ROW_206_2957 VGND VPWR sky130_fd_sc_hd__tapvpwrvgnd_1
XFILLER_227_658 VPWR VGND VPWR VGND sky130_ef_sc_hd__decap_12
XTAP_TAPCELL_ROW_206_2968 VGND VPWR sky130_fd_sc_hd__tapvpwrvgnd_1
XTAP_TAPCELL_ROW_206_2979 VGND VPWR sky130_fd_sc_hd__tapvpwrvgnd_1
XTAP_TAPCELL_ROW_239_4113 VGND VPWR sky130_fd_sc_hd__tapvpwrvgnd_1
XTAP_TAPCELL_ROW_239_4124 VGND VPWR sky130_fd_sc_hd__tapvpwrvgnd_1
XTAP_TAPCELL_ROW_198_2703 VGND VPWR sky130_fd_sc_hd__tapvpwrvgnd_1
XFILLER_242_617 VGND VGND VPWR VPWR sky130_fd_sc_hd__decap_6
XTAP_TAPCELL_ROW_239_4135 VGND VPWR sky130_fd_sc_hd__tapvpwrvgnd_1
XFILLER_240_34 VPWR VGND VPWR VGND sky130_ef_sc_hd__decap_12
XFILLER_254_488 VGND VGND VPWR VPWR sky130_fd_sc_hd__decap_6
XFILLER_130_1392 VGND VGND VPWR VPWR sky130_fd_sc_hd__decap_6
XFILLER_208_894 VPWR VGND VPWR VGND sky130_ef_sc_hd__decap_12
XFILLER_228_1121 VPWR VGND VPWR VGND sky130_ef_sc_hd__decap_12
XFILLER_39_1414 VGND VGND VPWR VPWR sky130_fd_sc_hd__decap_6
XFILLER_78_1485 VPWR VGND VPWR VGND sky130_ef_sc_hd__decap_12
XFILLER_223_842 VPWR VGND VPWR VGND sky130_ef_sc_hd__decap_12
XFILLER_240_89 VPWR VGND VPWR VGND sky130_ef_sc_hd__decap_12
XFILLER_74_1349 VGND VGND VPWR VPWR sky130_fd_sc_hd__decap_6
XFILLER_228_1176 VGND VGND VPWR VPWR sky130_fd_sc_hd__decap_6
XFILLER_223_897 VGND VGND VPWR VPWR sky130_fd_sc_hd__decap_6
XFILLER_206_1441 VPWR VGND VPWR VGND sky130_ef_sc_hd__decap_12
XFILLER_194_237 VPWR VGND VPWR VGND sky130_ef_sc_hd__decap_12
XFILLER_202_1305 VGND VGND VPWR VPWR sky130_fd_sc_hd__decap_6
XFILLER_206_1496 VPWR VGND VPWR VGND sky130_ef_sc_hd__decap_12
XFILLER_249_87 VPWR VGND VPWR VGND sky130_ef_sc_hd__decap_12
XFILLER_124_1196 VPWR VGND VPWR VGND sky130_ef_sc_hd__decap_12
XFILLER_190_421 VPWR VGND VPWR VGND sky130_ef_sc_hd__decap_12
XFILLER_118_58 VGND VGND VPWR VPWR sky130_fd_sc_hd__decap_6
XFILLER_190_476 VPWR VGND VPWR VGND sky130_ef_sc_hd__decap_12
XFILLER_239_1272 VPWR VGND VPWR VGND sky130_ef_sc_hd__decap_12
XFILLER_2_829 VGND VGND VPWR VPWR sky130_fd_sc_hd__decap_8
XFILLER_85_1445 VPWR VGND VPWR VGND sky130_ef_sc_hd__decap_12
XFILLER_249_216 VPWR VGND VPWR VGND sky130_ef_sc_hd__decap_12
XFILLER_213_1401 VPWR VGND VPWR VGND sky130_ef_sc_hd__decap_12
XFILLER_134_46 VPWR VGND VPWR VGND sky130_ef_sc_hd__decap_12
XTAP_TAPCELL_ROW_144_2_5814 VGND VPWR sky130_fd_sc_hd__tapvpwrvgnd_1
XFILLER_245_400 VPWR VGND VPWR VGND sky130_ef_sc_hd__decap_12
XFILLER_135_1292 VPWR VGND VPWR VGND sky130_ef_sc_hd__decap_12
XFILLER_213_1456 VGND VGND VPWR VPWR sky130_fd_sc_hd__decap_6
XFILLER_170_1183 VPWR VGND VPWR VGND sky130_ef_sc_hd__decap_12
XFILLER_218_636 VPWR VGND VPWR VGND sky130_ef_sc_hd__decap_12
XFILLER_248_1508 VGND VGND VPWR VPWR sky130_fd_sc_hd__decap_6
XFILLER_245_455 VPWR VGND VPWR VGND sky130_ef_sc_hd__decap_12
XFILLER_27_44 VPWR VGND VPWR VGND sky130_ef_sc_hd__decap_12
XFILLER_131_1189 VPWR VGND VPWR VGND sky130_ef_sc_hd__decap_12
XFILLER_79_1249 VPWR VGND VPWR VGND sky130_ef_sc_hd__decap_12
XFILLER_150_34 VPWR VGND VPWR VGND sky130_ef_sc_hd__decap_12
XFILLER_166_1219 VGND VGND VPWR VPWR sky130_fd_sc_hd__decap_6
XFILLER_233_639 VGND VGND VPWR VPWR sky130_fd_sc_hd__decap_6
X_460_ net607 net8 net42 VGND VGND VPWR VPWR addr0\[6\] sky130_fd_sc_hd__mux2_1
XFILLER_214_820 VPWR VGND VPWR VGND sky130_ef_sc_hd__decap_12
XFILLER_226_691 VPWR VGND VPWR VGND sky130_ef_sc_hd__decap_12
XTAP_TAPCELL_ROW_1_895 VGND VPWR sky130_fd_sc_hd__tapvpwrvgnd_1
XFILLER_168_1090 VGND VGND VPWR VPWR sky130_fd_sc_hd__decap_6
XFILLER_207_1205 VPWR VGND VPWR VGND sky130_ef_sc_hd__decap_12
XTAP_TAPCELL_ROW_62_2_5158 VGND VPWR sky130_fd_sc_hd__tapvpwrvgnd_1
XFILLER_18_1509 VGND VGND VPWR VPWR sky130_fd_sc_hd__decap_6
X_391_ net210 net208 VGND VGND VPWR VPWR _180_ sky130_fd_sc_hd__nor2_1
XFILLER_214_875 VGND VGND VPWR VPWR sky130_fd_sc_hd__decap_6
XFILLER_230_3 VPWR VGND VPWR VGND sky130_ef_sc_hd__decap_12
XTAP_TAPCELL_ROW_42_2_5001 VGND VPWR sky130_fd_sc_hd__tapvpwrvgnd_1
XFILLER_90_1184 VPWR VGND VPWR VGND sky130_ef_sc_hd__decap_12
XFILLER_185_259 VPWR VGND VPWR VGND sky130_ef_sc_hd__decap_12
XFILLER_142_1263 VGND VGND VPWR VPWR sky130_fd_sc_hd__decap_6
XTAP_TAPCELL_ROW_175_1865 VGND VPWR sky130_fd_sc_hd__tapvpwrvgnd_1
XTAP_TAPCELL_ROW_175_1876 VGND VPWR sky130_fd_sc_hd__tapvpwrvgnd_1
XTAP_TAPCELL_ROW_175_1887 VGND VPWR sky130_fd_sc_hd__tapvpwrvgnd_1
XTAP_TAPCELL_ROW_171_1729 VGND VPWR sky130_fd_sc_hd__tapvpwrvgnd_1
XTAP_TAPCELL_ROW_175_1898 VGND VPWR sky130_fd_sc_hd__tapvpwrvgnd_1
XFILLER_177_1315 VPWR VGND VPWR VGND sky130_ef_sc_hd__decap_12
XPHY_EDGE_ROW_253_Left_508 VGND VGND VPWR VPWR sky130_fd_sc_hd__decap_3
XFILLER_166_495 VPWR VGND VPWR VGND sky130_ef_sc_hd__decap_12
XFILLER_5_634 VGND VGND VPWR VPWR sky130_fd_sc_hd__fill_1
XFILLER_4_100 VGND VGND VPWR VPWR sky130_fd_sc_hd__decap_6
XFILLER_181_443 VPWR VGND VPWR VGND sky130_ef_sc_hd__decap_12
XPHY_EDGE_ROW_112_1_Right_768 VGND VGND VPWR VPWR sky130_fd_sc_hd__decap_3
XFILLER_4_144 VGND VGND VPWR VPWR sky130_fd_sc_hd__decap_6
XPHY_EDGE_ROW_114_2_Left_616 VGND VGND VPWR VPWR sky130_fd_sc_hd__decap_3
XFILLER_218_1312 VPWR VGND VPWR VGND sky130_ef_sc_hd__decap_12
XFILLER_5_689 VGND VGND VPWR VPWR sky130_fd_sc_hd__decap_3
XFILLER_181_498 VPWR VGND VPWR VGND sky130_ef_sc_hd__decap_12
XFILLER_4_188 VGND VGND VPWR VPWR sky130_fd_sc_hd__fill_2
XFILLER_218_1367 VPWR VGND VPWR VGND sky130_ef_sc_hd__decap_12
XFILLER_7_1401 VPWR VGND VPWR VGND sky130_ef_sc_hd__decap_12
XFILLER_62_1220 VGND VGND VPWR VPWR sky130_fd_sc_hd__decap_6
XTAP_TAPCELL_ROW_169_1658 VGND VPWR sky130_fd_sc_hd__tapvpwrvgnd_1
XTAP_TAPCELL_ROW_169_1669 VGND VPWR sky130_fd_sc_hd__tapvpwrvgnd_1
XFILLER_209_603 VPWR VGND VPWR VGND sky130_ef_sc_hd__decap_12
XFILLER_7_1456 VGND VGND VPWR VPWR sky130_fd_sc_hd__decap_6
XFILLER_188_1422 VPWR VGND VPWR VGND sky130_ef_sc_hd__decap_12
XFILLER_236_433 VPWR VGND VPWR VGND sky130_ef_sc_hd__decap_12
XFILLER_97_1316 VPWR VGND VPWR VGND sky130_ef_sc_hd__decap_12
XFILLER_209_658 VPWR VGND VPWR VGND sky130_ef_sc_hd__decap_12
XFILLER_224_617 VGND VGND VPWR VPWR sky130_fd_sc_hd__decap_6
XFILLER_252_937 VPWR VGND VPWR VGND sky130_ef_sc_hd__decap_12
XFILLER_188_1477 VGND VGND VPWR VPWR sky130_fd_sc_hd__decap_6
XFILLER_236_488 VGND VGND VPWR VPWR sky130_fd_sc_hd__decap_6
XFILLER_1_1033 VPWR VGND VPWR VGND sky130_ef_sc_hd__decap_12
X_658_ clknet_3_4__leaf_clk acc_core.adder.cla_blocks\[6\].block.sum\[0\] _066_ VGND
+ VGND VPWR VPWR net59 sky130_fd_sc_hd__dfrtp_1
XFILLER_189_510 VGND VGND VPWR VPWR sky130_fd_sc_hd__decap_6
XFILLER_205_842 VPWR VGND VPWR VGND sky130_ef_sc_hd__decap_12
XTAP_TAPCELL_ROW_253_4600 VGND VPWR sky130_fd_sc_hd__tapvpwrvgnd_1
XFILLER_210_15 VGND VGND VPWR VPWR sky130_fd_sc_hd__decap_6
XTAP_TAPCELL_ROW_253_4611 VGND VPWR sky130_fd_sc_hd__tapvpwrvgnd_1
XFILLER_229_1463 VPWR VGND VPWR VGND sky130_ef_sc_hd__decap_12
XTAP_TAPCELL_ROW_253_4622 VGND VPWR sky130_fd_sc_hd__tapvpwrvgnd_1
XFILLER_1_1088 VPWR VGND VPWR VGND sky130_ef_sc_hd__decap_12
X_589_ net671 VGND VGND VPWR VPWR _071_ sky130_fd_sc_hd__inv_2
XFILLER_225_1327 VGND VGND VPWR VPWR sky130_fd_sc_hd__decap_6
XFILLER_182_1054 VPWR VGND VPWR VGND sky130_ef_sc_hd__decap_12
XFILLER_205_897 VGND VGND VPWR VPWR sky130_fd_sc_hd__decap_6
XFILLER_73_1371 VGND VGND VPWR VPWR sky130_fd_sc_hd__decap_6
XFILLER_176_237 VPWR VGND VPWR VGND sky130_ef_sc_hd__decap_12
XPHY_EDGE_ROW_74_1_Right_730 VGND VGND VPWR VPWR sky130_fd_sc_hd__decap_3
XFILLER_30_1208 VPWR VGND VPWR VGND sky130_ef_sc_hd__decap_12
XFILLER_76_3 VPWR VGND VPWR VGND sky130_ef_sc_hd__decap_12
XFILLER_34_1399 VPWR VGND VPWR VGND sky130_ef_sc_hd__decap_12
XFILLER_121_1347 VPWR VGND VPWR VGND sky130_ef_sc_hd__decap_12
XFILLER_172_421 VPWR VGND VPWR VGND sky130_ef_sc_hd__decap_12
XPHY_EDGE_ROW_46_2_Left_548 VGND VGND VPWR VPWR sky130_fd_sc_hd__decap_3
XFILLER_219_68 VPWR VGND VPWR VGND sky130_ef_sc_hd__decap_12
XTAP_TAPCELL_ROW_247_4404 VGND VPWR sky130_fd_sc_hd__tapvpwrvgnd_1
XFILLER_184_292 VPWR VGND VPWR VGND sky130_ef_sc_hd__decap_12
XTAP_TAPCELL_ROW_247_4415 VGND VPWR sky130_fd_sc_hd__tapvpwrvgnd_1
XFILLER_172_476 VPWR VGND VPWR VGND sky130_ef_sc_hd__decap_12
XFILLER_236_1434 VGND VGND VPWR VPWR sky130_fd_sc_hd__decap_6
XFILLER_158_1270 VPWR VGND VPWR VGND sky130_ef_sc_hd__decap_12
XTAP_TAPCELL_ROW_130_2_5700 VGND VPWR sky130_fd_sc_hd__tapvpwrvgnd_1
XTAP_TAPCELL_ROW_75_1_1342 VGND VPWR sky130_fd_sc_hd__tapvpwrvgnd_1
XFILLER_235_56 VPWR VGND VPWR VGND sky130_ef_sc_hd__decap_12
XTAP_TAPCELL_ROW_9_1204 VGND VPWR sky130_fd_sc_hd__tapvpwrvgnd_1
XTAP_TAPCELL_ROW_9_1215 VGND VPWR sky130_fd_sc_hd__tapvpwrvgnd_1
XTAP_TAPCELL_ROW_9_1226 VGND VPWR sky130_fd_sc_hd__tapvpwrvgnd_1
XFILLER_41_1304 VPWR VGND VPWR VGND sky130_ef_sc_hd__decap_12
XTAP_TAPCELL_ROW_9_1237 VGND VPWR sky130_fd_sc_hd__tapvpwrvgnd_1
XFILLER_230_1011 VPWR VGND VPWR VGND sky130_ef_sc_hd__decap_12
XFILLER_227_400 VPWR VGND VPWR VGND sky130_ef_sc_hd__decap_12
XFILLER_239_271 VPWR VGND VPWR VGND sky130_ef_sc_hd__decap_12
XFILLER_132_1454 VPWR VGND VPWR VGND sky130_ef_sc_hd__decap_12
XFILLER_251_44 VPWR VGND VPWR VGND sky130_ef_sc_hd__decap_12
XFILLER_41_1359 VPWR VGND VPWR VGND sky130_ef_sc_hd__decap_12
XFILLER_230_1066 VPWR VGND VPWR VGND sky130_ef_sc_hd__decap_12
XFILLER_254_230 VGND VGND VPWR VPWR sky130_fd_sc_hd__decap_6
XPHY_EDGE_ROW_160_2_Left_662 VGND VGND VPWR VPWR sky130_fd_sc_hd__decap_3
XFILLER_243_904 VPWR VGND VPWR VGND sky130_ef_sc_hd__decap_12
XFILLER_227_455 VPWR VGND VPWR VGND sky130_ef_sc_hd__decap_12
XFILLER_167_1506 VGND VGND VPWR VPWR sky130_fd_sc_hd__decap_8
XFILLER_251_99 VPWR VGND VPWR VGND sky130_ef_sc_hd__decap_12
XTAP_TAPCELL_ROW_47_2_5038 VGND VPWR sky130_fd_sc_hd__tapvpwrvgnd_1
XFILLER_215_639 VGND VGND VPWR VPWR sky130_fd_sc_hd__decap_6
XFILLER_243_959 VPWR VGND VPWR VGND sky130_ef_sc_hd__decap_12
XFILLER_208_691 VPWR VGND VPWR VGND sky130_ef_sc_hd__decap_12
XFILLER_120_15 VGND VGND VPWR VPWR sky130_fd_sc_hd__decap_6
XFILLER_208_1514 VGND VGND VPWR VPWR sky130_fd_sc_hd__fill_1
XFILLER_78_1282 VPWR VGND VPWR VGND sky130_ef_sc_hd__decap_12
XFILLER_165_1252 VGND VGND VPWR VPWR sky130_fd_sc_hd__decap_8
XFILLER_52_1411 VPWR VGND VPWR VGND sky130_ef_sc_hd__decap_12
XPHY_EDGE_ROW_10_2_Right_101 VGND VGND VPWR VPWR sky130_fd_sc_hd__decap_3
XPHY_EDGE_ROW_112_1_Left_367 VGND VGND VPWR VPWR sky130_fd_sc_hd__decap_3
XFILLER_241_1162 VPWR VGND VPWR VGND sky130_ef_sc_hd__decap_12
XFILLER_167_259 VPWR VGND VPWR VGND sky130_ef_sc_hd__decap_12
XFILLER_210_366 VPWR VGND VPWR VGND sky130_ef_sc_hd__decap_12
XFILLER_52_1466 VPWR VGND VPWR VGND sky130_ef_sc_hd__decap_12
XFILLER_206_1293 VPWR VGND VPWR VGND sky130_ef_sc_hd__decap_12
XFILLER_13_68 VGND VGND VPWR VPWR sky130_fd_sc_hd__decap_3
XFILLER_182_218 VPWR VGND VPWR VGND sky130_ef_sc_hd__decap_12
XFILLER_87_1507 VGND VGND VPWR VPWR sky130_fd_sc_hd__decap_8
XFILLER_129_68 VGND VGND VPWR VPWR sky130_fd_sc_hd__decap_3
XFILLER_89_39 VGND VGND VPWR VPWR sky130_fd_sc_hd__decap_4
XTAP_TAPCELL_ROW_211_3150 VGND VPWR sky130_fd_sc_hd__tapvpwrvgnd_1
XTAP_TAPCELL_ROW_230_3795 VGND VPWR sky130_fd_sc_hd__tapvpwrvgnd_1
XFILLER_190_273 VGND VGND VPWR VPWR sky130_fd_sc_hd__decap_6
XFILLER_85_1242 VGND VGND VPWR VPWR sky130_fd_sc_hd__decap_6
Xmax_cap180 _099_ VGND VGND VPWR VPWR net180 sky130_fd_sc_hd__clkbuf_1
Xmax_cap191 _222_ VGND VGND VPWR VPWR net191 sky130_fd_sc_hd__clkbuf_1
XFILLER_145_56 VPWR VGND VPWR VGND sky130_ef_sc_hd__decap_12
XFILLER_133_1218 VPWR VGND VPWR VGND sky130_ef_sc_hd__decap_12
XPHY_EDGE_ROW_92_2_Left_594 VGND VGND VPWR VPWR sky130_fd_sc_hd__decap_3
XFILLER_38_65 VGND VGND VPWR VPWR sky130_fd_sc_hd__decap_6
XFILLER_161_44 VPWR VGND VPWR VGND sky130_ef_sc_hd__decap_12
XFILLER_180_3 VPWR VGND VPWR VGND sky130_ef_sc_hd__decap_12
XFILLER_218_433 VPWR VGND VPWR VGND sky130_ef_sc_hd__decap_12
XFILLER_246_753 VPWR VGND VPWR VGND sky130_ef_sc_hd__decap_12
XTAP_TAPCELL_ROW_224_3588 VGND VPWR sky130_fd_sc_hd__tapvpwrvgnd_1
XFILLER_248_1305 VGND VGND VPWR VPWR sky130_fd_sc_hd__decap_6
XTAP_TAPCELL_ROW_224_3599 VGND VPWR sky130_fd_sc_hd__tapvpwrvgnd_1
XFILLER_245_252 VGND VGND VPWR VPWR sky130_fd_sc_hd__decap_6
XFILLER_206_617 VGND VGND VPWR VPWR sky130_fd_sc_hd__decap_6
XFILLER_22_1270 VPWR VGND VPWR VGND sky130_ef_sc_hd__decap_12
XFILLER_218_488 VGND VGND VPWR VPWR sky130_fd_sc_hd__decap_6
XFILLER_234_937 VPWR VGND VPWR VGND sky130_ef_sc_hd__decap_12
X_512_ net184 VGND VGND VPWR VPWR _263_ sky130_fd_sc_hd__inv_2
XFILLER_54_42 VGND VGND VPWR VPWR sky130_fd_sc_hd__fill_2
XFILLER_199_830 VPWR VGND VPWR VGND sky130_ef_sc_hd__decap_12
X_443_ _220_ _222_ _231_ VGND VGND VPWR VPWR _232_ sky130_fd_sc_hd__a21o_1
XFILLER_207_1002 VPWR VGND VPWR VGND sky130_ef_sc_hd__decap_12
XFILLER_18_1306 VGND VGND VPWR VPWR sky130_fd_sc_hd__decap_6
XFILLER_220_108 VPWR VGND VPWR VGND sky130_ef_sc_hd__decap_12
XFILLER_242_992 VPWR VGND VPWR VGND sky130_ef_sc_hd__decap_12
XPHY_EDGE_ROW_44_1_Left_299 VGND VGND VPWR VPWR sky130_fd_sc_hd__decap_3
XFILLER_109_1445 VPWR VGND VPWR VGND sky130_ef_sc_hd__decap_12
XFILLER_144_1325 VPWR VGND VPWR VGND sky130_ef_sc_hd__decap_12
XFILLER_199_885 VPWR VGND VPWR VGND sky130_ef_sc_hd__decap_12
X_374_ net133 net159 VGND VGND VPWR VPWR _163_ sky130_fd_sc_hd__or2_1
XFILLER_207_1057 VPWR VGND VPWR VGND sky130_ef_sc_hd__decap_12
XTAP_TAPCELL_ROW_177_1938 VGND VPWR sky130_fd_sc_hd__tapvpwrvgnd_1
XTAP_TAPCELL_ROW_177_1949 VGND VPWR sky130_fd_sc_hd__tapvpwrvgnd_1
XTAP_TAPCELL_ROW_92_2_5397 VGND VPWR sky130_fd_sc_hd__tapvpwrvgnd_1
XFILLER_201_388 VPWR VGND VPWR VGND sky130_ef_sc_hd__decap_12
XFILLER_166_292 VPWR VGND VPWR VGND sky130_ef_sc_hd__decap_12
XFILLER_177_1112 VGND VGND VPWR VPWR sky130_fd_sc_hd__decap_6
XTAP_TAPCELL_ROW_104_2_5495 VGND VPWR sky130_fd_sc_hd__tapvpwrvgnd_1
XFILLER_5_431 VGND VGND VPWR VPWR sky130_fd_sc_hd__fill_2
XTAP_TAPCELL_ROW_72_2_5240 VGND VPWR sky130_fd_sc_hd__tapvpwrvgnd_1
XFILLER_181_240 VPWR VGND VPWR VGND sky130_ef_sc_hd__decap_12
XFILLER_170_925 VPWR VGND VPWR VGND sky130_ef_sc_hd__decap_12
XFILLER_120_1380 VPWR VGND VPWR VGND sky130_ef_sc_hd__decap_12
XFILLER_182_796 VPWR VGND VPWR VGND sky130_ef_sc_hd__decap_12
XFILLER_29_1402 VPWR VGND VPWR VGND sky130_ef_sc_hd__decap_12
XPHY_EDGE_ROW_113_1_Right_769 VGND VGND VPWR VPWR sky130_fd_sc_hd__decap_3
XFILLER_155_1421 VPWR VGND VPWR VGND sky130_ef_sc_hd__decap_12
XFILLER_181_295 VGND VGND VPWR VPWR sky130_fd_sc_hd__decap_6
XFILLER_253_1033 VPWR VGND VPWR VGND sky130_ef_sc_hd__decap_12
XFILLER_190_1312 VPWR VGND VPWR VGND sky130_ef_sc_hd__decap_12
XFILLER_64_1337 VPWR VGND VPWR VGND sky130_ef_sc_hd__decap_12
XFILLER_29_1457 VGND VGND VPWR VPWR sky130_fd_sc_hd__decap_6
XFILLER_218_1164 VPWR VGND VPWR VGND sky130_ef_sc_hd__decap_12
XTAP_TAPCELL_ROW_38_2_4964 VGND VPWR sky130_fd_sc_hd__tapvpwrvgnd_1
XFILLER_155_1476 VPWR VGND VPWR VGND sky130_ef_sc_hd__decap_12
XFILLER_205_15 VPWR VGND VPWR VGND sky130_ef_sc_hd__decap_12
XFILLER_253_1088 VPWR VGND VPWR VGND sky130_ef_sc_hd__decap_12
XFILLER_190_1367 VPWR VGND VPWR VGND sky130_ef_sc_hd__decap_12
XFILLER_209_400 VPWR VGND VPWR VGND sky130_ef_sc_hd__decap_12
XFILLER_225_904 VPWR VGND VPWR VGND sky130_ef_sc_hd__decap_12
XFILLER_236_230 VGND VGND VPWR VPWR sky130_fd_sc_hd__decap_6
XFILLER_114_1184 VPWR VGND VPWR VGND sky130_ef_sc_hd__decap_12
XFILLER_209_455 VPWR VGND VPWR VGND sky130_ef_sc_hd__decap_12
XFILLER_237_775 VPWR VGND VPWR VGND sky130_ef_sc_hd__decap_12
XTAP_TAPCELL_ROW_255_4706 VGND VPWR sky130_fd_sc_hd__tapvpwrvgnd_1
XFILLER_252_734 VPWR VGND VPWR VGND sky130_ef_sc_hd__decap_12
XFILLER_225_959 VPWR VGND VPWR VGND sky130_ef_sc_hd__decap_12
XTAP_TAPCELL_ROW_255_4717 VGND VPWR sky130_fd_sc_hd__tapvpwrvgnd_1
XFILLER_40_1392 VGND VGND VPWR VPWR sky130_fd_sc_hd__decap_6
XTAP_TAPCELL_ROW_31_2_4907 VGND VPWR sky130_fd_sc_hd__tapvpwrvgnd_1
XTAP_TAPCELL_ROW_255_4728 VGND VPWR sky130_fd_sc_hd__tapvpwrvgnd_1
XFILLER_240_918 VGND VGND VPWR VPWR sky130_fd_sc_hd__decap_6
XFILLER_75_1433 VPWR VGND VPWR VGND sky130_ef_sc_hd__decap_12
XFILLER_229_1260 VPWR VGND VPWR VGND sky130_ef_sc_hd__decap_12
XFILLER_252_789 VGND VGND VPWR VPWR sky130_fd_sc_hd__decap_6
XFILLER_75_1488 VPWR VGND VPWR VGND sky130_ef_sc_hd__decap_12
XFILLER_203_1444 VPWR VGND VPWR VGND sky130_ef_sc_hd__decap_12
XTAP_TAPCELL_ROW_193_2496 VGND VPWR sky130_fd_sc_hd__tapvpwrvgnd_1
XPHY_EDGE_ROW_75_1_Right_731 VGND VGND VPWR VPWR sky130_fd_sc_hd__decap_3
XFILLER_192_538 VPWR VGND VPWR VGND sky130_ef_sc_hd__decap_12
XFILLER_34_1196 VPWR VGND VPWR VGND sky130_ef_sc_hd__decap_12
XFILLER_199_1370 VGND VGND VPWR VPWR sky130_fd_sc_hd__decap_6
XFILLER_8_280 VGND VGND VPWR VPWR sky130_fd_sc_hd__decap_6
XFILLER_203_1499 VGND VGND VPWR VPWR sky130_fd_sc_hd__decap_6
XFILLER_246_22 VPWR VGND VPWR VGND sky130_ef_sc_hd__decap_12
XFILLER_121_1177 VPWR VGND VPWR VGND sky130_ef_sc_hd__decap_12
XFILLER_172_273 VGND VGND VPWR VPWR sky130_fd_sc_hd__decap_6
XFILLER_246_77 VPWR VGND VPWR VGND sky130_ef_sc_hd__decap_12
XFILLER_5_80 VGND VGND VPWR VPWR sky130_fd_sc_hd__decap_6
XFILLER_115_15 VPWR VGND VPWR VGND sky130_ef_sc_hd__decap_12
XTAP_TAPCELL_ROW_187_2289 VGND VPWR sky130_fd_sc_hd__tapvpwrvgnd_1
XFILLER_247_517 VPWR VGND VPWR VGND sky130_ef_sc_hd__decap_12
XFILLER_45_1292 VPWR VGND VPWR VGND sky130_ef_sc_hd__decap_12
XFILLER_132_1251 VPWR VGND VPWR VGND sky130_ef_sc_hd__decap_12
XTAP_TAPCELL_ROW_159_2_5933 VGND VPWR sky130_fd_sc_hd__tapvpwrvgnd_1
XFILLER_228_753 VPWR VGND VPWR VGND sky130_ef_sc_hd__decap_12
XFILLER_243_701 VPWR VGND VPWR VGND sky130_ef_sc_hd__decap_12
XTAP_TAPCELL_ROW_3_968 VGND VPWR sky130_fd_sc_hd__tapvpwrvgnd_1
XFILLER_227_252 VGND VGND VPWR VPWR sky130_fd_sc_hd__decap_6
XFILLER_41_1189 VPWR VGND VPWR VGND sky130_ef_sc_hd__decap_12
XTAP_TAPCELL_ROW_3_979 VGND VPWR sky130_fd_sc_hd__tapvpwrvgnd_1
XFILLER_167_1303 VPWR VGND VPWR VGND sky130_ef_sc_hd__decap_12
XFILLER_216_937 VPWR VGND VPWR VGND sky130_ef_sc_hd__decap_12
XFILLER_76_1208 VPWR VGND VPWR VGND sky130_ef_sc_hd__decap_12
XFILLER_243_756 VPWR VGND VPWR VGND sky130_ef_sc_hd__decap_12
XFILLER_93_1500 VGND VGND VPWR VPWR sky130_fd_sc_hd__decap_6
XFILLER_167_1358 VPWR VGND VPWR VGND sky130_ef_sc_hd__decap_12
XFILLER_202_108 VPWR VGND VPWR VGND sky130_ef_sc_hd__decap_12
XFILLER_224_992 VPWR VGND VPWR VGND sky130_ef_sc_hd__decap_12
XFILLER_180_1514 VGND VGND VPWR VPWR sky130_fd_sc_hd__fill_1
XFILLER_211_80 VGND VGND VPWR VPWR sky130_fd_sc_hd__decap_6
XFILLER_24_34 VGND VGND VPWR VPWR sky130_fd_sc_hd__decap_8
XFILLER_208_1355 VPWR VGND VPWR VGND sky130_ef_sc_hd__decap_12
XTAP_TAPCELL_ROW_77_2_5277 VGND VPWR sky130_fd_sc_hd__tapvpwrvgnd_1
XFILLER_165_1093 VPWR VGND VPWR VGND sky130_ef_sc_hd__decap_12
XFILLER_204_1219 VGND VGND VPWR VPWR sky130_fd_sc_hd__decap_6
XFILLER_210_163 VPWR VGND VPWR VGND sky130_ef_sc_hd__decap_12
XTAP_TAPCELL_ROW_213_3201 VGND VPWR sky130_fd_sc_hd__tapvpwrvgnd_1
XPHY_EDGE_ROW_11_2_Right_102 VGND VGND VPWR VPWR sky130_fd_sc_hd__decap_3
XTAP_TAPCELL_ROW_213_3212 VGND VPWR sky130_fd_sc_hd__tapvpwrvgnd_1
XFILLER_52_1263 VGND VGND VPWR VPWR sky130_fd_sc_hd__decap_6
Xwire627 net40 VGND VGND VPWR VPWR net627 sky130_fd_sc_hd__buf_1
XFILLER_206_1090 VGND VGND VPWR VPWR sky130_fd_sc_hd__decap_6
XTAP_TAPCELL_ROW_213_3223 VGND VPWR sky130_fd_sc_hd__tapvpwrvgnd_1
XTAP_TAPCELL_ROW_57_2_5120 VGND VPWR sky130_fd_sc_hd__tapvpwrvgnd_1
XFILLER_7_729 VGND VGND VPWR VPWR sky130_fd_sc_hd__fill_2
Xwire638 net31 VGND VGND VPWR VPWR net638 sky130_fd_sc_hd__buf_1
Xwire649 net22 VGND VGND VPWR VPWR net649 sky130_fd_sc_hd__buf_1
XFILLER_40_22 VPWR VGND VPWR VGND sky130_ef_sc_hd__decap_12
XFILLER_178_1410 VPWR VGND VPWR VGND sky130_ef_sc_hd__decap_12
XTAP_TAPCELL_ROW_232_3868 VGND VPWR sky130_fd_sc_hd__tapvpwrvgnd_1
XFILLER_87_1304 VPWR VGND VPWR VGND sky130_ef_sc_hd__decap_12
XTAP_TAPCELL_ROW_232_3879 VGND VPWR sky130_fd_sc_hd__tapvpwrvgnd_1
XFILLER_156_22 VPWR VGND VPWR VGND sky130_ef_sc_hd__decap_12
XFILLER_100_1239 VPWR VGND VPWR VGND sky130_ef_sc_hd__decap_12
XFILLER_178_1465 VPWR VGND VPWR VGND sky130_ef_sc_hd__decap_12
XFILLER_191_560 VPWR VGND VPWR VGND sky130_ef_sc_hd__decap_12
XFILLER_87_1359 VPWR VGND VPWR VGND sky130_ef_sc_hd__decap_12
XTAP_TAPCELL_ROW_24_2_4850 VGND VPWR sky130_fd_sc_hd__tapvpwrvgnd_1
XFILLER_215_1315 VPWR VGND VPWR VGND sky130_ef_sc_hd__decap_12
XTAP_TAPCELL_ROW_207_3005 VGND VPWR sky130_fd_sc_hd__tapvpwrvgnd_1
XTAP_TAPCELL_ROW_207_3016 VGND VPWR sky130_fd_sc_hd__tapvpwrvgnd_1
XFILLER_172_65 VPWR VGND VPWR VGND sky130_ef_sc_hd__decap_12
XFILLER_172_1097 VPWR VGND VPWR VGND sky130_ef_sc_hd__decap_12
XFILLER_98_1411 VPWR VGND VPWR VGND sky130_ef_sc_hd__decap_12
XFILLER_218_230 VGND VGND VPWR VPWR sky130_fd_sc_hd__decap_6
XFILLER_207_904 VPWR VGND VPWR VGND sky130_ef_sc_hd__decap_12
XFILLER_246_550 VPWR VGND VPWR VGND sky130_ef_sc_hd__decap_12
XFILLER_219_775 VPWR VGND VPWR VGND sky130_ef_sc_hd__decap_12
XFILLER_111_1335 VPWR VGND VPWR VGND sky130_ef_sc_hd__decap_12
XFILLER_98_1466 VPWR VGND VPWR VGND sky130_ef_sc_hd__decap_12
XFILLER_234_734 VPWR VGND VPWR VGND sky130_ef_sc_hd__decap_12
XFILLER_207_959 VPWR VGND VPWR VGND sky130_ef_sc_hd__decap_12
XFILLER_209_1119 VPWR VGND VPWR VGND sky130_ef_sc_hd__decap_12
XFILLER_222_918 VGND VGND VPWR VPWR sky130_fd_sc_hd__decap_6
XFILLER_2_1183 VPWR VGND VPWR VGND sky130_ef_sc_hd__decap_12
XFILLER_234_789 VGND VGND VPWR VPWR sky130_fd_sc_hd__decap_6
XFILLER_226_1422 VPWR VGND VPWR VGND sky130_ef_sc_hd__decap_12
XFILLER_187_811 VGND VGND VPWR VPWR sky130_fd_sc_hd__decap_6
X_426_ _213_ _214_ VGND VGND VPWR VPWR _215_ sky130_fd_sc_hd__or2_1
XFILLER_199_682 VGND VGND VPWR VPWR sky130_fd_sc_hd__decap_6
XFILLER_109_1242 VGND VGND VPWR VPWR sky130_fd_sc_hd__decap_6
XFILLER_226_1477 VGND VGND VPWR VPWR sky130_fd_sc_hd__decap_6
XFILLER_201_130 VPWR VGND VPWR VGND sky130_ef_sc_hd__decap_12
X_357_ _138_ net334 net338 VGND VGND VPWR VPWR _146_ sky130_fd_sc_hd__a21oi_1
XFILLER_144_1177 VGND VGND VPWR VPWR sky130_fd_sc_hd__decap_6
XFILLER_201_185 VPWR VGND VPWR VGND sky130_ef_sc_hd__decap_12
XFILLER_174_538 VPWR VGND VPWR VGND sky130_ef_sc_hd__decap_12
X_288_ net607 net608 net182 VGND VGND VPWR VPWR _085_ sky130_fd_sc_hd__and3_1
XFILLER_122_1442 VPWR VGND VPWR VGND sky130_ef_sc_hd__decap_12
XFILLER_179_1229 VPWR VGND VPWR VGND sky130_ef_sc_hd__decap_12
XFILLER_220_1054 VPWR VGND VPWR VGND sky130_ef_sc_hd__decap_12
XFILLER_31_1347 VPWR VGND VPWR VGND sky130_ef_sc_hd__decap_12
XFILLER_60_6 VPWR VGND VPWR VGND sky130_ef_sc_hd__decap_12
XFILLER_122_1497 VPWR VGND VPWR VGND sky130_ef_sc_hd__decap_12
XFILLER_170_722 VPWR VGND VPWR VGND sky130_ef_sc_hd__decap_12
XFILLER_182_593 VPWR VGND VPWR VGND sky130_ef_sc_hd__decap_12
XFILLER_68_1270 VPWR VGND VPWR VGND sky130_ef_sc_hd__decap_12
XFILLER_170_777 VPWR VGND VPWR VGND sky130_ef_sc_hd__decap_12
XFILLER_9_1315 VGND VGND VPWR VPWR sky130_fd_sc_hd__decap_8
XFILLER_216_58 VGND VGND VPWR VPWR sky130_fd_sc_hd__decap_6
XFILLER_39_3 VPWR VGND VPWR VGND sky130_ef_sc_hd__decap_12
XFILLER_155_1273 VPWR VGND VPWR VGND sky130_ef_sc_hd__decap_12
XFILLER_190_1164 VPWR VGND VPWR VGND sky130_ef_sc_hd__decap_12
XFILLER_229_517 VPWR VGND VPWR VGND sky130_ef_sc_hd__decap_12
XTAP_TAPCELL_ROW_182_2120 VGND VPWR sky130_fd_sc_hd__tapvpwrvgnd_1
XTAP_TAPCELL_ROW_182_2131 VGND VPWR sky130_fd_sc_hd__tapvpwrvgnd_1
XTAP_TAPCELL_ROW_182_2142 VGND VPWR sky130_fd_sc_hd__tapvpwrvgnd_1
XFILLER_42_1454 VPWR VGND VPWR VGND sky130_ef_sc_hd__decap_12
Xinput4 wr_addr[2] VGND VGND VPWR VPWR net4 sky130_fd_sc_hd__clkbuf_1
XFILLER_232_46 VPWR VGND VPWR VGND sky130_ef_sc_hd__decap_12
XFILLER_209_252 VGND VGND VPWR VPWR sky130_fd_sc_hd__decap_6
XFILLER_225_701 VPWR VGND VPWR VGND sky130_ef_sc_hd__decap_12
XFILLER_237_572 VPWR VGND VPWR VGND sky130_ef_sc_hd__decap_12
XFILLER_252_531 VGND VGND VPWR VPWR sky130_fd_sc_hd__decap_6
XFILLER_225_756 VPWR VGND VPWR VGND sky130_ef_sc_hd__decap_12
XTAP_TAPCELL_ROW_94_2_5416 VGND VPWR sky130_fd_sc_hd__tapvpwrvgnd_1
XFILLER_164_1509 VGND VGND VPWR VPWR sky130_fd_sc_hd__decap_6
XTAP_TAPCELL_ROW_63_2_5163 VGND VPWR sky130_fd_sc_hd__tapvpwrvgnd_1
XFILLER_75_1230 VPWR VGND VPWR VGND sky130_ef_sc_hd__decap_12
XFILLER_101_39 VGND VGND VPWR VPWR sky130_fd_sc_hd__decap_4
XFILLER_206_992 VPWR VGND VPWR VGND sky130_ef_sc_hd__decap_12
XFILLER_205_1506 VGND VGND VPWR VPWR sky130_fd_sc_hd__decap_8
XFILLER_221_940 VGND VGND VPWR VPWR sky130_fd_sc_hd__decap_6
XFILLER_166_1391 VGND VGND VPWR VPWR sky130_fd_sc_hd__decap_6
XFILLER_75_1285 VGND VGND VPWR VPWR sky130_fd_sc_hd__decap_6
XTAP_TAPCELL_ROW_195_2569 VGND VPWR sky130_fd_sc_hd__tapvpwrvgnd_1
XFILLER_123_1206 VPWR VGND VPWR VGND sky130_ef_sc_hd__decap_12
XFILLER_165_505 VPWR VGND VPWR VGND sky130_ef_sc_hd__decap_12
XFILLER_165_538 VGND VGND VPWR VPWR sky130_fd_sc_hd__decap_8
XFILLER_203_1241 VGND VGND VPWR VPWR sky130_fd_sc_hd__decap_6
XTAP_TAPCELL_ROW_63_1_1324 VGND VPWR sky130_fd_sc_hd__tapvpwrvgnd_1
XFILLER_192_335 VPWR VGND VPWR VGND sky130_ef_sc_hd__decap_12
XPHY_EDGE_ROW_76_1_Right_732 VGND VGND VPWR VPWR sky130_fd_sc_hd__decap_3
XFILLER_180_519 VPWR VGND VPWR VGND sky130_ef_sc_hd__decap_12
XFILLER_173_560 VPWR VGND VPWR VGND sky130_ef_sc_hd__decap_12
XFILLER_238_1348 VGND VGND VPWR VPWR sky130_fd_sc_hd__decap_6
XFILLER_10_58 VGND VGND VPWR VPWR sky130_fd_sc_hd__decap_6
XFILLER_86_1392 VGND VGND VPWR VPWR sky130_fd_sc_hd__decap_6
XFILLER_126_58 VGND VGND VPWR VPWR sky130_fd_sc_hd__decap_6
XFILLER_134_1313 VPWR VGND VPWR VGND sky130_ef_sc_hd__decap_12
XFILLER_43_1218 VPWR VGND VPWR VGND sky130_ef_sc_hd__decap_12
XFILLER_247_314 VPWR VGND VPWR VGND sky130_ef_sc_hd__decap_12
XFILLER_134_1368 VPWR VGND VPWR VGND sky130_ef_sc_hd__decap_12
XFILLER_19_56 VPWR VGND VPWR VGND sky130_ef_sc_hd__decap_12
XTAP_TAPCELL_ROW_221_3503 VGND VPWR sky130_fd_sc_hd__tapvpwrvgnd_1
XFILLER_247_369 VPWR VGND VPWR VGND sky130_ef_sc_hd__decap_12
XFILLER_228_550 VPWR VGND VPWR VGND sky130_ef_sc_hd__decap_12
XFILLER_142_46 VPWR VGND VPWR VGND sky130_ef_sc_hd__decap_12
XFILLER_167_1100 VPWR VGND VPWR VGND sky130_ef_sc_hd__decap_12
XFILLER_249_1444 VPWR VGND VPWR VGND sky130_ef_sc_hd__decap_12
XFILLER_216_734 VPWR VGND VPWR VGND sky130_ef_sc_hd__decap_12
XFILLER_255_391 VGND VGND VPWR VPWR sky130_fd_sc_hd__decap_8
XFILLER_243_553 VGND VGND VPWR VPWR sky130_fd_sc_hd__decap_6
XFILLER_167_1155 VGND VGND VPWR VPWR sky130_fd_sc_hd__decap_6
XFILLER_204_918 VGND VGND VPWR VPWR sky130_fd_sc_hd__decap_6
XFILLER_249_1499 VGND VGND VPWR VPWR sky130_fd_sc_hd__decap_6
XFILLER_35_44 VGND VGND VPWR VPWR sky130_fd_sc_hd__decap_4
XFILLER_216_789 VGND VGND VPWR VPWR sky130_fd_sc_hd__decap_6
XPHY_EDGE_ROW_123_2_Left_625 VGND VGND VPWR VPWR sky130_fd_sc_hd__decap_3
XTAP_TAPCELL_ROW_219_3410 VGND VPWR sky130_fd_sc_hd__tapvpwrvgnd_1
XFILLER_169_811 VGND VGND VPWR VPWR sky130_fd_sc_hd__decap_6
XTAP_TAPCELL_ROW_219_3421 VGND VPWR sky130_fd_sc_hd__tapvpwrvgnd_1
XTAP_TAPCELL_ROW_219_3432 VGND VPWR sky130_fd_sc_hd__tapvpwrvgnd_1
XFILLER_54_1325 VPWR VGND VPWR VGND sky130_ef_sc_hd__decap_12
XFILLER_208_1152 VPWR VGND VPWR VGND sky130_ef_sc_hd__decap_12
XFILLER_19_1445 VPWR VGND VPWR VGND sky130_ef_sc_hd__decap_12
XFILLER_143_3 VPWR VGND VPWR VGND sky130_ef_sc_hd__decap_12
XFILLER_145_1464 VPWR VGND VPWR VGND sky130_ef_sc_hd__decap_12
XFILLER_180_1355 VPWR VGND VPWR VGND sky130_ef_sc_hd__decap_12
XFILLER_243_1076 VPWR VGND VPWR VGND sky130_ef_sc_hd__decap_12
XFILLER_141_1328 VGND VGND VPWR VPWR sky130_fd_sc_hd__decap_6
Xwire402 net403 VGND VGND VPWR VPWR net402 sky130_fd_sc_hd__clkbuf_1
Xwire413 net414 VGND VGND VPWR VPWR net413 sky130_fd_sc_hd__clkbuf_1
XFILLER_183_302 VPWR VGND VPWR VGND sky130_ef_sc_hd__decap_12
Xwire424 net425 VGND VGND VPWR VPWR net424 sky130_fd_sc_hd__clkbuf_1
XFILLER_195_173 VPWR VGND VPWR VGND sky130_ef_sc_hd__decap_12
Xwire435 net436 VGND VGND VPWR VPWR net435 sky130_fd_sc_hd__clkbuf_1
XPHY_EDGE_ROW_12_2_Right_103 VGND VGND VPWR VPWR sky130_fd_sc_hd__decap_3
Xwire446 net447 VGND VGND VPWR VPWR net446 sky130_fd_sc_hd__clkbuf_1
Xwire457 net458 VGND VGND VPWR VPWR net457 sky130_fd_sc_hd__clkbuf_1
Xwire468 net469 VGND VGND VPWR VPWR net468 sky130_fd_sc_hd__clkbuf_1
XFILLER_183_357 VPWR VGND VPWR VGND sky130_ef_sc_hd__decap_12
Xwire479 net480 VGND VGND VPWR VPWR net479 sky130_fd_sc_hd__clkbuf_1
XFILLER_167_87 VPWR VGND VPWR VGND sky130_ef_sc_hd__decap_12
XTAP_TAPCELL_ROW_151_2_5873 VGND VPWR sky130_fd_sc_hd__tapvpwrvgnd_1
XFILLER_178_1262 VGND VGND VPWR VPWR sky130_fd_sc_hd__decap_6
XFILLER_30_1380 VPWR VGND VPWR VGND sky130_ef_sc_hd__decap_12
XFILLER_3_721 VGND VGND VPWR VPWR sky130_fd_sc_hd__decap_4
XFILLER_3_732 VGND VGND VPWR VPWR sky130_fd_sc_hd__fill_2
XFILLER_87_1189 VPWR VGND VPWR VGND sky130_ef_sc_hd__decap_12
XFILLER_65_1421 VPWR VGND VPWR VGND sky130_ef_sc_hd__decap_12
XFILLER_117_1500 VGND VGND VPWR VPWR sky130_fd_sc_hd__decap_6
XFILLER_215_1112 VGND VGND VPWR VPWR sky130_fd_sc_hd__decap_6
XFILLER_254_1183 VPWR VGND VPWR VGND sky130_ef_sc_hd__decap_12
XFILLER_65_1476 VPWR VGND VPWR VGND sky130_ef_sc_hd__decap_12
XFILLER_2_286 VGND VGND VPWR VPWR sky130_fd_sc_hd__fill_1
XFILLER_152_1435 VGND VGND VPWR VPWR sky130_fd_sc_hd__decap_6
XFILLER_250_1047 VGND VGND VPWR VPWR sky130_fd_sc_hd__decap_6
XFILLER_238_347 VPWR VGND VPWR VGND sky130_ef_sc_hd__decap_12
XTAP_TAPCELL_ROW_112_2_5557 VGND VPWR sky130_fd_sc_hd__tapvpwrvgnd_1
XTAP_TAPCELL_ROW_80_2_5302 VGND VPWR sky130_fd_sc_hd__tapvpwrvgnd_1
XFILLER_207_701 VPWR VGND VPWR VGND sky130_ef_sc_hd__decap_12
XFILLER_219_572 VPWR VGND VPWR VGND sky130_ef_sc_hd__decap_12
XFILLER_24_1184 VPWR VGND VPWR VGND sky130_ef_sc_hd__decap_12
XTAP_TAPCELL_ROW_48_2_5043 VGND VPWR sky130_fd_sc_hd__tapvpwrvgnd_1
XFILLER_98_1263 VGND VGND VPWR VPWR sky130_fd_sc_hd__decap_6
XFILLER_111_1165 VPWR VGND VPWR VGND sky130_ef_sc_hd__decap_12
XFILLER_234_531 VGND VGND VPWR VPWR sky130_fd_sc_hd__decap_6
XFILLER_207_756 VPWR VGND VPWR VGND sky130_ef_sc_hd__decap_12
XPHY_EDGE_ROW_55_2_Left_557 VGND VGND VPWR VPWR sky130_fd_sc_hd__decap_3
XFILLER_146_1239 VPWR VGND VPWR VGND sky130_ef_sc_hd__decap_12
XFILLER_181_1119 VPWR VGND VPWR VGND sky130_ef_sc_hd__decap_12
XFILLER_203_940 VGND VGND VPWR VPWR sky130_fd_sc_hd__decap_6
XTAP_TAPCELL_ROW_15_2_4784 VGND VPWR sky130_fd_sc_hd__tapvpwrvgnd_1
X_409_ net203 net132 net205 VGND VGND VPWR VPWR _198_ sky130_fd_sc_hd__a21oi_1
XTAP_TAPCELL_ROW_190_2400 VGND VPWR sky130_fd_sc_hd__tapvpwrvgnd_1
XFILLER_186_151 VPWR VGND VPWR VGND sky130_ef_sc_hd__decap_12
XTAP_TAPCELL_ROW_190_2411 VGND VPWR sky130_fd_sc_hd__tapvpwrvgnd_1
XTAP_TAPCELL_ROW_190_2422 VGND VPWR sky130_fd_sc_hd__tapvpwrvgnd_1
XTAP_TAPCELL_ROW_250_4499 VGND VPWR sky130_fd_sc_hd__tapvpwrvgnd_1
XFILLER_174_335 VPWR VGND VPWR VGND sky130_ef_sc_hd__decap_12
XFILLER_179_1026 VGND VGND VPWR VPWR sky130_fd_sc_hd__decap_6
XFILLER_31_1177 VPWR VGND VPWR VGND sky130_ef_sc_hd__decap_12
XFILLER_122_1294 VPWR VGND VPWR VGND sky130_ef_sc_hd__decap_12
XFILLER_190_839 VPWR VGND VPWR VGND sky130_ef_sc_hd__decap_12
XFILLER_157_1335 VPWR VGND VPWR VGND sky130_ef_sc_hd__decap_12
XFILLER_182_390 VPWR VGND VPWR VGND sky130_ef_sc_hd__decap_12
XFILLER_192_1226 VPWR VGND VPWR VGND sky130_ef_sc_hd__decap_12
XFILLER_227_68 VPWR VGND VPWR VGND sky130_ef_sc_hd__decap_12
XTAP_TAPCELL_ROW_188_2340 VGND VPWR sky130_fd_sc_hd__tapvpwrvgnd_1
XTAP_TAPCELL_ROW_188_2351 VGND VPWR sky130_fd_sc_hd__tapvpwrvgnd_1
XFILLER_170_574 VGND VGND VPWR VPWR sky130_fd_sc_hd__decap_6
XTAP_TAPCELL_ROW_184_2204 VGND VPWR sky130_fd_sc_hd__tapvpwrvgnd_1
XFILLER_237_1370 VGND VGND VPWR VPWR sky130_fd_sc_hd__decap_6
XPHY_EDGE_ROW_69_1_Left_324 VGND VGND VPWR VPWR sky130_fd_sc_hd__decap_3
XFILLER_9_1156 VPWR VGND VPWR VGND sky130_ef_sc_hd__decap_12
XFILLER_229_314 VPWR VGND VPWR VGND sky130_ef_sc_hd__decap_12
XFILLER_243_56 VPWR VGND VPWR VGND sky130_ef_sc_hd__decap_12
XFILLER_9_1189 VGND VGND VPWR VPWR sky130_fd_sc_hd__decap_8
XPHY_EDGE_ROW_121_1_Left_376 VGND VGND VPWR VPWR sky130_fd_sc_hd__decap_3
XFILLER_245_818 VPWR VGND VPWR VGND sky130_ef_sc_hd__decap_12
XFILLER_229_369 VPWR VGND VPWR VGND sky130_ef_sc_hd__decap_12
XFILLER_42_1251 VPWR VGND VPWR VGND sky130_ef_sc_hd__decap_12
XFILLER_133_1390 VPWR VGND VPWR VGND sky130_ef_sc_hd__decap_12
XFILLER_168_1453 VPWR VGND VPWR VGND sky130_ef_sc_hd__decap_12
XFILLER_225_553 VGND VGND VPWR VPWR sky130_fd_sc_hd__decap_6
XFILLER_253_873 VPWR VGND VPWR VGND sky130_ef_sc_hd__decap_12
XFILLER_77_1347 VPWR VGND VPWR VGND sky130_ef_sc_hd__decap_12
XFILLER_198_906 VPWR VGND VPWR VGND sky130_ef_sc_hd__decap_12
XFILLER_164_1306 VGND VGND VPWR VPWR sky130_fd_sc_hd__decap_6
XFILLER_205_1303 VPWR VGND VPWR VGND sky130_ef_sc_hd__decap_12
XFILLER_200_409 VPWR VGND VPWR VGND sky130_ef_sc_hd__decap_12
XFILLER_240_1238 VPWR VGND VPWR VGND sky130_ef_sc_hd__decap_12
XFILLER_205_1358 VPWR VGND VPWR VGND sky130_ef_sc_hd__decap_12
XFILLER_220_280 VPWR VGND VPWR VGND sky130_ef_sc_hd__decap_12
XFILLER_177_173 VPWR VGND VPWR VGND sky130_ef_sc_hd__decap_12
XTAP_TAPCELL_ROW_136_2_5753 VGND VPWR sky130_fd_sc_hd__tapvpwrvgnd_1
XFILLER_192_132 VPWR VGND VPWR VGND sky130_ef_sc_hd__decap_12
XFILLER_165_379 VPWR VGND VPWR VGND sky130_ef_sc_hd__decap_12
XFILLER_180_316 VGND VGND VPWR VPWR sky130_fd_sc_hd__decap_6
XFILLER_21_68 VGND VGND VPWR VPWR sky130_fd_sc_hd__decap_3
XFILLER_88_1454 VPWR VGND VPWR VGND sky130_ef_sc_hd__decap_12
XFILLER_10_1239 VPWR VGND VPWR VGND sky130_ef_sc_hd__decap_12
XPHY_EDGE_ROW_77_1_Right_733 VGND VGND VPWR VPWR sky130_fd_sc_hd__decap_3
XFILLER_192_187 VGND VGND VPWR VPWR sky130_fd_sc_hd__decap_6
XFILLER_175_1413 VGND VGND VPWR VPWR sky130_fd_sc_hd__decap_6
XFILLER_101_1378 VPWR VGND VPWR VGND sky130_ef_sc_hd__decap_12
XFILLER_137_68 VGND VGND VPWR VPWR sky130_fd_sc_hd__decap_3
XFILLER_97_39 VGND VGND VPWR VPWR sky130_fd_sc_hd__decap_4
XPHY_EDGE_ROW_208_Right_53 VGND VGND VPWR VPWR sky130_fd_sc_hd__decap_3
XFILLER_216_1410 VPWR VGND VPWR VGND sky130_ef_sc_hd__decap_12
XTAP_TAPCELL_ROW_227_3701 VGND VPWR sky130_fd_sc_hd__tapvpwrvgnd_1
XTAP_TAPCELL_ROW_85_2_5339 VGND VPWR sky130_fd_sc_hd__tapvpwrvgnd_1
XTAP_TAPCELL_ROW_227_3712 VGND VPWR sky130_fd_sc_hd__tapvpwrvgnd_1
XFILLER_255_1492 VPWR VGND VPWR VGND sky130_ef_sc_hd__decap_12
XFILLER_251_1334 VPWR VGND VPWR VGND sky130_ef_sc_hd__decap_12
XTAP_TAPCELL_ROW_54_2_5097 VGND VPWR sky130_fd_sc_hd__tapvpwrvgnd_1
XFILLER_216_1465 VPWR VGND VPWR VGND sky130_ef_sc_hd__decap_12
XFILLER_0_757 VGND VGND VPWR VPWR sky130_fd_sc_hd__fill_1
XFILLER_247_111 VPWR VGND VPWR VGND sky130_ef_sc_hd__decap_12
XFILLER_153_56 VPWR VGND VPWR VGND sky130_ef_sc_hd__decap_12
XFILLER_134_1165 VPWR VGND VPWR VGND sky130_ef_sc_hd__decap_12
XFILLER_251_1389 VPWR VGND VPWR VGND sky130_ef_sc_hd__decap_12
XFILLER_248_667 VPWR VGND VPWR VGND sky130_ef_sc_hd__decap_12
XFILLER_247_166 VGND VGND VPWR VPWR sky130_fd_sc_hd__decap_6
XFILLER_169_1217 VPWR VGND VPWR VGND sky130_ef_sc_hd__decap_12
XFILLER_21_1335 VPWR VGND VPWR VGND sky130_ef_sc_hd__decap_12
XTAP_TAPCELL_ROW_165_1480 VGND VPWR sky130_fd_sc_hd__tapvpwrvgnd_1
XFILLER_216_531 VGND VGND VPWR VPWR sky130_fd_sc_hd__decap_6
XFILLER_249_1241 VGND VGND VPWR VPWR sky130_fd_sc_hd__decap_6
XFILLER_46_65 VGND VGND VPWR VPWR sky130_fd_sc_hd__decap_6
XFILLER_95_1414 VGND VGND VPWR VPWR sky130_fd_sc_hd__decap_6
XTAP_TAPCELL_ROW_165_1491 VGND VPWR sky130_fd_sc_hd__tapvpwrvgnd_1
XFILLER_244_851 VPWR VGND VPWR VGND sky130_ef_sc_hd__decap_12
XFILLER_112_1485 VPWR VGND VPWR VGND sky130_ef_sc_hd__decap_12
XFILLER_210_1097 VPWR VGND VPWR VGND sky130_ef_sc_hd__decap_12
Xmax_cap77 net78 VGND VGND VPWR VPWR net77 sky130_fd_sc_hd__clkbuf_1
XPHY_EDGE_ROW_217_Right_62 VGND VGND VPWR VPWR sky130_fd_sc_hd__decap_3
XFILLER_189_928 VPWR VGND VPWR VGND sky130_ef_sc_hd__decap_12
Xmax_cap99 _242_ VGND VGND VPWR VPWR net99 sky130_fd_sc_hd__clkbuf_1
XFILLER_19_1242 VGND VGND VPWR VPWR sky130_fd_sc_hd__decap_6
XFILLER_145_1261 VPWR VGND VPWR VGND sky130_ef_sc_hd__decap_12
XFILLER_180_1152 VPWR VGND VPWR VGND sky130_ef_sc_hd__decap_12
XFILLER_197_983 VGND VGND VPWR VPWR sky130_fd_sc_hd__decap_6
XFILLER_168_151 VPWR VGND VPWR VGND sky130_ef_sc_hd__decap_12
XFILLER_54_1177 VGND VGND VPWR VPWR sky130_fd_sc_hd__decap_6
Xwire221 net222 VGND VGND VPWR VPWR net221 sky130_fd_sc_hd__clkbuf_1
Xwire232 net233 VGND VGND VPWR VPWR net232 sky130_fd_sc_hd__clkbuf_1
XFILLER_89_1218 VPWR VGND VPWR VGND sky130_ef_sc_hd__decap_12
XFILLER_32_1442 VPWR VGND VPWR VGND sky130_ef_sc_hd__decap_12
Xwire243 net244 VGND VGND VPWR VPWR net243 sky130_fd_sc_hd__clkbuf_1
Xwire254 net255 VGND VGND VPWR VPWR net254 sky130_fd_sc_hd__clkbuf_1
XFILLER_7_345 VGND VGND VPWR VPWR sky130_fd_sc_hd__fill_2
XFILLER_183_154 VPWR VGND VPWR VGND sky130_ef_sc_hd__decap_12
Xwire265 net266 VGND VGND VPWR VPWR net265 sky130_fd_sc_hd__clkbuf_1
XPHY_EDGE_ROW_13_2_Right_104 VGND VGND VPWR VPWR sky130_fd_sc_hd__decap_3
Xwire276 net277 VGND VGND VPWR VPWR net276 sky130_fd_sc_hd__clkbuf_1
XFILLER_172_839 VPWR VGND VPWR VGND sky130_ef_sc_hd__decap_12
Xwire287 net288 VGND VGND VPWR VPWR net287 sky130_fd_sc_hd__clkbuf_1
XFILLER_32_1497 VPWR VGND VPWR VGND sky130_ef_sc_hd__decap_12
Xwire298 net299 VGND VGND VPWR VPWR net298 sky130_fd_sc_hd__clkbuf_1
XFILLER_171_338 VGND VGND VPWR VPWR sky130_fd_sc_hd__decap_6
XPHY_EDGE_ROW_226_Right_71 VGND VGND VPWR VPWR sky130_fd_sc_hd__decap_3
XFILLER_252_1109 VPWR VGND VPWR VGND sky130_ef_sc_hd__decap_12
XTAP_TAPCELL_ROW_121_1_1411 VGND VPWR sky130_fd_sc_hd__tapvpwrvgnd_1
XFILLER_217_1229 VPWR VGND VPWR VGND sky130_ef_sc_hd__decap_12
XFILLER_180_894 VPWR VGND VPWR VGND sky130_ef_sc_hd__decap_12
XFILLER_65_1273 VPWR VGND VPWR VGND sky130_ef_sc_hd__decap_12
XTAP_TAPCELL_ROW_243_4270 VGND VPWR sky130_fd_sc_hd__tapvpwrvgnd_1
XFILLER_238_144 VGND VGND VPWR VPWR sky130_fd_sc_hd__decap_6
XFILLER_213_15 VPWR VGND VPWR VGND sky130_ef_sc_hd__decap_12
XFILLER_227_818 VPWR VGND VPWR VGND sky130_ef_sc_hd__decap_12
XFILLER_239_689 VPWR VGND VPWR VGND sky130_ef_sc_hd__decap_12
XFILLER_113_1249 VPWR VGND VPWR VGND sky130_ef_sc_hd__decap_12
XFILLER_254_648 VPWR VGND VPWR VGND sky130_ef_sc_hd__decap_12
XPHY_EDGE_ROW_235_Right_80 VGND VGND VPWR VPWR sky130_fd_sc_hd__decap_3
XFILLER_207_553 VGND VGND VPWR VPWR sky130_fd_sc_hd__decap_6
XFILLER_4_1097 VPWR VGND VPWR VGND sky130_ef_sc_hd__decap_12
XFILLER_235_873 VPWR VGND VPWR VGND sky130_ef_sc_hd__decap_12
XTAP_TAPCELL_ROW_204_2885 VGND VPWR sky130_fd_sc_hd__tapvpwrvgnd_1
XFILLER_74_1509 VGND VGND VPWR VPWR sky130_fd_sc_hd__decap_6
XFILLER_228_1336 VPWR VGND VPWR VGND sky130_ef_sc_hd__decap_12
XFILLER_250_832 VGND VGND VPWR VPWR sky130_fd_sc_hd__decap_6
XTAP_TAPCELL_ROW_142_2_5796 VGND VPWR sky130_fd_sc_hd__tapvpwrvgnd_1
XTAP_TAPCELL_ROW_196_2620 VGND VPWR sky130_fd_sc_hd__tapvpwrvgnd_1
XTAP_TAPCELL_ROW_204_2896 VGND VPWR sky130_fd_sc_hd__tapvpwrvgnd_1
XTAP_TAPCELL_ROW_237_4041 VGND VPWR sky130_fd_sc_hd__tapvpwrvgnd_1
XTAP_TAPCELL_ROW_196_2631 VGND VPWR sky130_fd_sc_hd__tapvpwrvgnd_1
XTAP_TAPCELL_ROW_237_4052 VGND VPWR sky130_fd_sc_hd__tapvpwrvgnd_1
XTAP_TAPCELL_ROW_200_2749 VGND VPWR sky130_fd_sc_hd__tapvpwrvgnd_1
XTAP_TAPCELL_ROW_237_4063 VGND VPWR sky130_fd_sc_hd__tapvpwrvgnd_1
XFILLER_76_1380 VPWR VGND VPWR VGND sky130_ef_sc_hd__decap_12
XTAP_TAPCELL_ROW_78_2_5282 VGND VPWR sky130_fd_sc_hd__tapvpwrvgnd_1
XFILLER_241_1514 VGND VGND VPWR VPWR sky130_fd_sc_hd__fill_1
XFILLER_188_961 VGND VGND VPWR VPWR sky130_fd_sc_hd__decap_6
XFILLER_33_1206 VPWR VGND VPWR VGND sky130_ef_sc_hd__decap_12
XFILLER_202_280 VPWR VGND VPWR VGND sky130_ef_sc_hd__decap_12
XFILLER_124_1356 VPWR VGND VPWR VGND sky130_ef_sc_hd__decap_12
XFILLER_174_132 VPWR VGND VPWR VGND sky130_ef_sc_hd__decap_12
XFILLER_238_34 VPWR VGND VPWR VGND sky130_ef_sc_hd__decap_12
Xinput40 wr_data[8] VGND VGND VPWR VPWR net40 sky130_fd_sc_hd__clkbuf_1
XFILLER_204_1391 VGND VGND VPWR VPWR sky130_fd_sc_hd__decap_6
Xmax_cap510 _096_ VGND VGND VPWR VPWR net510 sky130_fd_sc_hd__clkbuf_1
XFILLER_174_187 VGND VGND VPWR VPWR sky130_fd_sc_hd__decap_6
XFILLER_190_636 VPWR VGND VPWR VGND sky130_ef_sc_hd__decap_12
XFILLER_238_89 VPWR VGND VPWR VGND sky130_ef_sc_hd__decap_12
XFILLER_239_1432 VPWR VGND VPWR VGND sky130_ef_sc_hd__decap_12
Xmax_cap521 net522 VGND VGND VPWR VPWR net521 sky130_fd_sc_hd__clkbuf_1
Xmax_cap532 net59 VGND VGND VPWR VPWR net532 sky130_fd_sc_hd__clkbuf_1
Xmax_cap554 net72 VGND VGND VPWR VPWR net554 sky130_fd_sc_hd__buf_1
XFILLER_171_861 VPWR VGND VPWR VGND sky130_ef_sc_hd__decap_12
XFILLER_192_1023 VPWR VGND VPWR VGND sky130_ef_sc_hd__decap_12
XFILLER_254_22 VPWR VGND VPWR VGND sky130_ef_sc_hd__decap_12
XFILLER_239_1487 VPWR VGND VPWR VGND sky130_ef_sc_hd__decap_12
XFILLER_107_27 VPWR VGND VPWR VGND sky130_ef_sc_hd__decap_12
XFILLER_157_1165 VPWR VGND VPWR VGND sky130_ef_sc_hd__decap_12
XFILLER_192_1078 VPWR VGND VPWR VGND sky130_ef_sc_hd__decap_12
XFILLER_254_77 VPWR VGND VPWR VGND sky130_ef_sc_hd__decap_12
XFILLER_44_1313 VPWR VGND VPWR VGND sky130_ef_sc_hd__decap_12
XFILLER_229_111 VPWR VGND VPWR VGND sky130_ef_sc_hd__decap_12
XFILLER_44_1368 VPWR VGND VPWR VGND sky130_ef_sc_hd__decap_12
XFILLER_131_1316 VPWR VGND VPWR VGND sky130_ef_sc_hd__decap_12
XFILLER_123_15 VPWR VGND VPWR VGND sky130_ef_sc_hd__decap_12
XFILLER_245_615 VPWR VGND VPWR VGND sky130_ef_sc_hd__decap_12
XFILLER_229_166 VGND VGND VPWR VPWR sky130_fd_sc_hd__decap_6
XFILLER_170_1398 VPWR VGND VPWR VGND sky130_ef_sc_hd__decap_12
XFILLER_226_851 VPWR VGND VPWR VGND sky130_ef_sc_hd__decap_12
XFILLER_129_1201 VGND VGND VPWR VPWR sky130_fd_sc_hd__decap_4
XFILLER_168_1250 VPWR VGND VPWR VGND sky130_ef_sc_hd__decap_12
XFILLER_253_670 VPWR VGND VPWR VGND sky130_ef_sc_hd__decap_12
XFILLER_198_703 VGND VGND VPWR VPWR sky130_fd_sc_hd__decap_6
XTAP_TAPCELL_ROW_51_1_1306 VGND VPWR sky130_fd_sc_hd__tapvpwrvgnd_1
XFILLER_16_46 VPWR VGND VPWR VGND sky130_ef_sc_hd__decap_12
XFILLER_0_1462 VGND VGND VPWR VPWR sky130_fd_sc_hd__decap_8
XFILLER_77_1177 VPWR VGND VPWR VGND sky130_ef_sc_hd__decap_12
XFILLER_241_854 VGND VGND VPWR VPWR sky130_fd_sc_hd__decap_6
XFILLER_205_1100 VPWR VGND VPWR VGND sky130_ef_sc_hd__decap_12
XFILLER_200_206 VPWR VGND VPWR VGND sky130_ef_sc_hd__decap_12
XFILLER_55_1464 VPWR VGND VPWR VGND sky130_ef_sc_hd__decap_12
XFILLER_209_1291 VPWR VGND VPWR VGND sky130_ef_sc_hd__decap_12
XFILLER_142_1423 VPWR VGND VPWR VGND sky130_ef_sc_hd__decap_12
XFILLER_179_983 VGND VGND VPWR VPWR sky130_fd_sc_hd__decap_6
XFILLER_240_1035 VPWR VGND VPWR VGND sky130_ef_sc_hd__decap_12
XFILLER_205_1155 VGND VGND VPWR VPWR sky130_fd_sc_hd__decap_6
XFILLER_51_1328 VGND VGND VPWR VPWR sky130_fd_sc_hd__decap_6
XFILLER_32_34 VPWR VGND VPWR VGND sky130_ef_sc_hd__decap_12
XFILLER_90_1399 VPWR VGND VPWR VGND sky130_ef_sc_hd__decap_12
XFILLER_142_1478 VGND VGND VPWR VPWR sky130_fd_sc_hd__decap_6
XFILLER_148_34 VPWR VGND VPWR VGND sky130_ef_sc_hd__decap_12
XPHY_EDGE_ROW_140_2_Right_231 VGND VGND VPWR VPWR sky130_fd_sc_hd__decap_3
XFILLER_181_603 VPWR VGND VPWR VGND sky130_ef_sc_hd__decap_12
XFILLER_5_816 VGND VGND VPWR VPWR sky130_fd_sc_hd__fill_1
XFILLER_193_474 VPWR VGND VPWR VGND sky130_ef_sc_hd__decap_12
XFILLER_88_1251 VPWR VGND VPWR VGND sky130_ef_sc_hd__decap_12
XFILLER_181_658 VPWR VGND VPWR VGND sky130_ef_sc_hd__decap_12
XFILLER_106_3 VPWR VGND VPWR VGND sky130_ef_sc_hd__decap_12
XPHY_EDGE_ROW_78_1_Right_734 VGND VGND VPWR VPWR sky130_fd_sc_hd__decap_3
XFILLER_164_22 VPWR VGND VPWR VGND sky130_ef_sc_hd__decap_12
XTAP_TAPCELL_ROW_210_3089 VGND VPWR sky130_fd_sc_hd__tapvpwrvgnd_1
XFILLER_27_1500 VGND VGND VPWR VPWR sky130_fd_sc_hd__decap_6
XFILLER_136_1227 VPWR VGND VPWR VGND sky130_ef_sc_hd__decap_12
XFILLER_251_1131 VPWR VGND VPWR VGND sky130_ef_sc_hd__decap_12
XFILLER_62_1435 VGND VGND VPWR VPWR sky130_fd_sc_hd__decap_6
XFILLER_216_1262 VGND VGND VPWR VPWR sky130_fd_sc_hd__decap_6
XFILLER_209_818 VPWR VGND VPWR VGND sky130_ef_sc_hd__decap_12
XFILLER_251_1186 VPWR VGND VPWR VGND sky130_ef_sc_hd__decap_12
XFILLER_248_464 VPWR VGND VPWR VGND sky130_ef_sc_hd__decap_12
XTAP_TAPCELL_ROW_167_1586 VGND VPWR sky130_fd_sc_hd__tapvpwrvgnd_1
XTAP_TAPCELL_ROW_167_1597 VGND VPWR sky130_fd_sc_hd__tapvpwrvgnd_1
XFILLER_169_1014 VPWR VGND VPWR VGND sky130_ef_sc_hd__decap_12
XFILLER_180_65 VPWR VGND VPWR VGND sky130_ef_sc_hd__decap_12
XFILLER_236_648 VPWR VGND VPWR VGND sky130_ef_sc_hd__decap_12
XTAP_TAPCELL_ROW_158_2_5929 VGND VPWR sky130_fd_sc_hd__tapvpwrvgnd_1
XTAP_TAPCELL_ROW_127_2_5676 VGND VPWR sky130_fd_sc_hd__tapvpwrvgnd_1
XFILLER_21_1165 VPWR VGND VPWR VGND sky130_ef_sc_hd__decap_12
XTAP_TAPCELL_ROW_95_2_5421 VGND VPWR sky130_fd_sc_hd__tapvpwrvgnd_1
XFILLER_112_1282 VPWR VGND VPWR VGND sky130_ef_sc_hd__decap_12
XFILLER_169_1069 VGND VGND VPWR VPWR sky130_fd_sc_hd__decap_6
XFILLER_217_873 VPWR VGND VPWR VGND sky130_ef_sc_hd__decap_12
XFILLER_1_1248 VPWR VGND VPWR VGND sky130_ef_sc_hd__decap_12
XFILLER_189_725 VGND VGND VPWR VPWR sky130_fd_sc_hd__decap_6
XFILLER_232_832 VGND VGND VPWR VPWR sky130_fd_sc_hd__decap_6
XFILLER_56_1239 VPWR VGND VPWR VGND sky130_ef_sc_hd__decap_12
XFILLER_147_1378 VPWR VGND VPWR VGND sky130_ef_sc_hd__decap_12
XFILLER_182_1269 VPWR VGND VPWR VGND sky130_ef_sc_hd__decap_12
XTAP_TAPCELL_ROW_251_4550 VGND VPWR sky130_fd_sc_hd__tapvpwrvgnd_1
XTAP_TAPCELL_ROW_120_2_5619 VGND VPWR sky130_fd_sc_hd__tapvpwrvgnd_1
XFILLER_121_1507 VGND VGND VPWR VPWR sky130_fd_sc_hd__decap_8
XFILLER_184_452 VPWR VGND VPWR VGND sky130_ef_sc_hd__decap_12
XFILLER_7_142 VGND VGND VPWR VPWR sky130_fd_sc_hd__decap_6
XFILLER_172_636 VPWR VGND VPWR VGND sky130_ef_sc_hd__decap_12
XFILLER_208_15 VGND VGND VPWR VPWR sky130_fd_sc_hd__decap_6
XFILLER_32_1294 VPWR VGND VPWR VGND sky130_ef_sc_hd__decap_12
XPHY_EDGE_ROW_14_2_Right_105 VGND VGND VPWR VPWR sky130_fd_sc_hd__decap_3
XFILLER_67_1335 VPWR VGND VPWR VGND sky130_ef_sc_hd__decap_12
XTAP_TAPCELL_ROW_245_4321 VGND VPWR sky130_fd_sc_hd__tapvpwrvgnd_1
XFILLER_119_1414 VGND VGND VPWR VPWR sky130_fd_sc_hd__decap_6
XTAP_TAPCELL_ROW_245_4332 VGND VPWR sky130_fd_sc_hd__tapvpwrvgnd_1
XTAP_TAPCELL_ROW_23_2_4846 VGND VPWR sky130_fd_sc_hd__tapvpwrvgnd_1
XTAP_TAPCELL_ROW_245_4343 VGND VPWR sky130_fd_sc_hd__tapvpwrvgnd_1
XFILLER_4_882 VPWR VGND VPWR VGND sky130_ef_sc_hd__decap_12
XFILLER_158_1485 VPWR VGND VPWR VGND sky130_ef_sc_hd__decap_12
XFILLER_217_1026 VGND VGND VPWR VPWR sky130_fd_sc_hd__decap_6
XFILLER_180_691 VPWR VGND VPWR VGND sky130_ef_sc_hd__decap_12
XTAP_TAPCELL_ROW_241_4207 VGND VPWR sky130_fd_sc_hd__tapvpwrvgnd_1
XFILLER_154_1349 VGND VGND VPWR VPWR sky130_fd_sc_hd__decap_6
XFILLER_239_431 VPWR VGND VPWR VGND sky130_ef_sc_hd__decap_12
XFILLER_21_3 VPWR VGND VPWR VGND sky130_ef_sc_hd__decap_12
XFILLER_224_58 VGND VGND VPWR VPWR sky130_fd_sc_hd__decap_6
XFILLER_230_1226 VPWR VGND VPWR VGND sky130_ef_sc_hd__decap_12
XTAP_TAPCELL_ROW_7_1110 VGND VPWR sky130_fd_sc_hd__tapvpwrvgnd_1
XTAP_TAPCELL_ROW_7_1121 VGND VPWR sky130_fd_sc_hd__tapvpwrvgnd_1
XFILLER_227_615 VPWR VGND VPWR VGND sky130_ef_sc_hd__decap_12
XTAP_TAPCELL_ROW_7_1132 VGND VPWR sky130_fd_sc_hd__tapvpwrvgnd_1
XFILLER_239_486 VPWR VGND VPWR VGND sky130_ef_sc_hd__decap_12
XFILLER_255_946 VPWR VGND VPWR VGND sky130_ef_sc_hd__decap_12
XFILLER_254_445 VGND VGND VPWR VPWR sky130_fd_sc_hd__decap_6
XFILLER_43_1390 VPWR VGND VPWR VGND sky130_ef_sc_hd__decap_12
XTAP_TAPCELL_ROW_206_2958 VGND VPWR sky130_fd_sc_hd__tapvpwrvgnd_1
XFILLER_255_979 VGND VGND VPWR VPWR sky130_fd_sc_hd__decap_8
XPHY_EDGE_ROW_40_1_Right_696 VGND VGND VPWR VPWR sky130_fd_sc_hd__decap_3
XTAP_TAPCELL_ROW_206_2969 VGND VPWR sky130_fd_sc_hd__tapvpwrvgnd_1
XTAP_TAPCELL_ROW_239_4114 VGND VPWR sky130_fd_sc_hd__tapvpwrvgnd_1
XFILLER_208_851 VPWR VGND VPWR VGND sky130_ef_sc_hd__decap_12
XTAP_TAPCELL_ROW_239_4125 VGND VPWR sky130_fd_sc_hd__tapvpwrvgnd_1
XTAP_TAPCELL_ROW_239_4136 VGND VPWR sky130_fd_sc_hd__tapvpwrvgnd_1
XFILLER_78_1442 VPWR VGND VPWR VGND sky130_ef_sc_hd__decap_12
XFILLER_240_46 VPWR VGND VPWR VGND sky130_ef_sc_hd__decap_12
XFILLER_235_670 VPWR VGND VPWR VGND sky130_ef_sc_hd__decap_12
XFILLER_74_1306 VGND VGND VPWR VPWR sky130_fd_sc_hd__decap_6
XFILLER_228_1133 VGND VGND VPWR VPWR sky130_fd_sc_hd__decap_6
XFILLER_78_1497 VPWR VGND VPWR VGND sky130_ef_sc_hd__decap_12
XFILLER_223_854 VGND VGND VPWR VPWR sky130_fd_sc_hd__decap_6
XFILLER_206_1453 VPWR VGND VPWR VGND sky130_ef_sc_hd__decap_12
XFILLER_249_44 VPWR VGND VPWR VGND sky130_ef_sc_hd__decap_12
XFILLER_194_249 VPWR VGND VPWR VGND sky130_ef_sc_hd__decap_12
XFILLER_241_1377 VPWR VGND VPWR VGND sky130_ef_sc_hd__decap_12
XFILLER_249_99 VPWR VGND VPWR VGND sky130_ef_sc_hd__decap_12
XFILLER_175_474 VPWR VGND VPWR VGND sky130_ef_sc_hd__decap_12
XFILLER_118_15 VGND VGND VPWR VPWR sky130_fd_sc_hd__decap_6
XFILLER_85_1402 VPWR VGND VPWR VGND sky130_ef_sc_hd__decap_12
XFILLER_190_433 VPWR VGND VPWR VGND sky130_ef_sc_hd__decap_12
XFILLER_159_1249 VPWR VGND VPWR VGND sky130_ef_sc_hd__decap_12
XFILLER_11_1378 VPWR VGND VPWR VGND sky130_ef_sc_hd__decap_12
XFILLER_239_1284 VGND VGND VPWR VPWR sky130_fd_sc_hd__decap_6
XFILLER_190_488 VGND VGND VPWR VPWR sky130_fd_sc_hd__decap_6
XFILLER_85_1457 VGND VGND VPWR VPWR sky130_fd_sc_hd__decap_6
XPHY_EDGE_ROW_132_2_Left_634 VGND VGND VPWR VPWR sky130_fd_sc_hd__decap_3
XFILLER_249_228 VPWR VGND VPWR VGND sky130_ef_sc_hd__decap_12
XFILLER_213_1413 VGND VGND VPWR VPWR sky130_fd_sc_hd__decap_6
XFILLER_170_1140 VPWR VGND VPWR VGND sky130_ef_sc_hd__decap_12
XFILLER_252_1484 VPWR VGND VPWR VGND sky130_ef_sc_hd__decap_12
XFILLER_134_58 VGND VGND VPWR VPWR sky130_fd_sc_hd__decap_6
XTAP_TAPCELL_ROW_144_2_5815 VGND VPWR sky130_fd_sc_hd__tapvpwrvgnd_1
XFILLER_44_1165 VPWR VGND VPWR VGND sky130_ef_sc_hd__decap_12
XTAP_TAPCELL_ROW_113_2_5562 VGND VPWR sky130_fd_sc_hd__tapvpwrvgnd_1
XFILLER_245_412 VPWR VGND VPWR VGND sky130_ef_sc_hd__decap_12
XFILLER_79_1206 VPWR VGND VPWR VGND sky130_ef_sc_hd__decap_12
XFILLER_170_1195 VPWR VGND VPWR VGND sky130_ef_sc_hd__decap_12
XFILLER_218_648 VPWR VGND VPWR VGND sky130_ef_sc_hd__decap_12
XFILLER_246_968 VPWR VGND VPWR VGND sky130_ef_sc_hd__decap_12
XFILLER_245_467 VGND VGND VPWR VPWR sky130_fd_sc_hd__decap_6
XFILLER_27_56 VGND VGND VPWR VPWR sky130_fd_sc_hd__decap_3
XTAP_TAPCELL_ROW_69_1_1333 VGND VPWR sky130_fd_sc_hd__tapvpwrvgnd_1
XFILLER_22_1485 VPWR VGND VPWR VGND sky130_ef_sc_hd__decap_12
XFILLER_150_46 VPWR VGND VPWR VGND sky130_ef_sc_hd__decap_12
XFILLER_214_832 VGND VGND VPWR VPWR sky130_fd_sc_hd__decap_6
XTAP_TAPCELL_ROW_1_896 VGND VPWR sky130_fd_sc_hd__tapvpwrvgnd_1
XTAP_TAPCELL_ROW_62_2_5159 VGND VPWR sky130_fd_sc_hd__tapvpwrvgnd_1
X_390_ net591 net584 net70 VGND VGND VPWR VPWR _179_ sky130_fd_sc_hd__a21oi_1
XFILLER_207_1217 VPWR VGND VPWR VGND sky130_ef_sc_hd__decap_12
XFILLER_43_44 VGND VGND VPWR VPWR sky130_fd_sc_hd__fill_2
XFILLER_55_1261 VPWR VGND VPWR VGND sky130_ef_sc_hd__decap_12
XFILLER_185_216 VPWR VGND VPWR VGND sky130_ef_sc_hd__decap_12
XFILLER_142_1220 VGND VGND VPWR VPWR sky130_fd_sc_hd__decap_6
XFILLER_159_44 VPWR VGND VPWR VGND sky130_ef_sc_hd__decap_12
XFILLER_240_194 VPWR VGND VPWR VGND sky130_ef_sc_hd__decap_12
XFILLER_181_1291 VPWR VGND VPWR VGND sky130_ef_sc_hd__decap_12
XFILLER_223_3 VPWR VGND VPWR VGND sky130_ef_sc_hd__decap_12
XFILLER_90_1196 VPWR VGND VPWR VGND sky130_ef_sc_hd__decap_12
XFILLER_166_452 VPWR VGND VPWR VGND sky130_ef_sc_hd__decap_12
XTAP_TAPCELL_ROW_175_1866 VGND VPWR sky130_fd_sc_hd__tapvpwrvgnd_1
XPHY_EDGE_ROW_146_1_Left_401 VGND VGND VPWR VPWR sky130_fd_sc_hd__decap_3
XTAP_TAPCELL_ROW_175_1877 VGND VPWR sky130_fd_sc_hd__tapvpwrvgnd_1
XFILLER_181_400 VPWR VGND VPWR VGND sky130_ef_sc_hd__decap_12
XTAP_TAPCELL_ROW_175_1888 VGND VPWR sky130_fd_sc_hd__tapvpwrvgnd_1
XFILLER_193_271 VPWR VGND VPWR VGND sky130_ef_sc_hd__decap_12
XPHY_EDGE_ROW_141_2_Right_232 VGND VGND VPWR VPWR sky130_fd_sc_hd__decap_3
XFILLER_177_1327 VGND VGND VPWR VPWR sky130_fd_sc_hd__decap_6
XFILLER_181_455 VPWR VGND VPWR VGND sky130_ef_sc_hd__decap_12
XFILLER_218_1324 VPWR VGND VPWR VGND sky130_ef_sc_hd__decap_12
XPHY_EDGE_ROW_64_2_Left_566 VGND VGND VPWR VPWR sky130_fd_sc_hd__decap_3
XFILLER_175_87 VPWR VGND VPWR VGND sky130_ef_sc_hd__decap_12
XPHY_EDGE_ROW_79_1_Right_735 VGND VGND VPWR VPWR sky130_fd_sc_hd__decap_3
XFILLER_253_1248 VPWR VGND VPWR VGND sky130_ef_sc_hd__decap_12
XFILLER_218_1379 VPWR VGND VPWR VGND sky130_ef_sc_hd__decap_12
XFILLER_7_1413 VGND VGND VPWR VPWR sky130_fd_sc_hd__decap_6
XTAP_TAPCELL_ROW_169_1659 VGND VPWR sky130_fd_sc_hd__tapvpwrvgnd_1
XFILLER_153_1371 VGND VGND VPWR VPWR sky130_fd_sc_hd__decap_6
XFILLER_248_261 VPWR VGND VPWR VGND sky130_ef_sc_hd__decap_12
XFILLER_209_615 VPWR VGND VPWR VGND sky130_ef_sc_hd__decap_12
XFILLER_23_1249 VPWR VGND VPWR VGND sky130_ef_sc_hd__decap_12
XFILLER_110_1208 VPWR VGND VPWR VGND sky130_ef_sc_hd__decap_12
XFILLER_188_1434 VGND VGND VPWR VPWR sky130_fd_sc_hd__decap_6
XFILLER_236_445 VGND VGND VPWR VPWR sky130_fd_sc_hd__decap_6
XFILLER_97_1328 VGND VGND VPWR VPWR sky130_fd_sc_hd__decap_6
XFILLER_114_1399 VPWR VGND VPWR VGND sky130_ef_sc_hd__decap_12
XTAP_TAPCELL_ROW_201_2800 VGND VPWR sky130_fd_sc_hd__tapvpwrvgnd_1
XFILLER_229_1420 VPWR VGND VPWR VGND sky130_ef_sc_hd__decap_12
XFILLER_252_949 VPWR VGND VPWR VGND sky130_ef_sc_hd__decap_12
XFILLER_217_670 VPWR VGND VPWR VGND sky130_ef_sc_hd__decap_12
XFILLER_245_990 VPWR VGND VPWR VGND sky130_ef_sc_hd__decap_12
X_657_ clknet_3_4__leaf_clk acc_core.adder.cla_blocks\[5\].block.sum\[3\] _065_ VGND
+ VGND VPWR VPWR net58 sky130_fd_sc_hd__dfrtp_1
XFILLER_1_1045 VPWR VGND VPWR VGND sky130_ef_sc_hd__decap_12
XTAP_TAPCELL_ROW_253_4601 VGND VPWR sky130_fd_sc_hd__tapvpwrvgnd_1
XTAP_TAPCELL_ROW_253_4612 VGND VPWR sky130_fd_sc_hd__tapvpwrvgnd_1
XTAP_TAPCELL_ROW_21_1_1261 VGND VPWR sky130_fd_sc_hd__tapvpwrvgnd_1
XFILLER_182_1011 VPWR VGND VPWR VGND sky130_ef_sc_hd__decap_12
XFILLER_205_854 VGND VGND VPWR VPWR sky130_fd_sc_hd__decap_6
XFILLER_229_1475 VPWR VGND VPWR VGND sky130_ef_sc_hd__decap_12
XTAP_TAPCELL_ROW_253_4623 VGND VPWR sky130_fd_sc_hd__tapvpwrvgnd_1
X_588_ net671 VGND VGND VPWR VPWR _070_ sky130_fd_sc_hd__inv_2
XFILLER_182_1066 VPWR VGND VPWR VGND sky130_ef_sc_hd__decap_12
XPHY_EDGE_ROW_78_1_Left_333 VGND VGND VPWR VPWR sky130_fd_sc_hd__decap_3
XFILLER_176_249 VPWR VGND VPWR VGND sky130_ef_sc_hd__decap_12
XFILLER_34_1356 VPWR VGND VPWR VGND sky130_ef_sc_hd__decap_12
XFILLER_121_1304 VPWR VGND VPWR VGND sky130_ef_sc_hd__decap_12
XFILLER_200_581 VPWR VGND VPWR VGND sky130_ef_sc_hd__decap_12
XPHY_EDGE_ROW_130_1_Left_385 VGND VGND VPWR VPWR sky130_fd_sc_hd__decap_3
XFILLER_121_1359 VPWR VGND VPWR VGND sky130_ef_sc_hd__decap_12
XFILLER_69_3 VPWR VGND VPWR VGND sky130_ef_sc_hd__decap_12
XTAP_TAPCELL_ROW_247_4405 VGND VPWR sky130_fd_sc_hd__tapvpwrvgnd_1
XFILLER_172_433 VPWR VGND VPWR VGND sky130_ef_sc_hd__decap_12
XTAP_TAPCELL_ROW_247_4416 VGND VPWR sky130_fd_sc_hd__tapvpwrvgnd_1
XTAP_TAPCELL_ROW_150_2_5858 VGND VPWR sky130_fd_sc_hd__tapvpwrvgnd_1
XFILLER_172_488 VGND VGND VPWR VPWR sky130_fd_sc_hd__decap_6
XPHY_EDGE_ROW_15_2_Right_106 VGND VGND VPWR VPWR sky130_fd_sc_hd__decap_3
XFILLER_67_1165 VPWR VGND VPWR VGND sky130_ef_sc_hd__decap_12
XFILLER_193_1162 VPWR VGND VPWR VGND sky130_ef_sc_hd__decap_12
XFILLER_158_1282 VPWR VGND VPWR VGND sky130_ef_sc_hd__decap_12
XTAP_TAPCELL_ROW_130_2_5701 VGND VPWR sky130_fd_sc_hd__tapvpwrvgnd_1
XFILLER_235_68 VPWR VGND VPWR VGND sky130_ef_sc_hd__decap_12
XTAP_TAPCELL_ROW_9_1205 VGND VPWR sky130_fd_sc_hd__tapvpwrvgnd_1
XTAP_TAPCELL_ROW_9_1216 VGND VPWR sky130_fd_sc_hd__tapvpwrvgnd_1
XTAP_TAPCELL_ROW_9_1227 VGND VPWR sky130_fd_sc_hd__tapvpwrvgnd_1
XFILLER_132_1411 VPWR VGND VPWR VGND sky130_ef_sc_hd__decap_12
XTAP_TAPCELL_ROW_9_1238 VGND VPWR sky130_fd_sc_hd__tapvpwrvgnd_1
XFILLER_41_1316 VPWR VGND VPWR VGND sky130_ef_sc_hd__decap_12
XFILLER_230_1023 VPWR VGND VPWR VGND sky130_ef_sc_hd__decap_12
XFILLER_227_412 VPWR VGND VPWR VGND sky130_ef_sc_hd__decap_12
XFILLER_239_283 VPWR VGND VPWR VGND sky130_ef_sc_hd__decap_12
XFILLER_132_1466 VPWR VGND VPWR VGND sky130_ef_sc_hd__decap_12
XFILLER_228_968 VPWR VGND VPWR VGND sky130_ef_sc_hd__decap_12
XFILLER_251_56 VPWR VGND VPWR VGND sky130_ef_sc_hd__decap_12
XFILLER_230_1078 VPWR VGND VPWR VGND sky130_ef_sc_hd__decap_12
XFILLER_243_916 VPWR VGND VPWR VGND sky130_ef_sc_hd__decap_12
XFILLER_227_467 VGND VGND VPWR VPWR sky130_fd_sc_hd__decap_6
XTAP_TAPCELL_ROW_47_2_5039 VGND VPWR sky130_fd_sc_hd__tapvpwrvgnd_1
XPHY_EDGE_ROW_41_1_Right_697 VGND VGND VPWR VPWR sky130_fd_sc_hd__decap_3
XFILLER_165_1231 VGND VGND VPWR VPWR sky130_fd_sc_hd__decap_8
XFILLER_78_1294 VPWR VGND VPWR VGND sky130_ef_sc_hd__decap_12
XFILLER_251_971 VPWR VGND VPWR VGND sky130_ef_sc_hd__decap_12
XFILLER_210_323 VPWR VGND VPWR VGND sky130_ef_sc_hd__decap_12
XFILLER_167_216 VPWR VGND VPWR VGND sky130_ef_sc_hd__decap_12
XFILLER_206_1250 VPWR VGND VPWR VGND sky130_ef_sc_hd__decap_12
XFILLER_222_194 VPWR VGND VPWR VGND sky130_ef_sc_hd__decap_12
XFILLER_52_1423 VPWR VGND VPWR VGND sky130_ef_sc_hd__decap_12
XFILLER_210_378 VPWR VGND VPWR VGND sky130_ef_sc_hd__decap_12
XFILLER_241_1174 VPWR VGND VPWR VGND sky130_ef_sc_hd__decap_12
XFILLER_52_1478 VGND VGND VPWR VPWR sky130_fd_sc_hd__decap_6
XFILLER_175_271 VPWR VGND VPWR VGND sky130_ef_sc_hd__decap_12
XFILLER_190_230 VGND VGND VPWR VPWR sky130_fd_sc_hd__decap_6
XTAP_TAPCELL_ROW_211_3140 VGND VPWR sky130_fd_sc_hd__tapvpwrvgnd_1
XTAP_TAPCELL_ROW_211_3151 VGND VPWR sky130_fd_sc_hd__tapvpwrvgnd_1
XFILLER_102_1270 VPWR VGND VPWR VGND sky130_ef_sc_hd__decap_12
XFILLER_191_775 VPWR VGND VPWR VGND sky130_ef_sc_hd__decap_12
XFILLER_209_80 VGND VGND VPWR VPWR sky130_fd_sc_hd__decap_6
XTAP_TAPCELL_ROW_230_3796 VGND VPWR sky130_fd_sc_hd__tapvpwrvgnd_1
XFILLER_89_1390 VPWR VGND VPWR VGND sky130_ef_sc_hd__decap_12
XFILLER_2_627 VGND VGND VPWR VPWR sky130_fd_sc_hd__fill_1
Xmax_cap170 net171 VGND VGND VPWR VPWR net170 sky130_fd_sc_hd__clkbuf_1
XFILLER_46_1227 VPWR VGND VPWR VGND sky130_ef_sc_hd__decap_12
Xmax_cap181 _094_ VGND VGND VPWR VPWR net181 sky130_fd_sc_hd__clkbuf_1
Xmax_cap192 net193 VGND VGND VPWR VPWR net192 sky130_fd_sc_hd__clkbuf_1
XFILLER_145_68 VGND VGND VPWR VPWR sky130_fd_sc_hd__decap_3
XFILLER_38_22 VPWR VGND VPWR VGND sky130_ef_sc_hd__decap_12
XFILLER_237_209 VGND VGND VPWR VPWR sky130_fd_sc_hd__decap_6
XFILLER_252_1281 VPWR VGND VPWR VGND sky130_ef_sc_hd__decap_12
XTAP_TAPCELL_ROW_209_3080 VGND VPWR sky130_fd_sc_hd__tapvpwrvgnd_1
XFILLER_246_710 VPWR VGND VPWR VGND sky130_ef_sc_hd__decap_12
XFILLER_161_56 VPWR VGND VPWR VGND sky130_ef_sc_hd__decap_12
XFILLER_218_445 VGND VGND VPWR VPWR sky130_fd_sc_hd__decap_6
XTAP_TAPCELL_ROW_224_3589 VGND VPWR sky130_fd_sc_hd__tapvpwrvgnd_1
XFILLER_246_765 VPWR VGND VPWR VGND sky130_ef_sc_hd__decap_12
XFILLER_173_3 VPWR VGND VPWR VGND sky130_ef_sc_hd__decap_12
X_511_ net597 dout0_q\[30\] net526 VGND VGND VPWR VPWR _262_ sky130_fd_sc_hd__and3_1
XFILLER_22_1282 VPWR VGND VPWR VGND sky130_ef_sc_hd__decap_12
XFILLER_227_990 VPWR VGND VPWR VGND sky130_ef_sc_hd__decap_12
XFILLER_234_949 VPWR VGND VPWR VGND sky130_ef_sc_hd__decap_12
XFILLER_199_842 VPWR VGND VPWR VGND sky130_ef_sc_hd__decap_12
XFILLER_2_1398 VPWR VGND VPWR VGND sky130_ef_sc_hd__decap_12
X_442_ _224_ _226_ _230_ net197 VGND VGND VPWR VPWR _231_ sky130_fd_sc_hd__a211o_1
XFILLER_109_1402 VPWR VGND VPWR VGND sky130_ef_sc_hd__decap_12
XFILLER_54_65 VGND VGND VPWR VPWR sky130_fd_sc_hd__decap_6
XFILLER_207_1014 VPWR VGND VPWR VGND sky130_ef_sc_hd__decap_12
XFILLER_57_1378 VPWR VGND VPWR VGND sky130_ef_sc_hd__decap_12
X_373_ net245 _161_ VGND VGND VPWR VPWR _162_ sky130_fd_sc_hd__nand2_1
XFILLER_109_1457 VGND VGND VPWR VPWR sky130_fd_sc_hd__decap_6
XFILLER_144_1337 VPWR VGND VPWR VGND sky130_ef_sc_hd__decap_12
XFILLER_199_897 VGND VGND VPWR VPWR sky130_fd_sc_hd__decap_6
XTAP_TAPCELL_ROW_177_1939 VGND VPWR sky130_fd_sc_hd__tapvpwrvgnd_1
XFILLER_207_1069 VGND VGND VPWR VPWR sky130_fd_sc_hd__decap_6
XFILLER_201_345 VPWR VGND VPWR VGND sky130_ef_sc_hd__decap_12
XFILLER_31_1507 VGND VGND VPWR VPWR sky130_fd_sc_hd__decap_8
XTAP_TAPCELL_ROW_92_2_5398 VGND VPWR sky130_fd_sc_hd__tapvpwrvgnd_1
XTAP_TAPCELL_ROW_135_2_5738 VGND VPWR sky130_fd_sc_hd__tapvpwrvgnd_1
XPHY_EDGE_ROW_167_Right_12 VGND VGND VPWR VPWR sky130_fd_sc_hd__decap_3
XFILLER_220_1269 VPWR VGND VPWR VGND sky130_ef_sc_hd__decap_12
XTAP_TAPCELL_ROW_104_2_5496 VGND VPWR sky130_fd_sc_hd__tapvpwrvgnd_1
XFILLER_182_753 VPWR VGND VPWR VGND sky130_ef_sc_hd__decap_12
XTAP_TAPCELL_ROW_72_2_5241 VGND VPWR sky130_fd_sc_hd__tapvpwrvgnd_1
XPHY_EDGE_ROW_142_2_Right_233 VGND VGND VPWR VPWR sky130_fd_sc_hd__decap_3
XFILLER_181_252 VGND VGND VPWR VPWR sky130_fd_sc_hd__decap_6
XFILLER_120_1392 VGND VGND VPWR VPWR sky130_fd_sc_hd__decap_6
XFILLER_170_937 VPWR VGND VPWR VGND sky130_ef_sc_hd__decap_12
XFILLER_29_1414 VGND VGND VPWR VPWR sky130_fd_sc_hd__decap_6
XFILLER_218_1121 VPWR VGND VPWR VGND sky130_ef_sc_hd__decap_12
XFILLER_68_1485 VPWR VGND VPWR VGND sky130_ef_sc_hd__decap_12
XFILLER_155_1433 VPWR VGND VPWR VGND sky130_ef_sc_hd__decap_12
XFILLER_190_1324 VPWR VGND VPWR VGND sky130_ef_sc_hd__decap_12
XFILLER_253_1045 VPWR VGND VPWR VGND sky130_ef_sc_hd__decap_12
XFILLER_64_1349 VGND VGND VPWR VPWR sky130_fd_sc_hd__decap_6
XFILLER_218_1176 VGND VGND VPWR VPWR sky130_fd_sc_hd__decap_6
XTAP_TAPCELL_ROW_38_2_4965 VGND VPWR sky130_fd_sc_hd__tapvpwrvgnd_1
XFILLER_155_1488 VPWR VGND VPWR VGND sky130_ef_sc_hd__decap_12
XFILLER_190_1379 VPWR VGND VPWR VGND sky130_ef_sc_hd__decap_12
XFILLER_205_27 VPWR VGND VPWR VGND sky130_ef_sc_hd__decap_12
XFILLER_0_181 VGND VGND VPWR VPWR sky130_fd_sc_hd__decap_8
XFILLER_209_412 VPWR VGND VPWR VGND sky130_ef_sc_hd__decap_12
XPHY_EDGE_ROW_176_Right_21 VGND VGND VPWR VPWR sky130_fd_sc_hd__decap_3
XFILLER_237_732 VPWR VGND VPWR VGND sky130_ef_sc_hd__decap_12
XFILLER_209_467 VGND VGND VPWR VPWR sky130_fd_sc_hd__decap_6
XFILLER_225_916 VPWR VGND VPWR VGND sky130_ef_sc_hd__decap_12
XFILLER_114_1196 VPWR VGND VPWR VGND sky130_ef_sc_hd__decap_12
XTAP_TAPCELL_ROW_180_2070 VGND VPWR sky130_fd_sc_hd__tapvpwrvgnd_1
XFILLER_221_15 VPWR VGND VPWR VGND sky130_ef_sc_hd__decap_12
XFILLER_237_787 VPWR VGND VPWR VGND sky130_ef_sc_hd__decap_12
XTAP_TAPCELL_ROW_255_4707 VGND VPWR sky130_fd_sc_hd__tapvpwrvgnd_1
XTAP_TAPCELL_ROW_255_4718 VGND VPWR sky130_fd_sc_hd__tapvpwrvgnd_1
XFILLER_252_746 VGND VGND VPWR VPWR sky130_fd_sc_hd__decap_6
XTAP_TAPCELL_ROW_31_2_4908 VGND VPWR sky130_fd_sc_hd__tapvpwrvgnd_1
XTAP_TAPCELL_ROW_255_4729 VGND VPWR sky130_fd_sc_hd__tapvpwrvgnd_1
XFILLER_75_1445 VPWR VGND VPWR VGND sky130_ef_sc_hd__decap_12
XFILLER_229_1272 VPWR VGND VPWR VGND sky130_ef_sc_hd__decap_12
XFILLER_233_971 VPWR VGND VPWR VGND sky130_ef_sc_hd__decap_12
XFILLER_204_194 VPWR VGND VPWR VGND sky130_ef_sc_hd__decap_12
XTAP_TAPCELL_ROW_127_1_1420 VGND VPWR sky130_fd_sc_hd__tapvpwrvgnd_1
XFILLER_203_1401 VPWR VGND VPWR VGND sky130_ef_sc_hd__decap_12
XPHY_EDGE_ROW_185_Right_30 VGND VGND VPWR VPWR sky130_fd_sc_hd__decap_3
XTAP_TAPCELL_ROW_193_2497 VGND VPWR sky130_fd_sc_hd__tapvpwrvgnd_1
XFILLER_203_1456 VGND VGND VPWR VPWR sky130_fd_sc_hd__decap_6
XFILLER_125_1292 VPWR VGND VPWR VGND sky130_ef_sc_hd__decap_12
XFILLER_238_1508 VGND VGND VPWR VPWR sky130_fd_sc_hd__decap_6
XFILLER_172_230 VGND VGND VPWR VPWR sky130_fd_sc_hd__decap_6
XFILLER_246_34 VPWR VGND VPWR VGND sky130_ef_sc_hd__decap_12
XFILLER_69_1249 VPWR VGND VPWR VGND sky130_ef_sc_hd__decap_12
XFILLER_121_1189 VPWR VGND VPWR VGND sky130_ef_sc_hd__decap_12
XFILLER_173_775 VPWR VGND VPWR VGND sky130_ef_sc_hd__decap_12
XFILLER_156_1208 VPWR VGND VPWR VGND sky130_ef_sc_hd__decap_12
XFILLER_246_89 VPWR VGND VPWR VGND sky130_ef_sc_hd__decap_12
XPHY_EDGE_ROW_16_2_Right_107 VGND VGND VPWR VPWR sky130_fd_sc_hd__decap_3
XFILLER_115_27 VPWR VGND VPWR VGND sky130_ef_sc_hd__decap_12
XFILLER_219_209 VGND VGND VPWR VPWR sky130_fd_sc_hd__decap_6
XFILLER_247_529 VPWR VGND VPWR VGND sky130_ef_sc_hd__decap_12
XFILLER_228_710 VPWR VGND VPWR VGND sky130_ef_sc_hd__decap_12
XFILLER_80_1184 VPWR VGND VPWR VGND sky130_ef_sc_hd__decap_12
XFILLER_132_1263 VGND VGND VPWR VPWR sky130_fd_sc_hd__decap_6
XTAP_TAPCELL_ROW_160_2_5940 VGND VPWR sky130_fd_sc_hd__tapvpwrvgnd_1
XTAP_TAPCELL_ROW_159_2_5934 VGND VPWR sky130_fd_sc_hd__tapvpwrvgnd_1
XFILLER_228_765 VPWR VGND VPWR VGND sky130_ef_sc_hd__decap_12
XTAP_TAPCELL_ROW_3_969 VGND VPWR sky130_fd_sc_hd__tapvpwrvgnd_1
XFILLER_243_713 VPWR VGND VPWR VGND sky130_ef_sc_hd__decap_12
XFILLER_131_15 VPWR VGND VPWR VGND sky130_ef_sc_hd__decap_12
XFILLER_167_1315 VPWR VGND VPWR VGND sky130_ef_sc_hd__decap_12
XFILLER_216_949 VPWR VGND VPWR VGND sky130_ef_sc_hd__decap_12
XFILLER_209_990 VPWR VGND VPWR VGND sky130_ef_sc_hd__decap_12
XFILLER_243_768 VGND VGND VPWR VPWR sky130_fd_sc_hd__decap_6
XPHY_EDGE_ROW_42_1_Right_698 VGND VGND VPWR VPWR sky130_fd_sc_hd__decap_3
XFILLER_208_1312 VPWR VGND VPWR VGND sky130_ef_sc_hd__decap_12
XTAP_TAPCELL_ROW_162_1_1472 VGND VPWR sky130_fd_sc_hd__tapvpwrvgnd_1
XFILLER_165_1072 VGND VGND VPWR VPWR sky130_fd_sc_hd__decap_4
XFILLER_208_1367 VPWR VGND VPWR VGND sky130_ef_sc_hd__decap_12
XTAP_TAPCELL_ROW_77_2_5278 VGND VPWR sky130_fd_sc_hd__tapvpwrvgnd_1
XFILLER_210_120 VPWR VGND VPWR VGND sky130_ef_sc_hd__decap_12
XFILLER_52_1220 VGND VGND VPWR VPWR sky130_fd_sc_hd__decap_6
Xwire606 rd_addr\[7\] VGND VGND VPWR VPWR net606 sky130_fd_sc_hd__clkbuf_1
XTAP_TAPCELL_ROW_217_3360 VGND VPWR sky130_fd_sc_hd__tapvpwrvgnd_1
XTAP_TAPCELL_ROW_213_3202 VGND VPWR sky130_fd_sc_hd__tapvpwrvgnd_1
Xwire628 net629 VGND VGND VPWR VPWR net628 sky130_fd_sc_hd__buf_1
XFILLER_183_517 VPWR VGND VPWR VGND sky130_ef_sc_hd__decap_12
XFILLER_210_175 VPWR VGND VPWR VGND sky130_ef_sc_hd__decap_12
XTAP_TAPCELL_ROW_213_3213 VGND VPWR sky130_fd_sc_hd__tapvpwrvgnd_1
Xwire639 net30 VGND VGND VPWR VPWR net639 sky130_fd_sc_hd__buf_1
XFILLER_195_388 VPWR VGND VPWR VGND sky130_ef_sc_hd__decap_12
XTAP_TAPCELL_ROW_213_3224 VGND VPWR sky130_fd_sc_hd__tapvpwrvgnd_1
XTAP_TAPCELL_ROW_57_2_5121 VGND VPWR sky130_fd_sc_hd__tapvpwrvgnd_1
XTAP_TAPCELL_ROW_232_3869 VGND VPWR sky130_fd_sc_hd__tapvpwrvgnd_1
XFILLER_40_34 VPWR VGND VPWR VGND sky130_ef_sc_hd__decap_12
XFILLER_178_1422 VPWR VGND VPWR VGND sky130_ef_sc_hd__decap_12
XFILLER_87_1316 VPWR VGND VPWR VGND sky130_ef_sc_hd__decap_12
XFILLER_156_34 VPWR VGND VPWR VGND sky130_ef_sc_hd__decap_12
XFILLER_178_1477 VGND VGND VPWR VPWR sky130_fd_sc_hd__decap_6
XFILLER_191_572 VPWR VGND VPWR VGND sky130_ef_sc_hd__decap_12
XFILLER_2_413 VGND VGND VPWR VPWR sky130_fd_sc_hd__fill_1
XTAP_TAPCELL_ROW_24_2_4851 VGND VPWR sky130_fd_sc_hd__tapvpwrvgnd_1
XFILLER_3_947 VPWR VGND VPWR VGND sky130_ef_sc_hd__decap_12
XFILLER_219_1463 VPWR VGND VPWR VGND sky130_ef_sc_hd__decap_12
XFILLER_250_1207 VPWR VGND VPWR VGND sky130_ef_sc_hd__decap_12
XFILLER_215_1327 VGND VGND VPWR VPWR sky130_fd_sc_hd__decap_6
XFILLER_172_22 VPWR VGND VPWR VGND sky130_ef_sc_hd__decap_12
XTAP_TAPCELL_ROW_207_3006 VGND VPWR sky130_fd_sc_hd__tapvpwrvgnd_1
XTAP_TAPCELL_ROW_57_1_1315 VGND VPWR sky130_fd_sc_hd__tapvpwrvgnd_1
XFILLER_172_1054 VPWR VGND VPWR VGND sky130_ef_sc_hd__decap_12
XTAP_TAPCELL_ROW_207_3017 VGND VPWR sky130_fd_sc_hd__tapvpwrvgnd_1
XFILLER_254_1398 VPWR VGND VPWR VGND sky130_ef_sc_hd__decap_12
XFILLER_238_507 VPWR VGND VPWR VGND sky130_ef_sc_hd__decap_12
XFILLER_63_1371 VGND VGND VPWR VPWR sky130_fd_sc_hd__decap_6
XFILLER_172_77 VPWR VGND VPWR VGND sky130_ef_sc_hd__decap_12
XFILLER_219_732 VPWR VGND VPWR VGND sky130_ef_sc_hd__decap_12
XFILLER_20_1208 VPWR VGND VPWR VGND sky130_ef_sc_hd__decap_12
XFILLER_98_1423 VPWR VGND VPWR VGND sky130_ef_sc_hd__decap_12
XFILLER_246_562 VPWR VGND VPWR VGND sky130_ef_sc_hd__decap_12
XFILLER_65_31 VPWR VGND VPWR VGND sky130_ef_sc_hd__decap_12
XFILLER_207_916 VPWR VGND VPWR VGND sky130_ef_sc_hd__decap_12
XFILLER_219_787 VPWR VGND VPWR VGND sky130_ef_sc_hd__decap_12
XFILLER_24_1399 VPWR VGND VPWR VGND sky130_ef_sc_hd__decap_12
XFILLER_111_1347 VPWR VGND VPWR VGND sky130_ef_sc_hd__decap_12
XFILLER_2_1140 VPWR VGND VPWR VGND sky130_ef_sc_hd__decap_12
XFILLER_98_1478 VGND VGND VPWR VPWR sky130_fd_sc_hd__decap_6
XFILLER_234_746 VGND VGND VPWR VPWR sky130_fd_sc_hd__decap_6
XFILLER_2_1195 VPWR VGND VPWR VGND sky130_ef_sc_hd__decap_12
XFILLER_215_971 VPWR VGND VPWR VGND sky130_ef_sc_hd__decap_12
XFILLER_148_1270 VPWR VGND VPWR VGND sky130_ef_sc_hd__decap_12
XFILLER_226_1434 VGND VGND VPWR VPWR sky130_fd_sc_hd__decap_6
X_425_ net596 dout0_q\[23\] net533 VGND VGND VPWR VPWR _214_ sky130_fd_sc_hd__a21oi_1
X_356_ net338 net337 net166 _134_ VGND VGND VPWR VPWR _145_ sky130_fd_sc_hd__or4b_1
XFILLER_201_142 VPWR VGND VPWR VGND sky130_ef_sc_hd__decap_12
XFILLER_186_366 VPWR VGND VPWR VGND sky130_ef_sc_hd__decap_12
XFILLER_220_1011 VPWR VGND VPWR VGND sky130_ef_sc_hd__decap_12
XFILLER_31_1304 VPWR VGND VPWR VGND sky130_ef_sc_hd__decap_12
X_287_ net611 net612 net521 VGND VGND VPWR VPWR _084_ sky130_fd_sc_hd__and3_1
XFILLER_201_197 VPWR VGND VPWR VGND sky130_ef_sc_hd__decap_12
XFILLER_122_1454 VPWR VGND VPWR VGND sky130_ef_sc_hd__decap_12
XFILLER_220_1066 VPWR VGND VPWR VGND sky130_ef_sc_hd__decap_12
XFILLER_31_1359 VPWR VGND VPWR VGND sky130_ef_sc_hd__decap_12
XFILLER_182_550 VPWR VGND VPWR VGND sky130_ef_sc_hd__decap_12
XFILLER_5_251 VGND VGND VPWR VPWR sky130_fd_sc_hd__fill_1
XFILLER_170_734 VPWR VGND VPWR VGND sky130_ef_sc_hd__decap_12
XPHY_EDGE_ROW_143_2_Right_234 VGND VGND VPWR VPWR sky130_fd_sc_hd__decap_3
XFILLER_216_15 VGND VGND VPWR VPWR sky130_fd_sc_hd__decap_6
XFILLER_68_1282 VPWR VGND VPWR VGND sky130_ef_sc_hd__decap_12
XFILLER_155_1230 VPWR VGND VPWR VGND sky130_ef_sc_hd__decap_12
XTAP_TAPCELL_ROW_92_1_1367 VGND VPWR sky130_fd_sc_hd__tapvpwrvgnd_1
XFILLER_170_789 VGND VGND VPWR VPWR sky130_fd_sc_hd__decap_6
XFILLER_190_1121 VPWR VGND VPWR VGND sky130_ef_sc_hd__decap_12
XFILLER_2_980 VPWR VGND VPWR VGND sky130_ef_sc_hd__decap_12
XFILLER_155_1285 VGND VGND VPWR VPWR sky130_fd_sc_hd__decap_6
XTAP_TAPCELL_ROW_145_2_5820 VGND VPWR sky130_fd_sc_hd__tapvpwrvgnd_1
XTAP_TAPCELL_ROW_182_2110 VGND VPWR sky130_fd_sc_hd__tapvpwrvgnd_1
XFILLER_190_1176 VGND VGND VPWR VPWR sky130_fd_sc_hd__decap_6
XFILLER_229_529 VPWR VGND VPWR VGND sky130_ef_sc_hd__decap_12
XFILLER_42_1411 VPWR VGND VPWR VGND sky130_ef_sc_hd__decap_12
XTAP_TAPCELL_ROW_182_2121 VGND VPWR sky130_fd_sc_hd__tapvpwrvgnd_1
XPHY_EDGE_ROW_27_2_Left_529 VGND VGND VPWR VPWR sky130_fd_sc_hd__decap_3
XTAP_TAPCELL_ROW_182_2132 VGND VPWR sky130_fd_sc_hd__tapvpwrvgnd_1
XTAP_TAPCELL_ROW_182_2143 VGND VPWR sky130_fd_sc_hd__tapvpwrvgnd_1
XFILLER_231_1162 VPWR VGND VPWR VGND sky130_ef_sc_hd__decap_12
XFILLER_42_1466 VPWR VGND VPWR VGND sky130_ef_sc_hd__decap_12
Xinput5 wr_addr[3] VGND VGND VPWR VPWR net5 sky130_fd_sc_hd__clkbuf_1
XFILLER_232_58 VGND VGND VPWR VPWR sky130_fd_sc_hd__decap_6
XFILLER_225_713 VPWR VGND VPWR VGND sky130_ef_sc_hd__decap_12
XFILLER_77_1507 VGND VGND VPWR VPWR sky130_fd_sc_hd__decap_8
XFILLER_237_584 VPWR VGND VPWR VGND sky130_ef_sc_hd__decap_12
XTAP_TAPCELL_ROW_94_2_5417 VGND VPWR sky130_fd_sc_hd__tapvpwrvgnd_1
XFILLER_225_768 VGND VGND VPWR VPWR sky130_fd_sc_hd__decap_6
XTAP_TAPCELL_ROW_63_2_5164 VGND VPWR sky130_fd_sc_hd__tapvpwrvgnd_1
XFILLER_75_1242 VGND VGND VPWR VPWR sky130_fd_sc_hd__decap_6
XFILLER_196_108 VPWR VGND VPWR VGND sky130_ef_sc_hd__decap_12
XPHY_EDGE_ROW_141_2_Left_643 VGND VGND VPWR VPWR sky130_fd_sc_hd__decap_3
XFILLER_123_1218 VPWR VGND VPWR VGND sky130_ef_sc_hd__decap_12
XFILLER_165_517 VGND VGND VPWR VPWR sky130_fd_sc_hd__decap_8
XFILLER_177_388 VPWR VGND VPWR VGND sky130_ef_sc_hd__decap_12
XFILLER_220_495 VPWR VGND VPWR VGND sky130_ef_sc_hd__decap_12
XFILLER_192_347 VPWR VGND VPWR VGND sky130_ef_sc_hd__decap_12
XFILLER_238_1305 VGND VGND VPWR VPWR sky130_fd_sc_hd__decap_6
XFILLER_173_572 VPWR VGND VPWR VGND sky130_ef_sc_hd__decap_12
XFILLER_12_1270 VPWR VGND VPWR VGND sky130_ef_sc_hd__decap_12
XFILLER_195_1076 VPWR VGND VPWR VGND sky130_ef_sc_hd__decap_12
XFILLER_126_15 VGND VGND VPWR VPWR sky130_fd_sc_hd__decap_6
XPHY_EDGE_ROW_17_2_Right_108 VGND VGND VPWR VPWR sky130_fd_sc_hd__decap_3
XFILLER_134_1325 VPWR VGND VPWR VGND sky130_ef_sc_hd__decap_12
XFILLER_247_326 VPWR VGND VPWR VGND sky130_ef_sc_hd__decap_12
XTAP_TAPCELL_ROW_225_3640 VGND VPWR sky130_fd_sc_hd__tapvpwrvgnd_1
XTAP_TAPCELL_ROW_221_3504 VGND VPWR sky130_fd_sc_hd__tapvpwrvgnd_1
XFILLER_19_68 VGND VGND VPWR VPWR sky130_fd_sc_hd__decap_3
XFILLER_249_1401 VPWR VGND VPWR VGND sky130_ef_sc_hd__decap_12
XFILLER_142_58 VGND VGND VPWR VPWR sky130_fd_sc_hd__decap_6
XFILLER_228_562 VPWR VGND VPWR VGND sky130_ef_sc_hd__decap_12
XFILLER_255_370 VGND VGND VPWR VPWR sky130_fd_sc_hd__decap_8
XFILLER_243_510 VGND VGND VPWR VPWR sky130_fd_sc_hd__decap_6
XPHY_EDGE_ROW_155_1_Left_410 VGND VGND VPWR VPWR sky130_fd_sc_hd__decap_3
XFILLER_167_1112 VGND VGND VPWR VPWR sky130_fd_sc_hd__decap_6
XFILLER_249_1456 VGND VGND VPWR VPWR sky130_fd_sc_hd__decap_6
XFILLER_216_746 VGND VGND VPWR VPWR sky130_fd_sc_hd__decap_6
XFILLER_110_1380 VPWR VGND VPWR VGND sky130_ef_sc_hd__decap_12
XFILLER_19_1402 VPWR VGND VPWR VGND sky130_ef_sc_hd__decap_12
XTAP_TAPCELL_ROW_219_3411 VGND VPWR sky130_fd_sc_hd__tapvpwrvgnd_1
XPHY_EDGE_ROW_43_1_Right_699 VGND VGND VPWR VPWR sky130_fd_sc_hd__decap_3
XTAP_TAPCELL_ROW_219_3422 VGND VPWR sky130_fd_sc_hd__tapvpwrvgnd_1
XFILLER_145_1421 VPWR VGND VPWR VGND sky130_ef_sc_hd__decap_12
XTAP_TAPCELL_ROW_219_3433 VGND VPWR sky130_fd_sc_hd__tapvpwrvgnd_1
XPHY_EDGE_ROW_73_2_Left_575 VGND VGND VPWR VPWR sky130_fd_sc_hd__decap_3
XFILLER_180_1312 VPWR VGND VPWR VGND sky130_ef_sc_hd__decap_12
XFILLER_230_237 VPWR VGND VPWR VGND sky130_ef_sc_hd__decap_12
XFILLER_243_1033 VPWR VGND VPWR VGND sky130_ef_sc_hd__decap_12
XFILLER_54_1337 VPWR VGND VPWR VGND sky130_ef_sc_hd__decap_12
XFILLER_19_1457 VGND VGND VPWR VPWR sky130_fd_sc_hd__decap_6
XFILLER_208_1164 VPWR VGND VPWR VGND sky130_ef_sc_hd__decap_12
XFILLER_145_1476 VPWR VGND VPWR VGND sky130_ef_sc_hd__decap_12
XFILLER_195_130 VPWR VGND VPWR VGND sky130_ef_sc_hd__decap_12
XFILLER_180_1367 VPWR VGND VPWR VGND sky130_ef_sc_hd__decap_12
XFILLER_243_1088 VPWR VGND VPWR VGND sky130_ef_sc_hd__decap_12
Xwire403 net404 VGND VGND VPWR VPWR net403 sky130_fd_sc_hd__clkbuf_1
XFILLER_136_3 VPWR VGND VPWR VGND sky130_ef_sc_hd__decap_12
XFILLER_168_366 VPWR VGND VPWR VGND sky130_ef_sc_hd__decap_12
XFILLER_51_44 VGND VGND VPWR VPWR sky130_fd_sc_hd__decap_4
Xwire414 net415 VGND VGND VPWR VPWR net414 sky130_fd_sc_hd__clkbuf_1
Xwire425 net426 VGND VGND VPWR VPWR net425 sky130_fd_sc_hd__clkbuf_1
XFILLER_183_314 VPWR VGND VPWR VGND sky130_ef_sc_hd__decap_12
Xwire436 net437 VGND VGND VPWR VPWR net436 sky130_fd_sc_hd__clkbuf_1
XFILLER_195_185 VPWR VGND VPWR VGND sky130_ef_sc_hd__decap_12
Xwire447 net448 VGND VGND VPWR VPWR net447 sky130_fd_sc_hd__clkbuf_1
XFILLER_167_44 VPWR VGND VPWR VGND sky130_ef_sc_hd__decap_12
Xwire458 net459 VGND VGND VPWR VPWR net458 sky130_fd_sc_hd__clkbuf_1
Xwire469 net470 VGND VGND VPWR VPWR net469 sky130_fd_sc_hd__clkbuf_1
XFILLER_183_369 VPWR VGND VPWR VGND sky130_ef_sc_hd__decap_12
XFILLER_104_1184 VPWR VGND VPWR VGND sky130_ef_sc_hd__decap_12
XFILLER_167_99 VPWR VGND VPWR VGND sky130_ef_sc_hd__decap_12
XFILLER_30_1392 VGND VGND VPWR VPWR sky130_fd_sc_hd__decap_6
XTAP_TAPCELL_ROW_87_2_5360 VGND VPWR sky130_fd_sc_hd__tapvpwrvgnd_1
XFILLER_254_1140 VPWR VGND VPWR VGND sky130_ef_sc_hd__decap_12
XFILLER_65_1433 VPWR VGND VPWR VGND sky130_ef_sc_hd__decap_12
XFILLER_219_1260 VPWR VGND VPWR VGND sky130_ef_sc_hd__decap_12
XFILLER_250_1004 VGND VGND VPWR VPWR sky130_fd_sc_hd__decap_6
XFILLER_191_1463 VPWR VGND VPWR VGND sky130_ef_sc_hd__decap_12
XFILLER_183_87 VPWR VGND VPWR VGND sky130_ef_sc_hd__decap_12
XFILLER_254_1195 VPWR VGND VPWR VGND sky130_ef_sc_hd__decap_12
XFILLER_238_304 VPWR VGND VPWR VGND sky130_ef_sc_hd__decap_12
XFILLER_65_1488 VPWR VGND VPWR VGND sky130_ef_sc_hd__decap_12
XFILLER_254_808 VPWR VGND VPWR VGND sky130_ef_sc_hd__decap_12
XFILLER_238_359 VGND VGND VPWR VPWR sky130_fd_sc_hd__decap_6
XPHY_EDGE_ROW_87_1_Left_342 VGND VGND VPWR VPWR sky130_fd_sc_hd__decap_3
Xfanout591 net592 VGND VGND VPWR VPWR net591 sky130_fd_sc_hd__clkbuf_2
XTAP_TAPCELL_ROW_112_2_5558 VGND VPWR sky130_fd_sc_hd__tapvpwrvgnd_1
XFILLER_98_1220 VGND VGND VPWR VPWR sky130_fd_sc_hd__decap_6
XTAP_TAPCELL_ROW_80_2_5303 VGND VPWR sky130_fd_sc_hd__tapvpwrvgnd_1
XFILLER_207_713 VPWR VGND VPWR VGND sky130_ef_sc_hd__decap_12
XFILLER_24_1196 VPWR VGND VPWR VGND sky130_ef_sc_hd__decap_12
XFILLER_219_584 VPWR VGND VPWR VGND sky130_ef_sc_hd__decap_12
XTAP_TAPCELL_ROW_48_2_5044 VGND VPWR sky130_fd_sc_hd__tapvpwrvgnd_1
XFILLER_189_1370 VGND VGND VPWR VPWR sky130_fd_sc_hd__decap_6
XFILLER_111_1177 VPWR VGND VPWR VGND sky130_ef_sc_hd__decap_12
XFILLER_207_768 VGND VGND VPWR VPWR sky130_fd_sc_hd__decap_6
XFILLER_178_108 VPWR VGND VPWR VGND sky130_ef_sc_hd__decap_12
XTAP_TAPCELL_ROW_15_2_4785 VGND VPWR sky130_fd_sc_hd__tapvpwrvgnd_1
XFILLER_221_259 VPWR VGND VPWR VGND sky130_ef_sc_hd__decap_12
X_408_ _186_ _187_ VGND VGND VPWR VPWR _197_ sky130_fd_sc_hd__and2b_1
XTAP_TAPCELL_ROW_190_2401 VGND VPWR sky130_fd_sc_hd__tapvpwrvgnd_1
XTAP_TAPCELL_ROW_190_2412 VGND VPWR sky130_fd_sc_hd__tapvpwrvgnd_1
XFILLER_186_163 VPWR VGND VPWR VGND sky130_ef_sc_hd__decap_12
XTAP_TAPCELL_ROW_190_2423 VGND VPWR sky130_fd_sc_hd__tapvpwrvgnd_1
XFILLER_202_495 VPWR VGND VPWR VGND sky130_ef_sc_hd__decap_12
X_339_ _116_ _126_ _127_ net500 VGND VGND VPWR VPWR _128_ sky130_fd_sc_hd__a211o_1
XTAP_TAPCELL_ROW_250_4489 VGND VPWR sky130_fd_sc_hd__tapvpwrvgnd_1
XFILLER_35_1292 VPWR VGND VPWR VGND sky130_ef_sc_hd__decap_12
XFILLER_122_1251 VPWR VGND VPWR VGND sky130_ef_sc_hd__decap_12
XFILLER_174_347 VPWR VGND VPWR VGND sky130_ef_sc_hd__decap_12
XFILLER_31_1189 VPWR VGND VPWR VGND sky130_ef_sc_hd__decap_12
XFILLER_66_1208 VPWR VGND VPWR VGND sky130_ef_sc_hd__decap_12
XFILLER_51_3 VPWR VGND VPWR VGND sky130_ef_sc_hd__decap_12
XFILLER_170_531 VGND VGND VPWR VPWR sky130_fd_sc_hd__decap_6
XFILLER_83_1500 VGND VGND VPWR VPWR sky130_fd_sc_hd__decap_6
XFILLER_157_1347 VPWR VGND VPWR VGND sky130_ef_sc_hd__decap_12
XTAP_TAPCELL_ROW_188_2330 VGND VPWR sky130_fd_sc_hd__tapvpwrvgnd_1
XTAP_TAPCELL_ROW_188_2341 VGND VPWR sky130_fd_sc_hd__tapvpwrvgnd_1
XFILLER_192_1238 VPWR VGND VPWR VGND sky130_ef_sc_hd__decap_12
XTAP_TAPCELL_ROW_188_2352 VGND VPWR sky130_fd_sc_hd__tapvpwrvgnd_1
XPHY_EDGE_ROW_144_2_Right_235 VGND VGND VPWR VPWR sky130_fd_sc_hd__decap_3
XTAP_TAPCELL_ROW_184_2205 VGND VPWR sky130_fd_sc_hd__tapvpwrvgnd_1
XFILLER_9_1135 VPWR VGND VPWR VGND sky130_ef_sc_hd__decap_12
XFILLER_170_1514 VGND VGND VPWR VPWR sky130_fd_sc_hd__fill_1
XTAP_TAPCELL_ROW_27_1_1270 VGND VPWR sky130_fd_sc_hd__tapvpwrvgnd_1
XFILLER_9_1168 VGND VGND VPWR VPWR sky130_fd_sc_hd__decap_8
XFILLER_229_326 VPWR VGND VPWR VGND sky130_ef_sc_hd__decap_12
XFILLER_243_68 VPWR VGND VPWR VGND sky130_ef_sc_hd__decap_12
XFILLER_42_1263 VGND VGND VPWR VPWR sky130_fd_sc_hd__decap_6
XFILLER_238_882 VPWR VGND VPWR VGND sky130_ef_sc_hd__decap_12
XFILLER_225_510 VGND VGND VPWR VPWR sky130_fd_sc_hd__decap_6
XFILLER_253_830 VPWR VGND VPWR VGND sky130_ef_sc_hd__decap_12
XTAP_TAPCELL_ROW_115_1_1402 VGND VPWR sky130_fd_sc_hd__tapvpwrvgnd_1
XFILLER_168_1410 VPWR VGND VPWR VGND sky130_ef_sc_hd__decap_12
XFILLER_77_1304 VPWR VGND VPWR VGND sky130_ef_sc_hd__decap_12
XFILLER_237_381 VGND VGND VPWR VPWR sky130_fd_sc_hd__decap_6
XFILLER_168_1465 VPWR VGND VPWR VGND sky130_ef_sc_hd__decap_12
XFILLER_253_885 VPWR VGND VPWR VGND sky130_ef_sc_hd__decap_12
XFILLER_77_1359 VPWR VGND VPWR VGND sky130_ef_sc_hd__decap_12
XFILLER_198_918 VGND VGND VPWR VPWR sky130_fd_sc_hd__decap_6
XFILLER_212_237 VPWR VGND VPWR VGND sky130_ef_sc_hd__decap_12
XFILLER_205_1315 VPWR VGND VPWR VGND sky130_ef_sc_hd__decap_12
XFILLER_177_130 VPWR VGND VPWR VGND sky130_ef_sc_hd__decap_12
XTAP_TAPCELL_ROW_233_3920 VGND VPWR sky130_fd_sc_hd__tapvpwrvgnd_1
XFILLER_220_292 VPWR VGND VPWR VGND sky130_ef_sc_hd__decap_12
XFILLER_177_185 VPWR VGND VPWR VGND sky130_ef_sc_hd__decap_12
XFILLER_88_1411 VPWR VGND VPWR VGND sky130_ef_sc_hd__decap_12
XFILLER_165_358 VPWR VGND VPWR VGND sky130_ef_sc_hd__decap_12
XFILLER_192_144 VGND VGND VPWR VPWR sky130_fd_sc_hd__decap_6
XFILLER_181_818 VPWR VGND VPWR VGND sky130_ef_sc_hd__decap_12
XFILLER_193_689 VPWR VGND VPWR VGND sky130_ef_sc_hd__decap_12
XFILLER_101_1335 VPWR VGND VPWR VGND sky130_ef_sc_hd__decap_12
XFILLER_88_1466 VPWR VGND VPWR VGND sky130_ef_sc_hd__decap_12
XTAP_TAPCELL_ROW_227_3702 VGND VPWR sky130_fd_sc_hd__tapvpwrvgnd_1
XTAP_TAPCELL_ROW_227_3713 VGND VPWR sky130_fd_sc_hd__tapvpwrvgnd_1
XFILLER_255_1471 VPWR VGND VPWR VGND sky130_ef_sc_hd__decap_12
XFILLER_216_1422 VPWR VGND VPWR VGND sky130_ef_sc_hd__decap_12
XTAP_TAPCELL_ROW_39_2_4970 VGND VPWR sky130_fd_sc_hd__tapvpwrvgnd_1
XFILLER_217_80 VGND VGND VPWR VPWR sky130_fd_sc_hd__decap_6
XFILLER_251_1346 VPWR VGND VPWR VGND sky130_ef_sc_hd__decap_12
XFILLER_248_624 VPWR VGND VPWR VGND sky130_ef_sc_hd__decap_12
XFILLER_216_1477 VGND VGND VPWR VPWR sky130_fd_sc_hd__decap_6
XPHY_EDGE_ROW_18_2_Right_109 VGND VGND VPWR VPWR sky130_fd_sc_hd__decap_3
XFILLER_247_123 VGND VGND VPWR VPWR sky130_fd_sc_hd__decap_6
XFILLER_153_68 VGND VGND VPWR VPWR sky130_fd_sc_hd__decap_3
XFILLER_134_1177 VGND VGND VPWR VPWR sky130_fd_sc_hd__decap_6
XFILLER_236_808 VPWR VGND VPWR VGND sky130_ef_sc_hd__decap_12
XFILLER_248_679 VPWR VGND VPWR VGND sky130_ef_sc_hd__decap_12
XTAP_TAPCELL_ROW_150_1_1454 VGND VPWR sky130_fd_sc_hd__tapvpwrvgnd_1
XFILLER_46_22 VPWR VGND VPWR VGND sky130_ef_sc_hd__decap_12
XFILLER_112_1442 VPWR VGND VPWR VGND sky130_ef_sc_hd__decap_12
XFILLER_169_1229 VPWR VGND VPWR VGND sky130_ef_sc_hd__decap_12
XFILLER_21_1347 VPWR VGND VPWR VGND sky130_ef_sc_hd__decap_12
XTAP_TAPCELL_ROW_165_1481 VGND VPWR sky130_fd_sc_hd__tapvpwrvgnd_1
XFILLER_210_1054 VPWR VGND VPWR VGND sky130_ef_sc_hd__decap_12
XTAP_TAPCELL_ROW_165_1492 VGND VPWR sky130_fd_sc_hd__tapvpwrvgnd_1
XFILLER_244_863 VPWR VGND VPWR VGND sky130_ef_sc_hd__decap_12
XFILLER_112_1497 VPWR VGND VPWR VGND sky130_ef_sc_hd__decap_12
XFILLER_253_3 VPWR VGND VPWR VGND sky130_ef_sc_hd__decap_12
Xmax_cap89 net90 VGND VGND VPWR VPWR net89 sky130_fd_sc_hd__clkbuf_1
XFILLER_58_1270 VPWR VGND VPWR VGND sky130_ef_sc_hd__decap_12
XFILLER_197_940 VGND VGND VPWR VPWR sky130_fd_sc_hd__decap_6
XFILLER_203_259 VPWR VGND VPWR VGND sky130_ef_sc_hd__decap_12
XFILLER_62_65 VGND VGND VPWR VPWR sky130_fd_sc_hd__decap_6
XFILLER_145_1273 VPWR VGND VPWR VGND sky130_ef_sc_hd__decap_12
XFILLER_180_1164 VPWR VGND VPWR VGND sky130_ef_sc_hd__decap_12
XFILLER_168_163 VPWR VGND VPWR VGND sky130_ef_sc_hd__decap_12
XFILLER_178_65 VPWR VGND VPWR VGND sky130_ef_sc_hd__decap_12
Xwire222 net223 VGND VGND VPWR VPWR net222 sky130_fd_sc_hd__clkbuf_1
XFILLER_183_111 VPWR VGND VPWR VGND sky130_ef_sc_hd__decap_12
Xwire233 net234 VGND VGND VPWR VPWR net233 sky130_fd_sc_hd__clkbuf_1
XFILLER_7_335 VGND VGND VPWR VPWR sky130_fd_sc_hd__decap_8
Xwire244 net246 VGND VGND VPWR VPWR net244 sky130_fd_sc_hd__clkbuf_1
XFILLER_184_667 VPWR VGND VPWR VGND sky130_ef_sc_hd__decap_12
XFILLER_32_1454 VPWR VGND VPWR VGND sky130_ef_sc_hd__decap_12
Xwire255 net256 VGND VGND VPWR VPWR net255 sky130_fd_sc_hd__clkbuf_1
Xwire266 net267 VGND VGND VPWR VPWR net266 sky130_fd_sc_hd__clkbuf_1
Xwire277 net278 VGND VGND VPWR VPWR net277 sky130_fd_sc_hd__clkbuf_1
XFILLER_183_166 VGND VGND VPWR VPWR sky130_fd_sc_hd__decap_6
Xwire288 net289 VGND VGND VPWR VPWR net288 sky130_fd_sc_hd__clkbuf_1
Xwire299 net300 VGND VGND VPWR VPWR net299 sky130_fd_sc_hd__clkbuf_1
XFILLER_193_1514 VGND VGND VPWR VPWR sky130_fd_sc_hd__fill_1
XFILLER_180_851 VPWR VGND VPWR VGND sky130_ef_sc_hd__decap_12
XFILLER_154_1509 VGND VGND VPWR VPWR sky130_fd_sc_hd__decap_6
XFILLER_65_1230 VPWR VGND VPWR VGND sky130_ef_sc_hd__decap_12
XFILLER_3_574 VGND VGND VPWR VPWR sky130_fd_sc_hd__fill_1
XFILLER_156_1380 VPWR VGND VPWR VGND sky130_ef_sc_hd__decap_12
XFILLER_191_1260 VPWR VGND VPWR VGND sky130_ef_sc_hd__decap_12
XTAP_TAPCELL_ROW_243_4260 VGND VPWR sky130_fd_sc_hd__tapvpwrvgnd_1
XFILLER_65_1285 VGND VGND VPWR VPWR sky130_fd_sc_hd__decap_6
XFILLER_238_101 VGND VGND VPWR VPWR sky130_fd_sc_hd__decap_6
XTAP_TAPCELL_ROW_243_4271 VGND VPWR sky130_fd_sc_hd__tapvpwrvgnd_1
XFILLER_113_1206 VPWR VGND VPWR VGND sky130_ef_sc_hd__decap_12
XFILLER_239_646 VPWR VGND VPWR VGND sky130_ef_sc_hd__decap_12
XFILLER_254_605 VPWR VGND VPWR VGND sky130_ef_sc_hd__decap_12
XFILLER_213_27 VPWR VGND VPWR VGND sky130_ef_sc_hd__decap_12
XFILLER_207_510 VGND VGND VPWR VPWR sky130_fd_sc_hd__decap_6
XFILLER_4_1054 VPWR VGND VPWR VGND sky130_ef_sc_hd__decap_12
XFILLER_219_381 VGND VGND VPWR VPWR sky130_fd_sc_hd__decap_6
XFILLER_235_830 VPWR VGND VPWR VGND sky130_ef_sc_hd__decap_12
XTAP_TAPCELL_ROW_5_1060 VGND VPWR sky130_fd_sc_hd__tapvpwrvgnd_1
XFILLER_235_885 VPWR VGND VPWR VGND sky130_ef_sc_hd__decap_12
XTAP_TAPCELL_ROW_204_2886 VGND VPWR sky130_fd_sc_hd__tapvpwrvgnd_1
XTAP_TAPCELL_ROW_196_2610 VGND VPWR sky130_fd_sc_hd__tapvpwrvgnd_1
XTAP_TAPCELL_ROW_204_2897 VGND VPWR sky130_fd_sc_hd__tapvpwrvgnd_1
XFILLER_228_1348 VGND VGND VPWR VPWR sky130_fd_sc_hd__decap_6
XTAP_TAPCELL_ROW_142_2_5797 VGND VPWR sky130_fd_sc_hd__tapvpwrvgnd_1
XTAP_TAPCELL_ROW_196_2621 VGND VPWR sky130_fd_sc_hd__tapvpwrvgnd_1
XTAP_TAPCELL_ROW_200_2739 VGND VPWR sky130_fd_sc_hd__tapvpwrvgnd_1
XTAP_TAPCELL_ROW_237_4042 VGND VPWR sky130_fd_sc_hd__tapvpwrvgnd_1
XTAP_TAPCELL_ROW_196_2632 VGND VPWR sky130_fd_sc_hd__tapvpwrvgnd_1
XTAP_TAPCELL_ROW_237_4053 VGND VPWR sky130_fd_sc_hd__tapvpwrvgnd_1
XTAP_TAPCELL_ROW_237_4064 VGND VPWR sky130_fd_sc_hd__tapvpwrvgnd_1
XTAP_TAPCELL_ROW_78_2_5283 VGND VPWR sky130_fd_sc_hd__tapvpwrvgnd_1
XFILLER_76_1392 VGND VGND VPWR VPWR sky130_fd_sc_hd__decap_6
XFILLER_99_3 VPWR VGND VPWR VGND sky130_ef_sc_hd__decap_12
XTAP_TAPCELL_ROW_122_2_5640 VGND VPWR sky130_fd_sc_hd__tapvpwrvgnd_1
XFILLER_124_1313 VPWR VGND VPWR VGND sky130_ef_sc_hd__decap_12
XFILLER_194_409 VPWR VGND VPWR VGND sky130_ef_sc_hd__decap_12
XFILLER_33_1218 VPWR VGND VPWR VGND sky130_ef_sc_hd__decap_12
XFILLER_202_292 VPWR VGND VPWR VGND sky130_ef_sc_hd__decap_12
XFILLER_124_1368 VPWR VGND VPWR VGND sky130_ef_sc_hd__decap_12
XTAP_TAPCELL_ROW_80_1_1349 VGND VPWR sky130_fd_sc_hd__tapvpwrvgnd_1
XFILLER_174_144 VGND VGND VPWR VPWR sky130_fd_sc_hd__decap_6
XFILLER_238_46 VPWR VGND VPWR VGND sky130_ef_sc_hd__decap_12
Xinput30 wr_data[28] VGND VGND VPWR VPWR net30 sky130_fd_sc_hd__clkbuf_1
Xinput41 wr_data[9] VGND VGND VPWR VPWR net41 sky130_fd_sc_hd__clkbuf_1
XFILLER_175_689 VPWR VGND VPWR VGND sky130_ef_sc_hd__decap_12
Xmax_cap511 net512 VGND VGND VPWR VPWR net511 sky130_fd_sc_hd__clkbuf_1
XTAP_TAPCELL_ROW_71_2_5226 VGND VPWR sky130_fd_sc_hd__tapvpwrvgnd_1
Xmax_cap522 net523 VGND VGND VPWR VPWR net522 sky130_fd_sc_hd__buf_1
XFILLER_190_648 VPWR VGND VPWR VGND sky130_ef_sc_hd__decap_12
XFILLER_239_1444 VPWR VGND VPWR VGND sky130_ef_sc_hd__decap_12
Xmax_cap533 net58 VGND VGND VPWR VPWR net533 sky130_fd_sc_hd__clkbuf_1
Xmax_cap544 net545 VGND VGND VPWR VPWR net544 sky130_fd_sc_hd__clkbuf_1
Xmax_cap566 net65 VGND VGND VPWR VPWR net566 sky130_fd_sc_hd__clkbuf_1
XFILLER_171_873 VPWR VGND VPWR VGND sky130_ef_sc_hd__decap_12
XFILLER_192_1035 VPWR VGND VPWR VGND sky130_ef_sc_hd__decap_12
XFILLER_254_34 VPWR VGND VPWR VGND sky130_ef_sc_hd__decap_12
XFILLER_239_1499 VGND VGND VPWR VPWR sky130_fd_sc_hd__decap_6
XFILLER_107_39 VGND VGND VPWR VPWR sky130_fd_sc_hd__decap_4
XFILLER_157_1177 VPWR VGND VPWR VGND sky130_ef_sc_hd__decap_12
XPHY_EDGE_ROW_145_2_Right_236 VGND VGND VPWR VPWR sky130_fd_sc_hd__decap_3
XFILLER_254_89 VPWR VGND VPWR VGND sky130_ef_sc_hd__decap_12
XFILLER_44_1325 VPWR VGND VPWR VGND sky130_ef_sc_hd__decap_12
XFILLER_135_1464 VPWR VGND VPWR VGND sky130_ef_sc_hd__decap_12
XFILLER_170_1355 VPWR VGND VPWR VGND sky130_ef_sc_hd__decap_12
XFILLER_229_123 VGND VGND VPWR VPWR sky130_fd_sc_hd__decap_6
XFILLER_218_808 VPWR VGND VPWR VGND sky130_ef_sc_hd__decap_12
XFILLER_233_1076 VPWR VGND VPWR VGND sky130_ef_sc_hd__decap_12
XFILLER_131_1328 VGND VGND VPWR VPWR sky130_fd_sc_hd__decap_6
XFILLER_123_27 VPWR VGND VPWR VGND sky130_ef_sc_hd__decap_12
XFILLER_245_627 VPWR VGND VPWR VGND sky130_ef_sc_hd__decap_12
XFILLER_226_863 VPWR VGND VPWR VGND sky130_ef_sc_hd__decap_12
XFILLER_241_811 VGND VGND VPWR VPWR sky130_fd_sc_hd__decap_6
XFILLER_168_1262 VGND VGND VPWR VPWR sky130_fd_sc_hd__decap_6
XFILLER_253_682 VGND VGND VPWR VPWR sky130_fd_sc_hd__decap_6
XFILLER_0_1441 VGND VGND VPWR VPWR sky130_fd_sc_hd__decap_8
XFILLER_20_1380 VPWR VGND VPWR VGND sky130_ef_sc_hd__decap_12
XFILLER_16_58 VGND VGND VPWR VPWR sky130_fd_sc_hd__decap_6
XPHY_EDGE_ROW_9_Left_265 VGND VGND VPWR VPWR sky130_fd_sc_hd__decap_3
XFILLER_77_1189 VPWR VGND VPWR VGND sky130_ef_sc_hd__decap_12
XFILLER_55_1421 VPWR VGND VPWR VGND sky130_ef_sc_hd__decap_12
XFILLER_107_1500 VGND VGND VPWR VPWR sky130_fd_sc_hd__decap_6
XFILLER_179_940 VGND VGND VPWR VPWR sky130_fd_sc_hd__decap_6
XFILLER_205_1112 VGND VGND VPWR VPWR sky130_fd_sc_hd__decap_6
XFILLER_200_218 VPWR VGND VPWR VGND sky130_ef_sc_hd__decap_12
XFILLER_244_1183 VPWR VGND VPWR VGND sky130_ef_sc_hd__decap_12
XFILLER_55_1476 VPWR VGND VPWR VGND sky130_ef_sc_hd__decap_12
XFILLER_90_1356 VPWR VGND VPWR VGND sky130_ef_sc_hd__decap_12
XFILLER_142_1435 VGND VGND VPWR VPWR sky130_fd_sc_hd__decap_6
XFILLER_240_1047 VGND VGND VPWR VPWR sky130_fd_sc_hd__decap_6
XFILLER_32_46 VGND VGND VPWR VPWR sky130_fd_sc_hd__decap_8
XFILLER_193_431 VPWR VGND VPWR VGND sky130_ef_sc_hd__decap_12
XFILLER_148_46 VPWR VGND VPWR VGND sky130_ef_sc_hd__decap_12
XFILLER_166_667 VPWR VGND VPWR VGND sky130_ef_sc_hd__decap_12
XFILLER_181_615 VPWR VGND VPWR VGND sky130_ef_sc_hd__decap_12
XPHY_EDGE_ROW_104_2_Left_606 VGND VGND VPWR VPWR sky130_fd_sc_hd__decap_3
XFILLER_193_486 VPWR VGND VPWR VGND sky130_ef_sc_hd__decap_12
XFILLER_14_1184 VPWR VGND VPWR VGND sky130_ef_sc_hd__decap_12
XFILLER_5_839 VGND VGND VPWR VPWR sky130_fd_sc_hd__decap_3
XTAP_TAPCELL_ROW_173_1794 VGND VPWR sky130_fd_sc_hd__tapvpwrvgnd_1
XFILLER_88_1263 VGND VGND VPWR VPWR sky130_fd_sc_hd__decap_6
XFILLER_101_1165 VPWR VGND VPWR VGND sky130_ef_sc_hd__decap_12
XFILLER_164_34 VPWR VGND VPWR VGND sky130_ef_sc_hd__decap_12
XFILLER_136_1239 VPWR VGND VPWR VGND sky130_ef_sc_hd__decap_12
XFILLER_171_1119 VPWR VGND VPWR VGND sky130_ef_sc_hd__decap_12
XFILLER_251_1143 VPWR VGND VPWR VGND sky130_ef_sc_hd__decap_12
XFILLER_248_421 VPWR VGND VPWR VGND sky130_ef_sc_hd__decap_12
XFILLER_236_605 VPWR VGND VPWR VGND sky130_ef_sc_hd__decap_12
XFILLER_251_1198 VGND VGND VPWR VPWR sky130_fd_sc_hd__decap_6
XFILLER_180_22 VPWR VGND VPWR VGND sky130_ef_sc_hd__decap_12
XFILLER_248_476 VPWR VGND VPWR VGND sky130_ef_sc_hd__decap_12
XTAP_TAPCELL_ROW_167_1587 VGND VPWR sky130_fd_sc_hd__tapvpwrvgnd_1
XTAP_TAPCELL_ROW_167_1598 VGND VPWR sky130_fd_sc_hd__tapvpwrvgnd_1
XFILLER_169_1026 VGND VGND VPWR VPWR sky130_fd_sc_hd__decap_6
XFILLER_217_830 VPWR VGND VPWR VGND sky130_ef_sc_hd__decap_12
XFILLER_1_1205 VPWR VGND VPWR VGND sky130_ef_sc_hd__decap_12
XFILLER_180_77 VPWR VGND VPWR VGND sky130_ef_sc_hd__decap_12
XFILLER_95_1201 VGND VGND VPWR VPWR sky130_fd_sc_hd__decap_4
XTAP_TAPCELL_ROW_127_2_5677 VGND VPWR sky130_fd_sc_hd__tapvpwrvgnd_1
XTAP_TAPCELL_ROW_95_2_5422 VGND VPWR sky130_fd_sc_hd__tapvpwrvgnd_1
XFILLER_244_660 VGND VGND VPWR VPWR sky130_fd_sc_hd__decap_6
XFILLER_21_1177 VPWR VGND VPWR VGND sky130_ef_sc_hd__decap_12
XFILLER_112_1294 VPWR VGND VPWR VGND sky130_ef_sc_hd__decap_12
XFILLER_217_885 VPWR VGND VPWR VGND sky130_ef_sc_hd__decap_12
XFILLER_147_1335 VPWR VGND VPWR VGND sky130_ef_sc_hd__decap_12
XFILLER_182_1226 VPWR VGND VPWR VGND sky130_ef_sc_hd__decap_12
XTAP_TAPCELL_ROW_107_2_5520 VGND VPWR sky130_fd_sc_hd__tapvpwrvgnd_1
XFILLER_227_1370 VGND VGND VPWR VPWR sky130_fd_sc_hd__decap_6
XFILLER_176_409 VPWR VGND VPWR VGND sky130_ef_sc_hd__decap_12
XTAP_TAPCELL_ROW_251_4540 VGND VPWR sky130_fd_sc_hd__tapvpwrvgnd_1
XTAP_TAPCELL_ROW_251_4551 VGND VPWR sky130_fd_sc_hd__tapvpwrvgnd_1
XFILLER_196_280 VPWR VGND VPWR VGND sky130_ef_sc_hd__decap_12
XFILLER_7_110 VPWR VGND VPWR VGND sky130_ef_sc_hd__decap_12
XPHY_EDGE_ROW_36_2_Left_538 VGND VGND VPWR VPWR sky130_fd_sc_hd__decap_3
XTAP_TAPCELL_ROW_56_2_5106 VGND VPWR sky130_fd_sc_hd__tapvpwrvgnd_1
XFILLER_32_1251 VPWR VGND VPWR VGND sky130_ef_sc_hd__decap_12
XFILLER_184_464 VPWR VGND VPWR VGND sky130_ef_sc_hd__decap_12
XFILLER_200_796 VPWR VGND VPWR VGND sky130_ef_sc_hd__decap_12
XFILLER_123_1390 VPWR VGND VPWR VGND sky130_ef_sc_hd__decap_12
XFILLER_172_648 VPWR VGND VPWR VGND sky130_ef_sc_hd__decap_12
XFILLER_158_1442 VPWR VGND VPWR VGND sky130_ef_sc_hd__decap_12
XTAP_TAPCELL_ROW_249_4480 VGND VPWR sky130_fd_sc_hd__tapvpwrvgnd_1
XTAP_TAPCELL_ROW_245_4322 VGND VPWR sky130_fd_sc_hd__tapvpwrvgnd_1
XFILLER_67_1347 VPWR VGND VPWR VGND sky130_ef_sc_hd__decap_12
XTAP_TAPCELL_ROW_245_4333 VGND VPWR sky130_fd_sc_hd__tapvpwrvgnd_1
XFILLER_154_1306 VGND VGND VPWR VPWR sky130_fd_sc_hd__decap_6
XTAP_TAPCELL_ROW_23_2_4847 VGND VPWR sky130_fd_sc_hd__tapvpwrvgnd_1
XTAP_TAPCELL_ROW_245_4344 VGND VPWR sky130_fd_sc_hd__tapvpwrvgnd_1
XFILLER_3_371 VGND VGND VPWR VPWR sky130_fd_sc_hd__fill_1
XFILLER_4_894 VPWR VGND VPWR VGND sky130_ef_sc_hd__decap_12
XFILLER_158_1497 VPWR VGND VPWR VGND sky130_ef_sc_hd__decap_12
XFILLER_193_1377 VPWR VGND VPWR VGND sky130_ef_sc_hd__decap_12
XTAP_TAPCELL_ROW_241_4208 VGND VPWR sky130_fd_sc_hd__tapvpwrvgnd_1
XPHY_EDGE_ROW_98_2_Left_600 VGND VGND VPWR VPWR sky130_fd_sc_hd__decap_3
XFILLER_224_15 VGND VGND VPWR VPWR sky130_fd_sc_hd__decap_6
XFILLER_239_443 VPWR VGND VPWR VGND sky130_ef_sc_hd__decap_12
XTAP_TAPCELL_ROW_7_1111 VGND VPWR sky130_fd_sc_hd__tapvpwrvgnd_1
XPHY_EDGE_ROW_150_2_Left_652 VGND VGND VPWR VPWR sky130_fd_sc_hd__decap_3
XFILLER_230_1238 VPWR VGND VPWR VGND sky130_ef_sc_hd__decap_12
XFILLER_255_925 VPWR VGND VPWR VGND sky130_ef_sc_hd__decap_12
XFILLER_254_402 VGND VGND VPWR VPWR sky130_fd_sc_hd__decap_6
XTAP_TAPCELL_ROW_7_1122 VGND VPWR sky130_fd_sc_hd__tapvpwrvgnd_1
XFILLER_14_3 VPWR VGND VPWR VGND sky130_ef_sc_hd__decap_12
XTAP_TAPCELL_ROW_7_1133 VGND VPWR sky130_fd_sc_hd__tapvpwrvgnd_1
XFILLER_227_627 VPWR VGND VPWR VGND sky130_ef_sc_hd__decap_12
XFILLER_239_498 VPWR VGND VPWR VGND sky130_ef_sc_hd__decap_12
XFILLER_255_958 VGND VGND VPWR VPWR sky130_fd_sc_hd__decap_8
XTAP_TAPCELL_ROW_206_2959 VGND VPWR sky130_fd_sc_hd__tapvpwrvgnd_1
XTAP_TAPCELL_ROW_239_4104 VGND VPWR sky130_fd_sc_hd__tapvpwrvgnd_1
XTAP_TAPCELL_ROW_239_4115 VGND VPWR sky130_fd_sc_hd__tapvpwrvgnd_1
XTAP_TAPCELL_ROW_239_4126 VGND VPWR sky130_fd_sc_hd__tapvpwrvgnd_1
XTAP_TAPCELL_ROW_239_4137 VGND VPWR sky130_fd_sc_hd__tapvpwrvgnd_1
XFILLER_208_863 VPWR VGND VPWR VGND sky130_ef_sc_hd__decap_12
XFILLER_223_811 VGND VGND VPWR VPWR sky130_fd_sc_hd__decap_6
XFILLER_78_1454 VPWR VGND VPWR VGND sky130_ef_sc_hd__decap_12
XFILLER_240_58 VGND VGND VPWR VPWR sky130_fd_sc_hd__decap_6
XFILLER_235_682 VGND VGND VPWR VPWR sky130_fd_sc_hd__decap_6
XPHY_EDGE_ROW_102_1_Left_357 VGND VGND VPWR VPWR sky130_fd_sc_hd__decap_3
XFILLER_206_1410 VPWR VGND VPWR VGND sky130_ef_sc_hd__decap_12
XFILLER_194_206 VPWR VGND VPWR VGND sky130_ef_sc_hd__decap_12
XFILLER_241_1334 VPWR VGND VPWR VGND sky130_ef_sc_hd__decap_12
XFILLER_210_538 VPWR VGND VPWR VGND sky130_ef_sc_hd__decap_12
XFILLER_249_56 VPWR VGND VPWR VGND sky130_ef_sc_hd__decap_12
XTAP_TAPCELL_ROW_98_1_1376 VGND VPWR sky130_fd_sc_hd__tapvpwrvgnd_1
XFILLER_206_1465 VPWR VGND VPWR VGND sky130_ef_sc_hd__decap_12
XFILLER_175_431 VPWR VGND VPWR VGND sky130_ef_sc_hd__decap_12
XFILLER_241_1389 VPWR VGND VPWR VGND sky130_ef_sc_hd__decap_12
XFILLER_124_1165 VPWR VGND VPWR VGND sky130_ef_sc_hd__decap_12
XTAP_TAPCELL_ROW_15_1_1252 VGND VPWR sky130_fd_sc_hd__tapvpwrvgnd_1
XFILLER_159_1206 VPWR VGND VPWR VGND sky130_ef_sc_hd__decap_12
XFILLER_175_486 VPWR VGND VPWR VGND sky130_ef_sc_hd__decap_12
XFILLER_11_1335 VPWR VGND VPWR VGND sky130_ef_sc_hd__decap_12
XFILLER_190_445 VGND VGND VPWR VPWR sky130_fd_sc_hd__decap_6
XFILLER_239_1241 VGND VGND VPWR VPWR sky130_fd_sc_hd__decap_6
XFILLER_85_1414 VGND VGND VPWR VPWR sky130_fd_sc_hd__decap_6
Xmax_cap330 net331 VGND VGND VPWR VPWR net330 sky130_fd_sc_hd__clkbuf_1
XFILLER_102_1485 VPWR VGND VPWR VGND sky130_ef_sc_hd__decap_12
XFILLER_200_1097 VPWR VGND VPWR VGND sky130_ef_sc_hd__decap_12
XFILLER_171_670 VPWR VGND VPWR VGND sky130_ef_sc_hd__decap_12
XFILLER_252_1441 VPWR VGND VPWR VGND sky130_ef_sc_hd__decap_12
XFILLER_134_15 VGND VGND VPWR VPWR sky130_fd_sc_hd__decap_6
XPHY_EDGE_ROW_82_2_Left_584 VGND VGND VPWR VPWR sky130_fd_sc_hd__decap_3
XFILLER_135_1261 VPWR VGND VPWR VGND sky130_ef_sc_hd__decap_12
XPHY_EDGE_ROW_146_2_Right_237 VGND VGND VPWR VPWR sky130_fd_sc_hd__decap_3
XTAP_TAPCELL_ROW_144_2_5816 VGND VPWR sky130_fd_sc_hd__tapvpwrvgnd_1
XFILLER_170_1152 VPWR VGND VPWR VGND sky130_ef_sc_hd__decap_12
XFILLER_252_1496 VPWR VGND VPWR VGND sky130_ef_sc_hd__decap_12
XFILLER_218_605 VPWR VGND VPWR VGND sky130_ef_sc_hd__decap_12
XFILLER_246_925 VPWR VGND VPWR VGND sky130_ef_sc_hd__decap_12
XFILLER_44_1177 VGND VGND VPWR VPWR sky130_fd_sc_hd__decap_6
XTAP_TAPCELL_ROW_113_2_5563 VGND VPWR sky130_fd_sc_hd__tapvpwrvgnd_1
XFILLER_245_424 VGND VGND VPWR VPWR sky130_fd_sc_hd__decap_6
XFILLER_79_1218 VPWR VGND VPWR VGND sky130_ef_sc_hd__decap_12
XFILLER_22_1442 VPWR VGND VPWR VGND sky130_ef_sc_hd__decap_12
XFILLER_2_1514 VGND VGND VPWR VPWR sky130_fd_sc_hd__fill_1
XFILLER_226_660 VGND VGND VPWR VPWR sky130_fd_sc_hd__decap_6
XFILLER_254_980 VPWR VGND VPWR VGND sky130_ef_sc_hd__decap_12
XFILLER_22_1497 VPWR VGND VPWR VGND sky130_ef_sc_hd__decap_12
XFILLER_150_58 VGND VGND VPWR VPWR sky130_fd_sc_hd__decap_6
XPHY_EDGE_ROW_34_1_Left_289 VGND VGND VPWR VPWR sky130_fd_sc_hd__decap_3
XTAP_TAPCELL_ROW_1_897 VGND VPWR sky130_fd_sc_hd__tapvpwrvgnd_1
XFILLER_242_1109 VPWR VGND VPWR VGND sky130_ef_sc_hd__decap_12
XFILLER_207_1229 VPWR VGND VPWR VGND sky130_ef_sc_hd__decap_12
XTAP_TAPCELL_ROW_16_2_4790 VGND VPWR sky130_fd_sc_hd__tapvpwrvgnd_1
XFILLER_0_1282 VPWR VGND VPWR VGND sky130_ef_sc_hd__decap_12
XFILLER_240_151 VPWR VGND VPWR VGND sky130_ef_sc_hd__decap_12
XPHY_EDGE_ROW_254_Right_99 VGND VGND VPWR VPWR sky130_fd_sc_hd__decap_3
XFILLER_55_1273 VPWR VGND VPWR VGND sky130_ef_sc_hd__decap_12
XFILLER_185_228 VPWR VGND VPWR VGND sky130_ef_sc_hd__decap_12
XFILLER_159_56 VPWR VGND VPWR VGND sky130_ef_sc_hd__decap_12
XFILLER_178_280 VPWR VGND VPWR VGND sky130_ef_sc_hd__decap_12
XTAP_TAPCELL_ROW_175_1867 VGND VPWR sky130_fd_sc_hd__tapvpwrvgnd_1
XFILLER_166_464 VPWR VGND VPWR VGND sky130_ef_sc_hd__decap_12
XTAP_TAPCELL_ROW_175_1878 VGND VPWR sky130_fd_sc_hd__tapvpwrvgnd_1
XTAP_TAPCELL_ROW_216_3299 VGND VPWR sky130_fd_sc_hd__tapvpwrvgnd_1
XFILLER_5_603 VGND VGND VPWR VPWR sky130_fd_sc_hd__fill_1
XFILLER_103_1249 VPWR VGND VPWR VGND sky130_ef_sc_hd__decap_12
XTAP_TAPCELL_ROW_175_1889 VGND VPWR sky130_fd_sc_hd__tapvpwrvgnd_1
XPHY_EDGE_ROW_96_1_Left_351 VGND VGND VPWR VPWR sky130_fd_sc_hd__decap_3
XFILLER_181_412 VPWR VGND VPWR VGND sky130_ef_sc_hd__decap_12
XFILLER_216_3 VPWR VGND VPWR VGND sky130_ef_sc_hd__decap_12
XFILLER_193_283 VPWR VGND VPWR VGND sky130_ef_sc_hd__decap_12
XFILLER_182_968 VPWR VGND VPWR VGND sky130_ef_sc_hd__decap_12
XFILLER_175_44 VPWR VGND VPWR VGND sky130_ef_sc_hd__decap_12
XFILLER_5_669 VGND VGND VPWR VPWR sky130_fd_sc_hd__fill_1
XFILLER_181_467 VGND VGND VPWR VPWR sky130_fd_sc_hd__decap_6
XFILLER_253_1205 VPWR VGND VPWR VGND sky130_ef_sc_hd__decap_12
XFILLER_64_1509 VGND VGND VPWR VPWR sky130_fd_sc_hd__decap_6
XFILLER_175_99 VPWR VGND VPWR VGND sky130_ef_sc_hd__decap_12
XFILLER_218_1336 VPWR VGND VPWR VGND sky130_ef_sc_hd__decap_12
XFILLER_66_1380 VPWR VGND VPWR VGND sky130_ef_sc_hd__decap_12
XFILLER_231_1514 VGND VGND VPWR VPWR sky130_fd_sc_hd__fill_1
XFILLER_23_1206 VPWR VGND VPWR VGND sky130_ef_sc_hd__decap_12
XFILLER_191_87 VPWR VGND VPWR VGND sky130_ef_sc_hd__decap_12
XFILLER_236_402 VGND VGND VPWR VPWR sky130_fd_sc_hd__decap_6
XFILLER_248_273 VGND VGND VPWR VPWR sky130_fd_sc_hd__decap_6
XFILLER_114_1356 VPWR VGND VPWR VGND sky130_ef_sc_hd__decap_12
XFILLER_209_627 VPWR VGND VPWR VGND sky130_ef_sc_hd__decap_12
XFILLER_237_947 VPWR VGND VPWR VGND sky130_ef_sc_hd__decap_12
XFILLER_252_906 VPWR VGND VPWR VGND sky130_ef_sc_hd__decap_12
XFILLER_1_1002 VPWR VGND VPWR VGND sky130_ef_sc_hd__decap_12
X_656_ clknet_3_4__leaf_clk acc_core.adder.cla_blocks\[5\].block.sum\[2\] _064_ VGND
+ VGND VPWR VPWR net57 sky130_fd_sc_hd__dfrtp_1
XTAP_TAPCELL_ROW_201_2801 VGND VPWR sky130_fd_sc_hd__tapvpwrvgnd_1
XFILLER_205_811 VGND VGND VPWR VPWR sky130_fd_sc_hd__decap_6
XFILLER_217_682 VGND VGND VPWR VPWR sky130_fd_sc_hd__decap_6
XFILLER_229_1432 VPWR VGND VPWR VGND sky130_ef_sc_hd__decap_12
XFILLER_1_1057 VPWR VGND VPWR VGND sky130_ef_sc_hd__decap_12
XTAP_TAPCELL_ROW_253_4602 VGND VPWR sky130_fd_sc_hd__tapvpwrvgnd_1
XTAP_TAPCELL_ROW_253_4613 VGND VPWR sky130_fd_sc_hd__tapvpwrvgnd_1
XTAP_TAPCELL_ROW_253_4624 VGND VPWR sky130_fd_sc_hd__tapvpwrvgnd_1
X_587_ net671 VGND VGND VPWR VPWR _069_ sky130_fd_sc_hd__inv_2
XFILLER_182_1023 VPWR VGND VPWR VGND sky130_ef_sc_hd__decap_12
XFILLER_229_1487 VPWR VGND VPWR VGND sky130_ef_sc_hd__decap_12
XFILLER_147_1165 VPWR VGND VPWR VGND sky130_ef_sc_hd__decap_12
XFILLER_176_206 VPWR VGND VPWR VGND sky130_ef_sc_hd__decap_12
XFILLER_182_1078 VPWR VGND VPWR VGND sky130_ef_sc_hd__decap_12
XFILLER_231_173 VPWR VGND VPWR VGND sky130_ef_sc_hd__decap_12
XFILLER_34_1313 VPWR VGND VPWR VGND sky130_ef_sc_hd__decap_12
XFILLER_34_1368 VPWR VGND VPWR VGND sky130_ef_sc_hd__decap_12
XFILLER_121_1316 VPWR VGND VPWR VGND sky130_ef_sc_hd__decap_12
XFILLER_219_15 VPWR VGND VPWR VGND sky130_ef_sc_hd__decap_12
XFILLER_191_209 VGND VGND VPWR VPWR sky130_fd_sc_hd__decap_6
XFILLER_8_452 VGND VGND VPWR VPWR sky130_fd_sc_hd__fill_2
XFILLER_184_261 VPWR VGND VPWR VGND sky130_ef_sc_hd__decap_12
XFILLER_200_593 VPWR VGND VPWR VGND sky130_ef_sc_hd__decap_12
XTAP_TAPCELL_ROW_247_4406 VGND VPWR sky130_fd_sc_hd__tapvpwrvgnd_1
XTAP_TAPCELL_ROW_247_4417 VGND VPWR sky130_fd_sc_hd__tapvpwrvgnd_1
XFILLER_172_445 VGND VGND VPWR VPWR sky130_fd_sc_hd__decap_6
XTAP_TAPCELL_ROW_150_2_5859 VGND VPWR sky130_fd_sc_hd__tapvpwrvgnd_1
XFILLER_119_1201 VGND VGND VPWR VPWR sky130_fd_sc_hd__decap_4
XPHY_EDGE_ROW_134_1_Right_790 VGND VGND VPWR VPWR sky130_fd_sc_hd__decap_3
XFILLER_181_990 VPWR VGND VPWR VGND sky130_ef_sc_hd__decap_12
XFILLER_67_1177 VPWR VGND VPWR VGND sky130_ef_sc_hd__decap_12
XFILLER_158_1294 VPWR VGND VPWR VGND sky130_ef_sc_hd__decap_12
XFILLER_193_1174 VPWR VGND VPWR VGND sky130_ef_sc_hd__decap_12
XTAP_TAPCELL_ROW_130_2_5702 VGND VPWR sky130_fd_sc_hd__tapvpwrvgnd_1
XTAP_TAPCELL_ROW_9_1206 VGND VPWR sky130_fd_sc_hd__tapvpwrvgnd_1
XTAP_TAPCELL_ROW_9_1217 VGND VPWR sky130_fd_sc_hd__tapvpwrvgnd_1
XFILLER_45_1464 VPWR VGND VPWR VGND sky130_ef_sc_hd__decap_12
XTAP_TAPCELL_ROW_9_1228 VGND VPWR sky130_fd_sc_hd__tapvpwrvgnd_1
XTAP_TAPCELL_ROW_9_1239 VGND VPWR sky130_fd_sc_hd__tapvpwrvgnd_1
XFILLER_239_240 VPWR VGND VPWR VGND sky130_ef_sc_hd__decap_12
XFILLER_132_1423 VPWR VGND VPWR VGND sky130_ef_sc_hd__decap_12
XFILLER_228_925 VPWR VGND VPWR VGND sky130_ef_sc_hd__decap_12
XFILLER_41_1328 VGND VGND VPWR VPWR sky130_fd_sc_hd__decap_6
XFILLER_230_1035 VPWR VGND VPWR VGND sky130_ef_sc_hd__decap_12
XFILLER_80_1399 VPWR VGND VPWR VGND sky130_ef_sc_hd__decap_12
XFILLER_227_424 VGND VGND VPWR VPWR sky130_fd_sc_hd__decap_6
XFILLER_239_295 VGND VGND VPWR VPWR sky130_fd_sc_hd__decap_6
XFILLER_132_1478 VGND VGND VPWR VPWR sky130_fd_sc_hd__decap_6
XFILLER_251_68 VPWR VGND VPWR VGND sky130_ef_sc_hd__decap_12
XPHY_EDGE_ROW_70_2_Right_161 VGND VGND VPWR VPWR sky130_fd_sc_hd__decap_3
XFILLER_243_928 VPWR VGND VPWR VGND sky130_ef_sc_hd__decap_12
XFILLER_208_660 VGND VGND VPWR VPWR sky130_fd_sc_hd__decap_6
XFILLER_255_799 VPWR VGND VPWR VGND sky130_ef_sc_hd__decap_12
XFILLER_236_980 VPWR VGND VPWR VGND sky130_ef_sc_hd__decap_12
XFILLER_78_1251 VPWR VGND VPWR VGND sky130_ef_sc_hd__decap_12
XFILLER_165_1210 VGND VGND VPWR VPWR sky130_fd_sc_hd__decap_8
XFILLER_251_983 VGND VGND VPWR VPWR sky130_fd_sc_hd__decap_6
XFILLER_17_1500 VGND VGND VPWR VPWR sky130_fd_sc_hd__decap_6
XFILLER_222_151 VPWR VGND VPWR VGND sky130_ef_sc_hd__decap_12
XFILLER_126_1227 VPWR VGND VPWR VGND sky130_ef_sc_hd__decap_12
XFILLER_167_228 VPWR VGND VPWR VGND sky130_ef_sc_hd__decap_12
XFILLER_210_335 VPWR VGND VPWR VGND sky130_ef_sc_hd__decap_12
XFILLER_241_1131 VPWR VGND VPWR VGND sky130_ef_sc_hd__decap_12
XFILLER_13_15 VPWR VGND VPWR VGND sky130_ef_sc_hd__decap_12
XFILLER_52_1435 VGND VGND VPWR VPWR sky130_fd_sc_hd__decap_6
XFILLER_206_1262 VGND VGND VPWR VPWR sky130_fd_sc_hd__decap_6
XFILLER_129_15 VPWR VGND VPWR VGND sky130_ef_sc_hd__decap_12
XFILLER_241_1186 VPWR VGND VPWR VGND sky130_ef_sc_hd__decap_12
XFILLER_175_283 VPWR VGND VPWR VGND sky130_ef_sc_hd__decap_12
XFILLER_191_732 VPWR VGND VPWR VGND sky130_ef_sc_hd__decap_12
XTAP_TAPCELL_ROW_211_3130 VGND VPWR sky130_fd_sc_hd__tapvpwrvgnd_1
XTAP_TAPCELL_ROW_170_1720 VGND VPWR sky130_fd_sc_hd__tapvpwrvgnd_1
XTAP_TAPCELL_ROW_211_3141 VGND VPWR sky130_fd_sc_hd__tapvpwrvgnd_1
XTAP_TAPCELL_ROW_211_3152 VGND VPWR sky130_fd_sc_hd__tapvpwrvgnd_1
XFILLER_11_1165 VPWR VGND VPWR VGND sky130_ef_sc_hd__decap_12
XFILLER_102_1282 VPWR VGND VPWR VGND sky130_ef_sc_hd__decap_12
XFILLER_191_787 VPWR VGND VPWR VGND sky130_ef_sc_hd__decap_12
XTAP_TAPCELL_ROW_230_3797 VGND VPWR sky130_fd_sc_hd__tapvpwrvgnd_1
XFILLER_254_1514 VGND VGND VPWR VPWR sky130_fd_sc_hd__fill_1
Xmax_cap160 _156_ VGND VGND VPWR VPWR net160 sky130_fd_sc_hd__clkbuf_1
Xmax_cap182 net183 VGND VGND VPWR VPWR net182 sky130_fd_sc_hd__clkbuf_1
XFILLER_46_1239 VPWR VGND VPWR VGND sky130_ef_sc_hd__decap_12
Xmax_cap193 _217_ VGND VGND VPWR VPWR net193 sky130_fd_sc_hd__clkbuf_1
XFILLER_137_1378 VPWR VGND VPWR VGND sky130_ef_sc_hd__decap_12
XFILLER_172_1269 VPWR VGND VPWR VGND sky130_ef_sc_hd__decap_12
XTAP_TAPCELL_ROW_209_3070 VGND VPWR sky130_fd_sc_hd__tapvpwrvgnd_1
XFILLER_225_80 VGND VGND VPWR VPWR sky130_fd_sc_hd__decap_6
XFILLER_252_1293 VPWR VGND VPWR VGND sky130_ef_sc_hd__decap_12
XFILLER_38_34 VPWR VGND VPWR VGND sky130_ef_sc_hd__decap_12
XTAP_TAPCELL_ROW_209_3081 VGND VPWR sky130_fd_sc_hd__tapvpwrvgnd_1
XFILLER_218_402 VGND VGND VPWR VPWR sky130_fd_sc_hd__decap_6
XFILLER_246_722 VPWR VGND VPWR VGND sky130_ef_sc_hd__decap_12
XPHY_EDGE_ROW_147_2_Right_238 VGND VGND VPWR VPWR sky130_fd_sc_hd__decap_3
XFILLER_219_947 VPWR VGND VPWR VGND sky130_ef_sc_hd__decap_12
XFILLER_111_1507 VGND VGND VPWR VPWR sky130_fd_sc_hd__decap_8
XTAP_TAPCELL_ROW_224_3579 VGND VPWR sky130_fd_sc_hd__tapvpwrvgnd_1
XFILLER_234_906 VPWR VGND VPWR VGND sky130_ef_sc_hd__decap_12
XFILLER_161_68 VGND VGND VPWR VPWR sky130_fd_sc_hd__decap_3
XFILLER_246_777 VPWR VGND VPWR VGND sky130_ef_sc_hd__decap_12
X_510_ net597 dout0_q\[30\] net526 VGND VGND VPWR VPWR _261_ sky130_fd_sc_hd__a21o_1
XFILLER_54_22 VPWR VGND VPWR VGND sky130_ef_sc_hd__decap_12
XFILLER_2_1355 VPWR VGND VPWR VGND sky130_ef_sc_hd__decap_12
XFILLER_22_1294 VPWR VGND VPWR VGND sky130_ef_sc_hd__decap_12
XFILLER_166_3 VPWR VGND VPWR VGND sky130_ef_sc_hd__decap_12
X_441_ net196 _217_ VGND VGND VPWR VPWR _230_ sky130_fd_sc_hd__and2b_1
XFILLER_242_961 VGND VGND VPWR VPWR sky130_fd_sc_hd__decap_6
XFILLER_57_1335 VPWR VGND VPWR VGND sky130_ef_sc_hd__decap_12
XFILLER_199_854 VGND VGND VPWR VPWR sky130_fd_sc_hd__decap_6
XFILLER_109_1414 VGND VGND VPWR VPWR sky130_fd_sc_hd__decap_6
XFILLER_148_1485 VPWR VGND VPWR VGND sky130_ef_sc_hd__decap_12
XFILLER_207_1026 VGND VGND VPWR VPWR sky130_fd_sc_hd__decap_6
X_372_ net593 net578 net551 VGND VGND VPWR VPWR _161_ sky130_fd_sc_hd__a21o_1
XFILLER_201_302 VPWR VGND VPWR VGND sky130_ef_sc_hd__decap_12
XFILLER_246_1097 VPWR VGND VPWR VGND sky130_ef_sc_hd__decap_12
XFILLER_213_173 VPWR VGND VPWR VGND sky130_ef_sc_hd__decap_12
XFILLER_144_1349 VGND VGND VPWR VPWR sky130_fd_sc_hd__decap_6
XFILLER_201_357 VPWR VGND VPWR VGND sky130_ef_sc_hd__decap_12
XFILLER_70_65 VGND VGND VPWR VPWR sky130_fd_sc_hd__decap_6
XTAP_TAPCELL_ROW_92_2_5399 VGND VPWR sky130_fd_sc_hd__tapvpwrvgnd_1
XFILLER_173_209 VGND VGND VPWR VPWR sky130_fd_sc_hd__decap_6
XFILLER_220_1226 VPWR VGND VPWR VGND sky130_ef_sc_hd__decap_12
XFILLER_166_261 VPWR VGND VPWR VGND sky130_ef_sc_hd__decap_12
XFILLER_182_710 VPWR VGND VPWR VGND sky130_ef_sc_hd__decap_12
XTAP_TAPCELL_ROW_135_2_5739 VGND VPWR sky130_fd_sc_hd__tapvpwrvgnd_1
XFILLER_194_581 VPWR VGND VPWR VGND sky130_ef_sc_hd__decap_12
XFILLER_186_65 VPWR VGND VPWR VGND sky130_ef_sc_hd__decap_12
XFILLER_33_1390 VPWR VGND VPWR VGND sky130_ef_sc_hd__decap_12
XTAP_TAPCELL_ROW_104_2_5497 VGND VPWR sky130_fd_sc_hd__tapvpwrvgnd_1
XFILLER_182_765 VPWR VGND VPWR VGND sky130_ef_sc_hd__decap_12
XTAP_TAPCELL_ROW_156_1_1463 VGND VPWR sky130_fd_sc_hd__tapvpwrvgnd_1
XFILLER_68_1442 VPWR VGND VPWR VGND sky130_ef_sc_hd__decap_12
XFILLER_253_1002 VPWR VGND VPWR VGND sky130_ef_sc_hd__decap_12
XFILLER_170_949 VPWR VGND VPWR VGND sky130_ef_sc_hd__decap_12
XFILLER_64_1306 VGND VGND VPWR VPWR sky130_fd_sc_hd__decap_6
XFILLER_218_1133 VGND VGND VPWR VPWR sky130_fd_sc_hd__decap_6
XFILLER_68_1497 VPWR VGND VPWR VGND sky130_ef_sc_hd__decap_12
XFILLER_155_1445 VPWR VGND VPWR VGND sky130_ef_sc_hd__decap_12
XFILLER_190_1336 VPWR VGND VPWR VGND sky130_ef_sc_hd__decap_12
XFILLER_253_1057 VPWR VGND VPWR VGND sky130_ef_sc_hd__decap_12
XTAP_TAPCELL_ROW_38_2_4966 VGND VPWR sky130_fd_sc_hd__tapvpwrvgnd_1
XFILLER_205_39 VGND VGND VPWR VPWR sky130_fd_sc_hd__decap_4
XFILLER_0_160 VGND VGND VPWR VPWR sky130_fd_sc_hd__decap_8
XFILLER_249_560 VPWR VGND VPWR VGND sky130_ef_sc_hd__decap_12
XFILLER_209_424 VGND VGND VPWR VPWR sky130_fd_sc_hd__decap_6
XFILLER_237_744 VPWR VGND VPWR VGND sky130_ef_sc_hd__decap_12
XFILLER_3_1119 VPWR VGND VPWR VGND sky130_ef_sc_hd__decap_12
XFILLER_231_1377 VPWR VGND VPWR VGND sky130_ef_sc_hd__decap_12
XFILLER_252_703 VGND VGND VPWR VPWR sky130_fd_sc_hd__decap_6
XTAP_TAPCELL_ROW_180_2060 VGND VPWR sky130_fd_sc_hd__tapvpwrvgnd_1
XFILLER_225_928 VPWR VGND VPWR VGND sky130_ef_sc_hd__decap_12
XTAP_TAPCELL_ROW_180_2071 VGND VPWR sky130_fd_sc_hd__tapvpwrvgnd_1
XFILLER_237_799 VPWR VGND VPWR VGND sky130_ef_sc_hd__decap_12
XFILLER_218_980 VPWR VGND VPWR VGND sky130_ef_sc_hd__decap_12
XFILLER_221_27 VPWR VGND VPWR VGND sky130_ef_sc_hd__decap_12
XTAP_TAPCELL_ROW_255_4708 VGND VPWR sky130_fd_sc_hd__tapvpwrvgnd_1
XTAP_TAPCELL_ROW_255_4719 VGND VPWR sky130_fd_sc_hd__tapvpwrvgnd_1
XTAP_TAPCELL_ROW_31_2_4909 VGND VPWR sky130_fd_sc_hd__tapvpwrvgnd_1
XFILLER_75_1402 VPWR VGND VPWR VGND sky130_ef_sc_hd__decap_12
XFILLER_149_1249 VPWR VGND VPWR VGND sky130_ef_sc_hd__decap_12
X_639_ clknet_3_3__leaf_clk acc_core.adder.cla_blocks\[1\].block.sum\[1\] _047_ VGND
+ VGND VPWR VPWR net70 sky130_fd_sc_hd__dfrtp_1
XFILLER_75_1457 VGND VGND VPWR VPWR sky130_fd_sc_hd__decap_6
XFILLER_204_151 VPWR VGND VPWR VGND sky130_ef_sc_hd__decap_12
XFILLER_229_1284 VGND VGND VPWR VPWR sky130_fd_sc_hd__decap_6
XFILLER_233_983 VGND VGND VPWR VPWR sky130_fd_sc_hd__decap_6
XPHY_EDGE_ROW_109_2_Right_200 VGND VGND VPWR VPWR sky130_fd_sc_hd__decap_3
XFILLER_81_3 VPWR VGND VPWR VGND sky130_ef_sc_hd__decap_12
XFILLER_203_1413 VGND VGND VPWR VPWR sky130_fd_sc_hd__decap_6
XFILLER_242_1484 VPWR VGND VPWR VGND sky130_ef_sc_hd__decap_12
XFILLER_192_507 VPWR VGND VPWR VGND sky130_ef_sc_hd__decap_12
XFILLER_34_1165 VPWR VGND VPWR VGND sky130_ef_sc_hd__decap_12
XTAP_TAPCELL_ROW_193_2498 VGND VPWR sky130_fd_sc_hd__tapvpwrvgnd_1
XFILLER_160_1184 VPWR VGND VPWR VGND sky130_ef_sc_hd__decap_12
XFILLER_8_260 VGND VGND VPWR VPWR sky130_fd_sc_hd__decap_8
XFILLER_200_390 VPWR VGND VPWR VGND sky130_ef_sc_hd__decap_12
XFILLER_69_1206 VPWR VGND VPWR VGND sky130_ef_sc_hd__decap_12
XFILLER_173_732 VPWR VGND VPWR VGND sky130_ef_sc_hd__decap_12
XFILLER_246_46 VPWR VGND VPWR VGND sky130_ef_sc_hd__decap_12
XFILLER_173_787 VPWR VGND VPWR VGND sky130_ef_sc_hd__decap_12
XFILLER_12_1485 VPWR VGND VPWR VGND sky130_ef_sc_hd__decap_12
XPHY_EDGE_ROW_135_1_Right_791 VGND VGND VPWR VPWR sky130_fd_sc_hd__decap_3
XFILLER_115_39 VGND VGND VPWR VPWR sky130_fd_sc_hd__decap_4
XFILLER_45_1261 VPWR VGND VPWR VGND sky130_ef_sc_hd__decap_12
XFILLER_132_1220 VGND VGND VPWR VPWR sky130_fd_sc_hd__decap_6
XFILLER_228_722 VPWR VGND VPWR VGND sky130_ef_sc_hd__decap_12
XFILLER_171_1291 VPWR VGND VPWR VGND sky130_ef_sc_hd__decap_12
XTAP_TAPCELL_ROW_160_2_5941 VGND VPWR sky130_fd_sc_hd__tapvpwrvgnd_1
XFILLER_80_1196 VPWR VGND VPWR VGND sky130_ef_sc_hd__decap_12
XTAP_TAPCELL_ROW_159_2_5935 VGND VPWR sky130_fd_sc_hd__tapvpwrvgnd_1
XFILLER_216_906 VPWR VGND VPWR VGND sky130_ef_sc_hd__decap_12
XFILLER_228_777 VPWR VGND VPWR VGND sky130_ef_sc_hd__decap_12
XTAP_TAPCELL_ROW_128_2_5682 VGND VPWR sky130_fd_sc_hd__tapvpwrvgnd_1
XFILLER_243_725 VGND VGND VPWR VPWR sky130_fd_sc_hd__decap_6
XFILLER_131_27 VPWR VGND VPWR VGND sky130_ef_sc_hd__decap_12
XPHY_EDGE_ROW_71_2_Right_162 VGND VGND VPWR VPWR sky130_fd_sc_hd__decap_3
XTAP_TAPCELL_ROW_86_1_1358 VGND VPWR sky130_fd_sc_hd__tapvpwrvgnd_1
XFILLER_167_1327 VGND VGND VPWR VPWR sky130_fd_sc_hd__decap_6
XPHY_EDGE_ROW_113_2_Left_615 VGND VGND VPWR VPWR sky130_fd_sc_hd__decap_3
XFILLER_224_961 VGND VGND VPWR VPWR sky130_fd_sc_hd__decap_6
XFILLER_208_1324 VPWR VGND VPWR VGND sky130_ef_sc_hd__decap_12
XFILLER_165_1051 VPWR VGND VPWR VGND sky130_ef_sc_hd__decap_12
XTAP_TAPCELL_ROW_162_1_1473 VGND VPWR sky130_fd_sc_hd__tapvpwrvgnd_1
XFILLER_243_1248 VPWR VGND VPWR VGND sky130_ef_sc_hd__decap_12
XTAP_TAPCELL_ROW_77_2_5279 VGND VPWR sky130_fd_sc_hd__tapvpwrvgnd_1
XFILLER_208_1379 VPWR VGND VPWR VGND sky130_ef_sc_hd__decap_12
XFILLER_210_132 VPWR VGND VPWR VGND sky130_ef_sc_hd__decap_12
XFILLER_195_345 VPWR VGND VPWR VGND sky130_ef_sc_hd__decap_12
XTAP_TAPCELL_ROW_217_3350 VGND VPWR sky130_fd_sc_hd__tapvpwrvgnd_1
XTAP_TAPCELL_ROW_217_3361 VGND VPWR sky130_fd_sc_hd__tapvpwrvgnd_1
XFILLER_91_1292 VPWR VGND VPWR VGND sky130_ef_sc_hd__decap_12
XTAP_TAPCELL_ROW_213_3203 VGND VPWR sky130_fd_sc_hd__tapvpwrvgnd_1
XTAP_TAPCELL_ROW_213_3214 VGND VPWR sky130_fd_sc_hd__tapvpwrvgnd_1
Xwire629 net4 VGND VGND VPWR VPWR net629 sky130_fd_sc_hd__clkbuf_1
XFILLER_143_1371 VGND VGND VPWR VPWR sky130_fd_sc_hd__decap_6
XFILLER_183_529 VPWR VGND VPWR VGND sky130_ef_sc_hd__decap_12
XFILLER_210_187 VGND VGND VPWR VPWR sky130_fd_sc_hd__decap_6
XTAP_TAPCELL_ROW_213_3225 VGND VPWR sky130_fd_sc_hd__tapvpwrvgnd_1
XTAP_TAPCELL_ROW_232_3859 VGND VPWR sky130_fd_sc_hd__tapvpwrvgnd_1
XFILLER_176_581 VPWR VGND VPWR VGND sky130_ef_sc_hd__decap_12
XFILLER_13_1249 VPWR VGND VPWR VGND sky130_ef_sc_hd__decap_12
XFILLER_100_1208 VPWR VGND VPWR VGND sky130_ef_sc_hd__decap_12
XFILLER_178_1434 VGND VGND VPWR VPWR sky130_fd_sc_hd__decap_6
XFILLER_87_1328 VGND VGND VPWR VPWR sky130_fd_sc_hd__decap_6
XFILLER_104_1399 VPWR VGND VPWR VGND sky130_ef_sc_hd__decap_12
XFILLER_3_904 VPWR VGND VPWR VGND sky130_ef_sc_hd__decap_12
XFILLER_156_46 VPWR VGND VPWR VGND sky130_ef_sc_hd__decap_12
XFILLER_191_584 VPWR VGND VPWR VGND sky130_ef_sc_hd__decap_12
XFILLER_219_1420 VPWR VGND VPWR VGND sky130_ef_sc_hd__decap_12
XTAP_TAPCELL_ROW_24_2_4852 VGND VPWR sky130_fd_sc_hd__tapvpwrvgnd_1
XFILLER_3_959 VPWR VGND VPWR VGND sky130_ef_sc_hd__decap_12
XFILLER_172_1011 VPWR VGND VPWR VGND sky130_ef_sc_hd__decap_12
XFILLER_254_1355 VPWR VGND VPWR VGND sky130_ef_sc_hd__decap_12
XFILLER_219_1475 VPWR VGND VPWR VGND sky130_ef_sc_hd__decap_12
XFILLER_2_469 VGND VGND VPWR VPWR sky130_fd_sc_hd__fill_2
XFILLER_49_44 VGND VGND VPWR VPWR sky130_fd_sc_hd__decap_8
XTAP_TAPCELL_ROW_207_3007 VGND VPWR sky130_fd_sc_hd__tapvpwrvgnd_1
XFILLER_250_1219 VGND VGND VPWR VPWR sky130_fd_sc_hd__decap_6
XTAP_TAPCELL_ROW_207_3018 VGND VPWR sky130_fd_sc_hd__tapvpwrvgnd_1
XFILLER_172_34 VPWR VGND VPWR VGND sky130_ef_sc_hd__decap_12
XFILLER_172_1066 VPWR VGND VPWR VGND sky130_ef_sc_hd__decap_12
XFILLER_238_519 VPWR VGND VPWR VGND sky130_ef_sc_hd__decap_12
XFILLER_252_1090 VGND VGND VPWR VPWR sky130_fd_sc_hd__decap_6
XFILLER_172_89 VPWR VGND VPWR VGND sky130_ef_sc_hd__decap_12
XFILLER_219_744 VPWR VGND VPWR VGND sky130_ef_sc_hd__decap_12
XFILLER_24_1356 VPWR VGND VPWR VGND sky130_ef_sc_hd__decap_12
XFILLER_111_1304 VPWR VGND VPWR VGND sky130_ef_sc_hd__decap_12
XFILLER_98_1435 VGND VGND VPWR VPWR sky130_fd_sc_hd__decap_6
XPHY_EDGE_ROW_148_2_Right_239 VGND VGND VPWR VPWR sky130_fd_sc_hd__decap_3
XFILLER_234_703 VGND VGND VPWR VPWR sky130_fd_sc_hd__decap_6
XFILLER_246_574 VGND VGND VPWR VPWR sky130_fd_sc_hd__decap_6
XPHY_EDGE_ROW_45_2_Left_547 VGND VGND VPWR VPWR sky130_fd_sc_hd__decap_3
XFILLER_207_928 VPWR VGND VPWR VGND sky130_ef_sc_hd__decap_12
XFILLER_219_799 VPWR VGND VPWR VGND sky130_ef_sc_hd__decap_12
XFILLER_111_1359 VPWR VGND VPWR VGND sky130_ef_sc_hd__decap_12
XFILLER_2_1152 VPWR VGND VPWR VGND sky130_ef_sc_hd__decap_12
XFILLER_215_983 VGND VGND VPWR VPWR sky130_fd_sc_hd__decap_6
X_424_ net596 dout0_q\[23\] net533 VGND VGND VPWR VPWR _213_ sky130_fd_sc_hd__and3_1
XFILLER_57_1165 VPWR VGND VPWR VGND sky130_ef_sc_hd__decap_12
XFILLER_148_1282 VPWR VGND VPWR VGND sky130_ef_sc_hd__decap_12
XFILLER_183_1162 VPWR VGND VPWR VGND sky130_ef_sc_hd__decap_12
XFILLER_186_323 VPWR VGND VPWR VGND sky130_ef_sc_hd__decap_12
X_355_ _139_ net166 VGND VGND VPWR VPWR _144_ sky130_fd_sc_hd__or2_1
XFILLER_198_194 VPWR VGND VPWR VGND sky130_ef_sc_hd__decap_12
XFILLER_201_154 VPWR VGND VPWR VGND sky130_ef_sc_hd__decap_12
XFILLER_122_1411 VPWR VGND VPWR VGND sky130_ef_sc_hd__decap_12
XFILLER_174_507 VPWR VGND VPWR VGND sky130_ef_sc_hd__decap_12
XFILLER_186_378 VPWR VGND VPWR VGND sky130_ef_sc_hd__decap_12
XFILLER_31_1316 VPWR VGND VPWR VGND sky130_ef_sc_hd__decap_12
X_286_ web0 net614 net615 net618 VGND VGND VPWR VPWR _083_ sky130_fd_sc_hd__and4_1
XFILLER_220_1023 VPWR VGND VPWR VGND sky130_ef_sc_hd__decap_12
XFILLER_122_1466 VPWR VGND VPWR VGND sky130_ef_sc_hd__decap_12
XFILLER_220_1078 VPWR VGND VPWR VGND sky130_ef_sc_hd__decap_12
XFILLER_157_1507 VGND VGND VPWR VPWR sky130_fd_sc_hd__decap_8
XFILLER_182_562 VPWR VGND VPWR VGND sky130_ef_sc_hd__decap_12
XFILLER_29_1201 VGND VGND VPWR VPWR sky130_fd_sc_hd__decap_4
XFILLER_170_746 VGND VGND VPWR VPWR sky130_fd_sc_hd__decap_6
XPHY_EDGE_ROW_59_1_Left_314 VGND VGND VPWR VPWR sky130_fd_sc_hd__decap_3
XTAP_TAPCELL_ROW_92_1_1368 VGND VPWR sky130_fd_sc_hd__tapvpwrvgnd_1
XFILLER_68_1294 VPWR VGND VPWR VGND sky130_ef_sc_hd__decap_12
XFILLER_155_1242 VGND VGND VPWR VPWR sky130_fd_sc_hd__decap_6
XFILLER_190_1133 VGND VGND VPWR VPWR sky130_fd_sc_hd__decap_6
XFILLER_2_992 VPWR VGND VPWR VGND sky130_ef_sc_hd__decap_12
XPHY_EDGE_ROW_111_1_Left_366 VGND VGND VPWR VPWR sky130_fd_sc_hd__decap_3
XTAP_TAPCELL_ROW_145_2_5821 VGND VPWR sky130_fd_sc_hd__tapvpwrvgnd_1
XTAP_TAPCELL_ROW_182_2111 VGND VPWR sky130_fd_sc_hd__tapvpwrvgnd_1
XTAP_TAPCELL_ROW_186_2280 VGND VPWR sky130_fd_sc_hd__tapvpwrvgnd_1
XTAP_TAPCELL_ROW_182_2122 VGND VPWR sky130_fd_sc_hd__tapvpwrvgnd_1
XFILLER_42_1423 VPWR VGND VPWR VGND sky130_ef_sc_hd__decap_12
XTAP_TAPCELL_ROW_182_2133 VGND VPWR sky130_fd_sc_hd__tapvpwrvgnd_1
XFILLER_232_15 VGND VGND VPWR VPWR sky130_fd_sc_hd__decap_6
XFILLER_231_1174 VPWR VGND VPWR VGND sky130_ef_sc_hd__decap_12
XFILLER_237_541 VPWR VGND VPWR VGND sky130_ef_sc_hd__decap_12
Xinput6 wr_addr[4] VGND VGND VPWR VPWR net6 sky130_fd_sc_hd__clkbuf_1
XFILLER_42_1478 VGND VGND VPWR VPWR sky130_fd_sc_hd__decap_6
XFILLER_225_725 VGND VGND VPWR VPWR sky130_fd_sc_hd__decap_6
XFILLER_237_596 VGND VGND VPWR VPWR sky130_fd_sc_hd__decap_6
XFILLER_206_961 VGND VGND VPWR VPWR sky130_fd_sc_hd__decap_6
XTAP_TAPCELL_ROW_63_2_5165 VGND VPWR sky130_fd_sc_hd__tapvpwrvgnd_1
XFILLER_79_1390 VPWR VGND VPWR VGND sky130_ef_sc_hd__decap_12
XFILLER_36_1227 VPWR VGND VPWR VGND sky130_ef_sc_hd__decap_12
XFILLER_177_345 VPWR VGND VPWR VGND sky130_ef_sc_hd__decap_12
XFILLER_220_452 VPWR VGND VPWR VGND sky130_ef_sc_hd__decap_12
XPHY_EDGE_ROW_91_2_Left_593 VGND VGND VPWR VPWR sky130_fd_sc_hd__decap_3
XFILLER_242_1281 VPWR VGND VPWR VGND sky130_ef_sc_hd__decap_12
XFILLER_192_304 VPWR VGND VPWR VGND sky130_ef_sc_hd__decap_12
XFILLER_192_359 VGND VGND VPWR VPWR sky130_fd_sc_hd__decap_6
XFILLER_195_1033 VPWR VGND VPWR VGND sky130_ef_sc_hd__decap_12
XFILLER_173_584 VPWR VGND VPWR VGND sky130_ef_sc_hd__decap_12
XFILLER_12_1282 VPWR VGND VPWR VGND sky130_ef_sc_hd__decap_12
XFILLER_195_1088 VPWR VGND VPWR VGND sky130_ef_sc_hd__decap_12
XFILLER_251_1506 VGND VGND VPWR VPWR sky130_fd_sc_hd__decap_8
XPHY_EDGE_ROW_43_1_Left_298 VGND VGND VPWR VPWR sky130_fd_sc_hd__decap_3
XPHY_EDGE_ROW_136_1_Right_792 VGND VGND VPWR VPWR sky130_fd_sc_hd__decap_3
XFILLER_47_1378 VPWR VGND VPWR VGND sky130_ef_sc_hd__decap_12
XFILLER_134_1337 VPWR VGND VPWR VGND sky130_ef_sc_hd__decap_12
XFILLER_248_839 VPWR VGND VPWR VGND sky130_ef_sc_hd__decap_12
XTAP_TAPCELL_ROW_225_3630 VGND VPWR sky130_fd_sc_hd__tapvpwrvgnd_1
XTAP_TAPCELL_ROW_225_3641 VGND VPWR sky130_fd_sc_hd__tapvpwrvgnd_1
XFILLER_247_338 VGND VGND VPWR VPWR sky130_fd_sc_hd__decap_6
XFILLER_142_15 VGND VGND VPWR VPWR sky130_fd_sc_hd__decap_6
XTAP_TAPCELL_ROW_221_3505 VGND VPWR sky130_fd_sc_hd__tapvpwrvgnd_1
XFILLER_21_1507 VGND VGND VPWR VPWR sky130_fd_sc_hd__decap_8
XFILLER_216_703 VGND VGND VPWR VPWR sky130_fd_sc_hd__decap_6
XFILLER_249_1413 VGND VGND VPWR VPWR sky130_fd_sc_hd__decap_6
XFILLER_228_574 VGND VGND VPWR VPWR sky130_fd_sc_hd__decap_6
XFILLER_210_1269 VPWR VGND VPWR VGND sky130_ef_sc_hd__decap_12
XPHY_EDGE_ROW_72_2_Right_163 VGND VGND VPWR VPWR sky130_fd_sc_hd__decap_3
XFILLER_35_57 VPWR VGND VPWR VGND sky130_ef_sc_hd__decap_12
XFILLER_110_1392 VGND VGND VPWR VPWR sky130_fd_sc_hd__decap_6
XTAP_TAPCELL_ROW_219_3412 VGND VPWR sky130_fd_sc_hd__tapvpwrvgnd_1
XFILLER_19_1414 VGND VGND VPWR VPWR sky130_fd_sc_hd__decap_6
XFILLER_208_1121 VPWR VGND VPWR VGND sky130_ef_sc_hd__decap_12
XTAP_TAPCELL_ROW_219_3423 VGND VPWR sky130_fd_sc_hd__tapvpwrvgnd_1
XTAP_TAPCELL_ROW_219_3434 VGND VPWR sky130_fd_sc_hd__tapvpwrvgnd_1
XFILLER_58_1485 VPWR VGND VPWR VGND sky130_ef_sc_hd__decap_12
XFILLER_145_1433 VPWR VGND VPWR VGND sky130_ef_sc_hd__decap_12
XFILLER_180_1324 VPWR VGND VPWR VGND sky130_ef_sc_hd__decap_12
XFILLER_230_249 VPWR VGND VPWR VGND sky130_ef_sc_hd__decap_12
XFILLER_243_1045 VPWR VGND VPWR VGND sky130_ef_sc_hd__decap_12
XFILLER_168_323 VPWR VGND VPWR VGND sky130_ef_sc_hd__decap_12
XFILLER_54_1349 VGND VGND VPWR VPWR sky130_fd_sc_hd__decap_6
XFILLER_208_1176 VGND VGND VPWR VPWR sky130_fd_sc_hd__decap_6
Xclkbuf_3_3__f_clk clknet_0_clk VGND VGND VPWR VPWR clknet_3_3__leaf_clk sky130_fd_sc_hd__clkbuf_16
XFILLER_145_1488 VPWR VGND VPWR VGND sky130_ef_sc_hd__decap_12
XFILLER_195_142 VPWR VGND VPWR VGND sky130_ef_sc_hd__decap_12
XFILLER_211_474 VPWR VGND VPWR VGND sky130_ef_sc_hd__decap_12
Xwire404 net405 VGND VGND VPWR VPWR net404 sky130_fd_sc_hd__clkbuf_1
XFILLER_180_1379 VPWR VGND VPWR VGND sky130_ef_sc_hd__decap_12
Xwire415 net416 VGND VGND VPWR VPWR net415 sky130_fd_sc_hd__clkbuf_1
XFILLER_168_378 VPWR VGND VPWR VGND sky130_ef_sc_hd__decap_12
XFILLER_7_517 VGND VGND VPWR VPWR sky130_fd_sc_hd__fill_1
Xwire426 net427 VGND VGND VPWR VPWR net426 sky130_fd_sc_hd__clkbuf_1
XFILLER_183_326 VPWR VGND VPWR VGND sky130_ef_sc_hd__decap_12
Xwire437 net438 VGND VGND VPWR VPWR net437 sky130_fd_sc_hd__clkbuf_1
Xwire448 net449 VGND VGND VPWR VPWR net448 sky130_fd_sc_hd__clkbuf_1
XFILLER_129_3 VPWR VGND VPWR VGND sky130_ef_sc_hd__decap_12
XFILLER_195_197 VPWR VGND VPWR VGND sky130_ef_sc_hd__decap_12
Xwire459 net460 VGND VGND VPWR VPWR net459 sky130_fd_sc_hd__clkbuf_1
XFILLER_167_56 VPWR VGND VPWR VGND sky130_ef_sc_hd__decap_12
XFILLER_104_1196 VPWR VGND VPWR VGND sky130_ef_sc_hd__decap_12
XFILLER_192_882 VPWR VGND VPWR VGND sky130_ef_sc_hd__decap_12
XFILLER_191_381 VGND VGND VPWR VPWR sky130_fd_sc_hd__decap_6
XTAP_TAPCELL_ROW_87_2_5361 VGND VPWR sky130_fd_sc_hd__tapvpwrvgnd_1
XFILLER_2_233 VGND VGND VPWR VPWR sky130_fd_sc_hd__decap_3
XFILLER_183_44 VPWR VGND VPWR VGND sky130_ef_sc_hd__decap_12
XFILLER_191_1420 VPWR VGND VPWR VGND sky130_ef_sc_hd__decap_12
XFILLER_254_1152 VPWR VGND VPWR VGND sky130_ef_sc_hd__decap_12
XFILLER_65_1445 VPWR VGND VPWR VGND sky130_ef_sc_hd__decap_12
XFILLER_219_1272 VPWR VGND VPWR VGND sky130_ef_sc_hd__decap_12
XFILLER_191_1475 VPWR VGND VPWR VGND sky130_ef_sc_hd__decap_12
XFILLER_183_99 VPWR VGND VPWR VGND sky130_ef_sc_hd__decap_12
XFILLER_238_316 VGND VGND VPWR VPWR sky130_fd_sc_hd__decap_6
Xfanout592 valid_d2 VGND VGND VPWR VPWR net592 sky130_fd_sc_hd__clkbuf_2
XFILLER_219_541 VPWR VGND VPWR VGND sky130_ef_sc_hd__decap_12
XFILLER_247_861 VPWR VGND VPWR VGND sky130_ef_sc_hd__decap_12
XTAP_TAPCELL_ROW_112_2_5559 VGND VPWR sky130_fd_sc_hd__tapvpwrvgnd_1
XTAP_TAPCELL_ROW_80_2_5304 VGND VPWR sky130_fd_sc_hd__tapvpwrvgnd_1
XFILLER_115_1292 VPWR VGND VPWR VGND sky130_ef_sc_hd__decap_12
XFILLER_207_725 VGND VGND VPWR VPWR sky130_fd_sc_hd__decap_6
XFILLER_4_1269 VPWR VGND VPWR VGND sky130_ef_sc_hd__decap_12
XTAP_TAPCELL_ROW_48_2_5045 VGND VPWR sky130_fd_sc_hd__tapvpwrvgnd_1
XFILLER_219_596 VGND VGND VPWR VPWR sky130_fd_sc_hd__decap_6
XFILLER_228_1508 VGND VGND VPWR VPWR sky130_fd_sc_hd__decap_6
XFILLER_59_1249 VPWR VGND VPWR VGND sky130_ef_sc_hd__decap_12
XFILLER_111_1189 VPWR VGND VPWR VGND sky130_ef_sc_hd__decap_12
XFILLER_146_1208 VPWR VGND VPWR VGND sky130_ef_sc_hd__decap_12
XFILLER_163_1500 VGND VGND VPWR VPWR sky130_fd_sc_hd__decap_6
XFILLER_221_216 VPWR VGND VPWR VGND sky130_ef_sc_hd__decap_12
X_407_ _189_ _195_ _188_ VGND VGND VPWR VPWR _196_ sky130_fd_sc_hd__a21boi_1
XTAP_TAPCELL_ROW_144_1_1445 VGND VPWR sky130_fd_sc_hd__tapvpwrvgnd_1
XFILLER_186_120 VPWR VGND VPWR VGND sky130_ef_sc_hd__decap_12
XFILLER_202_452 VPWR VGND VPWR VGND sky130_ef_sc_hd__decap_12
XTAP_TAPCELL_ROW_194_2560 VGND VPWR sky130_fd_sc_hd__tapvpwrvgnd_1
XTAP_TAPCELL_ROW_190_2402 VGND VPWR sky130_fd_sc_hd__tapvpwrvgnd_1
X_338_ net499 _123_ VGND VGND VPWR VPWR _127_ sky130_fd_sc_hd__and2b_1
XFILLER_174_304 VPWR VGND VPWR VGND sky130_ef_sc_hd__decap_12
XTAP_TAPCELL_ROW_190_2413 VGND VPWR sky130_fd_sc_hd__tapvpwrvgnd_1
XFILLER_186_175 VPWR VGND VPWR VGND sky130_ef_sc_hd__decap_12
XFILLER_70_1184 VPWR VGND VPWR VGND sky130_ef_sc_hd__decap_12
XFILLER_174_359 VGND VGND VPWR VPWR sky130_fd_sc_hd__decap_6
XFILLER_190_808 VPWR VGND VPWR VGND sky130_ef_sc_hd__decap_12
XFILLER_122_1263 VGND VGND VPWR VPWR sky130_fd_sc_hd__decap_6
XFILLER_227_15 VPWR VGND VPWR VGND sky130_ef_sc_hd__decap_12
XFILLER_157_1304 VPWR VGND VPWR VGND sky130_ef_sc_hd__decap_12
XTAP_TAPCELL_ROW_188_2320 VGND VPWR sky130_fd_sc_hd__tapvpwrvgnd_1
XTAP_TAPCELL_ROW_188_2331 VGND VPWR sky130_fd_sc_hd__tapvpwrvgnd_1
XFILLER_157_1359 VPWR VGND VPWR VGND sky130_ef_sc_hd__decap_12
XTAP_TAPCELL_ROW_188_2342 VGND VPWR sky130_fd_sc_hd__tapvpwrvgnd_1
XFILLER_44_3 VPWR VGND VPWR VGND sky130_ef_sc_hd__decap_12
XTAP_TAPCELL_ROW_188_2353 VGND VPWR sky130_fd_sc_hd__tapvpwrvgnd_1
XTAP_TAPCELL_ROW_184_2206 VGND VPWR sky130_fd_sc_hd__tapvpwrvgnd_1
XFILLER_9_1114 VPWR VGND VPWR VGND sky130_ef_sc_hd__decap_12
XFILLER_9_1147 VGND VGND VPWR VPWR sky130_fd_sc_hd__decap_8
XFILLER_42_1220 VGND VGND VPWR VPWR sky130_fd_sc_hd__decap_6
XFILLER_229_338 VGND VGND VPWR VPWR sky130_fd_sc_hd__decap_6
XFILLER_238_894 VPWR VGND VPWR VGND sky130_ef_sc_hd__decap_12
XFILLER_168_1422 VPWR VGND VPWR VGND sky130_ef_sc_hd__decap_12
XFILLER_253_842 VPWR VGND VPWR VGND sky130_ef_sc_hd__decap_12
XFILLER_77_1316 VPWR VGND VPWR VGND sky130_ef_sc_hd__decap_12
XFILLER_168_1477 VGND VGND VPWR VPWR sky130_fd_sc_hd__decap_6
XFILLER_253_897 VGND VGND VPWR VPWR sky130_fd_sc_hd__decap_6
XFILLER_209_1463 VPWR VGND VPWR VGND sky130_ef_sc_hd__decap_12
XFILLER_212_249 VPWR VGND VPWR VGND sky130_ef_sc_hd__decap_12
XFILLER_240_1207 VPWR VGND VPWR VGND sky130_ef_sc_hd__decap_12
XFILLER_205_1327 VGND VGND VPWR VPWR sky130_fd_sc_hd__decap_6
XFILLER_177_142 VPWR VGND VPWR VGND sky130_ef_sc_hd__decap_12
XTAP_TAPCELL_ROW_233_3910 VGND VPWR sky130_fd_sc_hd__tapvpwrvgnd_1
XFILLER_244_1398 VPWR VGND VPWR VGND sky130_ef_sc_hd__decap_12
XTAP_TAPCELL_ROW_233_3921 VGND VPWR sky130_fd_sc_hd__tapvpwrvgnd_1
XFILLER_192_101 VGND VGND VPWR VPWR sky130_fd_sc_hd__decap_6
XFILLER_53_1371 VGND VGND VPWR VPWR sky130_fd_sc_hd__decap_6
XFILLER_165_337 VPWR VGND VPWR VGND sky130_ef_sc_hd__decap_12
XFILLER_177_197 VPWR VGND VPWR VGND sky130_ef_sc_hd__decap_12
XFILLER_193_646 VPWR VGND VPWR VGND sky130_ef_sc_hd__decap_12
XFILLER_21_15 VPWR VGND VPWR VGND sky130_ef_sc_hd__decap_12
XFILLER_88_1423 VPWR VGND VPWR VGND sky130_ef_sc_hd__decap_12
XFILLER_10_1208 VPWR VGND VPWR VGND sky130_ef_sc_hd__decap_12
XFILLER_137_15 VPWR VGND VPWR VGND sky130_ef_sc_hd__decap_12
XFILLER_14_1399 VPWR VGND VPWR VGND sky130_ef_sc_hd__decap_12
XFILLER_101_1347 VPWR VGND VPWR VGND sky130_ef_sc_hd__decap_12
XFILLER_174_882 VPWR VGND VPWR VGND sky130_ef_sc_hd__decap_12
XFILLER_88_1478 VGND VGND VPWR VPWR sky130_fd_sc_hd__decap_6
XFILLER_173_381 VGND VGND VPWR VPWR sky130_fd_sc_hd__decap_6
XFILLER_255_1450 VPWR VGND VPWR VGND sky130_ef_sc_hd__decap_12
XTAP_TAPCELL_ROW_227_3703 VGND VPWR sky130_fd_sc_hd__tapvpwrvgnd_1
XTAP_TAPCELL_ROW_227_3714 VGND VPWR sky130_fd_sc_hd__tapvpwrvgnd_1
XFILLER_251_1303 VPWR VGND VPWR VGND sky130_ef_sc_hd__decap_12
XFILLER_255_1483 VGND VGND VPWR VPWR sky130_fd_sc_hd__decap_8
XTAP_TAPCELL_ROW_39_2_4971 VGND VPWR sky130_fd_sc_hd__tapvpwrvgnd_1
XFILLER_138_1270 VPWR VGND VPWR VGND sky130_ef_sc_hd__decap_12
XFILLER_216_1434 VGND VGND VPWR VPWR sky130_fd_sc_hd__decap_6
XPHY_EDGE_ROW_137_1_Right_793 VGND VGND VPWR VPWR sky130_fd_sc_hd__decap_3
XFILLER_251_1358 VPWR VGND VPWR VGND sky130_ef_sc_hd__decap_12
XFILLER_248_636 VPWR VGND VPWR VGND sky130_ef_sc_hd__decap_12
XFILLER_229_861 VPWR VGND VPWR VGND sky130_ef_sc_hd__decap_12
XFILLER_21_1304 VPWR VGND VPWR VGND sky130_ef_sc_hd__decap_12
XFILLER_210_1011 VPWR VGND VPWR VGND sky130_ef_sc_hd__decap_12
XTAP_TAPCELL_ROW_150_1_1455 VGND VPWR sky130_fd_sc_hd__tapvpwrvgnd_1
XFILLER_233_80 VGND VGND VPWR VPWR sky130_fd_sc_hd__decap_6
XFILLER_244_820 VPWR VGND VPWR VGND sky130_ef_sc_hd__decap_12
XFILLER_46_34 VPWR VGND VPWR VGND sky130_ef_sc_hd__decap_12
XFILLER_112_1454 VPWR VGND VPWR VGND sky130_ef_sc_hd__decap_12
XTAP_TAPCELL_ROW_165_1482 VGND VPWR sky130_fd_sc_hd__tapvpwrvgnd_1
XFILLER_21_1359 VPWR VGND VPWR VGND sky130_ef_sc_hd__decap_12
XTAP_TAPCELL_ROW_165_1493 VGND VPWR sky130_fd_sc_hd__tapvpwrvgnd_1
XFILLER_210_1066 VPWR VGND VPWR VGND sky130_ef_sc_hd__decap_12
XFILLER_255_190 VPWR VGND VPWR VGND sky130_ef_sc_hd__decap_12
XTAP_TAPCELL_ROW_32_2_4914 VGND VPWR sky130_fd_sc_hd__tapvpwrvgnd_1
XFILLER_244_875 VGND VGND VPWR VPWR sky130_fd_sc_hd__decap_6
XFILLER_3_1291 VPWR VGND VPWR VGND sky130_ef_sc_hd__decap_12
Xmax_cap79 net80 VGND VGND VPWR VPWR net79 sky130_fd_sc_hd__clkbuf_1
XFILLER_203_216 VPWR VGND VPWR VGND sky130_ef_sc_hd__decap_12
XPHY_EDGE_ROW_73_2_Right_164 VGND VGND VPWR VPWR sky130_fd_sc_hd__decap_3
XFILLER_62_22 VPWR VGND VPWR VGND sky130_ef_sc_hd__decap_12
XFILLER_246_3 VPWR VGND VPWR VGND sky130_ef_sc_hd__decap_12
XFILLER_58_1282 VPWR VGND VPWR VGND sky130_ef_sc_hd__decap_12
XFILLER_145_1230 VPWR VGND VPWR VGND sky130_ef_sc_hd__decap_12
XFILLER_180_1121 VPWR VGND VPWR VGND sky130_ef_sc_hd__decap_12
XFILLER_168_120 VPWR VGND VPWR VGND sky130_ef_sc_hd__decap_12
XFILLER_178_22 VPWR VGND VPWR VGND sky130_ef_sc_hd__decap_12
XFILLER_145_1285 VGND VGND VPWR VPWR sky130_fd_sc_hd__decap_6
XFILLER_180_1176 VGND VGND VPWR VPWR sky130_fd_sc_hd__decap_6
XFILLER_211_271 VPWR VGND VPWR VGND sky130_ef_sc_hd__decap_12
XFILLER_32_1411 VPWR VGND VPWR VGND sky130_ef_sc_hd__decap_12
XFILLER_168_175 VPWR VGND VPWR VGND sky130_ef_sc_hd__decap_12
XFILLER_178_77 VPWR VGND VPWR VGND sky130_ef_sc_hd__decap_12
XFILLER_184_624 VPWR VGND VPWR VGND sky130_ef_sc_hd__decap_12
Xwire223 net224 VGND VGND VPWR VPWR net223 sky130_fd_sc_hd__clkbuf_1
XFILLER_196_495 VPWR VGND VPWR VGND sky130_ef_sc_hd__decap_12
Xwire234 net235 VGND VGND VPWR VPWR net234 sky130_fd_sc_hd__clkbuf_1
XFILLER_183_123 VGND VGND VPWR VPWR sky130_fd_sc_hd__decap_6
XFILLER_172_808 VPWR VGND VPWR VGND sky130_ef_sc_hd__decap_12
XFILLER_221_1162 VPWR VGND VPWR VGND sky130_ef_sc_hd__decap_12
XFILLER_32_1466 VPWR VGND VPWR VGND sky130_ef_sc_hd__decap_12
Xwire256 net257 VGND VGND VPWR VPWR net256 sky130_fd_sc_hd__clkbuf_1
XFILLER_184_679 VPWR VGND VPWR VGND sky130_ef_sc_hd__decap_12
Xwire267 net268 VGND VGND VPWR VPWR net267 sky130_fd_sc_hd__clkbuf_1
Xwire278 net279 VGND VGND VPWR VPWR net278 sky130_fd_sc_hd__clkbuf_1
Xwire289 net290 VGND VGND VPWR VPWR net289 sky130_fd_sc_hd__clkbuf_1
XFILLER_67_1507 VGND VGND VPWR VPWR sky130_fd_sc_hd__decap_8
XFILLER_194_65 VPWR VGND VPWR VGND sky130_ef_sc_hd__decap_12
XFILLER_180_863 VPWR VGND VPWR VGND sky130_ef_sc_hd__decap_12
XFILLER_3_564 VGND VGND VPWR VPWR sky130_fd_sc_hd__fill_2
XFILLER_65_1242 VGND VGND VPWR VPWR sky130_fd_sc_hd__decap_6
XFILLER_239_603 VPWR VGND VPWR VGND sky130_ef_sc_hd__decap_12
XFILLER_191_1272 VPWR VGND VPWR VGND sky130_ef_sc_hd__decap_12
XTAP_TAPCELL_ROW_243_4250 VGND VPWR sky130_fd_sc_hd__tapvpwrvgnd_1
XFILLER_156_1392 VGND VGND VPWR VPWR sky130_fd_sc_hd__decap_6
XTAP_TAPCELL_ROW_243_4261 VGND VPWR sky130_fd_sc_hd__tapvpwrvgnd_1
XTAP_TAPCELL_ROW_243_4272 VGND VPWR sky130_fd_sc_hd__tapvpwrvgnd_1
XFILLER_113_1218 VPWR VGND VPWR VGND sky130_ef_sc_hd__decap_12
XFILLER_239_658 VPWR VGND VPWR VGND sky130_ef_sc_hd__decap_12
XFILLER_254_617 VGND VGND VPWR VPWR sky130_fd_sc_hd__decap_6
XFILLER_4_1011 VPWR VGND VPWR VGND sky130_ef_sc_hd__decap_12
XFILLER_213_39 VGND VGND VPWR VPWR sky130_fd_sc_hd__decap_4
XFILLER_4_1066 VPWR VGND VPWR VGND sky130_ef_sc_hd__decap_12
XFILLER_235_842 VPWR VGND VPWR VGND sky130_ef_sc_hd__decap_12
XTAP_TAPCELL_ROW_5_1050 VGND VPWR sky130_fd_sc_hd__tapvpwrvgnd_1
XFILLER_228_1305 VGND VGND VPWR VPWR sky130_fd_sc_hd__decap_6
XTAP_TAPCELL_ROW_5_1061 VGND VPWR sky130_fd_sc_hd__tapvpwrvgnd_1
XTAP_TAPCELL_ROW_196_2600 VGND VPWR sky130_fd_sc_hd__tapvpwrvgnd_1
XTAP_TAPCELL_ROW_196_2611 VGND VPWR sky130_fd_sc_hd__tapvpwrvgnd_1
XTAP_TAPCELL_ROW_204_2887 VGND VPWR sky130_fd_sc_hd__tapvpwrvgnd_1
XFILLER_235_897 VGND VGND VPWR VPWR sky130_fd_sc_hd__decap_6
XTAP_TAPCELL_ROW_196_2622 VGND VPWR sky130_fd_sc_hd__tapvpwrvgnd_1
XTAP_TAPCELL_ROW_204_2898 VGND VPWR sky130_fd_sc_hd__tapvpwrvgnd_1
XTAP_TAPCELL_ROW_237_4043 VGND VPWR sky130_fd_sc_hd__tapvpwrvgnd_1
XTAP_TAPCELL_ROW_142_2_5798 VGND VPWR sky130_fd_sc_hd__tapvpwrvgnd_1
XFILLER_185_1076 VPWR VGND VPWR VGND sky130_ef_sc_hd__decap_12
XTAP_TAPCELL_ROW_196_2633 VGND VPWR sky130_fd_sc_hd__tapvpwrvgnd_1
XTAP_TAPCELL_ROW_237_4054 VGND VPWR sky130_fd_sc_hd__tapvpwrvgnd_1
XTAP_TAPCELL_ROW_237_4065 VGND VPWR sky130_fd_sc_hd__tapvpwrvgnd_1
XTAP_TAPCELL_ROW_78_2_5284 VGND VPWR sky130_fd_sc_hd__tapvpwrvgnd_1
XTAP_TAPCELL_ROW_122_2_5641 VGND VPWR sky130_fd_sc_hd__tapvpwrvgnd_1
XFILLER_124_1325 VPWR VGND VPWR VGND sky130_ef_sc_hd__decap_12
XFILLER_174_101 VGND VGND VPWR VPWR sky130_fd_sc_hd__decap_6
XFILLER_175_646 VPWR VGND VPWR VGND sky130_ef_sc_hd__decap_12
Xinput20 wr_data[19] VGND VGND VPWR VPWR net20 sky130_fd_sc_hd__clkbuf_1
Xinput31 wr_data[29] VGND VGND VPWR VPWR net31 sky130_fd_sc_hd__clkbuf_1
XFILLER_239_1401 VPWR VGND VPWR VGND sky130_ef_sc_hd__decap_12
XFILLER_190_605 VPWR VGND VPWR VGND sky130_ef_sc_hd__decap_12
XFILLER_238_58 VGND VGND VPWR VPWR sky130_fd_sc_hd__decap_6
Xinput42 wr_en VGND VGND VPWR VPWR net42 sky130_fd_sc_hd__clkbuf_2
Xmax_cap501 _116_ VGND VGND VPWR VPWR net501 sky130_fd_sc_hd__clkbuf_1
Xmax_cap512 net513 VGND VGND VPWR VPWR net512 sky130_fd_sc_hd__clkbuf_1
XTAP_TAPCELL_ROW_71_2_5227 VGND VPWR sky130_fd_sc_hd__tapvpwrvgnd_1
XFILLER_171_830 VPWR VGND VPWR VGND sky130_ef_sc_hd__decap_12
XFILLER_239_1456 VGND VGND VPWR VPWR sky130_fd_sc_hd__decap_6
Xmax_cap534 net57 VGND VGND VPWR VPWR net534 sky130_fd_sc_hd__clkbuf_1
XFILLER_6_391 VGND VGND VPWR VPWR sky130_fd_sc_hd__fill_2
Xmax_cap556 net71 VGND VGND VPWR VPWR net556 sky130_fd_sc_hd__clkbuf_1
XFILLER_196_1183 VPWR VGND VPWR VGND sky130_ef_sc_hd__decap_12
XPHY_EDGE_ROW_122_2_Left_624 VGND VGND VPWR VPWR sky130_fd_sc_hd__decap_3
XFILLER_100_1380 VPWR VGND VPWR VGND sky130_ef_sc_hd__decap_12
XFILLER_171_885 VPWR VGND VPWR VGND sky130_ef_sc_hd__decap_12
XFILLER_192_1047 VGND VGND VPWR VPWR sky130_fd_sc_hd__decap_6
XFILLER_254_46 VPWR VGND VPWR VGND sky130_ef_sc_hd__decap_12
XFILLER_157_1189 VPWR VGND VPWR VGND sky130_ef_sc_hd__decap_12
XFILLER_135_1421 VPWR VGND VPWR VGND sky130_ef_sc_hd__decap_12
XFILLER_170_1312 VPWR VGND VPWR VGND sky130_ef_sc_hd__decap_12
XFILLER_233_1033 VPWR VGND VPWR VGND sky130_ef_sc_hd__decap_12
XFILLER_44_1337 VPWR VGND VPWR VGND sky130_ef_sc_hd__decap_12
XFILLER_135_1476 VPWR VGND VPWR VGND sky130_ef_sc_hd__decap_12
XFILLER_170_1367 VPWR VGND VPWR VGND sky130_ef_sc_hd__decap_12
XFILLER_233_1088 VPWR VGND VPWR VGND sky130_ef_sc_hd__decap_12
XFILLER_123_39 VGND VGND VPWR VPWR sky130_fd_sc_hd__decap_4
XFILLER_250_1391 VGND VGND VPWR VPWR sky130_fd_sc_hd__decap_6
XFILLER_245_639 VGND VGND VPWR VPWR sky130_fd_sc_hd__decap_6
XFILLER_226_820 VPWR VGND VPWR VGND sky130_ef_sc_hd__decap_12
XFILLER_238_691 VPWR VGND VPWR VGND sky130_ef_sc_hd__decap_12
XFILLER_16_15 VGND VGND VPWR VPWR sky130_fd_sc_hd__decap_6
XFILLER_0_1420 VGND VGND VPWR VPWR sky130_fd_sc_hd__decap_8
XFILLER_226_875 VGND VGND VPWR VPWR sky130_fd_sc_hd__decap_6
XFILLER_20_1392 VGND VGND VPWR VPWR sky130_fd_sc_hd__decap_6
XFILLER_244_1140 VPWR VGND VPWR VGND sky130_ef_sc_hd__decap_12
XFILLER_55_1433 VPWR VGND VPWR VGND sky130_ef_sc_hd__decap_12
XFILLER_90_1313 VPWR VGND VPWR VGND sky130_ef_sc_hd__decap_12
XFILLER_209_1260 VPWR VGND VPWR VGND sky130_ef_sc_hd__decap_12
XFILLER_197_259 VPWR VGND VPWR VGND sky130_ef_sc_hd__decap_12
XFILLER_240_366 VPWR VGND VPWR VGND sky130_ef_sc_hd__decap_12
XFILLER_240_1004 VGND VGND VPWR VPWR sky130_fd_sc_hd__decap_6
XFILLER_181_1463 VPWR VGND VPWR VGND sky130_ef_sc_hd__decap_12
XFILLER_244_1195 VPWR VGND VPWR VGND sky130_ef_sc_hd__decap_12
XFILLER_55_1488 VPWR VGND VPWR VGND sky130_ef_sc_hd__decap_12
XFILLER_90_1368 VPWR VGND VPWR VGND sky130_ef_sc_hd__decap_12
XFILLER_166_624 VPWR VGND VPWR VGND sky130_ef_sc_hd__decap_12
XFILLER_178_495 VPWR VGND VPWR VGND sky130_ef_sc_hd__decap_12
XFILLER_193_443 VPWR VGND VPWR VGND sky130_ef_sc_hd__decap_12
XFILLER_148_58 VGND VGND VPWR VPWR sky130_fd_sc_hd__decap_6
XFILLER_166_679 VPWR VGND VPWR VGND sky130_ef_sc_hd__decap_12
XFILLER_88_1220 VGND VGND VPWR VPWR sky130_fd_sc_hd__decap_6
XFILLER_181_627 VPWR VGND VPWR VGND sky130_ef_sc_hd__decap_12
XFILLER_193_498 VPWR VGND VPWR VGND sky130_ef_sc_hd__decap_12
XFILLER_14_1196 VPWR VGND VPWR VGND sky130_ef_sc_hd__decap_12
XFILLER_179_1370 VGND VGND VPWR VPWR sky130_fd_sc_hd__decap_6
XPHY_EDGE_ROW_54_2_Left_556 VGND VGND VPWR VPWR sky130_fd_sc_hd__decap_3
XTAP_TAPCELL_ROW_173_1795 VGND VPWR sky130_fd_sc_hd__tapvpwrvgnd_1
XFILLER_101_1177 VPWR VGND VPWR VGND sky130_ef_sc_hd__decap_12
XFILLER_164_46 VPWR VGND VPWR VGND sky130_ef_sc_hd__decap_12
XFILLER_251_1100 VPWR VGND VPWR VGND sky130_ef_sc_hd__decap_12
XFILLER_251_1155 VGND VGND VPWR VPWR sky130_fd_sc_hd__decap_6
XFILLER_248_433 VPWR VGND VPWR VGND sky130_ef_sc_hd__decap_12
XPHY_EDGE_ROW_214_Left_469 VGND VGND VPWR VPWR sky130_fd_sc_hd__decap_3
XFILLER_196_3 VPWR VGND VPWR VGND sky130_ef_sc_hd__decap_12
XFILLER_57_44 VGND VGND VPWR VPWR sky130_fd_sc_hd__decap_3
XFILLER_0_589 VGND VGND VPWR VPWR sky130_fd_sc_hd__fill_2
XPHY_EDGE_ROW_138_1_Right_794 VGND VGND VPWR VPWR sky130_fd_sc_hd__decap_3
XFILLER_180_34 VPWR VGND VPWR VGND sky130_ef_sc_hd__decap_12
XFILLER_236_617 VGND VGND VPWR VPWR sky130_fd_sc_hd__decap_6
XFILLER_248_488 VGND VGND VPWR VPWR sky130_fd_sc_hd__decap_6
XTAP_TAPCELL_ROW_167_1588 VGND VPWR sky130_fd_sc_hd__tapvpwrvgnd_1
XTAP_TAPCELL_ROW_167_1599 VGND VPWR sky130_fd_sc_hd__tapvpwrvgnd_1
XFILLER_25_1292 VPWR VGND VPWR VGND sky130_ef_sc_hd__decap_12
XFILLER_112_1251 VPWR VGND VPWR VGND sky130_ef_sc_hd__decap_12
XFILLER_180_89 VPWR VGND VPWR VGND sky130_ef_sc_hd__decap_12
XFILLER_217_842 VPWR VGND VPWR VGND sky130_ef_sc_hd__decap_12
XFILLER_1_1217 VPWR VGND VPWR VGND sky130_ef_sc_hd__decap_12
XFILLER_99_1371 VGND VGND VPWR VPWR sky130_fd_sc_hd__decap_6
XTAP_TAPCELL_ROW_127_2_5678 VGND VPWR sky130_fd_sc_hd__tapvpwrvgnd_1
XTAP_TAPCELL_ROW_95_2_5423 VGND VPWR sky130_fd_sc_hd__tapvpwrvgnd_1
XFILLER_250_108 VPWR VGND VPWR VGND sky130_ef_sc_hd__decap_12
XTAP_TAPCELL_ROW_64_2_5170 VGND VPWR sky130_fd_sc_hd__tapvpwrvgnd_1
XFILLER_21_1189 VPWR VGND VPWR VGND sky130_ef_sc_hd__decap_12
XFILLER_217_897 VGND VGND VPWR VPWR sky130_fd_sc_hd__decap_6
XFILLER_56_1208 VPWR VGND VPWR VGND sky130_ef_sc_hd__decap_12
XFILLER_73_1500 VGND VGND VPWR VPWR sky130_fd_sc_hd__decap_6
XFILLER_147_1347 VPWR VGND VPWR VGND sky130_ef_sc_hd__decap_12
XTAP_TAPCELL_ROW_107_2_5521 VGND VPWR sky130_fd_sc_hd__tapvpwrvgnd_1
XFILLER_182_1238 VPWR VGND VPWR VGND sky130_ef_sc_hd__decap_12
XFILLER_188_237 VPWR VGND VPWR VGND sky130_ef_sc_hd__decap_12
XPHY_EDGE_ROW_74_2_Right_165 VGND VGND VPWR VPWR sky130_fd_sc_hd__decap_3
XTAP_TAPCELL_ROW_251_4530 VGND VPWR sky130_fd_sc_hd__tapvpwrvgnd_1
XPHY_EDGE_ROW_68_1_Left_323 VGND VGND VPWR VPWR sky130_fd_sc_hd__decap_3
XFILLER_189_87 VPWR VGND VPWR VGND sky130_ef_sc_hd__decap_12
XTAP_TAPCELL_ROW_251_4541 VGND VPWR sky130_fd_sc_hd__tapvpwrvgnd_1
XPHY_EDGE_ROW_223_Left_478 VGND VGND VPWR VPWR sky130_fd_sc_hd__decap_3
XFILLER_231_388 VPWR VGND VPWR VGND sky130_ef_sc_hd__decap_12
XTAP_TAPCELL_ROW_251_4552 VGND VPWR sky130_fd_sc_hd__tapvpwrvgnd_1
XPHY_EDGE_ROW_120_1_Left_375 VGND VGND VPWR VPWR sky130_fd_sc_hd__decap_3
XFILLER_184_421 VPWR VGND VPWR VGND sky130_ef_sc_hd__decap_12
XFILLER_200_753 VPWR VGND VPWR VGND sky130_ef_sc_hd__decap_12
XFILLER_196_292 VPWR VGND VPWR VGND sky130_ef_sc_hd__decap_12
XFILLER_7_122 VGND VGND VPWR VPWR sky130_fd_sc_hd__decap_6
XTAP_TAPCELL_ROW_56_2_5107 VGND VPWR sky130_fd_sc_hd__tapvpwrvgnd_1
XFILLER_172_605 VPWR VGND VPWR VGND sky130_ef_sc_hd__decap_12
XFILLER_8_667 VPWR VGND VPWR VGND sky130_ef_sc_hd__decap_12
XFILLER_32_1263 VGND VGND VPWR VPWR sky130_fd_sc_hd__decap_6
XFILLER_184_476 VPWR VGND VPWR VGND sky130_ef_sc_hd__decap_12
XFILLER_67_1304 VPWR VGND VPWR VGND sky130_ef_sc_hd__decap_12
XTAP_TAPCELL_ROW_249_4470 VGND VPWR sky130_fd_sc_hd__tapvpwrvgnd_1
XTAP_TAPCELL_ROW_249_4481 VGND VPWR sky130_fd_sc_hd__tapvpwrvgnd_1
XFILLER_158_1454 VPWR VGND VPWR VGND sky130_ef_sc_hd__decap_12
XFILLER_193_1334 VPWR VGND VPWR VGND sky130_ef_sc_hd__decap_12
XTAP_TAPCELL_ROW_245_4323 VGND VPWR sky130_fd_sc_hd__tapvpwrvgnd_1
XFILLER_180_660 VGND VGND VPWR VPWR sky130_fd_sc_hd__decap_6
XTAP_TAPCELL_ROW_245_4334 VGND VPWR sky130_fd_sc_hd__tapvpwrvgnd_1
XFILLER_67_1359 VPWR VGND VPWR VGND sky130_ef_sc_hd__decap_12
XTAP_TAPCELL_ROW_245_4345 VGND VPWR sky130_fd_sc_hd__tapvpwrvgnd_1
XTAP_TAPCELL_ROW_23_2_4848 VGND VPWR sky130_fd_sc_hd__tapvpwrvgnd_1
XFILLER_193_1389 VPWR VGND VPWR VGND sky130_ef_sc_hd__decap_12
XPHY_EDGE_ROW_232_Left_487 VGND VGND VPWR VPWR sky130_fd_sc_hd__decap_3
XFILLER_239_400 VPWR VGND VPWR VGND sky130_ef_sc_hd__decap_12
XTAP_TAPCELL_ROW_44_1_1295 VGND VPWR sky130_fd_sc_hd__tapvpwrvgnd_1
XFILLER_255_904 VPWR VGND VPWR VGND sky130_ef_sc_hd__decap_12
XFILLER_239_455 VPWR VGND VPWR VGND sky130_ef_sc_hd__decap_12
XTAP_TAPCELL_ROW_7_1112 VGND VPWR sky130_fd_sc_hd__tapvpwrvgnd_1
XTAP_TAPCELL_ROW_7_1123 VGND VPWR sky130_fd_sc_hd__tapvpwrvgnd_1
XFILLER_255_937 VGND VGND VPWR VPWR sky130_fd_sc_hd__decap_8
XTAP_TAPCELL_ROW_7_1134 VGND VPWR sky130_fd_sc_hd__tapvpwrvgnd_1
XFILLER_208_820 VPWR VGND VPWR VGND sky130_ef_sc_hd__decap_12
XFILLER_227_639 VGND VGND VPWR VPWR sky130_fd_sc_hd__decap_6
XTAP_TAPCELL_ROW_206_2949 VGND VPWR sky130_fd_sc_hd__tapvpwrvgnd_1
XTAP_TAPCELL_ROW_239_4105 VGND VPWR sky130_fd_sc_hd__tapvpwrvgnd_1
XFILLER_78_1411 VPWR VGND VPWR VGND sky130_ef_sc_hd__decap_12
XTAP_TAPCELL_ROW_132_1_1427 VGND VPWR sky130_fd_sc_hd__tapvpwrvgnd_1
XFILLER_240_15 VGND VGND VPWR VPWR sky130_fd_sc_hd__decap_6
XTAP_TAPCELL_ROW_239_4116 VGND VPWR sky130_fd_sc_hd__tapvpwrvgnd_1
XTAP_TAPCELL_ROW_239_4127 VGND VPWR sky130_fd_sc_hd__tapvpwrvgnd_1
XTAP_TAPCELL_ROW_239_4138 VGND VPWR sky130_fd_sc_hd__tapvpwrvgnd_1
XFILLER_208_875 VGND VGND VPWR VPWR sky130_fd_sc_hd__decap_6
XFILLER_78_1466 VPWR VGND VPWR VGND sky130_ef_sc_hd__decap_12
XPHY_EDGE_ROW_241_Left_496 VGND VGND VPWR VPWR sky130_fd_sc_hd__decap_3
XFILLER_179_259 VPWR VGND VPWR VGND sky130_ef_sc_hd__decap_12
XFILLER_206_1422 VPWR VGND VPWR VGND sky130_ef_sc_hd__decap_12
XFILLER_222_366 VPWR VGND VPWR VGND sky130_ef_sc_hd__decap_12
XFILLER_194_218 VPWR VGND VPWR VGND sky130_ef_sc_hd__decap_12
XFILLER_241_1346 VPWR VGND VPWR VGND sky130_ef_sc_hd__decap_12
XTAP_TAPCELL_ROW_98_1_1377 VGND VPWR sky130_fd_sc_hd__tapvpwrvgnd_1
XFILLER_249_68 VPWR VGND VPWR VGND sky130_ef_sc_hd__decap_12
XFILLER_206_1477 VGND VGND VPWR VPWR sky130_fd_sc_hd__decap_6
XFILLER_175_443 VPWR VGND VPWR VGND sky130_ef_sc_hd__decap_12
XFILLER_124_1177 VGND VGND VPWR VPWR sky130_fd_sc_hd__decap_6
XFILLER_190_402 VGND VGND VPWR VPWR sky130_fd_sc_hd__decap_6
XFILLER_159_1218 VPWR VGND VPWR VGND sky130_ef_sc_hd__decap_12
XFILLER_102_1442 VPWR VGND VPWR VGND sky130_ef_sc_hd__decap_12
XTAP_TAPCELL_ROW_152_2_5880 VGND VPWR sky130_fd_sc_hd__tapvpwrvgnd_1
XFILLER_175_498 VPWR VGND VPWR VGND sky130_ef_sc_hd__decap_12
XFILLER_191_947 VPWR VGND VPWR VGND sky130_ef_sc_hd__decap_12
XFILLER_194_1109 VPWR VGND VPWR VGND sky130_ef_sc_hd__decap_12
XFILLER_11_1347 VPWR VGND VPWR VGND sky130_ef_sc_hd__decap_12
XFILLER_200_1054 VPWR VGND VPWR VGND sky130_ef_sc_hd__decap_12
Xmax_cap331 net332 VGND VGND VPWR VPWR net331 sky130_fd_sc_hd__clkbuf_1
XFILLER_102_1497 VPWR VGND VPWR VGND sky130_ef_sc_hd__decap_12
XFILLER_171_682 VGND VGND VPWR VPWR sky130_fd_sc_hd__decap_6
XPHY_EDGE_ROW_4_Right_4 VGND VGND VPWR VPWR sky130_fd_sc_hd__decap_3
XFILLER_48_1270 VPWR VGND VPWR VGND sky130_ef_sc_hd__decap_12
XFILLER_252_1453 VPWR VGND VPWR VGND sky130_ef_sc_hd__decap_12
XFILLER_135_1273 VPWR VGND VPWR VGND sky130_ef_sc_hd__decap_12
XTAP_TAPCELL_ROW_144_2_5817 VGND VPWR sky130_fd_sc_hd__tapvpwrvgnd_1
XFILLER_170_1164 VPWR VGND VPWR VGND sky130_ef_sc_hd__decap_12
XTAP_TAPCELL_ROW_113_2_5564 VGND VPWR sky130_fd_sc_hd__tapvpwrvgnd_1
XFILLER_218_617 VGND VGND VPWR VPWR sky130_fd_sc_hd__decap_6
XFILLER_246_937 VPWR VGND VPWR VGND sky130_ef_sc_hd__decap_12
XTAP_TAPCELL_ROW_49_2_5050 VGND VPWR sky130_fd_sc_hd__tapvpwrvgnd_1
XFILLER_22_1454 VPWR VGND VPWR VGND sky130_ef_sc_hd__decap_12
XFILLER_150_15 VGND VGND VPWR VPWR sky130_fd_sc_hd__decap_6
XFILLER_232_108 VPWR VGND VPWR VGND sky130_ef_sc_hd__decap_12
XFILLER_254_992 VPWR VGND VPWR VGND sky130_ef_sc_hd__decap_12
XFILLER_183_1514 VGND VGND VPWR VPWR sky130_fd_sc_hd__fill_1
XTAP_TAPCELL_ROW_1_898 VGND VPWR sky130_fd_sc_hd__tapvpwrvgnd_1
XFILLER_0_1261 VPWR VGND VPWR VGND sky130_ef_sc_hd__decap_12
XFILLER_144_1509 VGND VGND VPWR VPWR sky130_fd_sc_hd__decap_6
XTAP_TAPCELL_ROW_16_2_4791 VGND VPWR sky130_fd_sc_hd__tapvpwrvgnd_1
XFILLER_55_1230 VPWR VGND VPWR VGND sky130_ef_sc_hd__decap_12
XFILLER_0_1294 VGND VGND VPWR VPWR sky130_fd_sc_hd__decap_8
XFILLER_201_517 VPWR VGND VPWR VGND sky130_ef_sc_hd__decap_12
XFILLER_240_163 VPWR VGND VPWR VGND sky130_ef_sc_hd__decap_12
XFILLER_213_388 VPWR VGND VPWR VGND sky130_ef_sc_hd__decap_12
XFILLER_146_1380 VPWR VGND VPWR VGND sky130_ef_sc_hd__decap_12
XFILLER_181_1260 VPWR VGND VPWR VGND sky130_ef_sc_hd__decap_12
XFILLER_55_1285 VGND VGND VPWR VPWR sky130_fd_sc_hd__decap_6
XFILLER_90_1165 VPWR VGND VPWR VGND sky130_ef_sc_hd__decap_12
XFILLER_159_68 VGND VGND VPWR VPWR sky130_fd_sc_hd__decap_3
XFILLER_166_421 VPWR VGND VPWR VGND sky130_ef_sc_hd__decap_12
XFILLER_103_1206 VPWR VGND VPWR VGND sky130_ef_sc_hd__decap_12
XFILLER_178_292 VPWR VGND VPWR VGND sky130_ef_sc_hd__decap_12
XTAP_TAPCELL_ROW_175_1868 VGND VPWR sky130_fd_sc_hd__tapvpwrvgnd_1
XFILLER_193_240 VPWR VGND VPWR VGND sky130_ef_sc_hd__decap_12
XFILLER_166_476 VPWR VGND VPWR VGND sky130_ef_sc_hd__decap_12
XTAP_TAPCELL_ROW_175_1879 VGND VPWR sky130_fd_sc_hd__tapvpwrvgnd_1
XFILLER_182_925 VPWR VGND VPWR VGND sky130_ef_sc_hd__decap_12
XFILLER_194_796 VPWR VGND VPWR VGND sky130_ef_sc_hd__decap_12
XFILLER_181_424 VGND VGND VPWR VPWR sky130_fd_sc_hd__decap_6
XFILLER_111_3 VPWR VGND VPWR VGND sky130_ef_sc_hd__decap_12
XFILLER_193_295 VGND VGND VPWR VPWR sky130_fd_sc_hd__decap_6
XFILLER_209_3 VPWR VGND VPWR VGND sky130_ef_sc_hd__decap_12
XFILLER_175_56 VPWR VGND VPWR VGND sky130_ef_sc_hd__decap_12
XFILLER_253_1217 VPWR VGND VPWR VGND sky130_ef_sc_hd__decap_12
XFILLER_190_980 VPWR VGND VPWR VGND sky130_ef_sc_hd__decap_12
XFILLER_218_1348 VGND VGND VPWR VPWR sky130_fd_sc_hd__decap_6
XFILLER_68_65 VGND VGND VPWR VPWR sky130_fd_sc_hd__decap_6
XFILLER_66_1392 VGND VGND VPWR VPWR sky130_fd_sc_hd__decap_6
XFILLER_191_44 VPWR VGND VPWR VGND sky130_ef_sc_hd__decap_12
XFILLER_248_230 VGND VGND VPWR VPWR sky130_fd_sc_hd__decap_6
XFILLER_114_1313 VPWR VGND VPWR VGND sky130_ef_sc_hd__decap_12
XFILLER_237_904 VPWR VGND VPWR VGND sky130_ef_sc_hd__decap_12
XFILLER_249_775 VPWR VGND VPWR VGND sky130_ef_sc_hd__decap_12
XFILLER_23_1218 VPWR VGND VPWR VGND sky130_ef_sc_hd__decap_12
XFILLER_191_99 VPWR VGND VPWR VGND sky130_ef_sc_hd__decap_12
XFILLER_209_639 VGND VGND VPWR VPWR sky130_fd_sc_hd__decap_6
XFILLER_114_1368 VPWR VGND VPWR VGND sky130_ef_sc_hd__decap_12
XPHY_EDGE_ROW_139_1_Right_795 VGND VGND VPWR VPWR sky130_fd_sc_hd__decap_3
XFILLER_237_959 VPWR VGND VPWR VGND sky130_ef_sc_hd__decap_12
XFILLER_252_918 VGND VGND VPWR VPWR sky130_fd_sc_hd__decap_6
XFILLER_1_1014 VPWR VGND VPWR VGND sky130_ef_sc_hd__decap_12
X_655_ clknet_3_4__leaf_clk acc_core.adder.cla_blocks\[5\].block.sum\[1\] _063_ VGND
+ VGND VPWR VPWR net56 sky130_fd_sc_hd__dfrtp_1
XTAP_TAPCELL_ROW_201_2802 VGND VPWR sky130_fd_sc_hd__tapvpwrvgnd_1
XFILLER_229_1444 VPWR VGND VPWR VGND sky130_ef_sc_hd__decap_12
XTAP_TAPCELL_ROW_253_4603 VGND VPWR sky130_fd_sc_hd__tapvpwrvgnd_1
XFILLER_1_1069 VGND VGND VPWR VPWR sky130_fd_sc_hd__decap_6
XTAP_TAPCELL_ROW_253_4614 VGND VPWR sky130_fd_sc_hd__tapvpwrvgnd_1
X_586_ net670 VGND VGND VPWR VPWR _068_ sky130_fd_sc_hd__inv_2
XTAP_TAPCELL_ROW_253_4625 VGND VPWR sky130_fd_sc_hd__tapvpwrvgnd_1
XFILLER_231_130 VPWR VGND VPWR VGND sky130_ef_sc_hd__decap_12
XFILLER_182_1035 VPWR VGND VPWR VGND sky130_ef_sc_hd__decap_12
XFILLER_204_366 VPWR VGND VPWR VGND sky130_ef_sc_hd__decap_12
XFILLER_229_1499 VGND VGND VPWR VPWR sky130_fd_sc_hd__decap_6
XFILLER_147_1177 VPWR VGND VPWR VGND sky130_ef_sc_hd__decap_12
XFILLER_231_185 VPWR VGND VPWR VGND sky130_ef_sc_hd__decap_12
XPHY_EDGE_ROW_75_2_Right_166 VGND VGND VPWR VPWR sky130_fd_sc_hd__decap_3
XFILLER_176_218 VPWR VGND VPWR VGND sky130_ef_sc_hd__decap_12
XFILLER_34_1325 VPWR VGND VPWR VGND sky130_ef_sc_hd__decap_12
XFILLER_125_1464 VPWR VGND VPWR VGND sky130_ef_sc_hd__decap_12
XTAP_TAPCELL_ROW_137_2_5760 VGND VPWR sky130_fd_sc_hd__tapvpwrvgnd_1
XFILLER_200_550 VPWR VGND VPWR VGND sky130_ef_sc_hd__decap_12
XFILLER_223_1076 VPWR VGND VPWR VGND sky130_ef_sc_hd__decap_12
XFILLER_121_1328 VGND VGND VPWR VPWR sky130_fd_sc_hd__decap_6
XFILLER_219_27 VPWR VGND VPWR VGND sky130_ef_sc_hd__decap_12
XFILLER_160_1399 VPWR VGND VPWR VGND sky130_ef_sc_hd__decap_12
XFILLER_172_402 VGND VGND VPWR VPWR sky130_fd_sc_hd__decap_6
XFILLER_184_273 VGND VGND VPWR VPWR sky130_fd_sc_hd__decap_6
XFILLER_173_947 VPWR VGND VPWR VGND sky130_ef_sc_hd__decap_12
XTAP_TAPCELL_ROW_247_4407 VGND VPWR sky130_fd_sc_hd__tapvpwrvgnd_1
XTAP_TAPCELL_ROW_247_4418 VGND VPWR sky130_fd_sc_hd__tapvpwrvgnd_1
XFILLER_158_1251 VPWR VGND VPWR VGND sky130_ef_sc_hd__decap_12
XFILLER_193_1131 VPWR VGND VPWR VGND sky130_ef_sc_hd__decap_12
XFILLER_235_15 VPWR VGND VPWR VGND sky130_ef_sc_hd__decap_12
XTAP_TAPCELL_ROW_86_2_5346 VGND VPWR sky130_fd_sc_hd__tapvpwrvgnd_1
XFILLER_10_1380 VPWR VGND VPWR VGND sky130_ef_sc_hd__decap_12
XTAP_TAPCELL_ROW_130_2_5703 VGND VPWR sky130_fd_sc_hd__tapvpwrvgnd_1
XFILLER_67_1189 VPWR VGND VPWR VGND sky130_ef_sc_hd__decap_12
XFILLER_193_1186 VPWR VGND VPWR VGND sky130_ef_sc_hd__decap_12
XFILLER_45_1421 VPWR VGND VPWR VGND sky130_ef_sc_hd__decap_12
XTAP_TAPCELL_ROW_9_1207 VGND VPWR sky130_fd_sc_hd__tapvpwrvgnd_1
XTAP_TAPCELL_ROW_9_1218 VGND VPWR sky130_fd_sc_hd__tapvpwrvgnd_1
XTAP_TAPCELL_ROW_9_1229 VGND VPWR sky130_fd_sc_hd__tapvpwrvgnd_1
XFILLER_45_1476 VPWR VGND VPWR VGND sky130_ef_sc_hd__decap_12
XFILLER_80_1356 VPWR VGND VPWR VGND sky130_ef_sc_hd__decap_12
XFILLER_234_1183 VPWR VGND VPWR VGND sky130_ef_sc_hd__decap_12
XFILLER_132_1435 VGND VGND VPWR VPWR sky130_fd_sc_hd__decap_6
XFILLER_239_252 VGND VGND VPWR VPWR sky130_fd_sc_hd__decap_6
XFILLER_228_937 VPWR VGND VPWR VGND sky130_ef_sc_hd__decap_12
XFILLER_230_1047 VGND VGND VPWR VPWR sky130_fd_sc_hd__decap_6
XFILLER_255_778 VPWR VGND VPWR VGND sky130_ef_sc_hd__decap_12
XFILLER_214_108 VPWR VGND VPWR VGND sky130_ef_sc_hd__decap_12
XFILLER_236_992 VPWR VGND VPWR VGND sky130_ef_sc_hd__decap_12
XFILLER_78_1263 VGND VGND VPWR VPWR sky130_fd_sc_hd__decap_6
XFILLER_251_940 VGND VGND VPWR VPWR sky130_fd_sc_hd__decap_6
XFILLER_222_163 VPWR VGND VPWR VGND sky130_ef_sc_hd__decap_12
XFILLER_126_1239 VPWR VGND VPWR VGND sky130_ef_sc_hd__decap_12
XFILLER_210_347 VPWR VGND VPWR VGND sky130_ef_sc_hd__decap_12
XFILLER_241_1143 VPWR VGND VPWR VGND sky130_ef_sc_hd__decap_12
XFILLER_13_27 VPWR VGND VPWR VGND sky130_ef_sc_hd__decap_12
XFILLER_129_27 VPWR VGND VPWR VGND sky130_ef_sc_hd__decap_12
XFILLER_175_240 VPWR VGND VPWR VGND sky130_ef_sc_hd__decap_12
XFILLER_241_1198 VGND VGND VPWR VPWR sky130_fd_sc_hd__decap_6
XFILLER_176_796 VPWR VGND VPWR VGND sky130_ef_sc_hd__decap_12
XTAP_TAPCELL_ROW_170_1710 VGND VPWR sky130_fd_sc_hd__tapvpwrvgnd_1
XFILLER_175_295 VGND VGND VPWR VPWR sky130_fd_sc_hd__decap_6
XFILLER_191_744 VPWR VGND VPWR VGND sky130_ef_sc_hd__decap_12
XTAP_TAPCELL_ROW_211_3131 VGND VPWR sky130_fd_sc_hd__tapvpwrvgnd_1
XTAP_TAPCELL_ROW_170_1721 VGND VPWR sky130_fd_sc_hd__tapvpwrvgnd_1
XTAP_TAPCELL_ROW_211_3142 VGND VPWR sky130_fd_sc_hd__tapvpwrvgnd_1
XFILLER_85_1201 VGND VGND VPWR VPWR sky130_fd_sc_hd__decap_4
XTAP_TAPCELL_ROW_211_3153 VGND VPWR sky130_fd_sc_hd__tapvpwrvgnd_1
XFILLER_198_1097 VPWR VGND VPWR VGND sky130_ef_sc_hd__decap_12
XTAP_TAPCELL_ROW_230_3798 VGND VPWR sky130_fd_sc_hd__tapvpwrvgnd_1
XFILLER_11_1177 VPWR VGND VPWR VGND sky130_ef_sc_hd__decap_12
XFILLER_102_1294 VPWR VGND VPWR VGND sky130_ef_sc_hd__decap_12
XFILLER_172_980 VPWR VGND VPWR VGND sky130_ef_sc_hd__decap_12
XFILLER_191_799 VPWR VGND VPWR VGND sky130_ef_sc_hd__decap_12
XFILLER_145_15 VPWR VGND VPWR VGND sky130_ef_sc_hd__decap_12
Xmax_cap183 _084_ VGND VGND VPWR VPWR net183 sky130_fd_sc_hd__buf_1
XFILLER_1_128 VGND VGND VPWR VPWR sky130_fd_sc_hd__fill_1
XFILLER_137_1335 VPWR VGND VPWR VGND sky130_ef_sc_hd__decap_12
Xmax_cap194 net195 VGND VGND VPWR VPWR net194 sky130_fd_sc_hd__clkbuf_1
XFILLER_172_1226 VPWR VGND VPWR VGND sky130_ef_sc_hd__decap_12
XFILLER_252_1250 VPWR VGND VPWR VGND sky130_ef_sc_hd__decap_12
XFILLER_217_1370 VGND VGND VPWR VPWR sky130_fd_sc_hd__decap_6
XTAP_TAPCELL_ROW_209_3060 VGND VPWR sky130_fd_sc_hd__tapvpwrvgnd_1
XFILLER_219_904 VPWR VGND VPWR VGND sky130_ef_sc_hd__decap_12
XTAP_TAPCELL_ROW_168_1650 VGND VPWR sky130_fd_sc_hd__tapvpwrvgnd_1
XTAP_TAPCELL_ROW_209_3071 VGND VPWR sky130_fd_sc_hd__tapvpwrvgnd_1
XTAP_TAPCELL_ROW_209_3082 VGND VPWR sky130_fd_sc_hd__tapvpwrvgnd_1
XFILLER_38_46 VPWR VGND VPWR VGND sky130_ef_sc_hd__decap_12
XFILLER_246_734 VPWR VGND VPWR VGND sky130_ef_sc_hd__decap_12
XFILLER_219_959 VPWR VGND VPWR VGND sky130_ef_sc_hd__decap_12
XFILLER_22_1251 VPWR VGND VPWR VGND sky130_ef_sc_hd__decap_12
XFILLER_2_1312 VPWR VGND VPWR VGND sky130_ef_sc_hd__decap_12
XFILLER_234_918 VGND VGND VPWR VPWR sky130_fd_sc_hd__decap_6
XTAP_TAPCELL_ROW_102_1_1382 VGND VPWR sky130_fd_sc_hd__tapvpwrvgnd_1
XFILLER_246_789 VGND VGND VPWR VPWR sky130_fd_sc_hd__decap_6
XFILLER_113_1390 VPWR VGND VPWR VGND sky130_ef_sc_hd__decap_12
XFILLER_241_80 VGND VGND VPWR VPWR sky130_fd_sc_hd__decap_6
XFILLER_199_811 VGND VGND VPWR VPWR sky130_fd_sc_hd__decap_6
XFILLER_54_34 VGND VGND VPWR VPWR sky130_fd_sc_hd__decap_8
XFILLER_2_1367 VPWR VGND VPWR VGND sky130_ef_sc_hd__decap_12
X_440_ net100 _211_ _228_ net112 VGND VGND VPWR VPWR _229_ sky130_fd_sc_hd__a211oi_1
XFILLER_148_1442 VPWR VGND VPWR VGND sky130_ef_sc_hd__decap_12
XFILLER_246_1054 VPWR VGND VPWR VGND sky130_ef_sc_hd__decap_12
XFILLER_57_1347 VPWR VGND VPWR VGND sky130_ef_sc_hd__decap_12
XFILLER_92_1227 VPWR VGND VPWR VGND sky130_ef_sc_hd__decap_12
XFILLER_213_130 VPWR VGND VPWR VGND sky130_ef_sc_hd__decap_12
XFILLER_159_3 VPWR VGND VPWR VGND sky130_ef_sc_hd__decap_12
X_371_ net134 _158_ _159_ VGND VGND VPWR VPWR _160_ sky130_fd_sc_hd__o21a_1
XFILLER_144_1306 VGND VGND VPWR VPWR sky130_fd_sc_hd__decap_6
XFILLER_148_1497 VPWR VGND VPWR VGND sky130_ef_sc_hd__decap_12
XFILLER_183_1377 VPWR VGND VPWR VGND sky130_ef_sc_hd__decap_12
XFILLER_201_314 VPWR VGND VPWR VGND sky130_ef_sc_hd__decap_12
XFILLER_213_185 VPWR VGND VPWR VGND sky130_ef_sc_hd__decap_12
XFILLER_186_538 VPWR VGND VPWR VGND sky130_ef_sc_hd__decap_12
XFILLER_70_22 VPWR VGND VPWR VGND sky130_ef_sc_hd__decap_12
XFILLER_201_369 VPWR VGND VPWR VGND sky130_ef_sc_hd__decap_12
XFILLER_186_22 VPWR VGND VPWR VGND sky130_ef_sc_hd__decap_12
XFILLER_220_1238 VPWR VGND VPWR VGND sky130_ef_sc_hd__decap_12
XFILLER_166_273 VGND VGND VPWR VPWR sky130_fd_sc_hd__decap_6
XFILLER_182_722 VPWR VGND VPWR VGND sky130_ef_sc_hd__decap_12
XFILLER_194_593 VPWR VGND VPWR VGND sky130_ef_sc_hd__decap_12
XFILLER_186_77 VPWR VGND VPWR VGND sky130_ef_sc_hd__decap_12
XFILLER_170_906 VPWR VGND VPWR VGND sky130_ef_sc_hd__decap_12
XFILLER_6_968 VPWR VGND VPWR VGND sky130_ef_sc_hd__decap_12
XFILLER_5_445 VGND VGND VPWR VPWR sky130_fd_sc_hd__fill_2
XFILLER_182_777 VPWR VGND VPWR VGND sky130_ef_sc_hd__decap_12
XTAP_TAPCELL_ROW_156_1_1464 VGND VPWR sky130_fd_sc_hd__tapvpwrvgnd_1
XFILLER_68_1454 VPWR VGND VPWR VGND sky130_ef_sc_hd__decap_12
XFILLER_155_1402 VPWR VGND VPWR VGND sky130_ef_sc_hd__decap_12
XFILLER_253_1014 VPWR VGND VPWR VGND sky130_ef_sc_hd__decap_12
XFILLER_194_1484 VPWR VGND VPWR VGND sky130_ef_sc_hd__decap_12
XFILLER_155_1457 VGND VGND VPWR VPWR sky130_fd_sc_hd__decap_6
XFILLER_190_1348 VGND VGND VPWR VPWR sky130_fd_sc_hd__decap_6
XFILLER_253_1069 VGND VGND VPWR VPWR sky130_fd_sc_hd__decap_6
XTAP_TAPCELL_ROW_38_2_4967 VGND VPWR sky130_fd_sc_hd__tapvpwrvgnd_1
XPHY_EDGE_ROW_17_2_Left_519 VGND VGND VPWR VPWR sky130_fd_sc_hd__decap_3
XFILLER_237_701 VPWR VGND VPWR VGND sky130_ef_sc_hd__decap_12
XFILLER_231_1334 VPWR VGND VPWR VGND sky130_ef_sc_hd__decap_12
XFILLER_249_572 VPWR VGND VPWR VGND sky130_ef_sc_hd__decap_12
XFILLER_114_1165 VPWR VGND VPWR VGND sky130_ef_sc_hd__decap_12
XFILLER_237_756 VPWR VGND VPWR VGND sky130_ef_sc_hd__decap_12
XFILLER_231_1389 VPWR VGND VPWR VGND sky130_ef_sc_hd__decap_12
XTAP_TAPCELL_ROW_180_2050 VGND VPWR sky130_fd_sc_hd__tapvpwrvgnd_1
XTAP_TAPCELL_ROW_180_2061 VGND VPWR sky130_fd_sc_hd__tapvpwrvgnd_1
XFILLER_149_1206 VPWR VGND VPWR VGND sky130_ef_sc_hd__decap_12
XTAP_TAPCELL_ROW_180_2072 VGND VPWR sky130_fd_sc_hd__tapvpwrvgnd_1
XTAP_TAPCELL_ROW_255_4709 VGND VPWR sky130_fd_sc_hd__tapvpwrvgnd_1
XFILLER_218_992 VPWR VGND VPWR VGND sky130_ef_sc_hd__decap_12
XFILLER_221_39 VGND VGND VPWR VPWR sky130_fd_sc_hd__decap_4
XFILLER_229_1241 VGND VGND VPWR VPWR sky130_fd_sc_hd__decap_6
X_638_ clknet_3_3__leaf_clk acc_core.adder.cla_blocks\[1\].block.sum\[0\] _046_ VGND
+ VGND VPWR VPWR net69 sky130_fd_sc_hd__dfrtp_1
XFILLER_75_1414 VGND VGND VPWR VPWR sky130_fd_sc_hd__decap_6
XFILLER_233_940 VGND VGND VPWR VPWR sky130_fd_sc_hd__decap_6
X_569_ net666 VGND VGND VPWR VPWR _051_ sky130_fd_sc_hd__inv_2
XPHY_EDGE_ROW_131_2_Left_633 VGND VGND VPWR VPWR sky130_fd_sc_hd__decap_3
XFILLER_204_163 VPWR VGND VPWR VGND sky130_ef_sc_hd__decap_12
XFILLER_242_1441 VPWR VGND VPWR VGND sky130_ef_sc_hd__decap_12
XFILLER_220_667 VPWR VGND VPWR VGND sky130_ef_sc_hd__decap_12
XPHY_EDGE_ROW_76_2_Right_167 VGND VGND VPWR VPWR sky130_fd_sc_hd__decap_3
XFILLER_125_1261 VPWR VGND VPWR VGND sky130_ef_sc_hd__decap_12
XFILLER_242_1496 VPWR VGND VPWR VGND sky130_ef_sc_hd__decap_12
XFILLER_192_519 VPWR VGND VPWR VGND sky130_ef_sc_hd__decap_12
XFILLER_74_3 VPWR VGND VPWR VGND sky130_ef_sc_hd__decap_12
XFILLER_185_560 VPWR VGND VPWR VGND sky130_ef_sc_hd__decap_12
XTAP_TAPCELL_ROW_193_2499 VGND VPWR sky130_fd_sc_hd__tapvpwrvgnd_1
XFILLER_34_1177 VGND VGND VPWR VPWR sky130_fd_sc_hd__decap_6
XTAP_TAPCELL_ROW_32_1_1277 VGND VPWR sky130_fd_sc_hd__tapvpwrvgnd_1
XFILLER_160_1196 VPWR VGND VPWR VGND sky130_ef_sc_hd__decap_12
XFILLER_173_744 VPWR VGND VPWR VGND sky130_ef_sc_hd__decap_12
XFILLER_69_1218 VPWR VGND VPWR VGND sky130_ef_sc_hd__decap_12
XFILLER_12_1442 VPWR VGND VPWR VGND sky130_ef_sc_hd__decap_12
XFILLER_195_1248 VPWR VGND VPWR VGND sky130_ef_sc_hd__decap_12
XFILLER_246_58 VGND VGND VPWR VPWR sky130_fd_sc_hd__decap_6
XFILLER_173_799 VPWR VGND VPWR VGND sky130_ef_sc_hd__decap_12
XFILLER_12_1497 VPWR VGND VPWR VGND sky130_ef_sc_hd__decap_12
XFILLER_5_990 VPWR VGND VPWR VGND sky130_ef_sc_hd__decap_12
XTAP_TAPCELL_ROW_120_1_1409 VGND VPWR sky130_fd_sc_hd__tapvpwrvgnd_1
XFILLER_232_1109 VPWR VGND VPWR VGND sky130_ef_sc_hd__decap_12
XFILLER_45_1273 VPWR VGND VPWR VGND sky130_ef_sc_hd__decap_12
XFILLER_228_734 VPWR VGND VPWR VGND sky130_ef_sc_hd__decap_12
XPHY_EDGE_ROW_145_1_Left_400 VGND VGND VPWR VPWR sky130_fd_sc_hd__decap_3
XTAP_TAPCELL_ROW_160_2_5942 VGND VPWR sky130_fd_sc_hd__tapvpwrvgnd_1
XTAP_TAPCELL_ROW_159_2_5936 VGND VPWR sky130_fd_sc_hd__tapvpwrvgnd_1
XFILLER_216_918 VGND VGND VPWR VPWR sky130_fd_sc_hd__decap_6
XTAP_TAPCELL_ROW_128_2_5683 VGND VPWR sky130_fd_sc_hd__tapvpwrvgnd_1
XFILLER_228_789 VGND VGND VPWR VPWR sky130_fd_sc_hd__decap_6
XTAP_TAPCELL_ROW_86_1_1359 VGND VPWR sky130_fd_sc_hd__tapvpwrvgnd_1
XFILLER_131_39 VGND VGND VPWR VPWR sky130_fd_sc_hd__decap_4
XPHY_EDGE_ROW_63_2_Left_565 VGND VGND VPWR VPWR sky130_fd_sc_hd__decap_3
XFILLER_165_1030 VPWR VGND VPWR VGND sky130_ef_sc_hd__decap_12
XFILLER_230_409 VPWR VGND VPWR VGND sky130_ef_sc_hd__decap_12
XFILLER_243_1205 VPWR VGND VPWR VGND sky130_ef_sc_hd__decap_12
XFILLER_54_1509 VGND VGND VPWR VPWR sky130_fd_sc_hd__decap_6
XFILLER_24_15 VGND VGND VPWR VPWR sky130_fd_sc_hd__decap_6
XFILLER_208_1336 VPWR VGND VPWR VGND sky130_ef_sc_hd__decap_12
XFILLER_165_1063 VGND VGND VPWR VPWR sky130_fd_sc_hd__decap_8
XFILLER_195_302 VPWR VGND VPWR VGND sky130_ef_sc_hd__decap_12
XFILLER_250_280 VPWR VGND VPWR VGND sky130_ef_sc_hd__decap_12
XFILLER_168_538 VPWR VGND VPWR VGND sky130_ef_sc_hd__decap_12
XFILLER_56_1380 VPWR VGND VPWR VGND sky130_ef_sc_hd__decap_12
XTAP_TAPCELL_ROW_217_3340 VGND VPWR sky130_fd_sc_hd__tapvpwrvgnd_1
XTAP_TAPCELL_ROW_121_2_5626 VGND VPWR sky130_fd_sc_hd__tapvpwrvgnd_1
XTAP_TAPCELL_ROW_176_1930 VGND VPWR sky130_fd_sc_hd__tapvpwrvgnd_1
XFILLER_210_144 VGND VGND VPWR VPWR sky130_fd_sc_hd__decap_6
XTAP_TAPCELL_ROW_217_3351 VGND VPWR sky130_fd_sc_hd__tapvpwrvgnd_1
XFILLER_221_1514 VGND VGND VPWR VPWR sky130_fd_sc_hd__fill_1
XFILLER_195_357 VPWR VGND VPWR VGND sky130_ef_sc_hd__decap_12
XTAP_TAPCELL_ROW_217_3362 VGND VPWR sky130_fd_sc_hd__tapvpwrvgnd_1
XFILLER_211_689 VPWR VGND VPWR VGND sky130_ef_sc_hd__decap_12
XTAP_TAPCELL_ROW_213_3204 VGND VPWR sky130_fd_sc_hd__tapvpwrvgnd_1
XFILLER_13_1206 VPWR VGND VPWR VGND sky130_ef_sc_hd__decap_12
XTAP_TAPCELL_ROW_213_3215 VGND VPWR sky130_fd_sc_hd__tapvpwrvgnd_1
XTAP_TAPCELL_ROW_213_3226 VGND VPWR sky130_fd_sc_hd__tapvpwrvgnd_1
XFILLER_104_1356 VPWR VGND VPWR VGND sky130_ef_sc_hd__decap_12
XFILLER_176_593 VPWR VGND VPWR VGND sky130_ef_sc_hd__decap_12
XFILLER_191_541 VPWR VGND VPWR VGND sky130_ef_sc_hd__decap_12
XFILLER_40_58 VGND VGND VPWR VPWR sky130_fd_sc_hd__decap_6
XFILLER_3_916 VPWR VGND VPWR VGND sky130_ef_sc_hd__decap_12
XFILLER_156_58 VGND VGND VPWR VPWR sky130_fd_sc_hd__decap_6
XFILLER_254_1312 VPWR VGND VPWR VGND sky130_ef_sc_hd__decap_12
XFILLER_191_596 VGND VGND VPWR VPWR sky130_fd_sc_hd__decap_6
XFILLER_219_1432 VPWR VGND VPWR VGND sky130_ef_sc_hd__decap_12
XTAP_TAPCELL_ROW_24_2_4853 VGND VPWR sky130_fd_sc_hd__tapvpwrvgnd_1
XFILLER_172_1023 VPWR VGND VPWR VGND sky130_ef_sc_hd__decap_12
XFILLER_254_1367 VPWR VGND VPWR VGND sky130_ef_sc_hd__decap_12
XFILLER_219_1487 VPWR VGND VPWR VGND sky130_ef_sc_hd__decap_12
XFILLER_137_1165 VPWR VGND VPWR VGND sky130_ef_sc_hd__decap_12
XTAP_TAPCELL_ROW_207_3008 VGND VPWR sky130_fd_sc_hd__tapvpwrvgnd_1
XFILLER_172_46 VPWR VGND VPWR VGND sky130_ef_sc_hd__decap_12
XFILLER_172_1078 VPWR VGND VPWR VGND sky130_ef_sc_hd__decap_12
XFILLER_24_1313 VPWR VGND VPWR VGND sky130_ef_sc_hd__decap_12
XPHY_EDGE_ROW_77_1_Left_332 VGND VGND VPWR VPWR sky130_fd_sc_hd__decap_3
XFILLER_219_701 VPWR VGND VPWR VGND sky130_ef_sc_hd__decap_12
XFILLER_246_531 VGND VGND VPWR VPWR sky130_fd_sc_hd__decap_6
XFILLER_24_1368 VPWR VGND VPWR VGND sky130_ef_sc_hd__decap_12
XFILLER_111_1316 VPWR VGND VPWR VGND sky130_ef_sc_hd__decap_12
XFILLER_219_756 VPWR VGND VPWR VGND sky130_ef_sc_hd__decap_12
XFILLER_65_44 VPWR VGND VPWR VGND sky130_ef_sc_hd__decap_12
XTAP_TAPCELL_ROW_2_960 VGND VPWR sky130_fd_sc_hd__tapvpwrvgnd_1
XFILLER_2_1164 VPWR VGND VPWR VGND sky130_ef_sc_hd__decap_12
XFILLER_215_940 VGND VGND VPWR VPWR sky130_fd_sc_hd__decap_6
XFILLER_109_1201 VGND VGND VPWR VPWR sky130_fd_sc_hd__decap_4
X_423_ net100 _211_ _129_ VGND VGND VPWR VPWR _212_ sky130_fd_sc_hd__a21oi_1
XFILLER_198_151 VPWR VGND VPWR VGND sky130_ef_sc_hd__decap_12
XFILLER_57_1177 VPWR VGND VPWR VGND sky130_ef_sc_hd__decap_12
XFILLER_148_1294 VPWR VGND VPWR VGND sky130_ef_sc_hd__decap_12
XFILLER_183_1174 VPWR VGND VPWR VGND sky130_ef_sc_hd__decap_12
XFILLER_201_111 VPWR VGND VPWR VGND sky130_ef_sc_hd__decap_12
X_354_ _140_ net333 VGND VGND VPWR VPWR _143_ sky130_fd_sc_hd__or2_1
XFILLER_186_335 VPWR VGND VPWR VGND sky130_ef_sc_hd__decap_12
XFILLER_202_667 VPWR VGND VPWR VGND sky130_ef_sc_hd__decap_12
XFILLER_201_166 VGND VGND VPWR VPWR sky130_fd_sc_hd__decap_6
XFILLER_35_1464 VPWR VGND VPWR VGND sky130_ef_sc_hd__decap_12
X_285_ web0 rd_addr\[0\] VGND VGND VPWR VPWR _082_ sky130_fd_sc_hd__nand2_1
XFILLER_122_1423 VPWR VGND VPWR VGND sky130_ef_sc_hd__decap_12
XFILLER_167_560 VPWR VGND VPWR VGND sky130_ef_sc_hd__decap_12
XFILLER_174_519 VPWR VGND VPWR VGND sky130_ef_sc_hd__decap_12
XFILLER_197_87 VPWR VGND VPWR VGND sky130_ef_sc_hd__decap_12
XFILLER_31_1328 VGND VGND VPWR VPWR sky130_fd_sc_hd__decap_6
XFILLER_220_1035 VPWR VGND VPWR VGND sky130_ef_sc_hd__decap_12
XFILLER_70_1399 VPWR VGND VPWR VGND sky130_ef_sc_hd__decap_12
XFILLER_122_1478 VGND VGND VPWR VPWR sky130_fd_sc_hd__decap_6
XFILLER_194_390 VPWR VGND VPWR VGND sky130_ef_sc_hd__decap_12
XFILLER_170_703 VGND VGND VPWR VPWR sky130_fd_sc_hd__decap_6
XFILLER_182_574 VGND VGND VPWR VPWR sky130_fd_sc_hd__decap_6
XFILLER_68_1251 VPWR VGND VPWR VGND sky130_ef_sc_hd__decap_12
XPHY_EDGE_ROW_173_Left_428 VGND VGND VPWR VPWR sky130_fd_sc_hd__decap_3
XFILLER_159_1390 VPWR VGND VPWR VGND sky130_ef_sc_hd__decap_12
XFILLER_194_1281 VPWR VGND VPWR VGND sky130_ef_sc_hd__decap_12
XFILLER_116_1227 VPWR VGND VPWR VGND sky130_ef_sc_hd__decap_12
XTAP_TAPCELL_ROW_186_2270 VGND VPWR sky130_fd_sc_hd__tapvpwrvgnd_1
XTAP_TAPCELL_ROW_145_2_5822 VGND VPWR sky130_fd_sc_hd__tapvpwrvgnd_1
XTAP_TAPCELL_ROW_182_2112 VGND VPWR sky130_fd_sc_hd__tapvpwrvgnd_1
XTAP_TAPCELL_ROW_186_2281 VGND VPWR sky130_fd_sc_hd__tapvpwrvgnd_1
XTAP_TAPCELL_ROW_182_2123 VGND VPWR sky130_fd_sc_hd__tapvpwrvgnd_1
XFILLER_231_1131 VPWR VGND VPWR VGND sky130_ef_sc_hd__decap_12
XTAP_TAPCELL_ROW_182_2134 VGND VPWR sky130_fd_sc_hd__tapvpwrvgnd_1
XFILLER_42_1435 VGND VGND VPWR VPWR sky130_fd_sc_hd__decap_6
Xinput7 wr_addr[5] VGND VGND VPWR VPWR net7 sky130_fd_sc_hd__clkbuf_1
XFILLER_231_1186 VPWR VGND VPWR VGND sky130_ef_sc_hd__decap_12
XFILLER_237_553 VGND VGND VPWR VPWR sky130_fd_sc_hd__decap_6
XPHY_EDGE_ROW_182_Left_437 VGND VGND VPWR VPWR sky130_fd_sc_hd__decap_3
XFILLER_244_1514 VGND VGND VPWR VPWR sky130_fd_sc_hd__fill_1
XTAP_TAPCELL_ROW_63_2_5166 VGND VPWR sky130_fd_sc_hd__tapvpwrvgnd_1
XFILLER_212_409 VPWR VGND VPWR VGND sky130_ef_sc_hd__decap_12
XTAP_TAPCELL_ROW_106_2_5506 VGND VPWR sky130_fd_sc_hd__tapvpwrvgnd_1
XFILLER_177_302 VPWR VGND VPWR VGND sky130_ef_sc_hd__decap_12
XFILLER_189_173 VPWR VGND VPWR VGND sky130_ef_sc_hd__decap_12
XFILLER_232_280 VPWR VGND VPWR VGND sky130_ef_sc_hd__decap_12
XFILLER_36_1239 VPWR VGND VPWR VGND sky130_ef_sc_hd__decap_12
XFILLER_127_1378 VPWR VGND VPWR VGND sky130_ef_sc_hd__decap_12
XFILLER_220_464 VPWR VGND VPWR VGND sky130_ef_sc_hd__decap_12
XFILLER_177_357 VPWR VGND VPWR VGND sky130_ef_sc_hd__decap_12
XFILLER_192_316 VGND VGND VPWR VPWR sky130_fd_sc_hd__decap_6
XFILLER_242_1293 VPWR VGND VPWR VGND sky130_ef_sc_hd__decap_12
XPHY_EDGE_ROW_77_2_Right_168 VGND VGND VPWR VPWR sky130_fd_sc_hd__decap_3
XFILLER_101_1507 VGND VGND VPWR VPWR sky130_fd_sc_hd__decap_8
XFILLER_173_541 VPWR VGND VPWR VGND sky130_ef_sc_hd__decap_12
XPHY_EDGE_ROW_191_Left_446 VGND VGND VPWR VPWR sky130_fd_sc_hd__decap_3
XFILLER_195_1045 VPWR VGND VPWR VGND sky130_ef_sc_hd__decap_12
XFILLER_173_596 VGND VGND VPWR VPWR sky130_fd_sc_hd__decap_6
XFILLER_12_1294 VPWR VGND VPWR VGND sky130_ef_sc_hd__decap_12
XTAP_TAPCELL_ROW_138_1_1436 VGND VPWR sky130_fd_sc_hd__tapvpwrvgnd_1
XFILLER_47_1335 VPWR VGND VPWR VGND sky130_ef_sc_hd__decap_12
XFILLER_138_1485 VPWR VGND VPWR VGND sky130_ef_sc_hd__decap_12
XTAP_TAPCELL_ROW_225_3620 VGND VPWR sky130_fd_sc_hd__tapvpwrvgnd_1
XFILLER_236_1097 VPWR VGND VPWR VGND sky130_ef_sc_hd__decap_12
XFILLER_19_15 VPWR VGND VPWR VGND sky130_ef_sc_hd__decap_12
XFILLER_134_1349 VGND VGND VPWR VPWR sky130_fd_sc_hd__decap_6
XTAP_TAPCELL_ROW_225_3631 VGND VPWR sky130_fd_sc_hd__tapvpwrvgnd_1
XTAP_TAPCELL_ROW_225_3642 VGND VPWR sky130_fd_sc_hd__tapvpwrvgnd_1
XTAP_TAPCELL_ROW_221_3506 VGND VPWR sky130_fd_sc_hd__tapvpwrvgnd_1
XFILLER_228_531 VGND VGND VPWR VPWR sky130_fd_sc_hd__decap_6
XFILLER_210_1226 VPWR VGND VPWR VGND sky130_ef_sc_hd__decap_12
XFILLER_23_1390 VPWR VGND VPWR VGND sky130_ef_sc_hd__decap_12
XFILLER_58_1442 VPWR VGND VPWR VGND sky130_ef_sc_hd__decap_12
XFILLER_243_1002 VPWR VGND VPWR VGND sky130_ef_sc_hd__decap_12
XFILLER_35_69 VGND VGND VPWR VPWR sky130_fd_sc_hd__fill_2
XTAP_TAPCELL_ROW_219_3413 VGND VPWR sky130_fd_sc_hd__tapvpwrvgnd_1
XFILLER_230_206 VPWR VGND VPWR VGND sky130_ef_sc_hd__decap_12
XTAP_TAPCELL_ROW_219_3424 VGND VPWR sky130_fd_sc_hd__tapvpwrvgnd_1
XFILLER_54_1306 VGND VGND VPWR VPWR sky130_fd_sc_hd__decap_6
XFILLER_208_1133 VGND VGND VPWR VPWR sky130_fd_sc_hd__decap_6
XTAP_TAPCELL_ROW_219_3435 VGND VPWR sky130_fd_sc_hd__tapvpwrvgnd_1
XFILLER_58_1497 VPWR VGND VPWR VGND sky130_ef_sc_hd__decap_12
XFILLER_145_1445 VPWR VGND VPWR VGND sky130_ef_sc_hd__decap_12
XFILLER_180_1336 VPWR VGND VPWR VGND sky130_ef_sc_hd__decap_12
XFILLER_211_431 VPWR VGND VPWR VGND sky130_ef_sc_hd__decap_12
XFILLER_243_1057 VPWR VGND VPWR VGND sky130_ef_sc_hd__decap_12
XFILLER_168_335 VPWR VGND VPWR VGND sky130_ef_sc_hd__decap_12
Xwire405 net406 VGND VGND VPWR VPWR net405 sky130_fd_sc_hd__clkbuf_1
XFILLER_195_154 VPWR VGND VPWR VGND sky130_ef_sc_hd__decap_12
XFILLER_211_486 VPWR VGND VPWR VGND sky130_ef_sc_hd__decap_12
Xwire416 net417 VGND VGND VPWR VPWR net416 sky130_fd_sc_hd__clkbuf_1
XFILLER_184_839 VPWR VGND VPWR VGND sky130_ef_sc_hd__decap_12
Xwire427 net428 VGND VGND VPWR VPWR net427 sky130_fd_sc_hd__clkbuf_1
Xwire438 net439 VGND VGND VPWR VPWR net438 sky130_fd_sc_hd__clkbuf_1
Xwire449 net450 VGND VGND VPWR VPWR net449 sky130_fd_sc_hd__clkbuf_1
XFILLER_183_338 VGND VGND VPWR VPWR sky130_fd_sc_hd__decap_6
XFILLER_176_390 VPWR VGND VPWR VGND sky130_ef_sc_hd__decap_12
XFILLER_221_1377 VPWR VGND VPWR VGND sky130_ef_sc_hd__decap_12
XFILLER_167_68 VPWR VGND VPWR VGND sky130_ef_sc_hd__decap_12
XFILLER_192_894 VPWR VGND VPWR VGND sky130_ef_sc_hd__decap_12
XFILLER_65_1402 VPWR VGND VPWR VGND sky130_ef_sc_hd__decap_12
XFILLER_139_1249 VPWR VGND VPWR VGND sky130_ef_sc_hd__decap_12
XFILLER_183_56 VPWR VGND VPWR VGND sky130_ef_sc_hd__decap_12
XFILLER_191_1432 VPWR VGND VPWR VGND sky130_ef_sc_hd__decap_12
XFILLER_254_1164 VPWR VGND VPWR VGND sky130_ef_sc_hd__decap_12
XFILLER_65_1457 VGND VGND VPWR VPWR sky130_fd_sc_hd__decap_6
XFILLER_219_1284 VGND VGND VPWR VPWR sky130_fd_sc_hd__decap_6
XFILLER_2_278 VGND VGND VPWR VPWR sky130_fd_sc_hd__fill_1
XFILLER_239_818 VPWR VGND VPWR VGND sky130_ef_sc_hd__decap_12
XPHY_EDGE_ROW_39_2_Right_130 VGND VGND VPWR VPWR sky130_fd_sc_hd__decap_3
XFILLER_191_1487 VPWR VGND VPWR VGND sky130_ef_sc_hd__decap_12
XFILLER_76_65 VGND VGND VPWR VPWR sky130_fd_sc_hd__decap_6
Xfanout593 net604 VGND VGND VPWR VPWR net593 sky130_fd_sc_hd__clkbuf_2
XFILLER_4_1226 VPWR VGND VPWR VGND sky130_ef_sc_hd__decap_12
XFILLER_219_553 VGND VGND VPWR VPWR sky130_fd_sc_hd__decap_6
XFILLER_232_1484 VPWR VGND VPWR VGND sky130_ef_sc_hd__decap_12
XFILLER_24_1165 VPWR VGND VPWR VGND sky130_ef_sc_hd__decap_12
XFILLER_247_873 VPWR VGND VPWR VGND sky130_ef_sc_hd__decap_12
XTAP_TAPCELL_ROW_80_2_5305 VGND VPWR sky130_fd_sc_hd__tapvpwrvgnd_1
XFILLER_150_1184 VPWR VGND VPWR VGND sky130_ef_sc_hd__decap_12
XFILLER_59_1206 VPWR VGND VPWR VGND sky130_ef_sc_hd__decap_12
XTAP_TAPCELL_ROW_48_2_5046 VGND VPWR sky130_fd_sc_hd__tapvpwrvgnd_1
XFILLER_221_228 VPWR VGND VPWR VGND sky130_ef_sc_hd__decap_12
XFILLER_214_280 VPWR VGND VPWR VGND sky130_ef_sc_hd__decap_12
X_406_ net200 _193_ _191_ VGND VGND VPWR VPWR _195_ sky130_fd_sc_hd__a21o_1
XTAP_TAPCELL_ROW_144_1_1446 VGND VPWR sky130_fd_sc_hd__tapvpwrvgnd_1
XFILLER_186_132 VPWR VGND VPWR VGND sky130_ef_sc_hd__decap_12
XTAP_TAPCELL_ROW_194_2550 VGND VPWR sky130_fd_sc_hd__tapvpwrvgnd_1
XTAP_TAPCELL_ROW_194_2561 VGND VPWR sky130_fd_sc_hd__tapvpwrvgnd_1
XFILLER_202_464 VPWR VGND VPWR VGND sky130_ef_sc_hd__decap_12
XTAP_TAPCELL_ROW_190_2403 VGND VPWR sky130_fd_sc_hd__tapvpwrvgnd_1
X_337_ net137 VGND VGND VPWR VPWR _126_ sky130_fd_sc_hd__inv_2
XTAP_TAPCELL_ROW_190_2414 VGND VPWR sky130_fd_sc_hd__tapvpwrvgnd_1
XFILLER_35_1261 VPWR VGND VPWR VGND sky130_ef_sc_hd__decap_12
XFILLER_122_1220 VGND VGND VPWR VPWR sky130_fd_sc_hd__decap_6
XFILLER_174_316 VGND VGND VPWR VPWR sky130_fd_sc_hd__decap_6
XFILLER_186_187 VGND VGND VPWR VPWR sky130_fd_sc_hd__decap_6
XFILLER_70_1196 VPWR VGND VPWR VGND sky130_ef_sc_hd__decap_12
XFILLER_183_861 VPWR VGND VPWR VGND sky130_ef_sc_hd__decap_12
XFILLER_227_27 VPWR VGND VPWR VGND sky130_ef_sc_hd__decap_12
XFILLER_157_1316 VPWR VGND VPWR VGND sky130_ef_sc_hd__decap_12
XFILLER_192_1207 VPWR VGND VPWR VGND sky130_ef_sc_hd__decap_12
XTAP_TAPCELL_ROW_188_2321 VGND VPWR sky130_fd_sc_hd__tapvpwrvgnd_1
XTAP_TAPCELL_ROW_188_2332 VGND VPWR sky130_fd_sc_hd__tapvpwrvgnd_1
XFILLER_196_1398 VPWR VGND VPWR VGND sky130_ef_sc_hd__decap_12
XTAP_TAPCELL_ROW_188_2343 VGND VPWR sky130_fd_sc_hd__tapvpwrvgnd_1
XTAP_TAPCELL_ROW_184_2207 VGND VPWR sky130_fd_sc_hd__tapvpwrvgnd_1
XFILLER_9_1126 VGND VGND VPWR VPWR sky130_fd_sc_hd__decap_8
XFILLER_243_15 VPWR VGND VPWR VGND sky130_ef_sc_hd__decap_12
XFILLER_37_3 VPWR VGND VPWR VGND sky130_ef_sc_hd__decap_12
XFILLER_233_1248 VPWR VGND VPWR VGND sky130_ef_sc_hd__decap_12
XFILLER_81_1292 VPWR VGND VPWR VGND sky130_ef_sc_hd__decap_12
XFILLER_238_851 VPWR VGND VPWR VGND sky130_ef_sc_hd__decap_12
XFILLER_133_1371 VGND VGND VPWR VPWR sky130_fd_sc_hd__decap_6
XFILLER_168_1434 VGND VGND VPWR VPWR sky130_fd_sc_hd__decap_6
XFILLER_253_854 VGND VGND VPWR VPWR sky130_fd_sc_hd__decap_6
XFILLER_77_1328 VGND VGND VPWR VPWR sky130_fd_sc_hd__decap_6
XFILLER_209_1420 VPWR VGND VPWR VGND sky130_ef_sc_hd__decap_12
XFILLER_212_206 VPWR VGND VPWR VGND sky130_ef_sc_hd__decap_12
XTAP_TAPCELL_ROW_20_1_1259 VGND VPWR sky130_fd_sc_hd__tapvpwrvgnd_1
XFILLER_244_1355 VPWR VGND VPWR VGND sky130_ef_sc_hd__decap_12
XFILLER_209_1475 VPWR VGND VPWR VGND sky130_ef_sc_hd__decap_12
XTAP_TAPCELL_ROW_233_3900 VGND VPWR sky130_fd_sc_hd__tapvpwrvgnd_1
XFILLER_240_1219 VGND VGND VPWR VPWR sky130_fd_sc_hd__decap_6
XTAP_TAPCELL_ROW_233_3911 VGND VPWR sky130_fd_sc_hd__tapvpwrvgnd_1
XFILLER_177_154 VPWR VGND VPWR VGND sky130_ef_sc_hd__decap_12
XFILLER_193_603 VPWR VGND VPWR VGND sky130_ef_sc_hd__decap_12
XFILLER_220_261 VPWR VGND VPWR VGND sky130_ef_sc_hd__decap_12
XTAP_TAPCELL_ROW_233_3922 VGND VPWR sky130_fd_sc_hd__tapvpwrvgnd_1
XFILLER_165_316 VPWR VGND VPWR VGND sky130_ef_sc_hd__decap_12
XFILLER_166_839 VPWR VGND VPWR VGND sky130_ef_sc_hd__decap_12
XFILLER_242_1090 VGND VGND VPWR VPWR sky130_fd_sc_hd__decap_6
XFILLER_165_349 VGND VGND VPWR VPWR sky130_fd_sc_hd__decap_8
XFILLER_193_658 VPWR VGND VPWR VGND sky130_ef_sc_hd__decap_12
XFILLER_21_27 VPWR VGND VPWR VGND sky130_ef_sc_hd__decap_12
XFILLER_14_1356 VPWR VGND VPWR VGND sky130_ef_sc_hd__decap_12
XFILLER_101_1304 VPWR VGND VPWR VGND sky130_ef_sc_hd__decap_12
XPHY_EDGE_ROW_78_2_Right_169 VGND VGND VPWR VPWR sky130_fd_sc_hd__decap_3
XFILLER_88_1435 VGND VGND VPWR VPWR sky130_fd_sc_hd__decap_6
XFILLER_137_27 VPWR VGND VPWR VGND sky130_ef_sc_hd__decap_12
XFILLER_101_1359 VPWR VGND VPWR VGND sky130_ef_sc_hd__decap_12
XFILLER_174_894 VPWR VGND VPWR VGND sky130_ef_sc_hd__decap_12
XTAP_TAPCELL_ROW_227_3704 VGND VPWR sky130_fd_sc_hd__tapvpwrvgnd_1
XFILLER_255_1462 VGND VGND VPWR VPWR sky130_fd_sc_hd__decap_8
XTAP_TAPCELL_ROW_227_3715 VGND VPWR sky130_fd_sc_hd__tapvpwrvgnd_1
XFILLER_251_1315 VPWR VGND VPWR VGND sky130_ef_sc_hd__decap_12
XTAP_TAPCELL_ROW_39_2_4972 VGND VPWR sky130_fd_sc_hd__tapvpwrvgnd_1
XFILLER_47_1165 VPWR VGND VPWR VGND sky130_ef_sc_hd__decap_12
XFILLER_138_1282 VPWR VGND VPWR VGND sky130_ef_sc_hd__decap_12
XFILLER_153_15 VPWR VGND VPWR VGND sky130_ef_sc_hd__decap_12
XFILLER_173_1162 VPWR VGND VPWR VGND sky130_ef_sc_hd__decap_12
XFILLER_248_648 VPWR VGND VPWR VGND sky130_ef_sc_hd__decap_12
XFILLER_112_1411 VPWR VGND VPWR VGND sky130_ef_sc_hd__decap_12
XFILLER_210_1023 VPWR VGND VPWR VGND sky130_ef_sc_hd__decap_12
XFILLER_229_873 VPWR VGND VPWR VGND sky130_ef_sc_hd__decap_12
XFILLER_21_1316 VPWR VGND VPWR VGND sky130_ef_sc_hd__decap_12
XFILLER_244_832 VGND VGND VPWR VPWR sky130_fd_sc_hd__decap_6
XFILLER_46_46 VPWR VGND VPWR VGND sky130_ef_sc_hd__decap_12
XFILLER_112_1466 VPWR VGND VPWR VGND sky130_ef_sc_hd__decap_12
XTAP_TAPCELL_ROW_165_1483 VGND VPWR sky130_fd_sc_hd__tapvpwrvgnd_1
XTAP_TAPCELL_ROW_165_1494 VGND VPWR sky130_fd_sc_hd__tapvpwrvgnd_1
XFILLER_210_1078 VPWR VGND VPWR VGND sky130_ef_sc_hd__decap_12
XTAP_TAPCELL_ROW_32_2_4915 VGND VPWR sky130_fd_sc_hd__tapvpwrvgnd_1
XFILLER_147_1507 VGND VGND VPWR VPWR sky130_fd_sc_hd__decap_8
XFILLER_245_1119 VPWR VGND VPWR VGND sky130_ef_sc_hd__decap_12
XFILLER_19_1201 VGND VGND VPWR VPWR sky130_fd_sc_hd__decap_4
XFILLER_203_228 VPWR VGND VPWR VGND sky130_ef_sc_hd__decap_12
XFILLER_62_34 VPWR VGND VPWR VGND sky130_ef_sc_hd__decap_12
XFILLER_58_1294 VPWR VGND VPWR VGND sky130_ef_sc_hd__decap_12
XFILLER_145_1242 VGND VGND VPWR VPWR sky130_fd_sc_hd__decap_6
XFILLER_180_1133 VGND VGND VPWR VPWR sky130_fd_sc_hd__decap_6
XFILLER_141_3 VPWR VGND VPWR VGND sky130_ef_sc_hd__decap_12
XFILLER_168_132 VPWR VGND VPWR VGND sky130_ef_sc_hd__decap_12
XFILLER_178_34 VPWR VGND VPWR VGND sky130_ef_sc_hd__decap_12
XFILLER_196_452 VPWR VGND VPWR VGND sky130_ef_sc_hd__decap_12
XFILLER_239_3 VPWR VGND VPWR VGND sky130_ef_sc_hd__decap_12
XPHY_EDGE_ROW_26_2_Left_528 VGND VGND VPWR VPWR sky130_fd_sc_hd__decap_3
XFILLER_211_283 VPWR VGND VPWR VGND sky130_ef_sc_hd__decap_12
XFILLER_32_1423 VPWR VGND VPWR VGND sky130_ef_sc_hd__decap_12
XFILLER_7_18 VPWR VGND VPWR VGND sky130_ef_sc_hd__decap_12
XFILLER_168_187 VGND VGND VPWR VPWR sky130_fd_sc_hd__decap_6
XFILLER_178_89 VPWR VGND VPWR VGND sky130_ef_sc_hd__decap_12
XFILLER_184_636 VPWR VGND VPWR VGND sky130_ef_sc_hd__decap_12
XFILLER_200_968 VPWR VGND VPWR VGND sky130_ef_sc_hd__decap_12
Xwire224 net225 VGND VGND VPWR VPWR net224 sky130_fd_sc_hd__clkbuf_1
Xwire235 net236 VGND VGND VPWR VPWR net235 sky130_fd_sc_hd__clkbuf_1
Xwire257 net258 VGND VGND VPWR VPWR net257 sky130_fd_sc_hd__clkbuf_1
Xwire268 net269 VGND VGND VPWR VPWR net268 sky130_fd_sc_hd__clkbuf_1
XFILLER_221_1174 VPWR VGND VPWR VGND sky130_ef_sc_hd__decap_12
XFILLER_32_1478 VGND VGND VPWR VPWR sky130_fd_sc_hd__decap_6
Xwire279 net280 VGND VGND VPWR VPWR net279 sky130_fd_sc_hd__clkbuf_1
XFILLER_194_22 VPWR VGND VPWR VGND sky130_ef_sc_hd__decap_12
XFILLER_165_883 VPWR VGND VPWR VGND sky130_ef_sc_hd__decap_12
XFILLER_180_820 VPWR VGND VPWR VGND sky130_ef_sc_hd__decap_12
XFILLER_192_691 VPWR VGND VPWR VGND sky130_ef_sc_hd__decap_12
XFILLER_194_77 VPWR VGND VPWR VGND sky130_ef_sc_hd__decap_12
XTAP_TAPCELL_ROW_108_1_1391 VGND VPWR sky130_fd_sc_hd__tapvpwrvgnd_1
XFILLER_180_875 VGND VGND VPWR VPWR sky130_fd_sc_hd__decap_6
XFILLER_69_1390 VPWR VGND VPWR VGND sky130_ef_sc_hd__decap_12
XFILLER_239_615 VPWR VGND VPWR VGND sky130_ef_sc_hd__decap_12
XTAP_TAPCELL_ROW_243_4251 VGND VPWR sky130_fd_sc_hd__tapvpwrvgnd_1
XFILLER_26_1227 VPWR VGND VPWR VGND sky130_ef_sc_hd__decap_12
XTAP_TAPCELL_ROW_243_4262 VGND VPWR sky130_fd_sc_hd__tapvpwrvgnd_1
XPHY_EDGE_ROW_140_2_Left_642 VGND VGND VPWR VPWR sky130_fd_sc_hd__decap_3
XFILLER_191_1284 VGND VGND VPWR VPWR sky130_fd_sc_hd__decap_6
XTAP_TAPCELL_ROW_243_4273 VGND VPWR sky130_fd_sc_hd__tapvpwrvgnd_1
XFILLER_232_1281 VPWR VGND VPWR VGND sky130_ef_sc_hd__decap_12
XFILLER_4_1023 VPWR VGND VPWR VGND sky130_ef_sc_hd__decap_12
XFILLER_247_670 VPWR VGND VPWR VGND sky130_ef_sc_hd__decap_12
XTAP_TAPCELL_ROW_5_1040 VGND VPWR sky130_fd_sc_hd__tapvpwrvgnd_1
XTAP_TAPCELL_ROW_5_1051 VGND VPWR sky130_fd_sc_hd__tapvpwrvgnd_1
XFILLER_4_1078 VPWR VGND VPWR VGND sky130_ef_sc_hd__decap_12
XFILLER_235_854 VGND VGND VPWR VPWR sky130_fd_sc_hd__decap_6
XTAP_TAPCELL_ROW_5_1062 VGND VPWR sky130_fd_sc_hd__tapvpwrvgnd_1
XFILLER_185_1033 VPWR VGND VPWR VGND sky130_ef_sc_hd__decap_12
XTAP_TAPCELL_ROW_196_2601 VGND VPWR sky130_fd_sc_hd__tapvpwrvgnd_1
XTAP_TAPCELL_ROW_204_2888 VGND VPWR sky130_fd_sc_hd__tapvpwrvgnd_1
XTAP_TAPCELL_ROW_196_2612 VGND VPWR sky130_fd_sc_hd__tapvpwrvgnd_1
XTAP_TAPCELL_ROW_204_2899 VGND VPWR sky130_fd_sc_hd__tapvpwrvgnd_1
XTAP_TAPCELL_ROW_142_2_5799 VGND VPWR sky130_fd_sc_hd__tapvpwrvgnd_1
XTAP_TAPCELL_ROW_196_2623 VGND VPWR sky130_fd_sc_hd__tapvpwrvgnd_1
XTAP_TAPCELL_ROW_237_4044 VGND VPWR sky130_fd_sc_hd__tapvpwrvgnd_1
XTAP_TAPCELL_ROW_237_4055 VGND VPWR sky130_fd_sc_hd__tapvpwrvgnd_1
XFILLER_185_1088 VPWR VGND VPWR VGND sky130_ef_sc_hd__decap_12
XTAP_TAPCELL_ROW_237_4066 VGND VPWR sky130_fd_sc_hd__tapvpwrvgnd_1
XFILLER_241_1506 VGND VGND VPWR VPWR sky130_fd_sc_hd__decap_8
XTAP_TAPCELL_ROW_78_2_5285 VGND VPWR sky130_fd_sc_hd__tapvpwrvgnd_1
XFILLER_37_1378 VPWR VGND VPWR VGND sky130_ef_sc_hd__decap_12
XFILLER_175_603 VPWR VGND VPWR VGND sky130_ef_sc_hd__decap_12
XFILLER_202_261 VPWR VGND VPWR VGND sky130_ef_sc_hd__decap_12
XFILLER_124_1337 VPWR VGND VPWR VGND sky130_ef_sc_hd__decap_12
XFILLER_187_474 VPWR VGND VPWR VGND sky130_ef_sc_hd__decap_12
XFILLER_230_581 VPWR VGND VPWR VGND sky130_ef_sc_hd__decap_12
XFILLER_238_15 VGND VGND VPWR VPWR sky130_fd_sc_hd__decap_6
Xinput10 wr_data[0] VGND VGND VPWR VPWR net10 sky130_fd_sc_hd__clkbuf_1
XFILLER_175_658 VPWR VGND VPWR VGND sky130_ef_sc_hd__decap_12
Xinput21 wr_data[1] VGND VGND VPWR VPWR net21 sky130_fd_sc_hd__clkbuf_1
XFILLER_11_1507 VGND VGND VPWR VPWR sky130_fd_sc_hd__decap_8
Xinput32 wr_data[2] VGND VGND VPWR VPWR net32 sky130_fd_sc_hd__clkbuf_1
XFILLER_239_1413 VGND VGND VPWR VPWR sky130_fd_sc_hd__decap_6
XFILLER_190_617 VGND VGND VPWR VPWR sky130_fd_sc_hd__decap_6
Xmax_cap502 net503 VGND VGND VPWR VPWR net502 sky130_fd_sc_hd__clkbuf_1
Xmax_cap513 net514 VGND VGND VPWR VPWR net513 sky130_fd_sc_hd__clkbuf_1
XFILLER_196_1140 VPWR VGND VPWR VGND sky130_ef_sc_hd__decap_12
XTAP_TAPCELL_ROW_71_2_5228 VGND VPWR sky130_fd_sc_hd__tapvpwrvgnd_1
Xmax_cap524 _082_ VGND VGND VPWR VPWR net524 sky130_fd_sc_hd__clkbuf_1
XFILLER_200_1269 VPWR VGND VPWR VGND sky130_ef_sc_hd__decap_12
Xmax_cap535 net56 VGND VGND VPWR VPWR net535 sky130_fd_sc_hd__clkbuf_1
XFILLER_171_842 VPWR VGND VPWR VGND sky130_ef_sc_hd__decap_12
XFILLER_192_1004 VGND VGND VPWR VPWR sky130_fd_sc_hd__decap_6
XFILLER_196_1195 VPWR VGND VPWR VGND sky130_ef_sc_hd__decap_12
XFILLER_100_1392 VGND VGND VPWR VPWR sky130_fd_sc_hd__decap_6
XFILLER_171_897 VGND VGND VPWR VPWR sky130_fd_sc_hd__decap_6
XFILLER_254_58 VGND VGND VPWR VPWR sky130_fd_sc_hd__decap_6
XPHY_EDGE_ROW_72_2_Left_574 VGND VGND VPWR VPWR sky130_fd_sc_hd__decap_3
XFILLER_48_1485 VPWR VGND VPWR VGND sky130_ef_sc_hd__decap_12
XFILLER_135_1433 VPWR VGND VPWR VGND sky130_ef_sc_hd__decap_12
XFILLER_170_1324 VPWR VGND VPWR VGND sky130_ef_sc_hd__decap_12
XFILLER_233_1045 VPWR VGND VPWR VGND sky130_ef_sc_hd__decap_12
XFILLER_44_1349 VGND VGND VPWR VPWR sky130_fd_sc_hd__decap_6
XFILLER_135_1488 VPWR VGND VPWR VGND sky130_ef_sc_hd__decap_12
XFILLER_170_1379 VPWR VGND VPWR VGND sky130_ef_sc_hd__decap_12
XFILLER_226_832 VGND VGND VPWR VPWR sky130_fd_sc_hd__decap_6
XPHY_EDGE_ROW_24_1_Left_279 VGND VGND VPWR VPWR sky130_fd_sc_hd__decap_3
XTAP_TAPCELL_ROW_38_1_1286 VGND VPWR sky130_fd_sc_hd__tapvpwrvgnd_1
XFILLER_197_216 VPWR VGND VPWR VGND sky130_ef_sc_hd__decap_12
XFILLER_240_323 VPWR VGND VPWR VGND sky130_ef_sc_hd__decap_12
XFILLER_252_194 VPWR VGND VPWR VGND sky130_ef_sc_hd__decap_12
XFILLER_181_1420 VPWR VGND VPWR VGND sky130_ef_sc_hd__decap_12
XFILLER_244_1152 VPWR VGND VPWR VGND sky130_ef_sc_hd__decap_12
XFILLER_90_1325 VPWR VGND VPWR VGND sky130_ef_sc_hd__decap_12
XFILLER_209_1272 VPWR VGND VPWR VGND sky130_ef_sc_hd__decap_12
XFILLER_55_1445 VPWR VGND VPWR VGND sky130_ef_sc_hd__decap_12
XFILLER_240_378 VPWR VGND VPWR VGND sky130_ef_sc_hd__decap_12
XFILLER_178_452 VPWR VGND VPWR VGND sky130_ef_sc_hd__decap_12
XFILLER_32_15 VGND VGND VPWR VPWR sky130_fd_sc_hd__decap_6
XFILLER_181_1475 VPWR VGND VPWR VGND sky130_ef_sc_hd__decap_12
XTAP_TAPCELL_ROW_126_1_1418 VGND VPWR sky130_fd_sc_hd__tapvpwrvgnd_1
XFILLER_193_400 VPWR VGND VPWR VGND sky130_ef_sc_hd__decap_12
XFILLER_148_15 VGND VGND VPWR VPWR sky130_fd_sc_hd__decap_6
XFILLER_166_636 VPWR VGND VPWR VGND sky130_ef_sc_hd__decap_12
XPHY_EDGE_ROW_86_1_Left_341 VGND VGND VPWR VPWR sky130_fd_sc_hd__decap_3
XFILLER_193_455 VPWR VGND VPWR VGND sky130_ef_sc_hd__decap_12
XFILLER_105_1292 VPWR VGND VPWR VGND sky130_ef_sc_hd__decap_12
XFILLER_181_639 VGND VGND VPWR VPWR sky130_fd_sc_hd__decap_6
XFILLER_174_691 VPWR VGND VPWR VGND sky130_ef_sc_hd__decap_12
XTAP_TAPCELL_ROW_173_1796 VGND VPWR sky130_fd_sc_hd__tapvpwrvgnd_1
XFILLER_218_1508 VGND VGND VPWR VPWR sky130_fd_sc_hd__decap_6
XFILLER_101_1189 VPWR VGND VPWR VGND sky130_ef_sc_hd__decap_12
XFILLER_49_1249 VPWR VGND VPWR VGND sky130_ef_sc_hd__decap_12
XFILLER_136_1208 VPWR VGND VPWR VGND sky130_ef_sc_hd__decap_12
XFILLER_153_1500 VGND VGND VPWR VPWR sky130_fd_sc_hd__decap_6
XFILLER_164_58 VGND VGND VPWR VPWR sky130_fd_sc_hd__decap_6
XFILLER_251_1112 VGND VGND VPWR VPWR sky130_fd_sc_hd__decap_6
XFILLER_248_445 VGND VGND VPWR VPWR sky130_fd_sc_hd__decap_6
XFILLER_57_56 VPWR VGND VPWR VGND sky130_ef_sc_hd__decap_12
XTAP_TAPCELL_ROW_167_1589 VGND VPWR sky130_fd_sc_hd__tapvpwrvgnd_1
XFILLER_180_46 VPWR VGND VPWR VGND sky130_ef_sc_hd__decap_12
XFILLER_189_3 VPWR VGND VPWR VGND sky130_ef_sc_hd__decap_12
XFILLER_229_670 VPWR VGND VPWR VGND sky130_ef_sc_hd__decap_12
XFILLER_60_1184 VPWR VGND VPWR VGND sky130_ef_sc_hd__decap_12
XFILLER_112_1263 VGND VGND VPWR VPWR sky130_fd_sc_hd__decap_6
XFILLER_217_854 VGND VGND VPWR VPWR sky130_fd_sc_hd__decap_6
XFILLER_1_1229 VPWR VGND VPWR VGND sky130_ef_sc_hd__decap_12
XTAP_TAPCELL_ROW_127_2_5679 VGND VPWR sky130_fd_sc_hd__tapvpwrvgnd_1
XTAP_TAPCELL_ROW_95_2_5424 VGND VPWR sky130_fd_sc_hd__tapvpwrvgnd_1
XFILLER_147_1304 VPWR VGND VPWR VGND sky130_ef_sc_hd__decap_12
XTAP_TAPCELL_ROW_64_2_5171 VGND VPWR sky130_fd_sc_hd__tapvpwrvgnd_1
XFILLER_73_44 VPWR VGND VPWR VGND sky130_ef_sc_hd__decap_12
XFILLER_189_44 VPWR VGND VPWR VGND sky130_ef_sc_hd__decap_12
XFILLER_147_1359 VPWR VGND VPWR VGND sky130_ef_sc_hd__decap_12
XFILLER_231_345 VPWR VGND VPWR VGND sky130_ef_sc_hd__decap_12
XFILLER_188_249 VPWR VGND VPWR VGND sky130_ef_sc_hd__decap_12
XTAP_TAPCELL_ROW_251_4531 VGND VPWR sky130_fd_sc_hd__tapvpwrvgnd_1
XFILLER_189_99 VPWR VGND VPWR VGND sky130_ef_sc_hd__decap_12
XTAP_TAPCELL_ROW_251_4542 VGND VPWR sky130_fd_sc_hd__tapvpwrvgnd_1
XFILLER_200_710 VPWR VGND VPWR VGND sky130_ef_sc_hd__decap_12
XTAP_TAPCELL_ROW_251_4553 VGND VPWR sky130_fd_sc_hd__tapvpwrvgnd_1
XFILLER_212_581 VPWR VGND VPWR VGND sky130_ef_sc_hd__decap_12
XFILLER_169_474 VPWR VGND VPWR VGND sky130_ef_sc_hd__decap_12
XFILLER_8_624 VPWR VGND VPWR VGND sky130_ef_sc_hd__decap_12
XFILLER_184_433 VPWR VGND VPWR VGND sky130_ef_sc_hd__decap_12
XFILLER_32_1220 VGND VGND VPWR VPWR sky130_fd_sc_hd__decap_6
XFILLER_200_765 VPWR VGND VPWR VGND sky130_ef_sc_hd__decap_12
XTAP_TAPCELL_ROW_56_2_5108 VGND VPWR sky130_fd_sc_hd__tapvpwrvgnd_1
XFILLER_8_679 VPWR VGND VPWR VGND sky130_ef_sc_hd__decap_12
XFILLER_172_617 VGND VGND VPWR VPWR sky130_fd_sc_hd__decap_6
XFILLER_184_488 VGND VGND VPWR VPWR sky130_fd_sc_hd__decap_6
XFILLER_158_1411 VPWR VGND VPWR VGND sky130_ef_sc_hd__decap_12
XTAP_TAPCELL_ROW_249_4460 VGND VPWR sky130_fd_sc_hd__tapvpwrvgnd_1
XFILLER_67_1316 VPWR VGND VPWR VGND sky130_ef_sc_hd__decap_12
XTAP_TAPCELL_ROW_249_4471 VGND VPWR sky130_fd_sc_hd__tapvpwrvgnd_1
XTAP_TAPCELL_ROW_249_4482 VGND VPWR sky130_fd_sc_hd__tapvpwrvgnd_1
XFILLER_4_852 VGND VGND VPWR VPWR sky130_fd_sc_hd__fill_1
XFILLER_193_1346 VPWR VGND VPWR VGND sky130_ef_sc_hd__decap_12
XTAP_TAPCELL_ROW_245_4324 VGND VPWR sky130_fd_sc_hd__tapvpwrvgnd_1
XFILLER_158_1466 VPWR VGND VPWR VGND sky130_ef_sc_hd__decap_12
XTAP_TAPCELL_ROW_245_4335 VGND VPWR sky130_fd_sc_hd__tapvpwrvgnd_1
XTAP_TAPCELL_ROW_23_2_4849 VGND VPWR sky130_fd_sc_hd__tapvpwrvgnd_1
XTAP_TAPCELL_ROW_245_4346 VGND VPWR sky130_fd_sc_hd__tapvpwrvgnd_1
XTAP_TAPCELL_ROW_44_1_1296 VGND VPWR sky130_fd_sc_hd__tapvpwrvgnd_1
XFILLER_239_412 VPWR VGND VPWR VGND sky130_ef_sc_hd__decap_12
XFILLER_230_1207 VPWR VGND VPWR VGND sky130_ef_sc_hd__decap_12
XFILLER_234_1398 VPWR VGND VPWR VGND sky130_ef_sc_hd__decap_12
XFILLER_255_916 VGND VGND VPWR VPWR sky130_fd_sc_hd__decap_8
XTAP_TAPCELL_ROW_7_1113 VGND VPWR sky130_fd_sc_hd__tapvpwrvgnd_1
XFILLER_239_467 VGND VGND VPWR VPWR sky130_fd_sc_hd__decap_6
XTAP_TAPCELL_ROW_7_1124 VGND VPWR sky130_fd_sc_hd__tapvpwrvgnd_1
XTAP_TAPCELL_ROW_7_1135 VGND VPWR sky130_fd_sc_hd__tapvpwrvgnd_1
XFILLER_43_1371 VGND VGND VPWR VPWR sky130_fd_sc_hd__decap_6
XFILLER_208_832 VGND VGND VPWR VPWR sky130_fd_sc_hd__decap_6
XTAP_TAPCELL_ROW_239_4106 VGND VPWR sky130_fd_sc_hd__tapvpwrvgnd_1
XTAP_TAPCELL_ROW_132_1_1428 VGND VPWR sky130_fd_sc_hd__tapvpwrvgnd_1
XTAP_TAPCELL_ROW_239_4117 VGND VPWR sky130_fd_sc_hd__tapvpwrvgnd_1
XTAP_TAPCELL_ROW_239_4128 VGND VPWR sky130_fd_sc_hd__tapvpwrvgnd_1
XFILLER_78_1423 VPWR VGND VPWR VGND sky130_ef_sc_hd__decap_12
XFILLER_78_1478 VGND VGND VPWR VPWR sky130_fd_sc_hd__decap_6
XFILLER_179_216 VPWR VGND VPWR VGND sky130_ef_sc_hd__decap_12
XFILLER_222_323 VPWR VGND VPWR VGND sky130_ef_sc_hd__decap_12
XFILLER_234_194 VPWR VGND VPWR VGND sky130_ef_sc_hd__decap_12
XFILLER_210_507 VPWR VGND VPWR VGND sky130_ef_sc_hd__decap_12
XFILLER_241_1303 VPWR VGND VPWR VGND sky130_ef_sc_hd__decap_12
XFILLER_206_1434 VGND VGND VPWR VPWR sky130_fd_sc_hd__decap_6
XFILLER_222_378 VPWR VGND VPWR VGND sky130_ef_sc_hd__decap_12
XFILLER_128_1270 VPWR VGND VPWR VGND sky130_ef_sc_hd__decap_12
XFILLER_175_400 VPWR VGND VPWR VGND sky130_ef_sc_hd__decap_12
XFILLER_241_1358 VPWR VGND VPWR VGND sky130_ef_sc_hd__decap_12
XFILLER_187_271 VPWR VGND VPWR VGND sky130_ef_sc_hd__decap_12
XFILLER_175_455 VPWR VGND VPWR VGND sky130_ef_sc_hd__decap_12
XFILLER_191_904 VPWR VGND VPWR VGND sky130_ef_sc_hd__decap_12
XFILLER_11_1304 VPWR VGND VPWR VGND sky130_ef_sc_hd__decap_12
XFILLER_200_1011 VPWR VGND VPWR VGND sky130_ef_sc_hd__decap_12
XTAP_TAPCELL_ROW_152_2_5881 VGND VPWR sky130_fd_sc_hd__tapvpwrvgnd_1
XFILLER_102_1454 VPWR VGND VPWR VGND sky130_ef_sc_hd__decap_12
XFILLER_191_959 VPWR VGND VPWR VGND sky130_ef_sc_hd__decap_12
XFILLER_11_1359 VPWR VGND VPWR VGND sky130_ef_sc_hd__decap_12
XFILLER_200_1066 VPWR VGND VPWR VGND sky130_ef_sc_hd__decap_12
Xmax_cap332 _148_ VGND VGND VPWR VPWR net332 sky130_fd_sc_hd__clkbuf_1
XPHY_EDGE_ROW_60_1_Right_716 VGND VGND VPWR VPWR sky130_fd_sc_hd__decap_3
XFILLER_252_1410 VPWR VGND VPWR VGND sky130_ef_sc_hd__decap_12
XFILLER_249_209 VGND VGND VPWR VPWR sky130_fd_sc_hd__decap_6
XFILLER_48_1282 VPWR VGND VPWR VGND sky130_ef_sc_hd__decap_12
XFILLER_135_1230 VPWR VGND VPWR VGND sky130_ef_sc_hd__decap_12
XFILLER_170_1121 VPWR VGND VPWR VGND sky130_ef_sc_hd__decap_12
XFILLER_252_1465 VPWR VGND VPWR VGND sky130_ef_sc_hd__decap_12
XFILLER_135_1285 VGND VGND VPWR VPWR sky130_fd_sc_hd__decap_6
XTAP_TAPCELL_ROW_113_2_5565 VGND VPWR sky130_fd_sc_hd__tapvpwrvgnd_1
XFILLER_170_1176 VGND VGND VPWR VPWR sky130_fd_sc_hd__decap_6
XFILLER_22_1411 VPWR VGND VPWR VGND sky130_ef_sc_hd__decap_12
XTAP_TAPCELL_ROW_81_2_5310 VGND VPWR sky130_fd_sc_hd__tapvpwrvgnd_1
XFILLER_246_949 VPWR VGND VPWR VGND sky130_ef_sc_hd__decap_12
XFILLER_239_990 VPWR VGND VPWR VGND sky130_ef_sc_hd__decap_12
XFILLER_27_15 VPWR VGND VPWR VGND sky130_ef_sc_hd__decap_12
XTAP_TAPCELL_ROW_49_2_5051 VGND VPWR sky130_fd_sc_hd__tapvpwrvgnd_1
XFILLER_211_1162 VPWR VGND VPWR VGND sky130_ef_sc_hd__decap_12
XFILLER_22_1466 VPWR VGND VPWR VGND sky130_ef_sc_hd__decap_12
XFILLER_57_1507 VGND VGND VPWR VPWR sky130_fd_sc_hd__decap_8
XFILLER_0_1240 VPWR VGND VPWR VGND sky130_ef_sc_hd__decap_12
XTAP_TAPCELL_ROW_1_899 VGND VPWR sky130_fd_sc_hd__tapvpwrvgnd_1
XFILLER_240_120 VPWR VGND VPWR VGND sky130_ef_sc_hd__decap_12
XFILLER_246_1269 VPWR VGND VPWR VGND sky130_ef_sc_hd__decap_12
XFILLER_213_345 VPWR VGND VPWR VGND sky130_ef_sc_hd__decap_12
XFILLER_0_1273 VGND VGND VPWR VPWR sky130_fd_sc_hd__decap_8
XTAP_TAPCELL_ROW_16_2_4792 VGND VPWR sky130_fd_sc_hd__tapvpwrvgnd_1
XFILLER_55_1242 VGND VGND VPWR VPWR sky130_fd_sc_hd__decap_6
XFILLER_201_529 VPWR VGND VPWR VGND sky130_ef_sc_hd__decap_12
XFILLER_43_69 VGND VGND VPWR VPWR sky130_fd_sc_hd__fill_2
XFILLER_240_175 VPWR VGND VPWR VGND sky130_ef_sc_hd__decap_12
XFILLER_146_1392 VGND VGND VPWR VPWR sky130_fd_sc_hd__decap_6
XFILLER_181_1272 VPWR VGND VPWR VGND sky130_ef_sc_hd__decap_12
XFILLER_90_1177 VGND VGND VPWR VPWR sky130_fd_sc_hd__decap_6
XFILLER_166_433 VPWR VGND VPWR VGND sky130_ef_sc_hd__decap_12
XFILLER_194_753 VPWR VGND VPWR VGND sky130_ef_sc_hd__decap_12
XFILLER_103_1218 VPWR VGND VPWR VGND sky130_ef_sc_hd__decap_12
XTAP_TAPCELL_ROW_175_1869 VGND VPWR sky130_fd_sc_hd__tapvpwrvgnd_1
XFILLER_193_252 VGND VGND VPWR VPWR sky130_fd_sc_hd__decap_6
XFILLER_239_80 VGND VGND VPWR VPWR sky130_fd_sc_hd__decap_6
XFILLER_166_488 VGND VGND VPWR VPWR sky130_fd_sc_hd__decap_6
XFILLER_182_937 VPWR VGND VPWR VGND sky130_ef_sc_hd__decap_12
XFILLER_5_638 VGND VGND VPWR VPWR sky130_fd_sc_hd__fill_2
XFILLER_5_649 VPWR VGND VPWR VGND sky130_ef_sc_hd__decap_12
XFILLER_218_1305 VGND VGND VPWR VPWR sky130_fd_sc_hd__decap_6
XFILLER_104_3 VPWR VGND VPWR VGND sky130_ef_sc_hd__decap_12
XFILLER_175_68 VPWR VGND VPWR VGND sky130_ef_sc_hd__decap_12
XFILLER_4_159 VGND VGND VPWR VPWR sky130_fd_sc_hd__fill_1
XFILLER_4_19 VGND VGND VPWR VPWR sky130_fd_sc_hd__fill_2
XFILLER_190_1508 VGND VGND VPWR VPWR sky130_fd_sc_hd__decap_6
XFILLER_253_1229 VPWR VGND VPWR VGND sky130_ef_sc_hd__decap_12
XFILLER_190_992 VPWR VGND VPWR VGND sky130_ef_sc_hd__decap_12
XFILLER_68_22 VPWR VGND VPWR VGND sky130_ef_sc_hd__decap_12
XFILLER_175_1076 VPWR VGND VPWR VGND sky130_ef_sc_hd__decap_12
XFILLER_249_732 VPWR VGND VPWR VGND sky130_ef_sc_hd__decap_12
XFILLER_0_365 VGND VGND VPWR VPWR sky130_fd_sc_hd__fill_1
XFILLER_191_56 VPWR VGND VPWR VGND sky130_ef_sc_hd__decap_12
XFILLER_114_1325 VPWR VGND VPWR VGND sky130_ef_sc_hd__decap_12
XFILLER_237_916 VPWR VGND VPWR VGND sky130_ef_sc_hd__decap_12
XFILLER_249_787 VPWR VGND VPWR VGND sky130_ef_sc_hd__decap_12
XFILLER_5_1162 VPWR VGND VPWR VGND sky130_ef_sc_hd__decap_12
X_654_ clknet_3_4__leaf_clk acc_core.adder.cla_blocks\[5\].block.sum\[0\] _062_ VGND
+ VGND VPWR VPWR net55 sky130_fd_sc_hd__dfrtp_1
XFILLER_84_65 VGND VGND VPWR VPWR sky130_fd_sc_hd__decap_6
XFILLER_229_1401 VPWR VGND VPWR VGND sky130_ef_sc_hd__decap_12
XFILLER_245_971 VPWR VGND VPWR VGND sky130_ef_sc_hd__decap_12
XFILLER_1_1026 VGND VGND VPWR VPWR sky130_fd_sc_hd__decap_6
XTAP_TAPCELL_ROW_201_2803 VGND VPWR sky130_fd_sc_hd__tapvpwrvgnd_1
XTAP_TAPCELL_ROW_253_4604 VGND VPWR sky130_fd_sc_hd__tapvpwrvgnd_1
X_585_ net670 VGND VGND VPWR VPWR _067_ sky130_fd_sc_hd__inv_2
XFILLER_204_323 VPWR VGND VPWR VGND sky130_ef_sc_hd__decap_12
XFILLER_229_1456 VGND VGND VPWR VPWR sky130_fd_sc_hd__decap_6
XTAP_TAPCELL_ROW_253_4615 VGND VPWR sky130_fd_sc_hd__tapvpwrvgnd_1
XFILLER_186_1183 VPWR VGND VPWR VGND sky130_ef_sc_hd__decap_12
XTAP_TAPCELL_ROW_253_4626 VGND VPWR sky130_fd_sc_hd__tapvpwrvgnd_1
XFILLER_216_194 VPWR VGND VPWR VGND sky130_ef_sc_hd__decap_12
XFILLER_231_142 VPWR VGND VPWR VGND sky130_ef_sc_hd__decap_12
XFILLER_182_1047 VGND VGND VPWR VPWR sky130_fd_sc_hd__decap_6
XFILLER_204_378 VPWR VGND VPWR VGND sky130_ef_sc_hd__decap_12
XFILLER_147_1189 VPWR VGND VPWR VGND sky130_ef_sc_hd__decap_12
XFILLER_125_1421 VPWR VGND VPWR VGND sky130_ef_sc_hd__decap_12
XFILLER_223_1033 VPWR VGND VPWR VGND sky130_ef_sc_hd__decap_12
XFILLER_231_197 VPWR VGND VPWR VGND sky130_ef_sc_hd__decap_12
XFILLER_169_271 VPWR VGND VPWR VGND sky130_ef_sc_hd__decap_12
XFILLER_34_1337 VPWR VGND VPWR VGND sky130_ef_sc_hd__decap_12
XFILLER_8_421 VGND VGND VPWR VPWR sky130_fd_sc_hd__fill_1
XFILLER_125_1476 VPWR VGND VPWR VGND sky130_ef_sc_hd__decap_12
XFILLER_160_1356 VPWR VGND VPWR VGND sky130_ef_sc_hd__decap_12
XTAP_TAPCELL_ROW_137_2_5761 VGND VPWR sky130_fd_sc_hd__tapvpwrvgnd_1
XFILLER_184_230 VGND VGND VPWR VPWR sky130_fd_sc_hd__decap_6
XFILLER_173_904 VPWR VGND VPWR VGND sky130_ef_sc_hd__decap_12
XFILLER_200_562 VPWR VGND VPWR VGND sky130_ef_sc_hd__decap_12
XFILLER_223_1088 VPWR VGND VPWR VGND sky130_ef_sc_hd__decap_12
XFILLER_185_775 VPWR VGND VPWR VGND sky130_ef_sc_hd__decap_12
XFILLER_219_39 VGND VGND VPWR VPWR sky130_fd_sc_hd__decap_4
XFILLER_9_988 VGND VGND VPWR VPWR sky130_fd_sc_hd__decap_8
XFILLER_240_1391 VGND VGND VPWR VPWR sky130_fd_sc_hd__decap_6
XTAP_TAPCELL_ROW_247_4408 VGND VPWR sky130_fd_sc_hd__tapvpwrvgnd_1
XFILLER_173_959 VPWR VGND VPWR VGND sky130_ef_sc_hd__decap_12
XFILLER_158_1263 VGND VGND VPWR VPWR sky130_fd_sc_hd__decap_6
XFILLER_193_1143 VPWR VGND VPWR VGND sky130_ef_sc_hd__decap_12
XTAP_TAPCELL_ROW_86_2_5347 VGND VPWR sky130_fd_sc_hd__tapvpwrvgnd_1
XFILLER_235_27 VPWR VGND VPWR VGND sky130_ef_sc_hd__decap_12
XFILLER_10_1392 VGND VGND VPWR VPWR sky130_fd_sc_hd__decap_6
XTAP_TAPCELL_ROW_130_2_5704 VGND VPWR sky130_fd_sc_hd__tapvpwrvgnd_1
XFILLER_193_1198 VGND VGND VPWR VPWR sky130_fd_sc_hd__decap_6
XFILLER_45_1433 VPWR VGND VPWR VGND sky130_ef_sc_hd__decap_12
XFILLER_80_1313 VPWR VGND VPWR VGND sky130_ef_sc_hd__decap_12
XFILLER_234_1140 VPWR VGND VPWR VGND sky130_ef_sc_hd__decap_12
XTAP_TAPCELL_ROW_9_1208 VGND VPWR sky130_fd_sc_hd__tapvpwrvgnd_1
XTAP_TAPCELL_ROW_9_1219 VGND VPWR sky130_fd_sc_hd__tapvpwrvgnd_1
XFILLER_230_1004 VGND VGND VPWR VPWR sky130_fd_sc_hd__decap_6
XFILLER_171_1463 VPWR VGND VPWR VGND sky130_ef_sc_hd__decap_12
XFILLER_45_1488 VPWR VGND VPWR VGND sky130_ef_sc_hd__decap_12
XFILLER_80_1368 VPWR VGND VPWR VGND sky130_ef_sc_hd__decap_12
XFILLER_234_1195 VPWR VGND VPWR VGND sky130_ef_sc_hd__decap_12
XFILLER_251_15 VPWR VGND VPWR VGND sky130_ef_sc_hd__decap_12
XFILLER_228_949 VPWR VGND VPWR VGND sky130_ef_sc_hd__decap_12
XFILLER_255_757 VPWR VGND VPWR VGND sky130_ef_sc_hd__decap_12
XPHY_EDGE_ROW_103_2_Left_605 VGND VGND VPWR VPWR sky130_fd_sc_hd__decap_3
XFILLER_78_1220 VGND VGND VPWR VPWR sky130_fd_sc_hd__decap_6
XFILLER_39_1204 VGND VGND VPWR VPWR sky130_fd_sc_hd__fill_1
XFILLER_169_1370 VGND VGND VPWR VPWR sky130_fd_sc_hd__decap_6
XFILLER_222_120 VPWR VGND VPWR VGND sky130_ef_sc_hd__decap_12
XFILLER_241_1100 VPWR VGND VPWR VGND sky130_ef_sc_hd__decap_12
XFILLER_210_304 VPWR VGND VPWR VGND sky130_ef_sc_hd__decap_12
XFILLER_195_517 VPWR VGND VPWR VGND sky130_ef_sc_hd__decap_12
XFILLER_222_175 VPWR VGND VPWR VGND sky130_ef_sc_hd__decap_12
XFILLER_250_495 VPWR VGND VPWR VGND sky130_ef_sc_hd__decap_12
XFILLER_245_1291 VPWR VGND VPWR VGND sky130_ef_sc_hd__decap_12
XFILLER_91_1464 VPWR VGND VPWR VGND sky130_ef_sc_hd__decap_12
XFILLER_210_359 VGND VGND VPWR VPWR sky130_fd_sc_hd__decap_6
XFILLER_241_1155 VGND VGND VPWR VPWR sky130_fd_sc_hd__decap_6
XFILLER_13_39 VGND VGND VPWR VPWR sky130_fd_sc_hd__decap_4
XFILLER_176_753 VPWR VGND VPWR VGND sky130_ef_sc_hd__decap_12
XFILLER_129_39 VGND VGND VPWR VPWR sky130_fd_sc_hd__decap_4
XFILLER_175_252 VGND VGND VPWR VPWR sky130_fd_sc_hd__decap_6
XFILLER_191_701 VPWR VGND VPWR VGND sky130_ef_sc_hd__decap_12
XFILLER_198_1054 VPWR VGND VPWR VGND sky130_ef_sc_hd__decap_12
XTAP_TAPCELL_ROW_170_1700 VGND VPWR sky130_fd_sc_hd__tapvpwrvgnd_1
XTAP_TAPCELL_ROW_215_3290 VGND VPWR sky130_fd_sc_hd__tapvpwrvgnd_1
XFILLER_15_1292 VPWR VGND VPWR VGND sky130_ef_sc_hd__decap_12
XTAP_TAPCELL_ROW_170_1711 VGND VPWR sky130_fd_sc_hd__tapvpwrvgnd_1
XTAP_TAPCELL_ROW_211_3132 VGND VPWR sky130_fd_sc_hd__tapvpwrvgnd_1
XFILLER_102_1251 VPWR VGND VPWR VGND sky130_ef_sc_hd__decap_12
XTAP_TAPCELL_ROW_170_1722 VGND VPWR sky130_fd_sc_hd__tapvpwrvgnd_1
XTAP_TAPCELL_ROW_211_3143 VGND VPWR sky130_fd_sc_hd__tapvpwrvgnd_1
XFILLER_191_756 VPWR VGND VPWR VGND sky130_ef_sc_hd__decap_12
XFILLER_89_1371 VGND VGND VPWR VPWR sky130_fd_sc_hd__decap_6
XTAP_TAPCELL_ROW_211_3154 VGND VPWR sky130_fd_sc_hd__tapvpwrvgnd_1
XTAP_TAPCELL_ROW_230_3799 VGND VPWR sky130_fd_sc_hd__tapvpwrvgnd_1
XFILLER_11_1189 VPWR VGND VPWR VGND sky130_ef_sc_hd__decap_12
Xmax_cap151 _181_ VGND VGND VPWR VPWR net151 sky130_fd_sc_hd__clkbuf_1
XFILLER_145_27 VPWR VGND VPWR VGND sky130_ef_sc_hd__decap_12
XFILLER_172_992 VPWR VGND VPWR VGND sky130_ef_sc_hd__decap_12
XFILLER_46_1208 VPWR VGND VPWR VGND sky130_ef_sc_hd__decap_12
XFILLER_63_1500 VGND VGND VPWR VPWR sky130_fd_sc_hd__decap_6
Xmax_cap184 net185 VGND VGND VPWR VPWR net184 sky130_fd_sc_hd__clkbuf_1
XPHY_EDGE_ROW_61_1_Right_717 VGND VGND VPWR VPWR sky130_fd_sc_hd__decap_3
Xmax_cap195 _216_ VGND VGND VPWR VPWR net195 sky130_fd_sc_hd__clkbuf_1
XFILLER_137_1347 VPWR VGND VPWR VGND sky130_ef_sc_hd__decap_12
XFILLER_172_1238 VPWR VGND VPWR VGND sky130_ef_sc_hd__decap_12
XFILLER_252_1262 VGND VGND VPWR VPWR sky130_fd_sc_hd__decap_6
XTAP_TAPCELL_ROW_209_3061 VGND VPWR sky130_fd_sc_hd__tapvpwrvgnd_1
XTAP_TAPCELL_ROW_26_1_1268 VGND VPWR sky130_fd_sc_hd__tapvpwrvgnd_1
XTAP_TAPCELL_ROW_168_1640 VGND VPWR sky130_fd_sc_hd__tapvpwrvgnd_1
XTAP_TAPCELL_ROW_168_1651 VGND VPWR sky130_fd_sc_hd__tapvpwrvgnd_1
XTAP_TAPCELL_ROW_209_3072 VGND VPWR sky130_fd_sc_hd__tapvpwrvgnd_1
XFILLER_219_916 VPWR VGND VPWR VGND sky130_ef_sc_hd__decap_12
XTAP_TAPCELL_ROW_209_3083 VGND VPWR sky130_fd_sc_hd__tapvpwrvgnd_1
XFILLER_161_15 VPWR VGND VPWR VGND sky130_ef_sc_hd__decap_12
XFILLER_38_58 VGND VGND VPWR VPWR sky130_fd_sc_hd__decap_6
XPHY_EDGE_ROW_35_2_Left_537 VGND VGND VPWR VPWR sky130_fd_sc_hd__decap_3
XFILLER_246_746 VGND VGND VPWR VPWR sky130_fd_sc_hd__decap_6
XFILLER_2_1324 VPWR VGND VPWR VGND sky130_ef_sc_hd__decap_12
XTAP_TAPCELL_ROW_102_1_1383 VGND VPWR sky130_fd_sc_hd__tapvpwrvgnd_1
XFILLER_22_1263 VGND VGND VPWR VPWR sky130_fd_sc_hd__decap_6
XFILLER_227_971 VPWR VGND VPWR VGND sky130_ef_sc_hd__decap_12
XFILLER_246_1011 VPWR VGND VPWR VGND sky130_ef_sc_hd__decap_12
XFILLER_57_1304 VPWR VGND VPWR VGND sky130_ef_sc_hd__decap_12
XFILLER_2_1379 VPWR VGND VPWR VGND sky130_ef_sc_hd__decap_12
XFILLER_148_1454 VPWR VGND VPWR VGND sky130_ef_sc_hd__decap_12
XFILLER_183_1334 VPWR VGND VPWR VGND sky130_ef_sc_hd__decap_12
XFILLER_246_1066 VPWR VGND VPWR VGND sky130_ef_sc_hd__decap_12
XFILLER_57_1359 VPWR VGND VPWR VGND sky130_ef_sc_hd__decap_12
X_370_ _152_ net248 net249 VGND VGND VPWR VPWR _159_ sky130_fd_sc_hd__a21oi_1
XFILLER_92_1239 VPWR VGND VPWR VGND sky130_ef_sc_hd__decap_12
XFILLER_213_142 VPWR VGND VPWR VGND sky130_ef_sc_hd__decap_12
XTAP_TAPCELL_ROW_79_2_5290 VGND VPWR sky130_fd_sc_hd__tapvpwrvgnd_1
XFILLER_198_366 VPWR VGND VPWR VGND sky130_ef_sc_hd__decap_12
XFILLER_183_1389 VPWR VGND VPWR VGND sky130_ef_sc_hd__decap_12
XFILLER_201_326 VPWR VGND VPWR VGND sky130_ef_sc_hd__decap_12
XFILLER_213_197 VPWR VGND VPWR VGND sky130_ef_sc_hd__decap_12
XFILLER_70_34 VPWR VGND VPWR VGND sky130_ef_sc_hd__decap_12
XFILLER_166_230 VGND VGND VPWR VPWR sky130_fd_sc_hd__decap_6
XFILLER_186_34 VPWR VGND VPWR VGND sky130_ef_sc_hd__decap_12
XFILLER_194_550 VPWR VGND VPWR VGND sky130_ef_sc_hd__decap_12
XFILLER_210_882 VPWR VGND VPWR VGND sky130_ef_sc_hd__decap_12
XFILLER_221_3 VPWR VGND VPWR VGND sky130_ef_sc_hd__decap_12
XFILLER_167_775 VPWR VGND VPWR VGND sky130_ef_sc_hd__decap_12
XFILLER_6_925 VPWR VGND VPWR VGND sky130_ef_sc_hd__decap_12
XFILLER_5_413 VGND VGND VPWR VPWR sky130_fd_sc_hd__fill_2
XFILLER_182_734 VPWR VGND VPWR VGND sky130_ef_sc_hd__decap_12
XFILLER_186_89 VPWR VGND VPWR VGND sky130_ef_sc_hd__decap_12
XFILLER_68_1411 VPWR VGND VPWR VGND sky130_ef_sc_hd__decap_12
XFILLER_170_918 VGND VGND VPWR VPWR sky130_fd_sc_hd__decap_6
XFILLER_182_789 VGND VGND VPWR VPWR sky130_fd_sc_hd__decap_6
XFILLER_194_1441 VPWR VGND VPWR VGND sky130_ef_sc_hd__decap_12
XPHY_EDGE_ROW_49_1_Left_304 VGND VGND VPWR VPWR sky130_fd_sc_hd__decap_3
XFILLER_5_479 VGND VGND VPWR VPWR sky130_fd_sc_hd__fill_2
XFILLER_68_1466 VPWR VGND VPWR VGND sky130_ef_sc_hd__decap_12
XFILLER_155_1414 VGND VGND VPWR VPWR sky130_fd_sc_hd__decap_6
XFILLER_190_1305 VGND VGND VPWR VPWR sky130_fd_sc_hd__decap_6
XFILLER_253_1026 VGND VGND VPWR VPWR sky130_fd_sc_hd__decap_6
XFILLER_194_1496 VPWR VGND VPWR VGND sky130_ef_sc_hd__decap_12
XPHY_EDGE_ROW_101_1_Left_356 VGND VGND VPWR VPWR sky130_fd_sc_hd__decap_3
XFILLER_1_641 VGND VGND VPWR VPWR sky130_fd_sc_hd__fill_1
XTAP_TAPCELL_ROW_38_2_4968 VGND VPWR sky130_fd_sc_hd__tapvpwrvgnd_1
XFILLER_1_674 VGND VGND VPWR VPWR sky130_fd_sc_hd__decap_4
XFILLER_231_1346 VPWR VGND VPWR VGND sky130_ef_sc_hd__decap_12
XFILLER_237_713 VPWR VGND VPWR VGND sky130_ef_sc_hd__decap_12
XFILLER_249_584 VPWR VGND VPWR VGND sky130_ef_sc_hd__decap_12
XFILLER_114_1177 VGND VGND VPWR VPWR sky130_fd_sc_hd__decap_6
XTAP_TAPCELL_ROW_180_2040 VGND VPWR sky130_fd_sc_hd__tapvpwrvgnd_1
XFILLER_237_768 VGND VGND VPWR VPWR sky130_fd_sc_hd__decap_6
XTAP_TAPCELL_ROW_180_2051 VGND VPWR sky130_fd_sc_hd__tapvpwrvgnd_1
XTAP_TAPCELL_ROW_180_2062 VGND VPWR sky130_fd_sc_hd__tapvpwrvgnd_1
XTAP_TAPCELL_ROW_180_2073 VGND VPWR sky130_fd_sc_hd__tapvpwrvgnd_1
XFILLER_149_1218 VPWR VGND VPWR VGND sky130_ef_sc_hd__decap_12
XFILLER_184_1109 VPWR VGND VPWR VGND sky130_ef_sc_hd__decap_12
X_637_ clknet_3_3__leaf_clk acc_core.adder.cla_blocks\[0\].block.sum\[3\] _045_ VGND
+ VGND VPWR VPWR net68 sky130_fd_sc_hd__dfrtp_1
XFILLER_251_259 VPWR VGND VPWR VGND sky130_ef_sc_hd__decap_12
XFILLER_204_120 VPWR VGND VPWR VGND sky130_ef_sc_hd__decap_12
X_568_ net666 VGND VGND VPWR VPWR _050_ sky130_fd_sc_hd__inv_2
XFILLER_177_517 VPWR VGND VPWR VGND sky130_ef_sc_hd__decap_12
XFILLER_204_175 VPWR VGND VPWR VGND sky130_ef_sc_hd__decap_12
XFILLER_220_624 VPWR VGND VPWR VGND sky130_ef_sc_hd__decap_12
XFILLER_189_388 VPWR VGND VPWR VGND sky130_ef_sc_hd__decap_12
XFILLER_232_495 VPWR VGND VPWR VGND sky130_ef_sc_hd__decap_12
XFILLER_38_1270 VPWR VGND VPWR VGND sky130_ef_sc_hd__decap_12
XPHY_EDGE_ROW_81_2_Left_583 VGND VGND VPWR VPWR sky130_fd_sc_hd__decap_3
X_499_ net96 net141 VGND VGND VPWR VPWR acc_core.adder.cla_blocks\[5\].block.sum\[0\]
+ sky130_fd_sc_hd__xor2_1
XFILLER_242_1453 VPWR VGND VPWR VGND sky130_ef_sc_hd__decap_12
XFILLER_220_679 VPWR VGND VPWR VGND sky130_ef_sc_hd__decap_12
XFILLER_125_1273 VPWR VGND VPWR VGND sky130_ef_sc_hd__decap_12
XFILLER_173_701 VPWR VGND VPWR VGND sky130_ef_sc_hd__decap_12
XFILLER_185_572 VPWR VGND VPWR VGND sky130_ef_sc_hd__decap_12
XTAP_TAPCELL_ROW_32_1_1278 VGND VPWR sky130_fd_sc_hd__tapvpwrvgnd_1
XFILLER_8_273 VGND VGND VPWR VPWR sky130_fd_sc_hd__decap_6
XFILLER_195_1205 VPWR VGND VPWR VGND sky130_ef_sc_hd__decap_12
XFILLER_246_15 VGND VGND VPWR VPWR sky130_fd_sc_hd__decap_6
XFILLER_67_3 VPWR VGND VPWR VGND sky130_ef_sc_hd__decap_12
XFILLER_173_756 VPWR VGND VPWR VGND sky130_ef_sc_hd__decap_12
XFILLER_12_1454 VPWR VGND VPWR VGND sky130_ef_sc_hd__decap_12
XPHY_EDGE_ROW_33_1_Left_288 VGND VGND VPWR VPWR sky130_fd_sc_hd__decap_3
XFILLER_173_1514 VGND VGND VPWR VPWR sky130_fd_sc_hd__fill_1
XFILLER_134_1509 VGND VGND VPWR VPWR sky130_fd_sc_hd__decap_6
XFILLER_45_1230 VPWR VGND VPWR VGND sky130_ef_sc_hd__decap_12
XFILLER_136_1380 VPWR VGND VPWR VGND sky130_ef_sc_hd__decap_12
XFILLER_171_1260 VPWR VGND VPWR VGND sky130_ef_sc_hd__decap_12
XFILLER_80_1165 VPWR VGND VPWR VGND sky130_ef_sc_hd__decap_12
XFILLER_45_1285 VGND VGND VPWR VPWR sky130_fd_sc_hd__decap_6
XFILLER_228_746 VGND VGND VPWR VPWR sky130_fd_sc_hd__decap_6
XTAP_TAPCELL_ROW_160_2_5943 VGND VPWR sky130_fd_sc_hd__tapvpwrvgnd_1
XTAP_TAPCELL_ROW_159_2_5937 VGND VPWR sky130_fd_sc_hd__tapvpwrvgnd_1
XPHY_EDGE_ROW_95_1_Left_350 VGND VGND VPWR VPWR sky130_fd_sc_hd__decap_3
XTAP_TAPCELL_ROW_128_2_5684 VGND VPWR sky130_fd_sc_hd__tapvpwrvgnd_1
XTAP_TAPCELL_ROW_223_3570 VGND VPWR sky130_fd_sc_hd__tapvpwrvgnd_1
XFILLER_209_971 VPWR VGND VPWR VGND sky130_ef_sc_hd__decap_12
XFILLER_242_237 VPWR VGND VPWR VGND sky130_ef_sc_hd__decap_12
XFILLER_165_1042 VGND VGND VPWR VPWR sky130_fd_sc_hd__decap_8
XFILLER_243_1217 VPWR VGND VPWR VGND sky130_ef_sc_hd__decap_12
XFILLER_208_1348 VGND VGND VPWR VPWR sky130_fd_sc_hd__decap_6
XFILLER_210_101 VGND VGND VPWR VPWR sky130_fd_sc_hd__decap_6
XFILLER_195_314 VPWR VGND VPWR VGND sky130_ef_sc_hd__decap_12
XFILLER_211_646 VPWR VGND VPWR VGND sky130_ef_sc_hd__decap_12
XFILLER_250_292 VPWR VGND VPWR VGND sky130_ef_sc_hd__decap_12
XFILLER_91_1261 VPWR VGND VPWR VGND sky130_ef_sc_hd__decap_12
XTAP_TAPCELL_ROW_121_2_5627 VGND VPWR sky130_fd_sc_hd__tapvpwrvgnd_1
XTAP_TAPCELL_ROW_176_1920 VGND VPWR sky130_fd_sc_hd__tapvpwrvgnd_1
XTAP_TAPCELL_ROW_217_3341 VGND VPWR sky130_fd_sc_hd__tapvpwrvgnd_1
XFILLER_56_1392 VGND VGND VPWR VPWR sky130_fd_sc_hd__decap_6
XTAP_TAPCELL_ROW_176_1931 VGND VPWR sky130_fd_sc_hd__tapvpwrvgnd_1
XTAP_TAPCELL_ROW_217_3352 VGND VPWR sky130_fd_sc_hd__tapvpwrvgnd_1
XTAP_TAPCELL_ROW_217_3363 VGND VPWR sky130_fd_sc_hd__tapvpwrvgnd_1
XTAP_TAPCELL_ROW_213_3205 VGND VPWR sky130_fd_sc_hd__tapvpwrvgnd_1
XFILLER_104_1313 VPWR VGND VPWR VGND sky130_ef_sc_hd__decap_12
XFILLER_176_550 VPWR VGND VPWR VGND sky130_ef_sc_hd__decap_12
XFILLER_195_369 VPWR VGND VPWR VGND sky130_ef_sc_hd__decap_12
XTAP_TAPCELL_ROW_213_3216 VGND VPWR sky130_fd_sc_hd__tapvpwrvgnd_1
XFILLER_13_1218 VPWR VGND VPWR VGND sky130_ef_sc_hd__decap_12
XTAP_TAPCELL_ROW_213_3227 VGND VPWR sky130_fd_sc_hd__tapvpwrvgnd_1
XFILLER_40_15 VGND VGND VPWR VPWR sky130_fd_sc_hd__decap_6
XFILLER_104_1368 VPWR VGND VPWR VGND sky130_ef_sc_hd__decap_12
XFILLER_156_15 VGND VGND VPWR VPWR sky130_fd_sc_hd__decap_6
XFILLER_191_553 VGND VGND VPWR VPWR sky130_fd_sc_hd__decap_6
XFILLER_3_928 VPWR VGND VPWR VGND sky130_ef_sc_hd__decap_12
XFILLER_254_1324 VPWR VGND VPWR VGND sky130_ef_sc_hd__decap_12
XTAP_TAPCELL_ROW_24_2_4854 VGND VPWR sky130_fd_sc_hd__tapvpwrvgnd_1
XFILLER_219_1444 VPWR VGND VPWR VGND sky130_ef_sc_hd__decap_12
XFILLER_6_7 VPWR VGND VPWR VGND sky130_ef_sc_hd__decap_12
XFILLER_172_1035 VPWR VGND VPWR VGND sky130_ef_sc_hd__decap_12
XFILLER_254_1379 VPWR VGND VPWR VGND sky130_ef_sc_hd__decap_12
XTAP_TAPCELL_ROW_207_3009 VGND VPWR sky130_fd_sc_hd__tapvpwrvgnd_1
XFILLER_219_1499 VGND VGND VPWR VPWR sky130_fd_sc_hd__decap_6
XPHY_EDGE_ROW_62_1_Right_718 VGND VGND VPWR VPWR sky130_fd_sc_hd__decap_3
XFILLER_137_1177 VPWR VGND VPWR VGND sky130_ef_sc_hd__decap_12
XFILLER_49_68 VGND VGND VPWR VPWR sky130_fd_sc_hd__decap_3
XFILLER_172_58 VGND VGND VPWR VPWR sky130_fd_sc_hd__decap_6
XFILLER_24_1325 VPWR VGND VPWR VGND sky130_ef_sc_hd__decap_12
XFILLER_219_713 VPWR VGND VPWR VGND sky130_ef_sc_hd__decap_12
XFILLER_115_1464 VPWR VGND VPWR VGND sky130_ef_sc_hd__decap_12
XFILLER_213_1076 VPWR VGND VPWR VGND sky130_ef_sc_hd__decap_12
XFILLER_111_1328 VGND VGND VPWR VPWR sky130_fd_sc_hd__decap_6
XFILLER_219_768 VGND VGND VPWR VPWR sky130_fd_sc_hd__decap_6
XFILLER_65_56 VPWR VGND VPWR VGND sky130_ef_sc_hd__decap_12
XTAP_TAPCELL_ROW_2_950 VGND VPWR sky130_fd_sc_hd__tapvpwrvgnd_1
XFILLER_2_1121 VPWR VGND VPWR VGND sky130_ef_sc_hd__decap_12
XFILLER_150_1399 VPWR VGND VPWR VGND sky130_ef_sc_hd__decap_12
XTAP_TAPCELL_ROW_2_961 VGND VPWR sky130_fd_sc_hd__tapvpwrvgnd_1
XFILLER_171_3 VPWR VGND VPWR VGND sky130_ef_sc_hd__decap_12
XFILLER_2_1176 VGND VGND VPWR VPWR sky130_fd_sc_hd__decap_6
XFILLER_233_259 VPWR VGND VPWR VGND sky130_ef_sc_hd__decap_12
X_422_ _128_ net340 VGND VGND VPWR VPWR _211_ sky130_fd_sc_hd__and2b_1
XFILLER_183_1131 VPWR VGND VPWR VGND sky130_ef_sc_hd__decap_12
XFILLER_148_1251 VPWR VGND VPWR VGND sky130_ef_sc_hd__decap_12
XFILLER_202_624 VPWR VGND VPWR VGND sky130_ef_sc_hd__decap_12
XFILLER_81_44 VPWR VGND VPWR VGND sky130_ef_sc_hd__decap_12
XFILLER_198_163 VPWR VGND VPWR VGND sky130_ef_sc_hd__decap_12
XFILLER_57_1189 VPWR VGND VPWR VGND sky130_ef_sc_hd__decap_12
X_353_ net594 net573 net542 VGND VGND VPWR VPWR _142_ sky130_fd_sc_hd__and3_1
XFILLER_183_1186 VPWR VGND VPWR VGND sky130_ef_sc_hd__decap_12
XFILLER_214_495 VPWR VGND VPWR VGND sky130_ef_sc_hd__decap_12
XFILLER_201_123 VGND VGND VPWR VPWR sky130_fd_sc_hd__decap_6
XFILLER_35_1421 VPWR VGND VPWR VGND sky130_ef_sc_hd__decap_12
XFILLER_197_44 VPWR VGND VPWR VGND sky130_ef_sc_hd__decap_12
XFILLER_186_347 VPWR VGND VPWR VGND sky130_ef_sc_hd__decap_12
XFILLER_202_679 VPWR VGND VPWR VGND sky130_ef_sc_hd__decap_12
X_284_ net665 VGND VGND VPWR VPWR _000_ sky130_fd_sc_hd__inv_2
XFILLER_70_1356 VPWR VGND VPWR VGND sky130_ef_sc_hd__decap_12
XFILLER_224_1183 VPWR VGND VPWR VGND sky130_ef_sc_hd__decap_12
XFILLER_35_1476 VPWR VGND VPWR VGND sky130_ef_sc_hd__decap_12
XFILLER_122_1435 VGND VGND VPWR VPWR sky130_fd_sc_hd__decap_6
XFILLER_167_572 VPWR VGND VPWR VGND sky130_ef_sc_hd__decap_12
XFILLER_197_99 VPWR VGND VPWR VGND sky130_ef_sc_hd__decap_12
XFILLER_220_1047 VGND VGND VPWR VPWR sky130_fd_sc_hd__decap_6
XFILLER_196_1514 VGND VGND VPWR VPWR sky130_fd_sc_hd__fill_1
XFILLER_182_531 VGND VGND VPWR VPWR sky130_fd_sc_hd__decap_6
XFILLER_5_232 VGND VGND VPWR VPWR sky130_fd_sc_hd__fill_1
XFILLER_6_799 VGND VGND VPWR VPWR sky130_fd_sc_hd__decap_8
XFILLER_68_1263 VGND VGND VPWR VPWR sky130_fd_sc_hd__decap_6
XFILLER_194_1293 VPWR VGND VPWR VGND sky130_ef_sc_hd__decap_12
XFILLER_2_961 VGND VGND VPWR VPWR sky130_fd_sc_hd__decap_6
XTAP_TAPCELL_ROW_186_2260 VGND VPWR sky130_fd_sc_hd__tapvpwrvgnd_1
XFILLER_116_1239 VPWR VGND VPWR VGND sky130_ef_sc_hd__decap_12
XTAP_TAPCELL_ROW_145_2_5823 VGND VPWR sky130_fd_sc_hd__tapvpwrvgnd_1
XTAP_TAPCELL_ROW_186_2271 VGND VPWR sky130_fd_sc_hd__tapvpwrvgnd_1
XTAP_TAPCELL_ROW_182_2113 VGND VPWR sky130_fd_sc_hd__tapvpwrvgnd_1
XTAP_TAPCELL_ROW_186_2282 VGND VPWR sky130_fd_sc_hd__tapvpwrvgnd_1
XTAP_TAPCELL_ROW_182_2124 VGND VPWR sky130_fd_sc_hd__tapvpwrvgnd_1
XTAP_TAPCELL_ROW_114_2_5570 VGND VPWR sky130_fd_sc_hd__tapvpwrvgnd_1
XTAP_TAPCELL_ROW_182_2135 VGND VPWR sky130_fd_sc_hd__tapvpwrvgnd_1
XFILLER_231_1143 VPWR VGND VPWR VGND sky130_ef_sc_hd__decap_12
XFILLER_237_510 VGND VGND VPWR VPWR sky130_fd_sc_hd__decap_6
XFILLER_249_381 VGND VGND VPWR VPWR sky130_fd_sc_hd__decap_6
XFILLER_7_1076 VPWR VGND VPWR VGND sky130_ef_sc_hd__decap_12
Xinput8 wr_addr[6] VGND VGND VPWR VPWR net8 sky130_fd_sc_hd__clkbuf_1
XFILLER_231_1198 VGND VGND VPWR VPWR sky130_fd_sc_hd__decap_6
XFILLER_224_237 VPWR VGND VPWR VGND sky130_ef_sc_hd__decap_12
XFILLER_75_1201 VGND VGND VPWR VPWR sky130_fd_sc_hd__decap_4
XFILLER_188_1097 VPWR VGND VPWR VGND sky130_ef_sc_hd__decap_12
XTAP_TAPCELL_ROW_63_2_5167 VGND VPWR sky130_fd_sc_hd__tapvpwrvgnd_1
XFILLER_189_130 VPWR VGND VPWR VGND sky130_ef_sc_hd__decap_12
XTAP_TAPCELL_ROW_106_2_5507 VGND VPWR sky130_fd_sc_hd__tapvpwrvgnd_1
XFILLER_127_1335 VPWR VGND VPWR VGND sky130_ef_sc_hd__decap_12
XFILLER_177_314 VPWR VGND VPWR VGND sky130_ef_sc_hd__decap_12
XFILLER_220_421 VPWR VGND VPWR VGND sky130_ef_sc_hd__decap_12
XFILLER_189_185 VPWR VGND VPWR VGND sky130_ef_sc_hd__decap_12
XFILLER_232_292 VPWR VGND VPWR VGND sky130_ef_sc_hd__decap_12
XFILLER_242_1250 VPWR VGND VPWR VGND sky130_ef_sc_hd__decap_12
XFILLER_207_1370 VGND VGND VPWR VPWR sky130_fd_sc_hd__decap_6
XFILLER_177_369 VPWR VGND VPWR VGND sky130_ef_sc_hd__decap_12
XFILLER_193_818 VPWR VGND VPWR VGND sky130_ef_sc_hd__decap_12
XFILLER_220_476 VPWR VGND VPWR VGND sky130_ef_sc_hd__decap_12
XFILLER_195_1002 VPWR VGND VPWR VGND sky130_ef_sc_hd__decap_12
XTAP_TAPCELL_ROW_231_3850 VGND VPWR sky130_fd_sc_hd__tapvpwrvgnd_1
XTAP_TAPCELL_ROW_10_2_4740 VGND VPWR sky130_fd_sc_hd__tapvpwrvgnd_1
XFILLER_173_553 VGND VGND VPWR VPWR sky130_fd_sc_hd__decap_6
XFILLER_12_1251 VPWR VGND VPWR VGND sky130_ef_sc_hd__decap_12
XFILLER_10_18 VGND VGND VPWR VPWR sky130_fd_sc_hd__decap_3
XFILLER_103_1390 VPWR VGND VPWR VGND sky130_ef_sc_hd__decap_12
XFILLER_195_1057 VPWR VGND VPWR VGND sky130_ef_sc_hd__decap_12
XTAP_TAPCELL_ROW_138_1_1437 VGND VPWR sky130_fd_sc_hd__tapvpwrvgnd_1
XFILLER_138_1442 VPWR VGND VPWR VGND sky130_ef_sc_hd__decap_12
XFILLER_236_1054 VPWR VGND VPWR VGND sky130_ef_sc_hd__decap_12
XFILLER_47_1347 VPWR VGND VPWR VGND sky130_ef_sc_hd__decap_12
XFILLER_82_1227 VPWR VGND VPWR VGND sky130_ef_sc_hd__decap_12
XFILLER_134_1306 VGND VGND VPWR VPWR sky130_fd_sc_hd__decap_6
XFILLER_248_808 VPWR VGND VPWR VGND sky130_ef_sc_hd__decap_12
XFILLER_173_1377 VPWR VGND VPWR VGND sky130_ef_sc_hd__decap_12
XFILLER_138_1497 VPWR VGND VPWR VGND sky130_ef_sc_hd__decap_12
XTAP_TAPCELL_ROW_225_3621 VGND VPWR sky130_fd_sc_hd__tapvpwrvgnd_1
XTAP_TAPCELL_ROW_225_3632 VGND VPWR sky130_fd_sc_hd__tapvpwrvgnd_1
XFILLER_19_27 VPWR VGND VPWR VGND sky130_ef_sc_hd__decap_12
XTAP_TAPCELL_ROW_225_3643 VGND VPWR sky130_fd_sc_hd__tapvpwrvgnd_1
XTAP_TAPCELL_ROW_221_3507 VGND VPWR sky130_fd_sc_hd__tapvpwrvgnd_1
XFILLER_210_1238 VPWR VGND VPWR VGND sky130_ef_sc_hd__decap_12
XFILLER_3_1463 VPWR VGND VPWR VGND sky130_ef_sc_hd__decap_12
XFILLER_35_15 VPWR VGND VPWR VGND sky130_ef_sc_hd__decap_12
XFILLER_215_259 VPWR VGND VPWR VGND sky130_ef_sc_hd__decap_12
XFILLER_58_1454 VPWR VGND VPWR VGND sky130_ef_sc_hd__decap_12
XFILLER_145_1402 VPWR VGND VPWR VGND sky130_ef_sc_hd__decap_12
XTAP_TAPCELL_ROW_219_3414 VGND VPWR sky130_fd_sc_hd__tapvpwrvgnd_1
XTAP_TAPCELL_ROW_219_3425 VGND VPWR sky130_fd_sc_hd__tapvpwrvgnd_1
XFILLER_230_218 VPWR VGND VPWR VGND sky130_ef_sc_hd__decap_12
XFILLER_243_1014 VPWR VGND VPWR VGND sky130_ef_sc_hd__decap_12
XTAP_TAPCELL_ROW_219_3436 VGND VPWR sky130_fd_sc_hd__tapvpwrvgnd_1
XFILLER_184_1484 VPWR VGND VPWR VGND sky130_ef_sc_hd__decap_12
XFILLER_93_1378 VPWR VGND VPWR VGND sky130_ef_sc_hd__decap_12
XFILLER_145_1457 VGND VGND VPWR VPWR sky130_fd_sc_hd__decap_6
XFILLER_195_111 VPWR VGND VPWR VGND sky130_ef_sc_hd__decap_12
XFILLER_180_1348 VGND VGND VPWR VPWR sky130_fd_sc_hd__decap_6
XFILLER_211_443 VPWR VGND VPWR VGND sky130_ef_sc_hd__decap_12
XFILLER_243_1069 VGND VGND VPWR VPWR sky130_fd_sc_hd__decap_6
XFILLER_168_347 VPWR VGND VPWR VGND sky130_ef_sc_hd__decap_12
XFILLER_196_667 VPWR VGND VPWR VGND sky130_ef_sc_hd__decap_12
Xwire406 net407 VGND VGND VPWR VPWR net406 sky130_fd_sc_hd__clkbuf_1
Xwire417 net418 VGND VGND VPWR VPWR net417 sky130_fd_sc_hd__clkbuf_1
XFILLER_195_166 VGND VGND VPWR VPWR sky130_fd_sc_hd__decap_6
XFILLER_211_498 VPWR VGND VPWR VGND sky130_ef_sc_hd__decap_12
XFILLER_221_1334 VPWR VGND VPWR VGND sky130_ef_sc_hd__decap_12
Xwire428 net429 VGND VGND VPWR VPWR net428 sky130_fd_sc_hd__clkbuf_1
Xwire439 net440 VGND VGND VPWR VPWR net439 sky130_fd_sc_hd__clkbuf_1
XFILLER_104_1165 VPWR VGND VPWR VGND sky130_ef_sc_hd__decap_12
XFILLER_192_851 VPWR VGND VPWR VGND sky130_ef_sc_hd__decap_12
XFILLER_221_1389 VPWR VGND VPWR VGND sky130_ef_sc_hd__decap_12
XTAP_TAPCELL_ROW_151_2_5866 VGND VPWR sky130_fd_sc_hd__tapvpwrvgnd_1
XFILLER_139_1206 VPWR VGND VPWR VGND sky130_ef_sc_hd__decap_12
XFILLER_247_80 VGND VGND VPWR VPWR sky130_fd_sc_hd__decap_6
XFILLER_3_725 VGND VGND VPWR VPWR sky130_fd_sc_hd__fill_1
XFILLER_2_202 VGND VGND VPWR VPWR sky130_fd_sc_hd__decap_3
XFILLER_254_1121 VPWR VGND VPWR VGND sky130_ef_sc_hd__decap_12
XFILLER_65_1414 VGND VGND VPWR VPWR sky130_fd_sc_hd__decap_6
XFILLER_219_1241 VGND VGND VPWR VPWR sky130_fd_sc_hd__decap_6
XFILLER_183_68 VPWR VGND VPWR VGND sky130_ef_sc_hd__decap_12
XFILLER_191_1444 VPWR VGND VPWR VGND sky130_ef_sc_hd__decap_12
XFILLER_254_1176 VGND VGND VPWR VPWR sky130_fd_sc_hd__decap_6
XFILLER_76_22 VPWR VGND VPWR VGND sky130_ef_sc_hd__decap_12
XFILLER_191_1499 VGND VGND VPWR VPWR sky130_fd_sc_hd__decap_6
XFILLER_232_1441 VPWR VGND VPWR VGND sky130_ef_sc_hd__decap_12
XPHY_EDGE_ROW_63_1_Right_719 VGND VGND VPWR VPWR sky130_fd_sc_hd__decap_3
XFILLER_219_510 VGND VGND VPWR VPWR sky130_fd_sc_hd__decap_6
XFILLER_247_830 VPWR VGND VPWR VGND sky130_ef_sc_hd__decap_12
XFILLER_115_1261 VPWR VGND VPWR VGND sky130_ef_sc_hd__decap_12
Xfanout594 net601 VGND VGND VPWR VPWR net594 sky130_fd_sc_hd__dlymetal6s2s_1
XFILLER_232_1496 VPWR VGND VPWR VGND sky130_ef_sc_hd__decap_12
XTAP_TAPCELL_ROW_241_4190 VGND VPWR sky130_fd_sc_hd__tapvpwrvgnd_1
XFILLER_4_1238 VPWR VGND VPWR VGND sky130_ef_sc_hd__decap_12
XFILLER_247_885 VPWR VGND VPWR VGND sky130_ef_sc_hd__decap_12
XFILLER_24_1177 VGND VGND VPWR VPWR sky130_fd_sc_hd__decap_6
XFILLER_150_1196 VPWR VGND VPWR VGND sky130_ef_sc_hd__decap_12
XTAP_TAPCELL_ROW_48_2_5047 VGND VPWR sky130_fd_sc_hd__tapvpwrvgnd_1
XFILLER_59_1218 VPWR VGND VPWR VGND sky130_ef_sc_hd__decap_12
XFILLER_206_237 VPWR VGND VPWR VGND sky130_ef_sc_hd__decap_12
XFILLER_185_1248 VPWR VGND VPWR VGND sky130_ef_sc_hd__decap_12
XFILLER_92_65 VGND VGND VPWR VPWR sky130_fd_sc_hd__decap_6
X_405_ _191_ _193_ VGND VGND VPWR VPWR _194_ sky130_fd_sc_hd__nand2b_1
XFILLER_202_421 VPWR VGND VPWR VGND sky130_ef_sc_hd__decap_12
XFILLER_214_292 VPWR VGND VPWR VGND sky130_ef_sc_hd__decap_12
XTAP_TAPCELL_ROW_194_2540 VGND VPWR sky130_fd_sc_hd__tapvpwrvgnd_1
XTAP_TAPCELL_ROW_194_2551 VGND VPWR sky130_fd_sc_hd__tapvpwrvgnd_1
XFILLER_222_1109 VPWR VGND VPWR VGND sky130_ef_sc_hd__decap_12
X_336_ _120_ _124_ VGND VGND VPWR VPWR _125_ sky130_fd_sc_hd__or2_1
XFILLER_186_144 VGND VGND VPWR VPWR sky130_fd_sc_hd__decap_6
XTAP_TAPCELL_ROW_194_2562 VGND VPWR sky130_fd_sc_hd__tapvpwrvgnd_1
XFILLER_175_818 VPWR VGND VPWR VGND sky130_ef_sc_hd__decap_12
XTAP_TAPCELL_ROW_190_2404 VGND VPWR sky130_fd_sc_hd__tapvpwrvgnd_1
XFILLER_202_476 VPWR VGND VPWR VGND sky130_ef_sc_hd__decap_12
XFILLER_187_689 VPWR VGND VPWR VGND sky130_ef_sc_hd__decap_12
XTAP_TAPCELL_ROW_190_2415 VGND VPWR sky130_fd_sc_hd__tapvpwrvgnd_1
XFILLER_230_796 VPWR VGND VPWR VGND sky130_ef_sc_hd__decap_12
XFILLER_35_1273 VPWR VGND VPWR VGND sky130_ef_sc_hd__decap_12
XFILLER_161_1292 VPWR VGND VPWR VGND sky130_ef_sc_hd__decap_12
XFILLER_183_873 VPWR VGND VPWR VGND sky130_ef_sc_hd__decap_12
XFILLER_196_1355 VPWR VGND VPWR VGND sky130_ef_sc_hd__decap_12
XPHY_EDGE_ROW_112_2_Left_614 VGND VGND VPWR VPWR sky130_fd_sc_hd__decap_3
XFILLER_227_39 VGND VGND VPWR VPWR sky130_fd_sc_hd__decap_4
XFILLER_157_1328 VGND VGND VPWR VPWR sky130_fd_sc_hd__decap_6
XFILLER_192_1219 VGND VGND VPWR VPWR sky130_fd_sc_hd__decap_6
XTAP_TAPCELL_ROW_188_2322 VGND VPWR sky130_fd_sc_hd__tapvpwrvgnd_1
XTAP_TAPCELL_ROW_188_2333 VGND VPWR sky130_fd_sc_hd__tapvpwrvgnd_1
XTAP_TAPCELL_ROW_188_2344 VGND VPWR sky130_fd_sc_hd__tapvpwrvgnd_1
XFILLER_9_1105 VGND VGND VPWR VPWR sky130_fd_sc_hd__decap_8
XFILLER_194_1090 VGND VGND VPWR VPWR sky130_fd_sc_hd__decap_6
XFILLER_233_1205 VPWR VGND VPWR VGND sky130_ef_sc_hd__decap_12
XTAP_TAPCELL_ROW_184_2208 VGND VPWR sky130_fd_sc_hd__tapvpwrvgnd_1
XFILLER_44_1509 VGND VGND VPWR VPWR sky130_fd_sc_hd__decap_6
XFILLER_243_27 VPWR VGND VPWR VGND sky130_ef_sc_hd__decap_12
XFILLER_46_1380 VPWR VGND VPWR VGND sky130_ef_sc_hd__decap_12
XFILLER_211_1514 VGND VGND VPWR VPWR sky130_fd_sc_hd__fill_1
XFILLER_238_863 VPWR VGND VPWR VGND sky130_ef_sc_hd__decap_12
XFILLER_253_811 VGND VGND VPWR VPWR sky130_fd_sc_hd__decap_6
XFILLER_244_1312 VPWR VGND VPWR VGND sky130_ef_sc_hd__decap_12
XFILLER_209_1432 VPWR VGND VPWR VGND sky130_ef_sc_hd__decap_12
XFILLER_212_218 VPWR VGND VPWR VGND sky130_ef_sc_hd__decap_12
XFILLER_240_538 VPWR VGND VPWR VGND sky130_ef_sc_hd__decap_12
XFILLER_177_111 VPWR VGND VPWR VGND sky130_ef_sc_hd__decap_12
XFILLER_244_1367 VPWR VGND VPWR VGND sky130_ef_sc_hd__decap_12
XFILLER_209_1487 VPWR VGND VPWR VGND sky130_ef_sc_hd__decap_12
XFILLER_127_1165 VPWR VGND VPWR VGND sky130_ef_sc_hd__decap_12
XTAP_TAPCELL_ROW_233_3901 VGND VPWR sky130_fd_sc_hd__tapvpwrvgnd_1
XFILLER_178_667 VPWR VGND VPWR VGND sky130_ef_sc_hd__decap_12
XTAP_TAPCELL_ROW_233_3912 VGND VPWR sky130_fd_sc_hd__tapvpwrvgnd_1
XTAP_TAPCELL_ROW_233_3923 VGND VPWR sky130_fd_sc_hd__tapvpwrvgnd_1
XFILLER_177_166 VGND VGND VPWR VPWR sky130_fd_sc_hd__decap_6
XFILLER_193_615 VPWR VGND VPWR VGND sky130_ef_sc_hd__decap_12
XFILLER_220_273 VGND VGND VPWR VPWR sky130_fd_sc_hd__decap_6
XFILLER_14_1313 VPWR VGND VPWR VGND sky130_ef_sc_hd__decap_12
XFILLER_165_328 VGND VGND VPWR VPWR sky130_fd_sc_hd__decap_8
XTAP_TAPCELL_ROW_136_2_5746 VGND VPWR sky130_fd_sc_hd__tapvpwrvgnd_1
XFILLER_197_1119 VPWR VGND VPWR VGND sky130_ef_sc_hd__decap_12
XPHY_EDGE_ROW_44_2_Left_546 VGND VGND VPWR VPWR sky130_fd_sc_hd__decap_3
XFILLER_21_39 VGND VGND VPWR VPWR sky130_fd_sc_hd__decap_4
XFILLER_14_1368 VPWR VGND VPWR VGND sky130_ef_sc_hd__decap_12
XFILLER_101_1316 VPWR VGND VPWR VGND sky130_ef_sc_hd__decap_12
XFILLER_174_851 VPWR VGND VPWR VGND sky130_ef_sc_hd__decap_12
XFILLER_137_39 VGND VGND VPWR VPWR sky130_fd_sc_hd__decap_4
XFILLER_255_1441 VGND VGND VPWR VPWR sky130_fd_sc_hd__decap_8
XTAP_TAPCELL_ROW_227_3705 VGND VPWR sky130_fd_sc_hd__tapvpwrvgnd_1
XTAP_TAPCELL_ROW_227_3716 VGND VPWR sky130_fd_sc_hd__tapvpwrvgnd_1
XTAP_TAPCELL_ROW_39_2_4973 VGND VPWR sky130_fd_sc_hd__tapvpwrvgnd_1
XFILLER_251_1327 VGND VGND VPWR VPWR sky130_fd_sc_hd__decap_6
XFILLER_248_605 VPWR VGND VPWR VGND sky130_ef_sc_hd__decap_12
XFILLER_47_1177 VPWR VGND VPWR VGND sky130_ef_sc_hd__decap_12
XFILLER_138_1294 VPWR VGND VPWR VGND sky130_ef_sc_hd__decap_12
XFILLER_153_27 VPWR VGND VPWR VGND sky130_ef_sc_hd__decap_12
XFILLER_173_1174 VPWR VGND VPWR VGND sky130_ef_sc_hd__decap_12
XFILLER_229_830 VPWR VGND VPWR VGND sky130_ef_sc_hd__decap_12
XFILLER_5_1514 VGND VGND VPWR VPWR sky130_fd_sc_hd__fill_1
XFILLER_25_1464 VPWR VGND VPWR VGND sky130_ef_sc_hd__decap_12
XFILLER_112_1423 VPWR VGND VPWR VGND sky130_ef_sc_hd__decap_12
XFILLER_21_1328 VGND VGND VPWR VPWR sky130_fd_sc_hd__decap_6
XFILLER_210_1035 VPWR VGND VPWR VGND sky130_ef_sc_hd__decap_12
XFILLER_229_885 VPWR VGND VPWR VGND sky130_ef_sc_hd__decap_12
XFILLER_60_1399 VPWR VGND VPWR VGND sky130_ef_sc_hd__decap_12
XTAP_TAPCELL_ROW_165_1484 VGND VPWR sky130_fd_sc_hd__tapvpwrvgnd_1
XFILLER_255_181 VGND VGND VPWR VPWR sky130_fd_sc_hd__decap_8
XFILLER_46_58 VGND VGND VPWR VPWR sky130_fd_sc_hd__decap_6
XFILLER_112_1478 VGND VGND VPWR VPWR sky130_fd_sc_hd__decap_6
XTAP_TAPCELL_ROW_165_1495 VGND VPWR sky130_fd_sc_hd__tapvpwrvgnd_1
XTAP_TAPCELL_ROW_32_2_4916 VGND VPWR sky130_fd_sc_hd__tapvpwrvgnd_1
XFILLER_3_1260 VPWR VGND VPWR VGND sky130_ef_sc_hd__decap_12
XFILLER_188_409 VPWR VGND VPWR VGND sky130_ef_sc_hd__decap_12
XFILLER_58_1251 VPWR VGND VPWR VGND sky130_ef_sc_hd__decap_12
XPHY_EDGE_ROW_58_1_Left_313 VGND VGND VPWR VPWR sky130_fd_sc_hd__decap_3
XFILLER_149_1390 VPWR VGND VPWR VGND sky130_ef_sc_hd__decap_12
XFILLER_184_1281 VPWR VGND VPWR VGND sky130_ef_sc_hd__decap_12
XFILLER_62_46 VGND VGND VPWR VPWR sky130_fd_sc_hd__fill_2
XFILLER_62_57 VGND VGND VPWR VPWR sky130_fd_sc_hd__decap_6
XFILLER_211_240 VPWR VGND VPWR VGND sky130_ef_sc_hd__decap_12
XPHY_EDGE_ROW_110_1_Left_365 VGND VGND VPWR VPWR sky130_fd_sc_hd__decap_3
XFILLER_106_1227 VPWR VGND VPWR VGND sky130_ef_sc_hd__decap_12
XFILLER_168_144 VGND VGND VPWR VPWR sky130_fd_sc_hd__decap_6
XFILLER_178_46 VPWR VGND VPWR VGND sky130_ef_sc_hd__decap_12
XFILLER_200_925 VPWR VGND VPWR VGND sky130_ef_sc_hd__decap_12
XFILLER_196_464 VPWR VGND VPWR VGND sky130_ef_sc_hd__decap_12
XFILLER_169_689 VPWR VGND VPWR VGND sky130_ef_sc_hd__decap_12
XFILLER_212_796 VPWR VGND VPWR VGND sky130_ef_sc_hd__decap_12
XFILLER_134_3 VPWR VGND VPWR VGND sky130_ef_sc_hd__decap_12
XFILLER_7_305 VGND VGND VPWR VPWR sky130_fd_sc_hd__decap_4
XFILLER_211_295 VGND VGND VPWR VPWR sky130_fd_sc_hd__decap_6
XFILLER_221_1131 VPWR VGND VPWR VGND sky130_ef_sc_hd__decap_12
XFILLER_8_839 VGND VGND VPWR VPWR sky130_fd_sc_hd__decap_3
Xwire225 net226 VGND VGND VPWR VPWR net225 sky130_fd_sc_hd__clkbuf_1
XFILLER_32_1435 VGND VGND VPWR VPWR sky130_fd_sc_hd__decap_6
Xwire236 net237 VGND VGND VPWR VPWR net236 sky130_fd_sc_hd__clkbuf_1
XFILLER_184_648 VPWR VGND VPWR VGND sky130_ef_sc_hd__decap_12
Xwire258 net259 VGND VGND VPWR VPWR net258 sky130_fd_sc_hd__clkbuf_1
Xwire269 net270 VGND VGND VPWR VPWR net269 sky130_fd_sc_hd__clkbuf_1
XFILLER_165_862 VPWR VGND VPWR VGND sky130_ef_sc_hd__decap_12
XFILLER_221_1186 VPWR VGND VPWR VGND sky130_ef_sc_hd__decap_12
XFILLER_194_34 VPWR VGND VPWR VGND sky130_ef_sc_hd__decap_12
XFILLER_165_895 VGND VGND VPWR VPWR sky130_fd_sc_hd__decap_8
XFILLER_193_1506 VGND VGND VPWR VPWR sky130_fd_sc_hd__decap_8
XFILLER_180_832 VGND VGND VPWR VPWR sky130_fd_sc_hd__decap_6
XTAP_TAPCELL_ROW_108_1_1392 VGND VPWR sky130_fd_sc_hd__tapvpwrvgnd_1
XFILLER_194_89 VPWR VGND VPWR VGND sky130_ef_sc_hd__decap_12
XFILLER_234_1514 VGND VGND VPWR VPWR sky130_fd_sc_hd__fill_1
XFILLER_191_1241 VGND VGND VPWR VPWR sky130_fd_sc_hd__decap_6
XTAP_TAPCELL_ROW_243_4252 VGND VPWR sky130_fd_sc_hd__tapvpwrvgnd_1
XFILLER_239_627 VPWR VGND VPWR VGND sky130_ef_sc_hd__decap_12
XTAP_TAPCELL_ROW_243_4263 VGND VPWR sky130_fd_sc_hd__tapvpwrvgnd_1
XFILLER_26_1239 VPWR VGND VPWR VGND sky130_ef_sc_hd__decap_12
XTAP_TAPCELL_ROW_243_4274 VGND VPWR sky130_fd_sc_hd__tapvpwrvgnd_1
XPHY_EDGE_ROW_90_2_Left_592 VGND VGND VPWR VPWR sky130_fd_sc_hd__decap_3
XFILLER_117_1378 VPWR VGND VPWR VGND sky130_ef_sc_hd__decap_12
XFILLER_232_1293 VPWR VGND VPWR VGND sky130_ef_sc_hd__decap_12
XFILLER_4_1035 VPWR VGND VPWR VGND sky130_ef_sc_hd__decap_12
XFILLER_235_811 VGND VGND VPWR VPWR sky130_fd_sc_hd__decap_6
XFILLER_247_682 VGND VGND VPWR VPWR sky130_fd_sc_hd__decap_6
XTAP_TAPCELL_ROW_5_1041 VGND VPWR sky130_fd_sc_hd__tapvpwrvgnd_1
XTAP_TAPCELL_ROW_5_1052 VGND VPWR sky130_fd_sc_hd__tapvpwrvgnd_1
XTAP_TAPCELL_ROW_5_1063 VGND VPWR sky130_fd_sc_hd__tapvpwrvgnd_1
XFILLER_185_1045 VPWR VGND VPWR VGND sky130_ef_sc_hd__decap_12
XTAP_TAPCELL_ROW_196_2602 VGND VPWR sky130_fd_sc_hd__tapvpwrvgnd_1
XTAP_TAPCELL_ROW_196_2613 VGND VPWR sky130_fd_sc_hd__tapvpwrvgnd_1
XTAP_TAPCELL_ROW_204_2889 VGND VPWR sky130_fd_sc_hd__tapvpwrvgnd_1
XTAP_TAPCELL_ROW_237_4034 VGND VPWR sky130_fd_sc_hd__tapvpwrvgnd_1
XTAP_TAPCELL_ROW_196_2624 VGND VPWR sky130_fd_sc_hd__tapvpwrvgnd_1
XTAP_TAPCELL_ROW_237_4045 VGND VPWR sky130_fd_sc_hd__tapvpwrvgnd_1
XFILLER_222_538 VPWR VGND VPWR VGND sky130_ef_sc_hd__decap_12
XTAP_TAPCELL_ROW_237_4056 VGND VPWR sky130_fd_sc_hd__tapvpwrvgnd_1
XTAP_TAPCELL_ROW_237_4067 VGND VPWR sky130_fd_sc_hd__tapvpwrvgnd_1
XPHY_EDGE_ROW_42_1_Left_297 VGND VGND VPWR VPWR sky130_fd_sc_hd__decap_3
XFILLER_37_1335 VPWR VGND VPWR VGND sky130_ef_sc_hd__decap_12
XTAP_TAPCELL_ROW_78_2_5286 VGND VPWR sky130_fd_sc_hd__tapvpwrvgnd_1
XFILLER_187_431 VPWR VGND VPWR VGND sky130_ef_sc_hd__decap_12
XFILLER_128_1485 VPWR VGND VPWR VGND sky130_ef_sc_hd__decap_12
XFILLER_175_615 VPWR VGND VPWR VGND sky130_ef_sc_hd__decap_12
XFILLER_202_273 VGND VGND VPWR VPWR sky130_fd_sc_hd__decap_6
XFILLER_226_1097 VPWR VGND VPWR VGND sky130_ef_sc_hd__decap_12
XFILLER_124_1349 VGND VGND VPWR VPWR sky130_fd_sc_hd__decap_6
XFILLER_187_486 VPWR VGND VPWR VGND sky130_ef_sc_hd__decap_12
XFILLER_230_593 VPWR VGND VPWR VGND sky130_ef_sc_hd__decap_12
X_319_ _097_ net177 VGND VGND VPWR VPWR _108_ sky130_fd_sc_hd__nor2_1
Xinput11 wr_data[10] VGND VGND VPWR VPWR net11 sky130_fd_sc_hd__clkbuf_1
Xinput22 wr_data[20] VGND VGND VPWR VPWR net22 sky130_fd_sc_hd__clkbuf_1
Xinput33 wr_data[30] VGND VGND VPWR VPWR net33 sky130_fd_sc_hd__clkbuf_1
XFILLER_200_1226 VPWR VGND VPWR VGND sky130_ef_sc_hd__decap_12
XFILLER_7_861 VPWR VGND VPWR VGND sky130_ef_sc_hd__decap_12
XFILLER_183_670 VPWR VGND VPWR VGND sky130_ef_sc_hd__decap_12
XFILLER_196_1152 VPWR VGND VPWR VGND sky130_ef_sc_hd__decap_12
XTAP_TAPCELL_ROW_71_2_5229 VGND VPWR sky130_fd_sc_hd__tapvpwrvgnd_1
Xmax_cap525 net67 VGND VGND VPWR VPWR net525 sky130_fd_sc_hd__clkbuf_1
XFILLER_13_1390 VPWR VGND VPWR VGND sky130_ef_sc_hd__decap_12
Xmax_cap536 net55 VGND VGND VPWR VPWR net536 sky130_fd_sc_hd__clkbuf_1
XFILLER_171_854 VGND VGND VPWR VPWR sky130_fd_sc_hd__decap_6
XFILLER_254_15 VGND VGND VPWR VPWR sky130_fd_sc_hd__decap_6
Xmax_cap558 net70 VGND VGND VPWR VPWR net558 sky130_fd_sc_hd__clkbuf_1
Xmax_cap569 net54 VGND VGND VPWR VPWR net569 sky130_fd_sc_hd__clkbuf_1
XFILLER_48_1442 VPWR VGND VPWR VGND sky130_ef_sc_hd__decap_12
XFILLER_233_1002 VPWR VGND VPWR VGND sky130_ef_sc_hd__decap_12
XFILLER_44_1306 VGND VGND VPWR VPWR sky130_fd_sc_hd__decap_6
XFILLER_48_1497 VPWR VGND VPWR VGND sky130_ef_sc_hd__decap_12
XFILLER_135_1445 VPWR VGND VPWR VGND sky130_ef_sc_hd__decap_12
XFILLER_170_1336 VPWR VGND VPWR VGND sky130_ef_sc_hd__decap_12
XFILLER_233_1057 VPWR VGND VPWR VGND sky130_ef_sc_hd__decap_12
XFILLER_238_660 VGND VGND VPWR VPWR sky130_fd_sc_hd__decap_6
XFILLER_211_1377 VPWR VGND VPWR VGND sky130_ef_sc_hd__decap_12
XFILLER_252_151 VPWR VGND VPWR VGND sky130_ef_sc_hd__decap_12
XTAP_TAPCELL_ROW_38_1_1287 VGND VPWR sky130_fd_sc_hd__tapvpwrvgnd_1
XFILLER_55_1402 VPWR VGND VPWR VGND sky130_ef_sc_hd__decap_12
XFILLER_129_1249 VPWR VGND VPWR VGND sky130_ef_sc_hd__decap_12
XFILLER_197_228 VPWR VGND VPWR VGND sky130_ef_sc_hd__decap_12
XFILLER_240_335 VPWR VGND VPWR VGND sky130_ef_sc_hd__decap_12
XFILLER_181_1432 VPWR VGND VPWR VGND sky130_ef_sc_hd__decap_12
XFILLER_244_1164 VPWR VGND VPWR VGND sky130_ef_sc_hd__decap_12
XFILLER_55_1457 VGND VGND VPWR VPWR sky130_fd_sc_hd__decap_6
XFILLER_90_1337 VPWR VGND VPWR VGND sky130_ef_sc_hd__decap_12
XFILLER_209_1284 VGND VGND VPWR VPWR sky130_fd_sc_hd__decap_6
XFILLER_221_560 VPWR VGND VPWR VGND sky130_ef_sc_hd__decap_12
XFILLER_178_464 VPWR VGND VPWR VGND sky130_ef_sc_hd__decap_12
XTAP_TAPCELL_ROW_126_1_1419 VGND VPWR sky130_fd_sc_hd__tapvpwrvgnd_1
XFILLER_181_1487 VPWR VGND VPWR VGND sky130_ef_sc_hd__decap_12
XFILLER_193_412 VPWR VGND VPWR VGND sky130_ef_sc_hd__decap_12
XFILLER_166_648 VPWR VGND VPWR VGND sky130_ef_sc_hd__decap_12
XFILLER_194_968 VPWR VGND VPWR VGND sky130_ef_sc_hd__decap_12
XFILLER_5_809 VGND VGND VPWR VPWR sky130_fd_sc_hd__decap_4
XFILLER_193_467 VGND VGND VPWR VPWR sky130_fd_sc_hd__decap_6
XFILLER_222_1484 VPWR VGND VPWR VGND sky130_ef_sc_hd__decap_12
XFILLER_14_1165 VPWR VGND VPWR VGND sky130_ef_sc_hd__decap_12
XFILLER_165_169 VPWR VGND VPWR VGND sky130_ef_sc_hd__decap_12
XFILLER_140_1184 VPWR VGND VPWR VGND sky130_ef_sc_hd__decap_12
XFILLER_49_1206 VPWR VGND VPWR VGND sky130_ef_sc_hd__decap_12
XTAP_TAPCELL_ROW_173_1797 VGND VPWR sky130_fd_sc_hd__tapvpwrvgnd_1
XFILLER_164_15 VGND VGND VPWR VPWR sky130_fd_sc_hd__decap_6
XFILLER_255_1282 VPWR VGND VPWR VGND sky130_ef_sc_hd__decap_12
XFILLER_248_402 VGND VGND VPWR VPWR sky130_fd_sc_hd__decap_6
XFILLER_249_947 VPWR VGND VPWR VGND sky130_ef_sc_hd__decap_12
XFILLER_57_68 VGND VGND VPWR VPWR sky130_fd_sc_hd__decap_3
XFILLER_25_1261 VPWR VGND VPWR VGND sky130_ef_sc_hd__decap_12
XFILLER_112_1220 VGND VGND VPWR VPWR sky130_fd_sc_hd__decap_6
XFILLER_217_811 VGND VGND VPWR VPWR sky130_fd_sc_hd__decap_6
XFILLER_180_58 VGND VGND VPWR VPWR sky130_fd_sc_hd__decap_6
XFILLER_229_682 VGND VGND VPWR VPWR sky130_fd_sc_hd__decap_6
XFILLER_60_1196 VPWR VGND VPWR VGND sky130_ef_sc_hd__decap_12
XFILLER_5_1377 VPWR VGND VPWR VGND sky130_ef_sc_hd__decap_12
XTAP_TAPCELL_ROW_95_2_5425 VGND VPWR sky130_fd_sc_hd__tapvpwrvgnd_1
XTAP_TAPCELL_ROW_64_2_5172 VGND VPWR sky130_fd_sc_hd__tapvpwrvgnd_1
XFILLER_147_1316 VPWR VGND VPWR VGND sky130_ef_sc_hd__decap_12
XFILLER_231_302 VPWR VGND VPWR VGND sky130_ef_sc_hd__decap_12
XFILLER_73_56 VPWR VGND VPWR VGND sky130_ef_sc_hd__decap_12
XFILLER_182_1207 VPWR VGND VPWR VGND sky130_ef_sc_hd__decap_12
XFILLER_251_3 VPWR VGND VPWR VGND sky130_ef_sc_hd__decap_12
XFILLER_243_173 VPWR VGND VPWR VGND sky130_ef_sc_hd__decap_12
XFILLER_188_206 VPWR VGND VPWR VGND sky130_ef_sc_hd__decap_12
XFILLER_204_538 VPWR VGND VPWR VGND sky130_ef_sc_hd__decap_12
XFILLER_186_1398 VPWR VGND VPWR VGND sky130_ef_sc_hd__decap_12
Xwire90 _234_ VGND VGND VPWR VPWR net90 sky130_fd_sc_hd__clkbuf_1
XFILLER_189_56 VPWR VGND VPWR VGND sky130_ef_sc_hd__decap_12
XFILLER_231_357 VPWR VGND VPWR VGND sky130_ef_sc_hd__decap_12
XFILLER_169_431 VPWR VGND VPWR VGND sky130_ef_sc_hd__decap_12
XTAP_TAPCELL_ROW_255_4690 VGND VPWR sky130_fd_sc_hd__tapvpwrvgnd_1
XTAP_TAPCELL_ROW_251_4532 VGND VPWR sky130_fd_sc_hd__tapvpwrvgnd_1
XTAP_TAPCELL_ROW_251_4543 VGND VPWR sky130_fd_sc_hd__tapvpwrvgnd_1
XTAP_TAPCELL_ROW_251_4554 VGND VPWR sky130_fd_sc_hd__tapvpwrvgnd_1
XFILLER_200_722 VPWR VGND VPWR VGND sky130_ef_sc_hd__decap_12
XFILLER_169_486 VPWR VGND VPWR VGND sky130_ef_sc_hd__decap_12
XFILLER_196_261 VPWR VGND VPWR VGND sky130_ef_sc_hd__decap_12
XFILLER_212_593 VPWR VGND VPWR VGND sky130_ef_sc_hd__decap_12
XFILLER_223_1248 VPWR VGND VPWR VGND sky130_ef_sc_hd__decap_12
XFILLER_8_636 VPWR VGND VPWR VGND sky130_ef_sc_hd__decap_12
XFILLER_184_445 VGND VGND VPWR VPWR sky130_fd_sc_hd__decap_6
XFILLER_200_777 VPWR VGND VPWR VGND sky130_ef_sc_hd__decap_12
XFILLER_71_1292 VPWR VGND VPWR VGND sky130_ef_sc_hd__decap_12
XTAP_TAPCELL_ROW_56_2_5109 VGND VPWR sky130_fd_sc_hd__tapvpwrvgnd_1
XFILLER_123_1371 VGND VGND VPWR VPWR sky130_fd_sc_hd__decap_6
XFILLER_193_990 VPWR VGND VPWR VGND sky130_ef_sc_hd__decap_12
XFILLER_158_1423 VPWR VGND VPWR VGND sky130_ef_sc_hd__decap_12
XFILLER_193_1303 VPWR VGND VPWR VGND sky130_ef_sc_hd__decap_12
XTAP_TAPCELL_ROW_249_4461 VGND VPWR sky130_fd_sc_hd__tapvpwrvgnd_1
XFILLER_4_831 VGND VGND VPWR VPWR sky130_fd_sc_hd__decap_6
XTAP_TAPCELL_ROW_249_4472 VGND VPWR sky130_fd_sc_hd__tapvpwrvgnd_1
XFILLER_67_1328 VGND VGND VPWR VPWR sky130_fd_sc_hd__decap_6
XTAP_TAPCELL_ROW_249_4483 VGND VPWR sky130_fd_sc_hd__tapvpwrvgnd_1
XTAP_TAPCELL_ROW_245_4314 VGND VPWR sky130_fd_sc_hd__tapvpwrvgnd_1
XTAP_TAPCELL_ROW_245_4325 VGND VPWR sky130_fd_sc_hd__tapvpwrvgnd_1
XTAP_TAPCELL_ROW_245_4336 VGND VPWR sky130_fd_sc_hd__tapvpwrvgnd_1
XFILLER_4_875 VGND VGND VPWR VPWR sky130_fd_sc_hd__decap_6
XFILLER_158_1478 VGND VGND VPWR VPWR sky130_fd_sc_hd__decap_6
XFILLER_193_1358 VPWR VGND VPWR VGND sky130_ef_sc_hd__decap_12
XTAP_TAPCELL_ROW_245_4347 VGND VPWR sky130_fd_sc_hd__tapvpwrvgnd_1
XPHY_EDGE_ROW_5_Left_261 VGND VGND VPWR VPWR sky130_fd_sc_hd__decap_3
XFILLER_234_1355 VPWR VGND VPWR VGND sky130_ef_sc_hd__decap_12
XFILLER_239_424 VGND VGND VPWR VPWR sky130_fd_sc_hd__decap_6
XFILLER_230_1219 VGND VGND VPWR VPWR sky130_fd_sc_hd__decap_6
XTAP_TAPCELL_ROW_7_1114 VGND VPWR sky130_fd_sc_hd__tapvpwrvgnd_1
XTAP_TAPCELL_ROW_7_1125 VGND VPWR sky130_fd_sc_hd__tapvpwrvgnd_1
XTAP_TAPCELL_ROW_7_1136 VGND VPWR sky130_fd_sc_hd__tapvpwrvgnd_1
XFILLER_248_980 VPWR VGND VPWR VGND sky130_ef_sc_hd__decap_12
XFILLER_232_1090 VGND VGND VPWR VPWR sky130_fd_sc_hd__decap_6
XTAP_TAPCELL_ROW_239_4107 VGND VPWR sky130_fd_sc_hd__tapvpwrvgnd_1
XTAP_TAPCELL_ROW_239_4118 VGND VPWR sky130_fd_sc_hd__tapvpwrvgnd_1
XTAP_TAPCELL_ROW_239_4129 VGND VPWR sky130_fd_sc_hd__tapvpwrvgnd_1
XFILLER_78_1435 VGND VGND VPWR VPWR sky130_fd_sc_hd__decap_6
XFILLER_234_151 VPWR VGND VPWR VGND sky130_ef_sc_hd__decap_12
XFILLER_222_335 VPWR VGND VPWR VGND sky130_ef_sc_hd__decap_12
XFILLER_179_228 VPWR VGND VPWR VGND sky130_ef_sc_hd__decap_12
XFILLER_249_15 VPWR VGND VPWR VGND sky130_ef_sc_hd__decap_12
XFILLER_97_3 VPWR VGND VPWR VGND sky130_ef_sc_hd__decap_12
XFILLER_210_519 VPWR VGND VPWR VGND sky130_ef_sc_hd__decap_12
XFILLER_241_1315 VPWR VGND VPWR VGND sky130_ef_sc_hd__decap_12
XFILLER_203_560 VPWR VGND VPWR VGND sky130_ef_sc_hd__decap_12
XFILLER_37_1165 VPWR VGND VPWR VGND sky130_ef_sc_hd__decap_12
XFILLER_128_1282 VPWR VGND VPWR VGND sky130_ef_sc_hd__decap_12
XFILLER_175_412 VPWR VGND VPWR VGND sky130_ef_sc_hd__decap_12
XFILLER_187_283 VPWR VGND VPWR VGND sky130_ef_sc_hd__decap_12
XFILLER_230_390 VPWR VGND VPWR VGND sky130_ef_sc_hd__decap_12
XFILLER_176_968 VPWR VGND VPWR VGND sky130_ef_sc_hd__decap_12
XFILLER_102_1411 VPWR VGND VPWR VGND sky130_ef_sc_hd__decap_12
XFILLER_175_467 VGND VGND VPWR VPWR sky130_fd_sc_hd__decap_6
XFILLER_191_916 VPWR VGND VPWR VGND sky130_ef_sc_hd__decap_12
XFILLER_11_1316 VPWR VGND VPWR VGND sky130_ef_sc_hd__decap_12
XFILLER_200_1023 VPWR VGND VPWR VGND sky130_ef_sc_hd__decap_12
XFILLER_198_1269 VPWR VGND VPWR VGND sky130_ef_sc_hd__decap_12
XFILLER_102_1466 VPWR VGND VPWR VGND sky130_ef_sc_hd__decap_12
Xmax_cap333 net334 VGND VGND VPWR VPWR net333 sky130_fd_sc_hd__clkbuf_1
XFILLER_200_1078 VPWR VGND VPWR VGND sky130_ef_sc_hd__decap_12
XFILLER_137_1507 VGND VGND VPWR VPWR sky130_fd_sc_hd__decap_8
XFILLER_235_1119 VPWR VGND VPWR VGND sky130_ef_sc_hd__decap_12
XFILLER_252_1422 VPWR VGND VPWR VGND sky130_ef_sc_hd__decap_12
XFILLER_170_194 VPWR VGND VPWR VGND sky130_ef_sc_hd__decap_12
XFILLER_48_1294 VPWR VGND VPWR VGND sky130_ef_sc_hd__decap_12
XFILLER_135_1242 VGND VGND VPWR VPWR sky130_fd_sc_hd__decap_6
XFILLER_170_1133 VGND VGND VPWR VPWR sky130_fd_sc_hd__decap_6
XFILLER_252_1477 VGND VGND VPWR VPWR sky130_fd_sc_hd__decap_6
XFILLER_246_906 VPWR VGND VPWR VGND sky130_ef_sc_hd__decap_12
XTAP_TAPCELL_ROW_113_2_5566 VGND VPWR sky130_fd_sc_hd__tapvpwrvgnd_1
XFILLER_22_1423 VPWR VGND VPWR VGND sky130_ef_sc_hd__decap_12
XTAP_TAPCELL_ROW_81_2_5311 VGND VPWR sky130_fd_sc_hd__tapvpwrvgnd_1
XFILLER_27_27 VPWR VGND VPWR VGND sky130_ef_sc_hd__decap_12
XTAP_TAPCELL_ROW_49_2_5052 VGND VPWR sky130_fd_sc_hd__tapvpwrvgnd_1
XFILLER_211_1174 VPWR VGND VPWR VGND sky130_ef_sc_hd__decap_12
XPHY_EDGE_ROW_214_Right_59 VGND VGND VPWR VPWR sky130_fd_sc_hd__decap_3
XFILLER_254_961 VGND VGND VPWR VPWR sky130_fd_sc_hd__decap_6
XFILLER_22_1478 VGND VGND VPWR VPWR sky130_fd_sc_hd__decap_6
XFILLER_246_1226 VPWR VGND VPWR VGND sky130_ef_sc_hd__decap_12
XFILLER_213_302 VPWR VGND VPWR VGND sky130_ef_sc_hd__decap_12
XFILLER_225_173 VPWR VGND VPWR VGND sky130_ef_sc_hd__decap_12
XFILLER_0_1252 VGND VGND VPWR VPWR sky130_fd_sc_hd__decap_8
XFILLER_43_15 VPWR VGND VPWR VGND sky130_ef_sc_hd__decap_12
XFILLER_240_132 VPWR VGND VPWR VGND sky130_ef_sc_hd__decap_12
XFILLER_94_1270 VPWR VGND VPWR VGND sky130_ef_sc_hd__decap_12
XFILLER_213_357 VPWR VGND VPWR VGND sky130_ef_sc_hd__decap_12
XFILLER_59_1390 VPWR VGND VPWR VGND sky130_ef_sc_hd__decap_12
XTAP_TAPCELL_ROW_16_2_4793 VGND VPWR sky130_fd_sc_hd__tapvpwrvgnd_1
XFILLER_159_15 VPWR VGND VPWR VGND sky130_ef_sc_hd__decap_12
XFILLER_185_209 VGND VGND VPWR VPWR sky130_fd_sc_hd__decap_6
XFILLER_240_187 VGND VGND VPWR VPWR sky130_fd_sc_hd__decap_6
XFILLER_16_1227 VPWR VGND VPWR VGND sky130_ef_sc_hd__decap_12
XFILLER_178_261 VPWR VGND VPWR VGND sky130_ef_sc_hd__decap_12
XFILLER_194_710 VPWR VGND VPWR VGND sky130_ef_sc_hd__decap_12
XFILLER_181_1284 VGND VGND VPWR VPWR sky130_fd_sc_hd__decap_6
XFILLER_166_445 VGND VGND VPWR VPWR sky130_fd_sc_hd__decap_6
XFILLER_194_765 VPWR VGND VPWR VGND sky130_ef_sc_hd__decap_12
XFILLER_222_1281 VPWR VGND VPWR VGND sky130_ef_sc_hd__decap_12
XPHY_EDGE_ROW_223_Right_68 VGND VGND VPWR VPWR sky130_fd_sc_hd__decap_3
XFILLER_182_949 VPWR VGND VPWR VGND sky130_ef_sc_hd__decap_12
XFILLER_175_990 VPWR VGND VPWR VGND sky130_ef_sc_hd__decap_12
XFILLER_175_1033 VPWR VGND VPWR VGND sky130_ef_sc_hd__decap_12
XFILLER_68_34 VPWR VGND VPWR VGND sky130_ef_sc_hd__decap_12
XFILLER_175_1088 VPWR VGND VPWR VGND sky130_ef_sc_hd__decap_12
XFILLER_192_1391 VGND VGND VPWR VPWR sky130_fd_sc_hd__decap_6
XFILLER_231_1506 VGND VGND VPWR VPWR sky130_fd_sc_hd__decap_8
XFILLER_249_744 VPWR VGND VPWR VGND sky130_ef_sc_hd__decap_12
XFILLER_191_68 VPWR VGND VPWR VGND sky130_ef_sc_hd__decap_12
XFILLER_27_1378 VPWR VGND VPWR VGND sky130_ef_sc_hd__decap_12
XFILLER_114_1337 VPWR VGND VPWR VGND sky130_ef_sc_hd__decap_12
XFILLER_237_928 VPWR VGND VPWR VGND sky130_ef_sc_hd__decap_12
XFILLER_249_799 VPWR VGND VPWR VGND sky130_ef_sc_hd__decap_12
XPHY_EDGE_ROW_232_Right_77 VGND VGND VPWR VPWR sky130_fd_sc_hd__decap_3
XFILLER_84_22 VPWR VGND VPWR VGND sky130_ef_sc_hd__decap_12
XFILLER_5_1174 VPWR VGND VPWR VGND sky130_ef_sc_hd__decap_12
X_653_ clknet_3_7__leaf_clk acc_core.adder.cla_blocks\[4\].block.sum\[3\] _061_ VGND
+ VGND VPWR VPWR net53 sky130_fd_sc_hd__dfrtp_1
XTAP_TAPCELL_ROW_205_2940 VGND VPWR sky130_fd_sc_hd__tapvpwrvgnd_1
XTAP_TAPCELL_ROW_201_2804 VGND VPWR sky130_fd_sc_hd__tapvpwrvgnd_1
XFILLER_229_1413 VGND VGND VPWR VPWR sky130_fd_sc_hd__decap_6
XFILLER_245_983 VGND VGND VPWR VPWR sky130_fd_sc_hd__decap_6
XFILLER_186_1140 VPWR VGND VPWR VGND sky130_ef_sc_hd__decap_12
XFILLER_216_151 VPWR VGND VPWR VGND sky130_ef_sc_hd__decap_12
X_584_ net670 VGND VGND VPWR VPWR _066_ sky130_fd_sc_hd__inv_2
XFILLER_182_1004 VGND VGND VPWR VPWR sky130_fd_sc_hd__decap_6
XTAP_TAPCELL_ROW_253_4605 VGND VPWR sky130_fd_sc_hd__tapvpwrvgnd_1
XPHY_EDGE_ROW_121_2_Left_623 VGND VGND VPWR VPWR sky130_fd_sc_hd__decap_3
XTAP_TAPCELL_ROW_253_4616 VGND VPWR sky130_fd_sc_hd__tapvpwrvgnd_1
XFILLER_204_335 VPWR VGND VPWR VGND sky130_ef_sc_hd__decap_12
XTAP_TAPCELL_ROW_253_4627 VGND VPWR sky130_fd_sc_hd__tapvpwrvgnd_1
XFILLER_186_1195 VPWR VGND VPWR VGND sky130_ef_sc_hd__decap_12
XFILLER_231_154 VPWR VGND VPWR VGND sky130_ef_sc_hd__decap_12
XFILLER_220_839 VPWR VGND VPWR VGND sky130_ef_sc_hd__decap_12
XFILLER_38_1485 VPWR VGND VPWR VGND sky130_ef_sc_hd__decap_12
XFILLER_125_1433 VPWR VGND VPWR VGND sky130_ef_sc_hd__decap_12
XFILLER_160_1313 VPWR VGND VPWR VGND sky130_ef_sc_hd__decap_12
XFILLER_223_1045 VPWR VGND VPWR VGND sky130_ef_sc_hd__decap_12
XFILLER_169_283 VPWR VGND VPWR VGND sky130_ef_sc_hd__decap_12
XFILLER_185_732 VPWR VGND VPWR VGND sky130_ef_sc_hd__decap_12
XFILLER_212_390 VPWR VGND VPWR VGND sky130_ef_sc_hd__decap_12
XFILLER_34_1349 VGND VGND VPWR VPWR sky130_fd_sc_hd__decap_6
XPHY_EDGE_ROW_241_Right_86 VGND VGND VPWR VPWR sky130_fd_sc_hd__decap_3
XFILLER_9_967 VPWR VGND VPWR VGND sky130_ef_sc_hd__decap_12
XFILLER_125_1488 VPWR VGND VPWR VGND sky130_ef_sc_hd__decap_12
XFILLER_160_1368 VPWR VGND VPWR VGND sky130_ef_sc_hd__decap_12
XFILLER_173_916 VPWR VGND VPWR VGND sky130_ef_sc_hd__decap_12
XFILLER_200_574 VGND VGND VPWR VPWR sky130_fd_sc_hd__decap_6
XFILLER_185_787 VPWR VGND VPWR VGND sky130_ef_sc_hd__decap_12
XTAP_TAPCELL_ROW_247_4409 VGND VPWR sky130_fd_sc_hd__tapvpwrvgnd_1
XFILLER_158_1220 VGND VGND VPWR VPWR sky130_fd_sc_hd__decap_6
XFILLER_193_1100 VPWR VGND VPWR VGND sky130_ef_sc_hd__decap_12
XFILLER_197_1291 VPWR VGND VPWR VGND sky130_ef_sc_hd__decap_12
XFILLER_181_971 VPWR VGND VPWR VGND sky130_ef_sc_hd__decap_12
XTAP_TAPCELL_ROW_86_2_5348 VGND VPWR sky130_fd_sc_hd__tapvpwrvgnd_1
XFILLER_193_1155 VGND VGND VPWR VPWR sky130_fd_sc_hd__decap_6
XFILLER_235_39 VGND VGND VPWR VPWR sky130_fd_sc_hd__decap_4
XTAP_TAPCELL_ROW_130_2_5705 VGND VPWR sky130_fd_sc_hd__tapvpwrvgnd_1
XFILLER_171_1420 VPWR VGND VPWR VGND sky130_ef_sc_hd__decap_12
XFILLER_3_193 VGND VGND VPWR VPWR sky130_fd_sc_hd__fill_2
XTAP_TAPCELL_ROW_9_1209 VGND VPWR sky130_fd_sc_hd__tapvpwrvgnd_1
XFILLER_45_1445 VPWR VGND VPWR VGND sky130_ef_sc_hd__decap_12
XFILLER_80_1325 VPWR VGND VPWR VGND sky130_ef_sc_hd__decap_12
XFILLER_234_1152 VPWR VGND VPWR VGND sky130_ef_sc_hd__decap_12
XPHY_EDGE_ROW_250_Right_95 VGND VGND VPWR VPWR sky130_fd_sc_hd__decap_3
XFILLER_228_906 VPWR VGND VPWR VGND sky130_ef_sc_hd__decap_12
XFILLER_171_1475 VPWR VGND VPWR VGND sky130_ef_sc_hd__decap_12
XFILLER_251_27 VPWR VGND VPWR VGND sky130_ef_sc_hd__decap_12
XFILLER_255_736 VPWR VGND VPWR VGND sky130_ef_sc_hd__decap_12
XFILLER_12_3 VGND VGND VPWR VPWR sky130_fd_sc_hd__decap_8
XFILLER_255_769 VGND VGND VPWR VPWR sky130_fd_sc_hd__decap_8
XFILLER_236_961 VGND VGND VPWR VPWR sky130_fd_sc_hd__decap_6
XPHY_EDGE_ROW_53_2_Left_555 VGND VGND VPWR VPWR sky130_fd_sc_hd__decap_3
XFILLER_207_173 VPWR VGND VPWR VGND sky130_ef_sc_hd__decap_12
XFILLER_208_1508 VGND VGND VPWR VPWR sky130_fd_sc_hd__decap_6
XFILLER_39_1249 VPWR VGND VPWR VGND sky130_ef_sc_hd__decap_12
XFILLER_222_132 VPWR VGND VPWR VGND sky130_ef_sc_hd__decap_12
XFILLER_250_452 VPWR VGND VPWR VGND sky130_ef_sc_hd__decap_12
XFILLER_126_1208 VPWR VGND VPWR VGND sky130_ef_sc_hd__decap_12
XFILLER_91_1421 VPWR VGND VPWR VGND sky130_ef_sc_hd__decap_12
XFILLER_143_1500 VGND VGND VPWR VPWR sky130_fd_sc_hd__decap_6
XFILLER_241_1112 VGND VGND VPWR VPWR sky130_fd_sc_hd__decap_6
XFILLER_167_209 VGND VGND VPWR VPWR sky130_fd_sc_hd__decap_6
XFILLER_210_316 VGND VGND VPWR VPWR sky130_fd_sc_hd__decap_6
XFILLER_195_529 VPWR VGND VPWR VGND sky130_ef_sc_hd__decap_12
XFILLER_222_187 VGND VGND VPWR VPWR sky130_fd_sc_hd__decap_6
XPHY_EDGE_ROW_154_1_Right_810 VGND VGND VPWR VPWR sky130_fd_sc_hd__decap_3
XFILLER_176_710 VPWR VGND VPWR VGND sky130_ef_sc_hd__decap_12
XFILLER_91_1476 VPWR VGND VPWR VGND sky130_ef_sc_hd__decap_12
XFILLER_188_581 VPWR VGND VPWR VGND sky130_ef_sc_hd__decap_12
XFILLER_198_1011 VPWR VGND VPWR VGND sky130_ef_sc_hd__decap_12
XFILLER_176_765 VPWR VGND VPWR VGND sky130_ef_sc_hd__decap_12
XFILLER_191_713 VPWR VGND VPWR VGND sky130_ef_sc_hd__decap_12
XTAP_TAPCELL_ROW_215_3280 VGND VPWR sky130_fd_sc_hd__tapvpwrvgnd_1
XTAP_TAPCELL_ROW_170_1701 VGND VPWR sky130_fd_sc_hd__tapvpwrvgnd_1
XFILLER_198_1066 VPWR VGND VPWR VGND sky130_ef_sc_hd__decap_12
XTAP_TAPCELL_ROW_215_3291 VGND VPWR sky130_fd_sc_hd__tapvpwrvgnd_1
XTAP_TAPCELL_ROW_170_1712 VGND VPWR sky130_fd_sc_hd__tapvpwrvgnd_1
XTAP_TAPCELL_ROW_211_3133 VGND VPWR sky130_fd_sc_hd__tapvpwrvgnd_1
XFILLER_50_1184 VPWR VGND VPWR VGND sky130_ef_sc_hd__decap_12
XTAP_TAPCELL_ROW_170_1723 VGND VPWR sky130_fd_sc_hd__tapvpwrvgnd_1
XTAP_TAPCELL_ROW_211_3144 VGND VPWR sky130_fd_sc_hd__tapvpwrvgnd_1
XFILLER_102_1263 VGND VGND VPWR VPWR sky130_fd_sc_hd__decap_6
XFILLER_191_768 VGND VGND VPWR VPWR sky130_fd_sc_hd__decap_6
XTAP_TAPCELL_ROW_211_3155 VGND VPWR sky130_fd_sc_hd__tapvpwrvgnd_1
Xmax_cap130 _200_ VGND VGND VPWR VPWR net130 sky130_fd_sc_hd__clkbuf_1
XTAP_TAPCELL_ROW_230_3789 VGND VPWR sky130_fd_sc_hd__tapvpwrvgnd_1
Xmax_cap141 net142 VGND VGND VPWR VPWR net141 sky130_fd_sc_hd__clkbuf_1
XFILLER_137_1304 VPWR VGND VPWR VGND sky130_ef_sc_hd__decap_12
Xmax_cap152 net153 VGND VGND VPWR VPWR net152 sky130_fd_sc_hd__clkbuf_1
Xmax_cap163 net164 VGND VGND VPWR VPWR net163 sky130_fd_sc_hd__clkbuf_1
Xmax_cap174 _117_ VGND VGND VPWR VPWR net174 sky130_fd_sc_hd__clkbuf_1
XFILLER_145_39 VGND VGND VPWR VPWR sky130_fd_sc_hd__decap_4
Xmax_cap185 net186 VGND VGND VPWR VPWR net185 sky130_fd_sc_hd__clkbuf_1
Xmax_cap196 _214_ VGND VGND VPWR VPWR net196 sky130_fd_sc_hd__clkbuf_1
XFILLER_137_1359 VPWR VGND VPWR VGND sky130_ef_sc_hd__decap_12
XPHY_EDGE_ROW_67_1_Left_322 VGND VGND VPWR VPWR sky130_fd_sc_hd__decap_3
XTAP_TAPCELL_ROW_168_1630 VGND VPWR sky130_fd_sc_hd__tapvpwrvgnd_1
XFILLER_38_15 VGND VGND VPWR VPWR sky130_fd_sc_hd__decap_6
XTAP_TAPCELL_ROW_26_1_1269 VGND VPWR sky130_fd_sc_hd__tapvpwrvgnd_1
XTAP_TAPCELL_ROW_168_1641 VGND VPWR sky130_fd_sc_hd__tapvpwrvgnd_1
XTAP_TAPCELL_ROW_209_3062 VGND VPWR sky130_fd_sc_hd__tapvpwrvgnd_1
XTAP_TAPCELL_ROW_168_1652 VGND VPWR sky130_fd_sc_hd__tapvpwrvgnd_1
XTAP_TAPCELL_ROW_209_3073 VGND VPWR sky130_fd_sc_hd__tapvpwrvgnd_1
XFILLER_246_703 VGND VGND VPWR VPWR sky130_fd_sc_hd__decap_6
XTAP_TAPCELL_ROW_209_3084 VGND VPWR sky130_fd_sc_hd__tapvpwrvgnd_1
XFILLER_219_928 VPWR VGND VPWR VGND sky130_ef_sc_hd__decap_12
XFILLER_161_27 VPWR VGND VPWR VGND sky130_ef_sc_hd__decap_12
XFILLER_22_1220 VGND VGND VPWR VPWR sky130_fd_sc_hd__decap_6
XFILLER_2_1336 VPWR VGND VPWR VGND sky130_ef_sc_hd__decap_12
XFILLER_227_983 VGND VGND VPWR VPWR sky130_fd_sc_hd__decap_6
XFILLER_148_1411 VPWR VGND VPWR VGND sky130_ef_sc_hd__decap_12
XFILLER_246_1023 VPWR VGND VPWR VGND sky130_ef_sc_hd__decap_12
XFILLER_57_1316 VPWR VGND VPWR VGND sky130_ef_sc_hd__decap_12
XFILLER_198_323 VPWR VGND VPWR VGND sky130_ef_sc_hd__decap_12
XFILLER_148_1466 VPWR VGND VPWR VGND sky130_ef_sc_hd__decap_12
XFILLER_183_1346 VPWR VGND VPWR VGND sky130_ef_sc_hd__decap_12
XTAP_TAPCELL_ROW_79_2_5291 VGND VPWR sky130_fd_sc_hd__tapvpwrvgnd_1
XFILLER_246_1078 VPWR VGND VPWR VGND sky130_ef_sc_hd__decap_12
XFILLER_213_154 VPWR VGND VPWR VGND sky130_ef_sc_hd__decap_12
XFILLER_241_474 VPWR VGND VPWR VGND sky130_ef_sc_hd__decap_12
XFILLER_0_1093 VPWR VGND VPWR VGND sky130_ef_sc_hd__decap_12
XFILLER_186_507 VPWR VGND VPWR VGND sky130_ef_sc_hd__decap_12
XFILLER_202_839 VPWR VGND VPWR VGND sky130_ef_sc_hd__decap_12
XFILLER_198_378 VPWR VGND VPWR VGND sky130_ef_sc_hd__decap_12
XFILLER_201_338 VGND VGND VPWR VPWR sky130_fd_sc_hd__decap_6
XFILLER_167_732 VPWR VGND VPWR VGND sky130_ef_sc_hd__decap_12
XFILLER_70_46 VPWR VGND VPWR VGND sky130_ef_sc_hd__decap_12
XFILLER_220_1207 VPWR VGND VPWR VGND sky130_ef_sc_hd__decap_12
XFILLER_224_1398 VPWR VGND VPWR VGND sky130_ef_sc_hd__decap_12
XFILLER_186_46 VPWR VGND VPWR VGND sky130_ef_sc_hd__decap_12
XFILLER_194_562 VPWR VGND VPWR VGND sky130_ef_sc_hd__decap_12
XFILLER_210_894 VPWR VGND VPWR VGND sky130_ef_sc_hd__decap_12
XFILLER_167_787 VPWR VGND VPWR VGND sky130_ef_sc_hd__decap_12
XFILLER_33_1371 VGND VGND VPWR VPWR sky130_fd_sc_hd__decap_6
XFILLER_6_937 VPWR VGND VPWR VGND sky130_ef_sc_hd__decap_12
XFILLER_214_3 VPWR VGND VPWR VGND sky130_ef_sc_hd__decap_12
XFILLER_182_746 VGND VGND VPWR VPWR sky130_fd_sc_hd__decap_6
XTAP_TAPCELL_ROW_72_2_5234 VGND VPWR sky130_fd_sc_hd__tapvpwrvgnd_1
XFILLER_68_1423 VPWR VGND VPWR VGND sky130_ef_sc_hd__decap_12
XFILLER_5_469 VGND VGND VPWR VPWR sky130_fd_sc_hd__fill_1
XFILLER_79_44 VPWR VGND VPWR VGND sky130_ef_sc_hd__decap_12
XFILLER_194_1453 VPWR VGND VPWR VGND sky130_ef_sc_hd__decap_12
XFILLER_68_1478 VGND VGND VPWR VPWR sky130_fd_sc_hd__decap_6
XTAP_TAPCELL_ROW_38_2_4969 VGND VPWR sky130_fd_sc_hd__tapvpwrvgnd_1
XFILLER_231_1303 VPWR VGND VPWR VGND sky130_ef_sc_hd__decap_12
XFILLER_249_541 VPWR VGND VPWR VGND sky130_ef_sc_hd__decap_12
XFILLER_118_1270 VPWR VGND VPWR VGND sky130_ef_sc_hd__decap_12
XFILLER_231_1358 VPWR VGND VPWR VGND sky130_ef_sc_hd__decap_12
XFILLER_237_725 VGND VGND VPWR VPWR sky130_fd_sc_hd__decap_6
XFILLER_249_596 VGND VGND VPWR VPWR sky130_fd_sc_hd__decap_6
XTAP_TAPCELL_ROW_180_2041 VGND VPWR sky130_fd_sc_hd__tapvpwrvgnd_1
XTAP_TAPCELL_ROW_180_2052 VGND VPWR sky130_fd_sc_hd__tapvpwrvgnd_1
XFILLER_218_961 VGND VGND VPWR VPWR sky130_fd_sc_hd__decap_6
XTAP_TAPCELL_ROW_180_2063 VGND VPWR sky130_fd_sc_hd__tapvpwrvgnd_1
XFILLER_251_216 VPWR VGND VPWR VGND sky130_ef_sc_hd__decap_12
X_636_ clknet_3_3__leaf_clk acc_core.adder.cla_blocks\[0\].block.sum\[2\] _044_ VGND
+ VGND VPWR VPWR net65 sky130_fd_sc_hd__dfrtp_1
X_567_ net666 VGND VGND VPWR VPWR _049_ sky130_fd_sc_hd__inv_2
XFILLER_204_132 VPWR VGND VPWR VGND sky130_ef_sc_hd__decap_12
XFILLER_189_345 VPWR VGND VPWR VGND sky130_ef_sc_hd__decap_12
XFILLER_232_452 VPWR VGND VPWR VGND sky130_ef_sc_hd__decap_12
XFILLER_242_1410 VPWR VGND VPWR VGND sky130_ef_sc_hd__decap_12
XFILLER_220_636 VPWR VGND VPWR VGND sky130_ef_sc_hd__decap_12
X_498_ net143 net84 VGND VGND VPWR VPWR acc_core.adder.cla_blocks\[5\].block.sum\[1\]
+ sky130_fd_sc_hd__xor2_1
XFILLER_177_529 VPWR VGND VPWR VGND sky130_ef_sc_hd__decap_12
XFILLER_204_187 VGND VGND VPWR VPWR sky130_fd_sc_hd__decap_6
XFILLER_38_1282 VPWR VGND VPWR VGND sky130_ef_sc_hd__decap_12
XFILLER_125_1230 VPWR VGND VPWR VGND sky130_ef_sc_hd__decap_12
XFILLER_242_1465 VPWR VGND VPWR VGND sky130_ef_sc_hd__decap_12
XFILLER_201_861 VPWR VGND VPWR VGND sky130_ef_sc_hd__decap_12
XFILLER_8_241 VGND VGND VPWR VPWR sky130_fd_sc_hd__fill_1
XFILLER_125_1285 VGND VGND VPWR VPWR sky130_fd_sc_hd__decap_6
XFILLER_160_1165 VPWR VGND VPWR VGND sky130_ef_sc_hd__decap_12
XFILLER_173_713 VPWR VGND VPWR VGND sky130_ef_sc_hd__decap_12
XFILLER_12_1411 VPWR VGND VPWR VGND sky130_ef_sc_hd__decap_12
XFILLER_185_584 VPWR VGND VPWR VGND sky130_ef_sc_hd__decap_12
XPHY_EDGE_ROW_229_Left_484 VGND VGND VPWR VPWR sky130_fd_sc_hd__decap_3
XFILLER_195_1217 VPWR VGND VPWR VGND sky130_ef_sc_hd__decap_12
XFILLER_201_1162 VPWR VGND VPWR VGND sky130_ef_sc_hd__decap_12
XFILLER_173_768 VGND VGND VPWR VPWR sky130_fd_sc_hd__decap_6
XFILLER_12_1466 VPWR VGND VPWR VGND sky130_ef_sc_hd__decap_12
XFILLER_5_30 VPWR VGND VPWR VGND sky130_ef_sc_hd__decap_12
XFILLER_47_1507 VGND VGND VPWR VPWR sky130_fd_sc_hd__decap_8
XFILLER_236_1269 VPWR VGND VPWR VGND sky130_ef_sc_hd__decap_12
XFILLER_45_1242 VGND VGND VPWR VPWR sky130_fd_sc_hd__decap_6
XFILLER_228_703 VGND VGND VPWR VPWR sky130_fd_sc_hd__decap_6
XFILLER_136_1392 VGND VGND VPWR VPWR sky130_fd_sc_hd__decap_6
XFILLER_171_1272 VPWR VGND VPWR VGND sky130_ef_sc_hd__decap_12
XFILLER_80_1177 VGND VGND VPWR VPWR sky130_fd_sc_hd__decap_6
XTAP_TAPCELL_ROW_160_2_5944 VGND VPWR sky130_fd_sc_hd__tapvpwrvgnd_1
XPHY_EDGE_ROW_238_Left_493 VGND VGND VPWR VPWR sky130_fd_sc_hd__decap_3
XTAP_TAPCELL_ROW_223_3560 VGND VPWR sky130_fd_sc_hd__tapvpwrvgnd_1
XTAP_TAPCELL_ROW_223_3571 VGND VPWR sky130_fd_sc_hd__tapvpwrvgnd_1
XTAP_TAPCELL_ROW_128_2_5685 VGND VPWR sky130_fd_sc_hd__tapvpwrvgnd_1
XTAP_TAPCELL_ROW_96_2_5430 VGND VPWR sky130_fd_sc_hd__tapvpwrvgnd_1
XFILLER_209_983 VGND VGND VPWR VPWR sky130_fd_sc_hd__decap_6
XFILLER_242_249 VPWR VGND VPWR VGND sky130_ef_sc_hd__decap_12
XFILLER_165_1021 VGND VGND VPWR VPWR sky130_fd_sc_hd__decap_8
XFILLER_208_1305 VGND VGND VPWR VPWR sky130_fd_sc_hd__decap_6
XFILLER_180_1508 VGND VGND VPWR VPWR sky130_fd_sc_hd__decap_6
XFILLER_211_603 VPWR VGND VPWR VGND sky130_ef_sc_hd__decap_12
XFILLER_243_1229 VPWR VGND VPWR VGND sky130_ef_sc_hd__decap_12
XFILLER_223_474 VPWR VGND VPWR VGND sky130_ef_sc_hd__decap_12
XFILLER_168_507 VPWR VGND VPWR VGND sky130_ef_sc_hd__decap_12
XTAP_TAPCELL_ROW_176_1910 VGND VPWR sky130_fd_sc_hd__tapvpwrvgnd_1
XFILLER_195_326 VPWR VGND VPWR VGND sky130_ef_sc_hd__decap_12
XFILLER_211_658 VPWR VGND VPWR VGND sky130_ef_sc_hd__decap_12
XTAP_TAPCELL_ROW_121_2_5628 VGND VPWR sky130_fd_sc_hd__tapvpwrvgnd_1
XTAP_TAPCELL_ROW_176_1921 VGND VPWR sky130_fd_sc_hd__tapvpwrvgnd_1
XTAP_TAPCELL_ROW_217_3342 VGND VPWR sky130_fd_sc_hd__tapvpwrvgnd_1
XFILLER_91_1273 VPWR VGND VPWR VGND sky130_ef_sc_hd__decap_12
XTAP_TAPCELL_ROW_176_1932 VGND VPWR sky130_fd_sc_hd__tapvpwrvgnd_1
XTAP_TAPCELL_ROW_217_3353 VGND VPWR sky130_fd_sc_hd__tapvpwrvgnd_1
XPHY_EDGE_ROW_155_1_Right_811 VGND VGND VPWR VPWR sky130_fd_sc_hd__decap_3
XTAP_TAPCELL_ROW_217_3364 VGND VPWR sky130_fd_sc_hd__tapvpwrvgnd_1
XTAP_TAPCELL_ROW_213_3206 VGND VPWR sky130_fd_sc_hd__tapvpwrvgnd_1
XFILLER_104_1325 VPWR VGND VPWR VGND sky130_ef_sc_hd__decap_12
XTAP_TAPCELL_ROW_213_3217 VGND VPWR sky130_fd_sc_hd__tapvpwrvgnd_1
XTAP_TAPCELL_ROW_57_2_5114 VGND VPWR sky130_fd_sc_hd__tapvpwrvgnd_1
XFILLER_176_562 VPWR VGND VPWR VGND sky130_ef_sc_hd__decap_12
XTAP_TAPCELL_ROW_213_3228 VGND VPWR sky130_fd_sc_hd__tapvpwrvgnd_1
XFILLER_191_510 VGND VGND VPWR VPWR sky130_fd_sc_hd__decap_6
XFILLER_219_1401 VPWR VGND VPWR VGND sky130_ef_sc_hd__decap_12
XTAP_TAPCELL_ROW_24_2_4855 VGND VPWR sky130_fd_sc_hd__tapvpwrvgnd_1
XFILLER_254_1336 VPWR VGND VPWR VGND sky130_ef_sc_hd__decap_12
XFILLER_219_1456 VGND VGND VPWR VPWR sky130_fd_sc_hd__decap_6
XFILLER_176_1183 VPWR VGND VPWR VGND sky130_ef_sc_hd__decap_12
XFILLER_172_15 VGND VGND VPWR VPWR sky130_fd_sc_hd__decap_6
XFILLER_172_1047 VGND VGND VPWR VPWR sky130_fd_sc_hd__decap_6
XFILLER_137_1189 VPWR VGND VPWR VGND sky130_ef_sc_hd__decap_12
XFILLER_115_1421 VPWR VGND VPWR VGND sky130_ef_sc_hd__decap_12
XFILLER_213_1033 VPWR VGND VPWR VGND sky130_ef_sc_hd__decap_12
XFILLER_219_725 VGND VGND VPWR VPWR sky130_fd_sc_hd__decap_6
XFILLER_24_1337 VPWR VGND VPWR VGND sky130_ef_sc_hd__decap_12
XFILLER_115_1476 VPWR VGND VPWR VGND sky130_ef_sc_hd__decap_12
XFILLER_150_1356 VPWR VGND VPWR VGND sky130_ef_sc_hd__decap_12
XFILLER_213_1088 VPWR VGND VPWR VGND sky130_ef_sc_hd__decap_12
XTAP_TAPCELL_ROW_2_940 VGND VPWR sky130_fd_sc_hd__tapvpwrvgnd_1
XTAP_TAPCELL_ROW_2_951 VGND VPWR sky130_fd_sc_hd__tapvpwrvgnd_1
XFILLER_230_1391 VGND VGND VPWR VPWR sky130_fd_sc_hd__decap_6
XFILLER_65_68 VGND VGND VPWR VPWR sky130_fd_sc_hd__decap_3
XFILLER_2_1133 VGND VGND VPWR VPWR sky130_fd_sc_hd__decap_6
XTAP_TAPCELL_ROW_2_962 VGND VPWR sky130_fd_sc_hd__tapvpwrvgnd_1
XFILLER_233_216 VPWR VGND VPWR VGND sky130_ef_sc_hd__decap_12
XFILLER_164_3 VPWR VGND VPWR VGND sky130_ef_sc_hd__decap_12
X_421_ net105 net119 net171 net127 VGND VGND VPWR VPWR _210_ sky130_fd_sc_hd__a211o_1
XFILLER_96_1184 VPWR VGND VPWR VGND sky130_ef_sc_hd__decap_12
XFILLER_198_120 VPWR VGND VPWR VGND sky130_ef_sc_hd__decap_12
XFILLER_214_452 VPWR VGND VPWR VGND sky130_ef_sc_hd__decap_12
XFILLER_148_1263 VGND VGND VPWR VPWR sky130_fd_sc_hd__decap_6
XFILLER_183_1143 VPWR VGND VPWR VGND sky130_ef_sc_hd__decap_12
XFILLER_241_271 VPWR VGND VPWR VGND sky130_ef_sc_hd__decap_12
X_352_ net335 VGND VGND VPWR VPWR _141_ sky130_fd_sc_hd__inv_2
XFILLER_186_304 VPWR VGND VPWR VGND sky130_ef_sc_hd__decap_12
XFILLER_202_636 VPWR VGND VPWR VGND sky130_ef_sc_hd__decap_12
XFILLER_81_56 VPWR VGND VPWR VGND sky130_ef_sc_hd__decap_12
XFILLER_198_175 VPWR VGND VPWR VGND sky130_ef_sc_hd__decap_12
XFILLER_183_1198 VGND VGND VPWR VPWR sky130_fd_sc_hd__decap_6
XFILLER_70_1313 VPWR VGND VPWR VGND sky130_ef_sc_hd__decap_12
XFILLER_35_1433 VPWR VGND VPWR VGND sky130_ef_sc_hd__decap_12
XFILLER_224_1140 VPWR VGND VPWR VGND sky130_ef_sc_hd__decap_12
XFILLER_197_56 VPWR VGND VPWR VGND sky130_ef_sc_hd__decap_12
X_283_ net624 VGND VGND VPWR VPWR web0 sky130_fd_sc_hd__inv_2
XFILLER_186_359 VGND VGND VPWR VPWR sky130_fd_sc_hd__decap_6
XFILLER_220_1004 VGND VGND VPWR VPWR sky130_fd_sc_hd__decap_6
XFILLER_70_1368 VPWR VGND VPWR VGND sky130_ef_sc_hd__decap_12
XFILLER_35_1488 VPWR VGND VPWR VGND sky130_ef_sc_hd__decap_12
XFILLER_224_1195 VPWR VGND VPWR VGND sky130_ef_sc_hd__decap_12
XFILLER_167_584 VPWR VGND VPWR VGND sky130_ef_sc_hd__decap_12
XFILLER_210_691 VPWR VGND VPWR VGND sky130_ef_sc_hd__decap_12
XTAP_TAPCELL_ROW_192_2490 VGND VPWR sky130_fd_sc_hd__tapvpwrvgnd_1
XFILLER_68_1220 VGND VGND VPWR VPWR sky130_fd_sc_hd__decap_6
XFILLER_194_1250 VPWR VGND VPWR VGND sky130_ef_sc_hd__decap_12
XTAP_TAPCELL_ROW_186_2250 VGND VPWR sky130_fd_sc_hd__tapvpwrvgnd_1
XTAP_TAPCELL_ROW_186_2261 VGND VPWR sky130_fd_sc_hd__tapvpwrvgnd_1
XTAP_TAPCELL_ROW_186_2272 VGND VPWR sky130_fd_sc_hd__tapvpwrvgnd_1
XFILLER_231_1100 VPWR VGND VPWR VGND sky130_ef_sc_hd__decap_12
XTAP_TAPCELL_ROW_145_2_5824 VGND VPWR sky130_fd_sc_hd__tapvpwrvgnd_1
XTAP_TAPCELL_ROW_182_2114 VGND VPWR sky130_fd_sc_hd__tapvpwrvgnd_1
XFILLER_81_1464 VPWR VGND VPWR VGND sky130_ef_sc_hd__decap_12
XTAP_TAPCELL_ROW_186_2283 VGND VPWR sky130_fd_sc_hd__tapvpwrvgnd_1
XFILLER_235_1291 VPWR VGND VPWR VGND sky130_ef_sc_hd__decap_12
XFILLER_7_1033 VPWR VGND VPWR VGND sky130_ef_sc_hd__decap_12
XFILLER_1_494 VGND VGND VPWR VPWR sky130_fd_sc_hd__fill_1
XTAP_TAPCELL_ROW_182_2125 VGND VPWR sky130_fd_sc_hd__tapvpwrvgnd_1
XTAP_TAPCELL_ROW_114_2_5571 VGND VPWR sky130_fd_sc_hd__tapvpwrvgnd_1
XTAP_TAPCELL_ROW_182_2136 VGND VPWR sky130_fd_sc_hd__tapvpwrvgnd_1
XFILLER_231_1155 VGND VGND VPWR VPWR sky130_fd_sc_hd__decap_6
Xinput9 wr_addr[7] VGND VGND VPWR VPWR net9 sky130_fd_sc_hd__clkbuf_1
XFILLER_7_1088 VPWR VGND VPWR VGND sky130_ef_sc_hd__decap_12
XFILLER_188_1054 VPWR VGND VPWR VGND sky130_ef_sc_hd__decap_12
XFILLER_79_1371 VGND VGND VPWR VPWR sky130_fd_sc_hd__decap_6
XFILLER_224_249 VPWR VGND VPWR VGND sky130_ef_sc_hd__decap_12
XTAP_TAPCELL_ROW_63_2_5168 VGND VPWR sky130_fd_sc_hd__tapvpwrvgnd_1
X_619_ clknet_3_7__leaf_clk dout0\[17\] _027_ VGND VGND VPWR VPWR dout0_q\[17\] sky130_fd_sc_hd__dfrtp_1
XFILLER_36_1208 VPWR VGND VPWR VGND sky130_ef_sc_hd__decap_12
XTAP_TAPCELL_ROW_106_2_5508 VGND VPWR sky130_fd_sc_hd__tapvpwrvgnd_1
XFILLER_189_142 VPWR VGND VPWR VGND sky130_ef_sc_hd__decap_12
XFILLER_205_474 VPWR VGND VPWR VGND sky130_ef_sc_hd__decap_12
XFILLER_53_1500 VGND VGND VPWR VPWR sky130_fd_sc_hd__decap_6
XFILLER_127_1347 VPWR VGND VPWR VGND sky130_ef_sc_hd__decap_12
XFILLER_162_1227 VPWR VGND VPWR VGND sky130_ef_sc_hd__decap_12
XFILLER_177_326 VPWR VGND VPWR VGND sky130_ef_sc_hd__decap_12
XFILLER_220_433 VPWR VGND VPWR VGND sky130_ef_sc_hd__decap_12
XFILLER_189_197 VPWR VGND VPWR VGND sky130_ef_sc_hd__decap_12
XFILLER_242_1262 VGND VGND VPWR VPWR sky130_fd_sc_hd__decap_6
XTAP_TAPCELL_ROW_30_2_4898 VGND VPWR sky130_fd_sc_hd__tapvpwrvgnd_1
XFILLER_220_488 VGND VGND VPWR VPWR sky130_fd_sc_hd__decap_6
XFILLER_186_882 VPWR VGND VPWR VGND sky130_ef_sc_hd__decap_12
XFILLER_173_510 VGND VGND VPWR VPWR sky130_fd_sc_hd__decap_6
XFILLER_185_381 VGND VGND VPWR VPWR sky130_fd_sc_hd__decap_6
XTAP_TAPCELL_ROW_231_3840 VGND VPWR sky130_fd_sc_hd__tapvpwrvgnd_1
XTAP_TAPCELL_ROW_231_3851 VGND VPWR sky130_fd_sc_hd__tapvpwrvgnd_1
XTAP_TAPCELL_ROW_10_2_4741 VGND VPWR sky130_fd_sc_hd__tapvpwrvgnd_1
XFILLER_195_1014 VPWR VGND VPWR VGND sky130_ef_sc_hd__decap_12
XFILLER_12_1263 VGND VGND VPWR VPWR sky130_fd_sc_hd__decap_6
XFILLER_195_1069 VGND VGND VPWR VPWR sky130_fd_sc_hd__decap_6
XFILLER_47_1304 VPWR VGND VPWR VGND sky130_ef_sc_hd__decap_12
XFILLER_236_1011 VPWR VGND VPWR VGND sky130_ef_sc_hd__decap_12
XFILLER_138_1454 VPWR VGND VPWR VGND sky130_ef_sc_hd__decap_12
XFILLER_173_1334 VPWR VGND VPWR VGND sky130_ef_sc_hd__decap_12
XFILLER_82_1239 VPWR VGND VPWR VGND sky130_ef_sc_hd__decap_12
XFILLER_236_1066 VPWR VGND VPWR VGND sky130_ef_sc_hd__decap_12
XFILLER_47_1359 VPWR VGND VPWR VGND sky130_ef_sc_hd__decap_12
XTAP_TAPCELL_ROW_229_3780 VGND VPWR sky130_fd_sc_hd__tapvpwrvgnd_1
XFILLER_173_1389 VPWR VGND VPWR VGND sky130_ef_sc_hd__decap_12
XTAP_TAPCELL_ROW_225_3622 VGND VPWR sky130_fd_sc_hd__tapvpwrvgnd_1
XPHY_EDGE_ROW_246_Left_501 VGND VGND VPWR VPWR sky130_fd_sc_hd__decap_3
XTAP_TAPCELL_ROW_225_3633 VGND VPWR sky130_fd_sc_hd__tapvpwrvgnd_1
XTAP_TAPCELL_ROW_225_3644 VGND VPWR sky130_fd_sc_hd__tapvpwrvgnd_1
XFILLER_19_39 VGND VGND VPWR VPWR sky130_fd_sc_hd__decap_4
XTAP_TAPCELL_ROW_221_3508 VGND VPWR sky130_fd_sc_hd__tapvpwrvgnd_1
XFILLER_3_1420 VPWR VGND VPWR VGND sky130_ef_sc_hd__decap_12
XFILLER_215_216 VPWR VGND VPWR VGND sky130_ef_sc_hd__decap_12
XFILLER_58_1411 VPWR VGND VPWR VGND sky130_ef_sc_hd__decap_12
XFILLER_3_1475 VPWR VGND VPWR VGND sky130_ef_sc_hd__decap_12
XFILLER_35_27 VPWR VGND VPWR VGND sky130_ef_sc_hd__decap_12
XFILLER_247_1162 VPWR VGND VPWR VGND sky130_ef_sc_hd__decap_12
XFILLER_184_1441 VPWR VGND VPWR VGND sky130_ef_sc_hd__decap_12
XTAP_TAPCELL_ROW_219_3404 VGND VPWR sky130_fd_sc_hd__tapvpwrvgnd_1
XFILLER_93_1335 VPWR VGND VPWR VGND sky130_ef_sc_hd__decap_12
XTAP_TAPCELL_ROW_219_3415 VGND VPWR sky130_fd_sc_hd__tapvpwrvgnd_1
XFILLER_58_1466 VPWR VGND VPWR VGND sky130_ef_sc_hd__decap_12
XFILLER_145_1414 VGND VGND VPWR VPWR sky130_fd_sc_hd__decap_6
XTAP_TAPCELL_ROW_219_3426 VGND VPWR sky130_fd_sc_hd__tapvpwrvgnd_1
XFILLER_180_1305 VGND VGND VPWR VPWR sky130_fd_sc_hd__decap_6
XFILLER_211_400 VPWR VGND VPWR VGND sky130_ef_sc_hd__decap_12
XTAP_TAPCELL_ROW_219_3437 VGND VPWR sky130_fd_sc_hd__tapvpwrvgnd_1
XFILLER_243_1026 VGND VGND VPWR VPWR sky130_fd_sc_hd__decap_6
XFILLER_168_304 VPWR VGND VPWR VGND sky130_ef_sc_hd__decap_12
XFILLER_223_271 VPWR VGND VPWR VGND sky130_ef_sc_hd__decap_12
XFILLER_196_624 VPWR VGND VPWR VGND sky130_ef_sc_hd__decap_12
XPHY_EDGE_ROW_16_2_Left_518 VGND VGND VPWR VPWR sky130_fd_sc_hd__decap_3
XFILLER_184_1496 VPWR VGND VPWR VGND sky130_ef_sc_hd__decap_12
XPHY_EDGE_ROW_255_Left_510 VGND VGND VPWR VPWR sky130_fd_sc_hd__decap_3
XFILLER_195_123 VGND VGND VPWR VPWR sky130_fd_sc_hd__decap_6
XFILLER_51_15 VPWR VGND VPWR VGND sky130_ef_sc_hd__decap_12
XFILLER_211_455 VPWR VGND VPWR VGND sky130_ef_sc_hd__decap_12
XFILLER_168_359 VGND VGND VPWR VPWR sky130_fd_sc_hd__decap_6
XFILLER_184_808 VPWR VGND VPWR VGND sky130_ef_sc_hd__decap_12
XFILLER_196_679 VPWR VGND VPWR VGND sky130_ef_sc_hd__decap_12
Xwire407 net408 VGND VGND VPWR VPWR net407 sky130_fd_sc_hd__clkbuf_1
XFILLER_51_48 VGND VGND VPWR VPWR sky130_fd_sc_hd__fill_1
Xwire418 net419 VGND VGND VPWR VPWR net418 sky130_fd_sc_hd__clkbuf_1
XFILLER_167_15 VPWR VGND VPWR VGND sky130_ef_sc_hd__decap_12
Xwire429 net430 VGND VGND VPWR VPWR net429 sky130_fd_sc_hd__clkbuf_1
XPHY_EDGE_ROW_156_1_Right_812 VGND VGND VPWR VPWR sky130_fd_sc_hd__decap_3
XFILLER_221_1346 VPWR VGND VPWR VGND sky130_ef_sc_hd__decap_12
XPHY_EDGE_ROW_99_2_Right_190 VGND VGND VPWR VPWR sky130_fd_sc_hd__decap_3
XFILLER_104_1177 VGND VGND VPWR VPWR sky130_fd_sc_hd__decap_6
XFILLER_192_863 VPWR VGND VPWR VGND sky130_ef_sc_hd__decap_12
XTAP_TAPCELL_ROW_151_2_5867 VGND VPWR sky130_fd_sc_hd__tapvpwrvgnd_1
XFILLER_139_1218 VPWR VGND VPWR VGND sky130_ef_sc_hd__decap_12
XFILLER_174_1109 VPWR VGND VPWR VGND sky130_ef_sc_hd__decap_12
XFILLER_191_1401 VPWR VGND VPWR VGND sky130_ef_sc_hd__decap_12
XFILLER_254_1133 VGND VGND VPWR VPWR sky130_fd_sc_hd__decap_6
XFILLER_2_225 VGND VGND VPWR VPWR sky130_fd_sc_hd__decap_8
XTAP_TAPCELL_ROW_131_2_5710 VGND VPWR sky130_fd_sc_hd__tapvpwrvgnd_1
XPHY_EDGE_ROW_130_2_Left_632 VGND VGND VPWR VPWR sky130_fd_sc_hd__decap_3
XFILLER_191_1456 VGND VGND VPWR VPWR sky130_fd_sc_hd__decap_6
XFILLER_28_1270 VPWR VGND VPWR VGND sky130_ef_sc_hd__decap_12
XPHY_EDGE_ROW_173_Right_18 VGND VGND VPWR VPWR sky130_fd_sc_hd__decap_3
XFILLER_76_34 VPWR VGND VPWR VGND sky130_ef_sc_hd__decap_12
XFILLER_232_1453 VPWR VGND VPWR VGND sky130_ef_sc_hd__decap_12
XFILLER_247_842 VPWR VGND VPWR VGND sky130_ef_sc_hd__decap_12
XTAP_TAPCELL_ROW_241_4180 VGND VPWR sky130_fd_sc_hd__tapvpwrvgnd_1
Xfanout595 net598 VGND VGND VPWR VPWR net595 sky130_fd_sc_hd__buf_2
XFILLER_115_1273 VPWR VGND VPWR VGND sky130_ef_sc_hd__decap_12
XTAP_TAPCELL_ROW_241_4191 VGND VPWR sky130_fd_sc_hd__tapvpwrvgnd_1
XFILLER_247_897 VGND VGND VPWR VPWR sky130_fd_sc_hd__decap_6
XFILLER_185_1205 VPWR VGND VPWR VGND sky130_ef_sc_hd__decap_12
XTAP_TAPCELL_ROW_48_2_5048 VGND VPWR sky130_fd_sc_hd__tapvpwrvgnd_1
XFILLER_92_22 VPWR VGND VPWR VGND sky130_ef_sc_hd__decap_12
XFILLER_206_249 VPWR VGND VPWR VGND sky130_ef_sc_hd__decap_12
X_404_ net591 net589 net569 VGND VGND VPWR VPWR _193_ sky130_fd_sc_hd__a21o_1
XTAP_TAPCELL_ROW_15_2_4778 VGND VPWR sky130_fd_sc_hd__tapvpwrvgnd_1
XFILLER_186_101 VGND VGND VPWR VPWR sky130_fd_sc_hd__decap_6
XPHY_EDGE_ROW_182_Right_27 VGND VGND VPWR VPWR sky130_fd_sc_hd__decap_3
XTAP_TAPCELL_ROW_194_2530 VGND VPWR sky130_fd_sc_hd__tapvpwrvgnd_1
XFILLER_202_433 VPWR VGND VPWR VGND sky130_ef_sc_hd__decap_12
XFILLER_124_1509 VGND VGND VPWR VPWR sky130_fd_sc_hd__decap_6
XFILLER_187_646 VPWR VGND VPWR VGND sky130_ef_sc_hd__decap_12
XTAP_TAPCELL_ROW_194_2541 VGND VPWR sky130_fd_sc_hd__tapvpwrvgnd_1
XFILLER_230_753 VPWR VGND VPWR VGND sky130_ef_sc_hd__decap_12
XTAP_TAPCELL_ROW_194_2552 VGND VPWR sky130_fd_sc_hd__tapvpwrvgnd_1
XFILLER_35_1230 VPWR VGND VPWR VGND sky130_ef_sc_hd__decap_12
X_335_ _121_ net497 VGND VGND VPWR VPWR _124_ sky130_fd_sc_hd__or2_1
XTAP_TAPCELL_ROW_194_2563 VGND VPWR sky130_fd_sc_hd__tapvpwrvgnd_1
XTAP_TAPCELL_ROW_190_2405 VGND VPWR sky130_fd_sc_hd__tapvpwrvgnd_1
XTAP_TAPCELL_ROW_190_2416 VGND VPWR sky130_fd_sc_hd__tapvpwrvgnd_1
XFILLER_202_488 VGND VGND VPWR VPWR sky130_fd_sc_hd__decap_6
XFILLER_126_1380 VPWR VGND VPWR VGND sky130_ef_sc_hd__decap_12
XFILLER_168_882 VPWR VGND VPWR VGND sky130_ef_sc_hd__decap_12
XFILLER_70_1165 VPWR VGND VPWR VGND sky130_ef_sc_hd__decap_12
XFILLER_35_1285 VGND VGND VPWR VPWR sky130_fd_sc_hd__decap_6
XFILLER_183_830 VPWR VGND VPWR VGND sky130_ef_sc_hd__decap_12
XFILLER_167_381 VGND VGND VPWR VPWR sky130_fd_sc_hd__decap_6
XFILLER_196_1312 VPWR VGND VPWR VGND sky130_ef_sc_hd__decap_12
XFILLER_183_885 VPWR VGND VPWR VGND sky130_ef_sc_hd__decap_12
XFILLER_196_1367 VPWR VGND VPWR VGND sky130_ef_sc_hd__decap_12
XTAP_TAPCELL_ROW_188_2323 VGND VPWR sky130_fd_sc_hd__tapvpwrvgnd_1
XPHY_EDGE_ROW_62_2_Left_564 VGND VGND VPWR VPWR sky130_fd_sc_hd__decap_3
XTAP_TAPCELL_ROW_188_2334 VGND VPWR sky130_fd_sc_hd__tapvpwrvgnd_1
XTAP_TAPCELL_ROW_188_2345 VGND VPWR sky130_fd_sc_hd__tapvpwrvgnd_1
XTAP_TAPCELL_ROW_184_2209 VGND VPWR sky130_fd_sc_hd__tapvpwrvgnd_1
XPHY_EDGE_ROW_191_Right_36 VGND VGND VPWR VPWR sky130_fd_sc_hd__decap_3
XFILLER_233_1217 VPWR VGND VPWR VGND sky130_ef_sc_hd__decap_12
XFILLER_243_39 VGND VGND VPWR VPWR sky130_fd_sc_hd__decap_4
XFILLER_173_80 VGND VGND VPWR VPWR sky130_fd_sc_hd__decap_6
XFILLER_81_1261 VPWR VGND VPWR VGND sky130_ef_sc_hd__decap_12
XFILLER_238_820 VPWR VGND VPWR VGND sky130_ef_sc_hd__decap_12
XFILLER_46_1392 VGND VGND VPWR VPWR sky130_fd_sc_hd__decap_6
XFILLER_238_875 VGND VGND VPWR VPWR sky130_fd_sc_hd__decap_6
XPHY_EDGE_ROW_14_1_Left_269 VGND VGND VPWR VPWR sky130_fd_sc_hd__decap_3
XFILLER_252_366 VPWR VGND VPWR VGND sky130_ef_sc_hd__decap_12
XPHY_EDGE_ROW_139_1_Left_394 VGND VGND VPWR VPWR sky130_fd_sc_hd__decap_3
XFILLER_244_1324 VPWR VGND VPWR VGND sky130_ef_sc_hd__decap_12
XFILLER_209_1444 VPWR VGND VPWR VGND sky130_ef_sc_hd__decap_12
XFILLER_205_271 VPWR VGND VPWR VGND sky130_ef_sc_hd__decap_12
XFILLER_178_624 VPWR VGND VPWR VGND sky130_ef_sc_hd__decap_12
XFILLER_220_230 VGND VGND VPWR VPWR sky130_fd_sc_hd__decap_6
XFILLER_244_1379 VPWR VGND VPWR VGND sky130_ef_sc_hd__decap_12
XFILLER_177_123 VGND VGND VPWR VPWR sky130_fd_sc_hd__decap_6
XFILLER_209_1499 VGND VGND VPWR VPWR sky130_fd_sc_hd__decap_6
XTAP_TAPCELL_ROW_233_3902 VGND VPWR sky130_fd_sc_hd__tapvpwrvgnd_1
XFILLER_127_1177 VPWR VGND VPWR VGND sky130_ef_sc_hd__decap_12
XFILLER_166_808 VPWR VGND VPWR VGND sky130_ef_sc_hd__decap_12
XFILLER_221_775 VPWR VGND VPWR VGND sky130_ef_sc_hd__decap_12
XTAP_TAPCELL_ROW_233_3913 VGND VPWR sky130_fd_sc_hd__tapvpwrvgnd_1
XPHY_EDGE_ROW_76_1_Left_331 VGND VGND VPWR VPWR sky130_fd_sc_hd__decap_3
XFILLER_178_679 VPWR VGND VPWR VGND sky130_ef_sc_hd__decap_12
XTAP_TAPCELL_ROW_233_3924 VGND VPWR sky130_fd_sc_hd__tapvpwrvgnd_1
XFILLER_165_307 VGND VGND VPWR VPWR sky130_fd_sc_hd__decap_8
XFILLER_193_627 VPWR VGND VPWR VGND sky130_ef_sc_hd__decap_12
XFILLER_14_1325 VPWR VGND VPWR VGND sky130_ef_sc_hd__decap_12
XTAP_TAPCELL_ROW_136_2_5747 VGND VPWR sky130_fd_sc_hd__tapvpwrvgnd_1
XFILLER_105_1464 VPWR VGND VPWR VGND sky130_ef_sc_hd__decap_12
XFILLER_203_1076 VPWR VGND VPWR VGND sky130_ef_sc_hd__decap_12
XFILLER_9_391 VGND VGND VPWR VPWR sky130_fd_sc_hd__decap_8
XFILLER_174_863 VPWR VGND VPWR VGND sky130_ef_sc_hd__decap_12
XFILLER_101_1328 VGND VGND VPWR VPWR sky130_fd_sc_hd__decap_6
XFILLER_140_1399 VPWR VGND VPWR VGND sky130_ef_sc_hd__decap_12
XFILLER_255_1420 VGND VGND VPWR VPWR sky130_fd_sc_hd__decap_8
XTAP_TAPCELL_ROW_227_3706 VGND VPWR sky130_fd_sc_hd__tapvpwrvgnd_1
XFILLER_138_1251 VPWR VGND VPWR VGND sky130_ef_sc_hd__decap_12
XFILLER_173_1131 VPWR VGND VPWR VGND sky130_ef_sc_hd__decap_12
XTAP_TAPCELL_ROW_227_3717 VGND VPWR sky130_fd_sc_hd__tapvpwrvgnd_1
XTAP_TAPCELL_ROW_40_2_4980 VGND VPWR sky130_fd_sc_hd__tapvpwrvgnd_1
XTAP_TAPCELL_ROW_39_2_4974 VGND VPWR sky130_fd_sc_hd__tapvpwrvgnd_1
XFILLER_248_617 VGND VGND VPWR VPWR sky130_fd_sc_hd__decap_6
XFILLER_153_39 VGND VGND VPWR VPWR sky130_fd_sc_hd__decap_4
XFILLER_47_1189 VPWR VGND VPWR VGND sky130_ef_sc_hd__decap_12
XFILLER_173_1186 VPWR VGND VPWR VGND sky130_ef_sc_hd__decap_12
XFILLER_25_1421 VPWR VGND VPWR VGND sky130_ef_sc_hd__decap_12
XFILLER_99_1500 VGND VGND VPWR VPWR sky130_fd_sc_hd__decap_6
XFILLER_229_842 VPWR VGND VPWR VGND sky130_ef_sc_hd__decap_12
XFILLER_60_1356 VPWR VGND VPWR VGND sky130_ef_sc_hd__decap_12
XFILLER_46_15 VGND VGND VPWR VPWR sky130_fd_sc_hd__decap_6
XFILLER_25_1476 VPWR VGND VPWR VGND sky130_ef_sc_hd__decap_12
XFILLER_214_1183 VPWR VGND VPWR VGND sky130_ef_sc_hd__decap_12
XFILLER_112_1435 VGND VGND VPWR VPWR sky130_fd_sc_hd__decap_6
XFILLER_210_1047 VGND VGND VPWR VPWR sky130_fd_sc_hd__decap_6
XFILLER_229_897 VGND VGND VPWR VPWR sky130_fd_sc_hd__decap_6
XFILLER_255_160 VGND VGND VPWR VPWR sky130_fd_sc_hd__decap_8
XFILLER_186_1514 VGND VGND VPWR VPWR sky130_fd_sc_hd__fill_1
XTAP_TAPCELL_ROW_165_1485 VGND VPWR sky130_fd_sc_hd__tapvpwrvgnd_1
XTAP_TAPCELL_ROW_165_1496 VGND VPWR sky130_fd_sc_hd__tapvpwrvgnd_1
XTAP_TAPCELL_ROW_32_2_4917 VGND VPWR sky130_fd_sc_hd__tapvpwrvgnd_1
XFILLER_3_1272 VPWR VGND VPWR VGND sky130_ef_sc_hd__decap_12
XFILLER_231_517 VPWR VGND VPWR VGND sky130_ef_sc_hd__decap_12
XFILLER_243_388 VPWR VGND VPWR VGND sky130_ef_sc_hd__decap_12
XFILLER_102_65 VGND VGND VPWR VPWR sky130_fd_sc_hd__decap_6
XFILLER_58_1263 VGND VGND VPWR VPWR sky130_fd_sc_hd__decap_6
XFILLER_93_1165 VPWR VGND VPWR VGND sky130_ef_sc_hd__decap_12
XFILLER_168_101 VGND VGND VPWR VPWR sky130_fd_sc_hd__decap_6
XFILLER_184_1293 VPWR VGND VPWR VGND sky130_ef_sc_hd__decap_12
XFILLER_196_421 VPWR VGND VPWR VGND sky130_ef_sc_hd__decap_12
XFILLER_212_753 VPWR VGND VPWR VGND sky130_ef_sc_hd__decap_12
XFILLER_169_646 VPWR VGND VPWR VGND sky130_ef_sc_hd__decap_12
XFILLER_211_252 VGND VGND VPWR VPWR sky130_fd_sc_hd__decap_6
XFILLER_106_1239 VPWR VGND VPWR VGND sky130_ef_sc_hd__decap_12
XFILLER_178_58 VGND VGND VPWR VPWR sky130_fd_sc_hd__decap_6
XFILLER_184_605 VPWR VGND VPWR VGND sky130_ef_sc_hd__decap_12
XFILLER_200_937 VPWR VGND VPWR VGND sky130_ef_sc_hd__decap_12
XFILLER_196_476 VPWR VGND VPWR VGND sky130_ef_sc_hd__decap_12
Xwire226 net227 VGND VGND VPWR VPWR net226 sky130_fd_sc_hd__clkbuf_1
XFILLER_221_1143 VPWR VGND VPWR VGND sky130_ef_sc_hd__decap_12
Xwire237 net238 VGND VGND VPWR VPWR net237 sky130_fd_sc_hd__clkbuf_1
Xwire248 _154_ VGND VGND VPWR VPWR net248 sky130_fd_sc_hd__clkbuf_1
XFILLER_127_3 VPWR VGND VPWR VGND sky130_ef_sc_hd__decap_12
XFILLER_165_841 VPWR VGND VPWR VGND sky130_ef_sc_hd__decap_12
Xwire259 net260 VGND VGND VPWR VPWR net259 sky130_fd_sc_hd__clkbuf_1
XPHY_EDGE_ROW_157_1_Right_813 VGND VGND VPWR VPWR sky130_fd_sc_hd__decap_3
XFILLER_165_874 VGND VGND VPWR VPWR sky130_fd_sc_hd__decap_8
XFILLER_192_660 VGND VGND VPWR VPWR sky130_fd_sc_hd__decap_6
XFILLER_221_1198 VGND VGND VPWR VPWR sky130_fd_sc_hd__decap_6
XFILLER_194_46 VPWR VGND VPWR VGND sky130_ef_sc_hd__decap_12
XFILLER_65_1201 VGND VGND VPWR VPWR sky130_fd_sc_hd__decap_4
XFILLER_178_1097 VPWR VGND VPWR VGND sky130_ef_sc_hd__decap_12
XFILLER_87_44 VPWR VGND VPWR VGND sky130_ef_sc_hd__decap_12
XFILLER_117_1335 VPWR VGND VPWR VGND sky130_ef_sc_hd__decap_12
XTAP_TAPCELL_ROW_243_4253 VGND VPWR sky130_fd_sc_hd__tapvpwrvgnd_1
XTAP_TAPCELL_ROW_243_4264 VGND VPWR sky130_fd_sc_hd__tapvpwrvgnd_1
XFILLER_239_639 VGND VGND VPWR VPWR sky130_fd_sc_hd__decap_6
XTAP_TAPCELL_ROW_243_4275 VGND VPWR sky130_fd_sc_hd__tapvpwrvgnd_1
XFILLER_232_1250 VPWR VGND VPWR VGND sky130_ef_sc_hd__decap_12
XFILLER_8_1183 VPWR VGND VPWR VGND sky130_ef_sc_hd__decap_12
XTAP_TAPCELL_ROW_129_2_5690 VGND VPWR sky130_fd_sc_hd__tapvpwrvgnd_1
XFILLER_4_1047 VGND VGND VPWR VPWR sky130_fd_sc_hd__decap_6
XTAP_TAPCELL_ROW_5_1042 VGND VPWR sky130_fd_sc_hd__tapvpwrvgnd_1
XFILLER_185_1002 VPWR VGND VPWR VGND sky130_ef_sc_hd__decap_12
XTAP_TAPCELL_ROW_5_1053 VGND VPWR sky130_fd_sc_hd__tapvpwrvgnd_1
XTAP_TAPCELL_ROW_5_1064 VGND VPWR sky130_fd_sc_hd__tapvpwrvgnd_1
XTAP_TAPCELL_ROW_204_2879 VGND VPWR sky130_fd_sc_hd__tapvpwrvgnd_1
XTAP_TAPCELL_ROW_196_2603 VGND VPWR sky130_fd_sc_hd__tapvpwrvgnd_1
XFILLER_234_366 VPWR VGND VPWR VGND sky130_ef_sc_hd__decap_12
XFILLER_185_1057 VPWR VGND VPWR VGND sky130_ef_sc_hd__decap_12
XTAP_TAPCELL_ROW_196_2614 VGND VPWR sky130_fd_sc_hd__tapvpwrvgnd_1
XTAP_TAPCELL_ROW_237_4035 VGND VPWR sky130_fd_sc_hd__tapvpwrvgnd_1
XTAP_TAPCELL_ROW_196_2625 VGND VPWR sky130_fd_sc_hd__tapvpwrvgnd_1
XTAP_TAPCELL_ROW_237_4046 VGND VPWR sky130_fd_sc_hd__tapvpwrvgnd_1
XTAP_TAPCELL_ROW_237_4057 VGND VPWR sky130_fd_sc_hd__tapvpwrvgnd_1
XTAP_TAPCELL_ROW_237_4068 VGND VPWR sky130_fd_sc_hd__tapvpwrvgnd_1
XFILLER_128_1442 VPWR VGND VPWR VGND sky130_ef_sc_hd__decap_12
XFILLER_37_1347 VPWR VGND VPWR VGND sky130_ef_sc_hd__decap_12
XFILLER_72_1227 VPWR VGND VPWR VGND sky130_ef_sc_hd__decap_12
XTAP_TAPCELL_ROW_78_2_5287 VGND VPWR sky130_fd_sc_hd__tapvpwrvgnd_1
XFILLER_202_230 VGND VGND VPWR VPWR sky130_fd_sc_hd__decap_6
XFILLER_226_1054 VPWR VGND VPWR VGND sky130_ef_sc_hd__decap_12
XFILLER_124_1306 VGND VGND VPWR VPWR sky130_fd_sc_hd__decap_6
XFILLER_230_550 VPWR VGND VPWR VGND sky130_ef_sc_hd__decap_12
XFILLER_187_443 VPWR VGND VPWR VGND sky130_ef_sc_hd__decap_12
XFILLER_203_775 VPWR VGND VPWR VGND sky130_ef_sc_hd__decap_12
XFILLER_128_1497 VPWR VGND VPWR VGND sky130_ef_sc_hd__decap_12
XFILLER_175_627 VPWR VGND VPWR VGND sky130_ef_sc_hd__decap_12
X_318_ net180 _106_ VGND VGND VPWR VPWR _107_ sky130_fd_sc_hd__or2_1
XFILLER_187_498 VPWR VGND VPWR VGND sky130_ef_sc_hd__decap_12
Xinput12 wr_data[11] VGND VGND VPWR VPWR net12 sky130_fd_sc_hd__clkbuf_1
Xinput23 wr_data[21] VGND VGND VPWR VPWR net23 sky130_fd_sc_hd__clkbuf_1
Xinput34 wr_data[31] VGND VGND VPWR VPWR net34 sky130_fd_sc_hd__clkbuf_1
XFILLER_200_1238 VPWR VGND VPWR VGND sky130_ef_sc_hd__decap_12
XFILLER_7_873 VPWR VGND VPWR VGND sky130_ef_sc_hd__decap_12
Xmax_cap515 net516 VGND VGND VPWR VPWR net515 sky130_fd_sc_hd__clkbuf_1
XFILLER_171_811 VGND VGND VPWR VPWR sky130_fd_sc_hd__decap_6
XFILLER_6_361 VGND VGND VPWR VPWR sky130_fd_sc_hd__fill_1
XFILLER_183_682 VGND VGND VPWR VPWR sky130_fd_sc_hd__decap_6
Xmax_cap526 net66 VGND VGND VPWR VPWR net526 sky130_fd_sc_hd__clkbuf_1
XFILLER_196_1164 VPWR VGND VPWR VGND sky130_ef_sc_hd__decap_12
Xmax_cap537 net53 VGND VGND VPWR VPWR net537 sky130_fd_sc_hd__clkbuf_1
XTAP_TAPCELL_ROW_25_2_4860 VGND VPWR sky130_fd_sc_hd__tapvpwrvgnd_1
Xmax_cap548 net45 VGND VGND VPWR VPWR net548 sky130_fd_sc_hd__clkbuf_1
XFILLER_42_3 VPWR VGND VPWR VGND sky130_ef_sc_hd__decap_12
XFILLER_48_1454 VPWR VGND VPWR VGND sky130_ef_sc_hd__decap_12
XFILLER_135_1402 VPWR VGND VPWR VGND sky130_ef_sc_hd__decap_12
XFILLER_233_1014 VPWR VGND VPWR VGND sky130_ef_sc_hd__decap_12
XFILLER_174_1484 VPWR VGND VPWR VGND sky130_ef_sc_hd__decap_12
XFILLER_83_1378 VPWR VGND VPWR VGND sky130_ef_sc_hd__decap_12
XFILLER_135_1457 VGND VGND VPWR VPWR sky130_fd_sc_hd__decap_6
XFILLER_170_1348 VGND VGND VPWR VPWR sky130_fd_sc_hd__decap_6
XPHY_EDGE_ROW_179_Left_434 VGND VGND VPWR VPWR sky130_fd_sc_hd__decap_3
XFILLER_233_1069 VGND VGND VPWR VPWR sky130_fd_sc_hd__decap_6
XFILLER_211_1334 VPWR VGND VPWR VGND sky130_ef_sc_hd__decap_12
XFILLER_244_108 VPWR VGND VPWR VGND sky130_ef_sc_hd__decap_12
XFILLER_211_1389 VPWR VGND VPWR VGND sky130_ef_sc_hd__decap_12
XFILLER_129_1206 VPWR VGND VPWR VGND sky130_ef_sc_hd__decap_12
XFILLER_213_517 VPWR VGND VPWR VGND sky130_ef_sc_hd__decap_12
XFILLER_252_163 VPWR VGND VPWR VGND sky130_ef_sc_hd__decap_12
XFILLER_225_388 VPWR VGND VPWR VGND sky130_ef_sc_hd__decap_12
XFILLER_244_1121 VPWR VGND VPWR VGND sky130_ef_sc_hd__decap_12
XFILLER_55_1414 VGND VGND VPWR VPWR sky130_fd_sc_hd__decap_6
XFILLER_209_1241 VGND VGND VPWR VPWR sky130_fd_sc_hd__decap_6
XFILLER_240_347 VPWR VGND VPWR VGND sky130_ef_sc_hd__decap_12
XFILLER_94_1485 VPWR VGND VPWR VGND sky130_ef_sc_hd__decap_12
XFILLER_178_421 VPWR VGND VPWR VGND sky130_ef_sc_hd__decap_12
XFILLER_181_1444 VPWR VGND VPWR VGND sky130_ef_sc_hd__decap_12
XPHY_EDGE_ROW_188_Left_443 VGND VGND VPWR VPWR sky130_fd_sc_hd__decap_3
XFILLER_244_1176 VGND VGND VPWR VPWR sky130_fd_sc_hd__decap_6
XFILLER_90_1349 VGND VGND VPWR VPWR sky130_fd_sc_hd__decap_6
XFILLER_166_605 VPWR VGND VPWR VGND sky130_ef_sc_hd__decap_12
XFILLER_221_572 VPWR VGND VPWR VGND sky130_ef_sc_hd__decap_12
XFILLER_194_925 VPWR VGND VPWR VGND sky130_ef_sc_hd__decap_12
XFILLER_178_476 VPWR VGND VPWR VGND sky130_ef_sc_hd__decap_12
XFILLER_181_1499 VGND VGND VPWR VPWR sky130_fd_sc_hd__decap_6
XFILLER_193_424 VGND VGND VPWR VPWR sky130_fd_sc_hd__decap_6
XFILLER_222_1441 VPWR VGND VPWR VGND sky130_ef_sc_hd__decap_12
XFILLER_105_1261 VPWR VGND VPWR VGND sky130_ef_sc_hd__decap_12
XFILLER_165_148 VPWR VGND VPWR VGND sky130_ef_sc_hd__decap_12
XFILLER_222_1496 VPWR VGND VPWR VGND sky130_ef_sc_hd__decap_12
XFILLER_14_1177 VGND VGND VPWR VPWR sky130_fd_sc_hd__decap_6
XFILLER_174_660 VGND VGND VPWR VPWR sky130_fd_sc_hd__decap_6
XFILLER_140_1196 VPWR VGND VPWR VGND sky130_ef_sc_hd__decap_12
XFILLER_49_1218 VPWR VGND VPWR VGND sky130_ef_sc_hd__decap_12
XTAP_TAPCELL_ROW_173_1798 VGND VPWR sky130_fd_sc_hd__tapvpwrvgnd_1
XFILLER_175_1248 VPWR VGND VPWR VGND sky130_ef_sc_hd__decap_12
XFILLER_255_1261 VPWR VGND VPWR VGND sky130_ef_sc_hd__decap_12
XFILLER_249_904 VPWR VGND VPWR VGND sky130_ef_sc_hd__decap_12
XPHY_EDGE_ROW_197_Left_452 VGND VGND VPWR VPWR sky130_fd_sc_hd__decap_3
XFILLER_0_526 VGND VGND VPWR VPWR sky130_fd_sc_hd__fill_2
XFILLER_255_1294 VGND VGND VPWR VPWR sky130_fd_sc_hd__decap_8
XFILLER_249_959 VPWR VGND VPWR VGND sky130_ef_sc_hd__decap_12
XFILLER_212_1109 VPWR VGND VPWR VGND sky130_ef_sc_hd__decap_12
XFILLER_180_15 VGND VGND VPWR VPWR sky130_fd_sc_hd__decap_6
XFILLER_9_1492 VPWR VGND VPWR VGND sky130_ef_sc_hd__decap_12
XFILLER_25_1273 VPWR VGND VPWR VGND sky130_ef_sc_hd__decap_12
XFILLER_5_1334 VPWR VGND VPWR VGND sky130_ef_sc_hd__decap_12
XFILLER_151_1292 VPWR VGND VPWR VGND sky130_ef_sc_hd__decap_12
XFILLER_5_1389 VPWR VGND VPWR VGND sky130_ef_sc_hd__decap_12
XFILLER_243_130 VPWR VGND VPWR VGND sky130_ef_sc_hd__decap_12
XFILLER_186_1355 VPWR VGND VPWR VGND sky130_ef_sc_hd__decap_12
XFILLER_249_1076 VPWR VGND VPWR VGND sky130_ef_sc_hd__decap_12
XTAP_TAPCELL_ROW_64_2_5173 VGND VPWR sky130_fd_sc_hd__tapvpwrvgnd_1
XFILLER_95_1249 VPWR VGND VPWR VGND sky130_ef_sc_hd__decap_12
XFILLER_216_366 VPWR VGND VPWR VGND sky130_ef_sc_hd__decap_12
XFILLER_147_1328 VGND VGND VPWR VPWR sky130_fd_sc_hd__decap_6
XFILLER_231_314 VPWR VGND VPWR VGND sky130_ef_sc_hd__decap_12
XFILLER_73_68 VGND VGND VPWR VPWR sky130_fd_sc_hd__decap_3
XFILLER_182_1219 VGND VGND VPWR VPWR sky130_fd_sc_hd__decap_6
XFILLER_243_185 VPWR VGND VPWR VGND sky130_ef_sc_hd__decap_12
XFILLER_188_218 VPWR VGND VPWR VGND sky130_ef_sc_hd__decap_12
Xwire80 net82 VGND VGND VPWR VPWR net80 sky130_fd_sc_hd__clkbuf_1
Xwire91 _233_ VGND VGND VPWR VPWR net91 sky130_fd_sc_hd__clkbuf_1
XFILLER_189_68 VPWR VGND VPWR VGND sky130_ef_sc_hd__decap_12
XTAP_TAPCELL_ROW_255_4680 VGND VPWR sky130_fd_sc_hd__tapvpwrvgnd_1
XFILLER_244_3 VPWR VGND VPWR VGND sky130_ef_sc_hd__decap_12
XFILLER_223_1205 VPWR VGND VPWR VGND sky130_ef_sc_hd__decap_12
XFILLER_231_369 VPWR VGND VPWR VGND sky130_ef_sc_hd__decap_12
XTAP_TAPCELL_ROW_255_4691 VGND VPWR sky130_fd_sc_hd__tapvpwrvgnd_1
XFILLER_169_443 VPWR VGND VPWR VGND sky130_ef_sc_hd__decap_12
XFILLER_184_1090 VGND VGND VPWR VPWR sky130_fd_sc_hd__decap_6
XFILLER_212_550 VPWR VGND VPWR VGND sky130_ef_sc_hd__decap_12
XTAP_TAPCELL_ROW_251_4533 VGND VPWR sky130_fd_sc_hd__tapvpwrvgnd_1
XFILLER_34_1509 VGND VGND VPWR VPWR sky130_fd_sc_hd__decap_6
XTAP_TAPCELL_ROW_251_4544 VGND VPWR sky130_fd_sc_hd__tapvpwrvgnd_1
XTAP_TAPCELL_ROW_251_4555 VGND VPWR sky130_fd_sc_hd__tapvpwrvgnd_1
XFILLER_184_402 VGND VGND VPWR VPWR sky130_fd_sc_hd__decap_6
XFILLER_196_273 VGND VGND VPWR VPWR sky130_fd_sc_hd__decap_6
XFILLER_200_734 VPWR VGND VPWR VGND sky130_ef_sc_hd__decap_12
XFILLER_169_498 VPWR VGND VPWR VGND sky130_ef_sc_hd__decap_12
XFILLER_185_947 VPWR VGND VPWR VGND sky130_ef_sc_hd__decap_12
XFILLER_36_1380 VPWR VGND VPWR VGND sky130_ef_sc_hd__decap_12
XFILLER_8_648 VPWR VGND VPWR VGND sky130_ef_sc_hd__decap_12
XFILLER_201_1514 VGND VGND VPWR VPWR sky130_fd_sc_hd__fill_1
XFILLER_200_789 VGND VGND VPWR VPWR sky130_fd_sc_hd__decap_6
XPHY_EDGE_ROW_158_1_Right_814 VGND VGND VPWR VPWR sky130_fd_sc_hd__decap_3
XTAP_TAPCELL_ROW_249_4462 VGND VPWR sky130_fd_sc_hd__tapvpwrvgnd_1
XFILLER_158_1435 VGND VGND VPWR VPWR sky130_fd_sc_hd__decap_6
XFILLER_193_1315 VPWR VGND VPWR VGND sky130_ef_sc_hd__decap_12
XTAP_TAPCELL_ROW_249_4473 VGND VPWR sky130_fd_sc_hd__tapvpwrvgnd_1
XTAP_TAPCELL_ROW_249_4484 VGND VPWR sky130_fd_sc_hd__tapvpwrvgnd_1
XTAP_TAPCELL_ROW_245_4315 VGND VPWR sky130_fd_sc_hd__tapvpwrvgnd_1
XTAP_TAPCELL_ROW_245_4326 VGND VPWR sky130_fd_sc_hd__tapvpwrvgnd_1
XFILLER_3_342 VGND VGND VPWR VPWR sky130_fd_sc_hd__fill_2
XFILLER_98_65 VGND VGND VPWR VPWR sky130_fd_sc_hd__decap_6
XTAP_TAPCELL_ROW_245_4337 VGND VPWR sky130_fd_sc_hd__tapvpwrvgnd_1
XTAP_TAPCELL_ROW_245_4348 VGND VPWR sky130_fd_sc_hd__tapvpwrvgnd_1
XFILLER_234_1312 VPWR VGND VPWR VGND sky130_ef_sc_hd__decap_12
XFILLER_3_397 VGND VGND VPWR VPWR sky130_fd_sc_hd__fill_2
XFILLER_6_1109 VPWR VGND VPWR VGND sky130_ef_sc_hd__decap_12
XFILLER_234_1367 VPWR VGND VPWR VGND sky130_ef_sc_hd__decap_12
XFILLER_117_1165 VPWR VGND VPWR VGND sky130_ef_sc_hd__decap_12
XTAP_TAPCELL_ROW_7_1104 VGND VPWR sky130_fd_sc_hd__tapvpwrvgnd_1
XTAP_TAPCELL_ROW_7_1115 VGND VPWR sky130_fd_sc_hd__tapvpwrvgnd_1
XTAP_TAPCELL_ROW_7_1126 VGND VPWR sky130_fd_sc_hd__tapvpwrvgnd_1
XTAP_TAPCELL_ROW_7_1137 VGND VPWR sky130_fd_sc_hd__tapvpwrvgnd_1
XFILLER_226_108 VPWR VGND VPWR VGND sky130_ef_sc_hd__decap_12
XFILLER_248_992 VPWR VGND VPWR VGND sky130_ef_sc_hd__decap_12
XPHY_EDGE_ROW_201_Left_456 VGND VGND VPWR VPWR sky130_fd_sc_hd__decap_3
XFILLER_187_1119 VPWR VGND VPWR VGND sky130_ef_sc_hd__decap_12
XTAP_TAPCELL_ROW_239_4108 VGND VPWR sky130_fd_sc_hd__tapvpwrvgnd_1
XTAP_TAPCELL_ROW_239_4119 VGND VPWR sky130_fd_sc_hd__tapvpwrvgnd_1
XFILLER_207_388 VPWR VGND VPWR VGND sky130_ef_sc_hd__decap_12
XFILLER_234_163 VPWR VGND VPWR VGND sky130_ef_sc_hd__decap_12
XFILLER_222_347 VPWR VGND VPWR VGND sky130_ef_sc_hd__decap_12
XFILLER_250_667 VPWR VGND VPWR VGND sky130_ef_sc_hd__decap_12
XFILLER_245_1463 VPWR VGND VPWR VGND sky130_ef_sc_hd__decap_12
XFILLER_249_27 VPWR VGND VPWR VGND sky130_ef_sc_hd__decap_12
XFILLER_187_240 VPWR VGND VPWR VGND sky130_ef_sc_hd__decap_12
XFILLER_241_1327 VGND VGND VPWR VPWR sky130_fd_sc_hd__decap_6
XFILLER_203_572 VPWR VGND VPWR VGND sky130_ef_sc_hd__decap_12
XFILLER_37_1177 VPWR VGND VPWR VGND sky130_ef_sc_hd__decap_12
XFILLER_128_1294 VPWR VGND VPWR VGND sky130_ef_sc_hd__decap_12
XFILLER_176_925 VPWR VGND VPWR VGND sky130_ef_sc_hd__decap_12
XFILLER_188_796 VPWR VGND VPWR VGND sky130_ef_sc_hd__decap_12
XFILLER_175_424 VGND VGND VPWR VPWR sky130_fd_sc_hd__decap_6
XFILLER_187_295 VGND VGND VPWR VPWR sky130_fd_sc_hd__decap_6
XFILLER_198_1226 VPWR VGND VPWR VGND sky130_ef_sc_hd__decap_12
XPHY_EDGE_ROW_210_Left_465 VGND VGND VPWR VPWR sky130_fd_sc_hd__decap_3
XFILLER_15_1464 VPWR VGND VPWR VGND sky130_ef_sc_hd__decap_12
XFILLER_102_1423 VPWR VGND VPWR VGND sky130_ef_sc_hd__decap_12
XFILLER_191_928 VPWR VGND VPWR VGND sky130_ef_sc_hd__decap_12
XFILLER_200_1035 VPWR VGND VPWR VGND sky130_ef_sc_hd__decap_12
XFILLER_11_1328 VGND VGND VPWR VPWR sky130_fd_sc_hd__decap_6
XFILLER_184_980 VPWR VGND VPWR VGND sky130_ef_sc_hd__decap_12
XFILLER_50_1399 VPWR VGND VPWR VGND sky130_ef_sc_hd__decap_12
Xwire590 dout0_q\[0\] VGND VGND VPWR VPWR net590 sky130_fd_sc_hd__clkbuf_1
XFILLER_7_692 VGND VGND VPWR VPWR sky130_fd_sc_hd__decap_8
XFILLER_102_1478 VGND VGND VPWR VPWR sky130_fd_sc_hd__decap_6
XFILLER_170_151 VPWR VGND VPWR VGND sky130_ef_sc_hd__decap_12
XFILLER_48_1251 VPWR VGND VPWR VGND sky130_ef_sc_hd__decap_12
XFILLER_252_1434 VGND VGND VPWR VPWR sky130_fd_sc_hd__decap_6
XFILLER_139_1390 VPWR VGND VPWR VGND sky130_ef_sc_hd__decap_12
XFILLER_174_1281 VPWR VGND VPWR VGND sky130_ef_sc_hd__decap_12
XPHY_EDGE_ROW_25_2_Left_527 VGND VGND VPWR VPWR sky130_fd_sc_hd__decap_3
XFILLER_246_918 VGND VGND VPWR VPWR sky130_fd_sc_hd__decap_6
XTAP_TAPCELL_ROW_113_2_5567 VGND VPWR sky130_fd_sc_hd__tapvpwrvgnd_1
XTAP_TAPCELL_ROW_81_2_5312 VGND VPWR sky130_fd_sc_hd__tapvpwrvgnd_1
XPHY_EDGE_ROW_120_1_Right_776 VGND VGND VPWR VPWR sky130_fd_sc_hd__decap_3
XFILLER_211_1131 VPWR VGND VPWR VGND sky130_ef_sc_hd__decap_12
XFILLER_22_1435 VGND VGND VPWR VPWR sky130_fd_sc_hd__decap_6
XTAP_TAPCELL_ROW_49_2_5053 VGND VPWR sky130_fd_sc_hd__tapvpwrvgnd_1
XFILLER_27_39 VGND VGND VPWR VPWR sky130_fd_sc_hd__decap_4
XTAP_TAPCELL_ROW_166_1580 VGND VPWR sky130_fd_sc_hd__tapvpwrvgnd_1
XFILLER_211_1186 VPWR VGND VPWR VGND sky130_ef_sc_hd__decap_12
XFILLER_225_130 VPWR VGND VPWR VGND sky130_ef_sc_hd__decap_12
XFILLER_183_1506 VGND VGND VPWR VPWR sky130_fd_sc_hd__decap_8
XFILLER_0_1231 VGND VGND VPWR VPWR sky130_fd_sc_hd__decap_8
XFILLER_246_1238 VPWR VGND VPWR VGND sky130_ef_sc_hd__decap_12
XFILLER_213_314 VPWR VGND VPWR VGND sky130_ef_sc_hd__decap_12
XFILLER_225_185 VPWR VGND VPWR VGND sky130_ef_sc_hd__decap_12
XFILLER_198_538 VPWR VGND VPWR VGND sky130_ef_sc_hd__decap_12
XFILLER_43_27 VPWR VGND VPWR VGND sky130_ef_sc_hd__decap_12
XFILLER_240_144 VGND VGND VPWR VPWR sky130_fd_sc_hd__decap_6
XFILLER_94_1282 VPWR VGND VPWR VGND sky130_ef_sc_hd__decap_12
XFILLER_213_369 VPWR VGND VPWR VGND sky130_ef_sc_hd__decap_12
XFILLER_224_1514 VGND VGND VPWR VPWR sky130_fd_sc_hd__fill_1
XFILLER_241_689 VPWR VGND VPWR VGND sky130_ef_sc_hd__decap_12
XFILLER_181_1241 VGND VGND VPWR VPWR sky130_fd_sc_hd__decap_6
XFILLER_159_27 VPWR VGND VPWR VGND sky130_ef_sc_hd__decap_12
XFILLER_166_402 VGND VGND VPWR VPWR sky130_fd_sc_hd__decap_6
XFILLER_16_1239 VPWR VGND VPWR VGND sky130_ef_sc_hd__decap_12
XFILLER_178_273 VGND VGND VPWR VPWR sky130_fd_sc_hd__decap_6
XFILLER_194_722 VPWR VGND VPWR VGND sky130_ef_sc_hd__decap_12
XFILLER_167_947 VPWR VGND VPWR VGND sky130_ef_sc_hd__decap_12
XFILLER_107_1378 VPWR VGND VPWR VGND sky130_ef_sc_hd__decap_12
XFILLER_182_906 VPWR VGND VPWR VGND sky130_ef_sc_hd__decap_12
XFILLER_194_777 VPWR VGND VPWR VGND sky130_ef_sc_hd__decap_12
XFILLER_222_1293 VPWR VGND VPWR VGND sky130_ef_sc_hd__decap_12
XFILLER_175_15 VPWR VGND VPWR VGND sky130_ef_sc_hd__decap_12
XFILLER_4_106 VGND VGND VPWR VPWR sky130_fd_sc_hd__fill_1
XFILLER_190_961 VGND VGND VPWR VPWR sky130_fd_sc_hd__decap_6
XFILLER_175_1045 VPWR VGND VPWR VGND sky130_ef_sc_hd__decap_12
XFILLER_1_813 VGND VGND VPWR VPWR sky130_fd_sc_hd__fill_1
XFILLER_249_701 VPWR VGND VPWR VGND sky130_ef_sc_hd__decap_12
XFILLER_68_46 VPWR VGND VPWR VGND sky130_ef_sc_hd__decap_12
XFILLER_27_1335 VPWR VGND VPWR VGND sky130_ef_sc_hd__decap_12
XFILLER_249_756 VPWR VGND VPWR VGND sky130_ef_sc_hd__decap_12
XFILLER_118_1485 VPWR VGND VPWR VGND sky130_ef_sc_hd__decap_12
XFILLER_194_3 VPWR VGND VPWR VGND sky130_ef_sc_hd__decap_12
XFILLER_216_1097 VPWR VGND VPWR VGND sky130_ef_sc_hd__decap_12
XFILLER_114_1349 VGND VGND VPWR VPWR sky130_fd_sc_hd__decap_6
XFILLER_208_108 VPWR VGND VPWR VGND sky130_ef_sc_hd__decap_12
XFILLER_5_1131 VPWR VGND VPWR VGND sky130_ef_sc_hd__decap_12
XFILLER_84_34 VPWR VGND VPWR VGND sky130_ef_sc_hd__decap_12
XTAP_TAPCELL_ROW_205_2930 VGND VPWR sky130_fd_sc_hd__tapvpwrvgnd_1
XFILLER_245_940 VGND VGND VPWR VPWR sky130_fd_sc_hd__decap_6
X_652_ clknet_3_7__leaf_clk acc_core.adder.cla_blocks\[4\].block.sum\[2\] _060_ VGND
+ VGND VPWR VPWR net52 sky130_fd_sc_hd__dfrtp_1
XTAP_TAPCELL_ROW_205_2941 VGND VPWR sky130_fd_sc_hd__tapvpwrvgnd_1
XFILLER_5_1186 VPWR VGND VPWR VGND sky130_ef_sc_hd__decap_12
XTAP_TAPCELL_ROW_201_2805 VGND VPWR sky130_fd_sc_hd__tapvpwrvgnd_1
X_583_ net670 VGND VGND VPWR VPWR _065_ sky130_fd_sc_hd__inv_2
XFILLER_186_1152 VPWR VGND VPWR VGND sky130_ef_sc_hd__decap_12
XFILLER_216_163 VPWR VGND VPWR VGND sky130_ef_sc_hd__decap_12
XTAP_TAPCELL_ROW_253_4606 VGND VPWR sky130_fd_sc_hd__tapvpwrvgnd_1
XTAP_TAPCELL_ROW_253_4617 VGND VPWR sky130_fd_sc_hd__tapvpwrvgnd_1
XFILLER_231_111 VPWR VGND VPWR VGND sky130_ef_sc_hd__decap_12
XTAP_TAPCELL_ROW_253_4628 VGND VPWR sky130_fd_sc_hd__tapvpwrvgnd_1
XFILLER_204_347 VPWR VGND VPWR VGND sky130_ef_sc_hd__decap_12
XPHY_EDGE_ROW_71_2_Left_573 VGND VGND VPWR VPWR sky130_fd_sc_hd__decap_3
XTAP_TAPCELL_ROW_0_890 VGND VPWR sky130_fd_sc_hd__tapvpwrvgnd_1
XFILLER_232_667 VPWR VGND VPWR VGND sky130_ef_sc_hd__decap_12
XFILLER_38_1442 VPWR VGND VPWR VGND sky130_ef_sc_hd__decap_12
XFILLER_223_1002 VPWR VGND VPWR VGND sky130_ef_sc_hd__decap_12
XFILLER_231_166 VGND VGND VPWR VPWR sky130_fd_sc_hd__decap_6
XFILLER_34_1306 VGND VGND VPWR VPWR sky130_fd_sc_hd__decap_6
XFILLER_169_240 VPWR VGND VPWR VGND sky130_ef_sc_hd__decap_12
XFILLER_197_560 VPWR VGND VPWR VGND sky130_ef_sc_hd__decap_12
XFILLER_38_1497 VPWR VGND VPWR VGND sky130_ef_sc_hd__decap_12
XFILLER_125_1445 VPWR VGND VPWR VGND sky130_ef_sc_hd__decap_12
XFILLER_160_1325 VPWR VGND VPWR VGND sky130_ef_sc_hd__decap_12
XFILLER_200_531 VGND VGND VPWR VPWR sky130_fd_sc_hd__decap_6
XFILLER_223_1057 VPWR VGND VPWR VGND sky130_ef_sc_hd__decap_12
XFILLER_9_946 VPWR VGND VPWR VGND sky130_ef_sc_hd__decap_12
XFILLER_169_295 VGND VGND VPWR VPWR sky130_fd_sc_hd__decap_6
XFILLER_185_744 VPWR VGND VPWR VGND sky130_ef_sc_hd__decap_12
XFILLER_9_979 VGND VGND VPWR VPWR sky130_fd_sc_hd__decap_8
XFILLER_173_928 VPWR VGND VPWR VGND sky130_ef_sc_hd__decap_12
XFILLER_166_980 VPWR VGND VPWR VGND sky130_ef_sc_hd__decap_12
XFILLER_185_799 VPWR VGND VPWR VGND sky130_ef_sc_hd__decap_12
XPHY_EDGE_ROW_23_1_Left_278 VGND VGND VPWR VPWR sky130_fd_sc_hd__decap_3
XFILLER_201_1377 VPWR VGND VPWR VGND sky130_ef_sc_hd__decap_12
XFILLER_193_1112 VGND VGND VPWR VPWR sky130_fd_sc_hd__decap_6
XFILLER_4_640 VGND VGND VPWR VPWR sky130_fd_sc_hd__fill_2
XPHY_EDGE_ROW_159_1_Right_815 VGND VGND VPWR VPWR sky130_fd_sc_hd__decap_3
XFILLER_181_983 VGND VGND VPWR VPWR sky130_fd_sc_hd__decap_6
XTAP_TAPCELL_ROW_86_2_5349 VGND VPWR sky130_fd_sc_hd__tapvpwrvgnd_1
XFILLER_45_1402 VPWR VGND VPWR VGND sky130_ef_sc_hd__decap_12
XFILLER_119_1249 VPWR VGND VPWR VGND sky130_ef_sc_hd__decap_12
XFILLER_171_1432 VPWR VGND VPWR VGND sky130_ef_sc_hd__decap_12
XFILLER_234_1164 VPWR VGND VPWR VGND sky130_ef_sc_hd__decap_12
XFILLER_45_1457 VGND VGND VPWR VPWR sky130_fd_sc_hd__decap_6
XFILLER_80_1337 VPWR VGND VPWR VGND sky130_ef_sc_hd__decap_12
XFILLER_228_918 VGND VGND VPWR VPWR sky130_fd_sc_hd__decap_6
XFILLER_171_1487 VPWR VGND VPWR VGND sky130_ef_sc_hd__decap_12
XFILLER_255_715 VPWR VGND VPWR VGND sky130_ef_sc_hd__decap_12
XPHY_EDGE_ROW_85_1_Left_340 VGND VGND VPWR VPWR sky130_fd_sc_hd__decap_3
Xhold1 valid_d1 VGND VGND VPWR VPWR net689 sky130_fd_sc_hd__dlygate4sd3_1
XFILLER_251_39 VGND VGND VPWR VPWR sky130_fd_sc_hd__decap_4
XFILLER_255_748 VGND VGND VPWR VPWR sky130_fd_sc_hd__decap_8
XFILLER_181_80 VGND VGND VPWR VPWR sky130_fd_sc_hd__decap_6
XFILLER_212_1484 VPWR VGND VPWR VGND sky130_ef_sc_hd__decap_12
XTAP_TAPCELL_ROW_33_2_4922 VGND VPWR sky130_fd_sc_hd__tapvpwrvgnd_1
XFILLER_242_409 VPWR VGND VPWR VGND sky130_ef_sc_hd__decap_12
XFILLER_207_130 VPWR VGND VPWR VGND sky130_ef_sc_hd__decap_12
XFILLER_247_1514 VGND VGND VPWR VPWR sky130_fd_sc_hd__fill_1
XFILLER_130_1184 VPWR VGND VPWR VGND sky130_ef_sc_hd__decap_12
XFILLER_39_1206 VPWR VGND VPWR VGND sky130_ef_sc_hd__decap_12
XFILLER_207_185 VPWR VGND VPWR VGND sky130_ef_sc_hd__decap_12
XPHY_EDGE_ROW_8_Right_8 VGND VGND VPWR VPWR sky130_fd_sc_hd__decap_3
XFILLER_211_818 VPWR VGND VPWR VGND sky130_ef_sc_hd__decap_12
XFILLER_222_144 VGND VGND VPWR VPWR sky130_fd_sc_hd__decap_6
XFILLER_250_464 VPWR VGND VPWR VGND sky130_ef_sc_hd__decap_12
XFILLER_245_1260 VPWR VGND VPWR VGND sky130_ef_sc_hd__decap_12
XFILLER_91_1433 VPWR VGND VPWR VGND sky130_ef_sc_hd__decap_12
XFILLER_223_689 VPWR VGND VPWR VGND sky130_ef_sc_hd__decap_12
XFILLER_200_65 VPWR VGND VPWR VGND sky130_ef_sc_hd__decap_12
XFILLER_176_722 VPWR VGND VPWR VGND sky130_ef_sc_hd__decap_12
XFILLER_91_1488 VPWR VGND VPWR VGND sky130_ef_sc_hd__decap_12
XFILLER_188_593 VPWR VGND VPWR VGND sky130_ef_sc_hd__decap_12
XFILLER_198_1023 VPWR VGND VPWR VGND sky130_ef_sc_hd__decap_12
XFILLER_176_777 VPWR VGND VPWR VGND sky130_ef_sc_hd__decap_12
XFILLER_15_1261 VPWR VGND VPWR VGND sky130_ef_sc_hd__decap_12
XTAP_TAPCELL_ROW_215_3270 VGND VPWR sky130_fd_sc_hd__tapvpwrvgnd_1
XFILLER_102_1220 VGND VGND VPWR VPWR sky130_fd_sc_hd__decap_6
XTAP_TAPCELL_ROW_174_1860 VGND VPWR sky130_fd_sc_hd__tapvpwrvgnd_1
XFILLER_191_725 VGND VGND VPWR VPWR sky130_fd_sc_hd__decap_6
XTAP_TAPCELL_ROW_215_3281 VGND VPWR sky130_fd_sc_hd__tapvpwrvgnd_1
XTAP_TAPCELL_ROW_170_1702 VGND VPWR sky130_fd_sc_hd__tapvpwrvgnd_1
XTAP_TAPCELL_ROW_215_3292 VGND VPWR sky130_fd_sc_hd__tapvpwrvgnd_1
XTAP_TAPCELL_ROW_170_1713 VGND VPWR sky130_fd_sc_hd__tapvpwrvgnd_1
XTAP_TAPCELL_ROW_211_3134 VGND VPWR sky130_fd_sc_hd__tapvpwrvgnd_1
XFILLER_198_1078 VPWR VGND VPWR VGND sky130_ef_sc_hd__decap_12
XTAP_TAPCELL_ROW_211_3145 VGND VPWR sky130_fd_sc_hd__tapvpwrvgnd_1
XFILLER_50_1196 VPWR VGND VPWR VGND sky130_ef_sc_hd__decap_12
XTAP_TAPCELL_ROW_211_3156 VGND VPWR sky130_fd_sc_hd__tapvpwrvgnd_1
Xmax_cap131 net132 VGND VGND VPWR VPWR net131 sky130_fd_sc_hd__clkbuf_1
XFILLER_172_961 VGND VGND VPWR VPWR sky130_fd_sc_hd__decap_6
Xmax_cap142 _227_ VGND VGND VPWR VPWR net142 sky130_fd_sc_hd__clkbuf_1
Xmax_cap153 _175_ VGND VGND VPWR VPWR net153 sky130_fd_sc_hd__clkbuf_1
XFILLER_137_1316 VPWR VGND VPWR VGND sky130_ef_sc_hd__decap_12
XFILLER_172_1207 VPWR VGND VPWR VGND sky130_ef_sc_hd__decap_12
Xmax_cap175 _114_ VGND VGND VPWR VPWR net175 sky130_fd_sc_hd__clkbuf_1
Xmax_cap197 _213_ VGND VGND VPWR VPWR net197 sky130_fd_sc_hd__clkbuf_1
XFILLER_176_1398 VPWR VGND VPWR VGND sky130_ef_sc_hd__decap_12
XTAP_TAPCELL_ROW_168_1620 VGND VPWR sky130_fd_sc_hd__tapvpwrvgnd_1
XTAP_TAPCELL_ROW_168_1631 VGND VPWR sky130_fd_sc_hd__tapvpwrvgnd_1
XTAP_TAPCELL_ROW_168_1642 VGND VPWR sky130_fd_sc_hd__tapvpwrvgnd_1
XTAP_TAPCELL_ROW_209_3063 VGND VPWR sky130_fd_sc_hd__tapvpwrvgnd_1
XTAP_TAPCELL_ROW_168_1653 VGND VPWR sky130_fd_sc_hd__tapvpwrvgnd_1
XTAP_TAPCELL_ROW_209_3074 VGND VPWR sky130_fd_sc_hd__tapvpwrvgnd_1
XTAP_TAPCELL_ROW_209_3085 VGND VPWR sky130_fd_sc_hd__tapvpwrvgnd_1
XFILLER_213_1248 VPWR VGND VPWR VGND sky130_ef_sc_hd__decap_12
XFILLER_161_39 VGND VGND VPWR VPWR sky130_fd_sc_hd__decap_4
XPHY_EDGE_ROW_121_1_Right_777 VGND VGND VPWR VPWR sky130_fd_sc_hd__decap_3
XFILLER_227_940 VGND VGND VPWR VPWR sky130_fd_sc_hd__decap_6
XFILLER_61_1292 VPWR VGND VPWR VGND sky130_ef_sc_hd__decap_12
XFILLER_6_1484 VPWR VGND VPWR VGND sky130_ef_sc_hd__decap_12
XFILLER_113_1371 VGND VGND VPWR VPWR sky130_fd_sc_hd__decap_6
XFILLER_2_1348 VGND VGND VPWR VPWR sky130_fd_sc_hd__decap_6
XFILLER_54_15 VGND VGND VPWR VPWR sky130_fd_sc_hd__decap_6
XFILLER_183_1303 VPWR VGND VPWR VGND sky130_ef_sc_hd__decap_12
XFILLER_148_1423 VPWR VGND VPWR VGND sky130_ef_sc_hd__decap_12
XFILLER_213_111 VPWR VGND VPWR VGND sky130_ef_sc_hd__decap_12
XFILLER_246_1035 VPWR VGND VPWR VGND sky130_ef_sc_hd__decap_12
XFILLER_57_1328 VGND VGND VPWR VPWR sky130_fd_sc_hd__decap_6
XFILLER_92_1208 VPWR VGND VPWR VGND sky130_ef_sc_hd__decap_12
XFILLER_241_431 VPWR VGND VPWR VGND sky130_ef_sc_hd__decap_12
XFILLER_96_1399 VPWR VGND VPWR VGND sky130_ef_sc_hd__decap_12
XFILLER_198_335 VPWR VGND VPWR VGND sky130_ef_sc_hd__decap_12
XFILLER_0_1072 VPWR VGND VPWR VGND sky130_ef_sc_hd__decap_12
XFILLER_183_1358 VPWR VGND VPWR VGND sky130_ef_sc_hd__decap_12
XFILLER_214_667 VPWR VGND VPWR VGND sky130_ef_sc_hd__decap_12
XTAP_TAPCELL_ROW_79_2_5292 VGND VPWR sky130_fd_sc_hd__tapvpwrvgnd_1
XFILLER_148_1478 VGND VGND VPWR VPWR sky130_fd_sc_hd__decap_6
XFILLER_213_166 VGND VGND VPWR VPWR sky130_fd_sc_hd__decap_6
XFILLER_241_486 VPWR VGND VPWR VGND sky130_ef_sc_hd__decap_12
XFILLER_186_519 VPWR VGND VPWR VGND sky130_ef_sc_hd__decap_12
XFILLER_179_560 VPWR VGND VPWR VGND sky130_ef_sc_hd__decap_12
XFILLER_110_65 VGND VGND VPWR VPWR sky130_fd_sc_hd__decap_6
XFILLER_224_1355 VPWR VGND VPWR VGND sky130_ef_sc_hd__decap_12
XFILLER_167_744 VPWR VGND VPWR VGND sky130_ef_sc_hd__decap_12
XFILLER_210_851 VPWR VGND VPWR VGND sky130_ef_sc_hd__decap_12
XFILLER_70_58 VGND VGND VPWR VPWR sky130_fd_sc_hd__decap_6
XFILLER_220_1219 VGND VGND VPWR VPWR sky130_fd_sc_hd__decap_6
XFILLER_182_703 VGND VGND VPWR VPWR sky130_fd_sc_hd__decap_6
XFILLER_167_799 VPWR VGND VPWR VGND sky130_ef_sc_hd__decap_12
XFILLER_186_58 VGND VGND VPWR VPWR sky130_fd_sc_hd__decap_6
XFILLER_194_574 VGND VGND VPWR VPWR sky130_fd_sc_hd__decap_6
XFILLER_222_1090 VGND VGND VPWR VPWR sky130_fd_sc_hd__decap_6
XFILLER_6_949 VPWR VGND VPWR VGND sky130_ef_sc_hd__decap_12
XTAP_TAPCELL_ROW_72_2_5235 VGND VPWR sky130_fd_sc_hd__tapvpwrvgnd_1
XFILLER_194_1410 VPWR VGND VPWR VGND sky130_ef_sc_hd__decap_12
XFILLER_207_3 VPWR VGND VPWR VGND sky130_ef_sc_hd__decap_12
XFILLER_68_1435 VGND VGND VPWR VPWR sky130_fd_sc_hd__decap_6
XFILLER_79_56 VPWR VGND VPWR VGND sky130_ef_sc_hd__decap_12
XFILLER_194_1465 VPWR VGND VPWR VGND sky130_ef_sc_hd__decap_12
XFILLER_231_1315 VPWR VGND VPWR VGND sky130_ef_sc_hd__decap_12
XFILLER_249_553 VGND VGND VPWR VPWR sky130_fd_sc_hd__decap_6
XFILLER_1_687 VGND VGND VPWR VPWR sky130_fd_sc_hd__fill_1
XFILLER_27_1165 VPWR VGND VPWR VGND sky130_ef_sc_hd__decap_12
XFILLER_118_1282 VPWR VGND VPWR VGND sky130_ef_sc_hd__decap_12
XFILLER_7_1248 VPWR VGND VPWR VGND sky130_ef_sc_hd__decap_12
XFILLER_95_44 VPWR VGND VPWR VGND sky130_ef_sc_hd__decap_12
XTAP_TAPCELL_ROW_18_2_4802 VGND VPWR sky130_fd_sc_hd__tapvpwrvgnd_1
XTAP_TAPCELL_ROW_180_2042 VGND VPWR sky130_fd_sc_hd__tapvpwrvgnd_1
XTAP_TAPCELL_ROW_180_2053 VGND VPWR sky130_fd_sc_hd__tapvpwrvgnd_1
XTAP_TAPCELL_ROW_180_2064 VGND VPWR sky130_fd_sc_hd__tapvpwrvgnd_1
XFILLER_224_409 VPWR VGND VPWR VGND sky130_ef_sc_hd__decap_12
XFILLER_188_1269 VPWR VGND VPWR VGND sky130_ef_sc_hd__decap_12
X_635_ clknet_3_3__leaf_clk acc_core.adder.cla_blocks\[0\].block.sum\[1\] _043_ VGND
+ VGND VPWR VPWR net54 sky130_fd_sc_hd__dfrtp_1
XFILLER_251_228 VPWR VGND VPWR VGND sky130_ef_sc_hd__decap_12
XFILLER_189_302 VPWR VGND VPWR VGND sky130_ef_sc_hd__decap_12
XFILLER_244_280 VPWR VGND VPWR VGND sky130_ef_sc_hd__decap_12
X_566_ net664 VGND VGND VPWR VPWR _048_ sky130_fd_sc_hd__inv_2
XFILLER_127_1507 VGND VGND VPWR VPWR sky130_fd_sc_hd__decap_8
XFILLER_204_144 VGND VGND VPWR VPWR sky130_fd_sc_hd__decap_6
XFILLER_225_1119 VPWR VGND VPWR VGND sky130_ef_sc_hd__decap_12
XFILLER_189_357 VPWR VGND VPWR VGND sky130_ef_sc_hd__decap_12
XFILLER_205_689 VPWR VGND VPWR VGND sky130_ef_sc_hd__decap_12
XFILLER_232_464 VPWR VGND VPWR VGND sky130_ef_sc_hd__decap_12
XFILLER_242_1422 VPWR VGND VPWR VGND sky130_ef_sc_hd__decap_12
X_497_ _218_ net77 VGND VGND VPWR VPWR acc_core.adder.cla_blocks\[5\].block.sum\[2\]
+ sky130_fd_sc_hd__xnor2_1
XFILLER_220_648 VPWR VGND VPWR VGND sky130_ef_sc_hd__decap_12
XFILLER_38_1294 VPWR VGND VPWR VGND sky130_ef_sc_hd__decap_12
XFILLER_125_1242 VGND VGND VPWR VPWR sky130_fd_sc_hd__decap_6
XFILLER_242_1477 VGND VGND VPWR VPWR sky130_fd_sc_hd__decap_6
XFILLER_185_541 VPWR VGND VPWR VGND sky130_ef_sc_hd__decap_12
XFILLER_201_873 VPWR VGND VPWR VGND sky130_ef_sc_hd__decap_12
XFILLER_160_1177 VGND VGND VPWR VPWR sky130_fd_sc_hd__decap_6
XFILLER_173_725 VGND VGND VPWR VPWR sky130_fd_sc_hd__decap_6
XFILLER_12_1423 VPWR VGND VPWR VGND sky130_ef_sc_hd__decap_12
XFILLER_185_596 VGND VGND VPWR VPWR sky130_fd_sc_hd__decap_6
XFILLER_8_286 VGND VGND VPWR VPWR sky130_fd_sc_hd__fill_1
XFILLER_195_1229 VPWR VGND VPWR VGND sky130_ef_sc_hd__decap_12
XFILLER_201_1174 VPWR VGND VPWR VGND sky130_ef_sc_hd__decap_12
XFILLER_12_1478 VGND VGND VPWR VPWR sky130_fd_sc_hd__decap_6
XFILLER_5_971 VPWR VGND VPWR VGND sky130_ef_sc_hd__decap_12
XTAP_TAPCELL_ROW_94_1_1370 VGND VPWR sky130_fd_sc_hd__tapvpwrvgnd_1
XFILLER_5_42 VGND VGND VPWR VPWR sky130_fd_sc_hd__fill_1
XFILLER_236_1226 VPWR VGND VPWR VGND sky130_ef_sc_hd__decap_12
XFILLER_49_1390 VPWR VGND VPWR VGND sky130_ef_sc_hd__decap_12
XFILLER_84_1270 VPWR VGND VPWR VGND sky130_ef_sc_hd__decap_12
XFILLER_171_1284 VGND VGND VPWR VPWR sky130_fd_sc_hd__decap_6
XTAP_TAPCELL_ROW_160_2_5945 VGND VPWR sky130_fd_sc_hd__tapvpwrvgnd_1
XFILLER_209_940 VGND VGND VPWR VPWR sky130_fd_sc_hd__decap_6
XTAP_TAPCELL_ROW_223_3550 VGND VPWR sky130_fd_sc_hd__tapvpwrvgnd_1
XTAP_TAPCELL_ROW_223_3561 VGND VPWR sky130_fd_sc_hd__tapvpwrvgnd_1
XTAP_TAPCELL_ROW_223_3572 VGND VPWR sky130_fd_sc_hd__tapvpwrvgnd_1
XTAP_TAPCELL_ROW_128_2_5686 VGND VPWR sky130_fd_sc_hd__tapvpwrvgnd_1
XFILLER_212_1281 VPWR VGND VPWR VGND sky130_ef_sc_hd__decap_12
XTAP_TAPCELL_ROW_96_2_5431 VGND VPWR sky130_fd_sc_hd__tapvpwrvgnd_1
XFILLER_255_589 VPWR VGND VPWR VGND sky130_ef_sc_hd__decap_12
XFILLER_242_206 VPWR VGND VPWR VGND sky130_ef_sc_hd__decap_12
XFILLER_165_1000 VGND VGND VPWR VPWR sky130_fd_sc_hd__decap_8
XFILLER_223_431 VPWR VGND VPWR VGND sky130_ef_sc_hd__decap_12
XFILLER_1_1370 VGND VGND VPWR VPWR sky130_fd_sc_hd__decap_6
XFILLER_247_1377 VPWR VGND VPWR VGND sky130_ef_sc_hd__decap_12
XFILLER_211_615 VPWR VGND VPWR VGND sky130_ef_sc_hd__decap_12
XFILLER_250_261 VPWR VGND VPWR VGND sky130_ef_sc_hd__decap_12
XFILLER_91_1230 VPWR VGND VPWR VGND sky130_ef_sc_hd__decap_12
XFILLER_168_519 VPWR VGND VPWR VGND sky130_ef_sc_hd__decap_12
XFILLER_223_486 VPWR VGND VPWR VGND sky130_ef_sc_hd__decap_12
XTAP_TAPCELL_ROW_176_1900 VGND VPWR sky130_fd_sc_hd__tapvpwrvgnd_1
XFILLER_196_839 VPWR VGND VPWR VGND sky130_ef_sc_hd__decap_12
XTAP_TAPCELL_ROW_176_1911 VGND VPWR sky130_fd_sc_hd__tapvpwrvgnd_1
XTAP_TAPCELL_ROW_176_1922 VGND VPWR sky130_fd_sc_hd__tapvpwrvgnd_1
XFILLER_195_338 VGND VGND VPWR VPWR sky130_fd_sc_hd__decap_6
XTAP_TAPCELL_ROW_217_3343 VGND VPWR sky130_fd_sc_hd__tapvpwrvgnd_1
XTAP_TAPCELL_ROW_121_2_5629 VGND VPWR sky130_fd_sc_hd__tapvpwrvgnd_1
XTAP_TAPCELL_ROW_176_1933 VGND VPWR sky130_fd_sc_hd__tapvpwrvgnd_1
XFILLER_182_1391 VGND VGND VPWR VPWR sky130_fd_sc_hd__decap_6
XTAP_TAPCELL_ROW_217_3354 VGND VPWR sky130_fd_sc_hd__tapvpwrvgnd_1
XFILLER_221_1506 VGND VGND VPWR VPWR sky130_fd_sc_hd__decap_8
XFILLER_91_1285 VGND VGND VPWR VPWR sky130_fd_sc_hd__decap_6
XFILLER_188_390 VPWR VGND VPWR VGND sky130_ef_sc_hd__decap_12
XTAP_TAPCELL_ROW_217_3365 VGND VPWR sky130_fd_sc_hd__tapvpwrvgnd_1
XTAP_TAPCELL_ROW_213_3207 VGND VPWR sky130_fd_sc_hd__tapvpwrvgnd_1
XTAP_TAPCELL_ROW_236_3999 VGND VPWR sky130_fd_sc_hd__tapvpwrvgnd_1
XFILLER_17_1378 VPWR VGND VPWR VGND sky130_ef_sc_hd__decap_12
XTAP_TAPCELL_ROW_213_3218 VGND VPWR sky130_fd_sc_hd__tapvpwrvgnd_1
XTAP_TAPCELL_ROW_57_2_5115 VGND VPWR sky130_fd_sc_hd__tapvpwrvgnd_1
XFILLER_104_1337 VPWR VGND VPWR VGND sky130_ef_sc_hd__decap_12
XFILLER_176_574 VGND VGND VPWR VPWR sky130_fd_sc_hd__decap_6
XFILLER_219_1413 VGND VGND VPWR VPWR sky130_fd_sc_hd__decap_6
XFILLER_2_407 VGND VGND VPWR VPWR sky130_fd_sc_hd__fill_1
XFILLER_176_1140 VPWR VGND VPWR VGND sky130_ef_sc_hd__decap_12
XTAP_TAPCELL_ROW_24_2_4856 VGND VPWR sky130_fd_sc_hd__tapvpwrvgnd_1
XFILLER_172_1004 VGND VGND VPWR VPWR sky130_fd_sc_hd__decap_6
XFILLER_254_1348 VGND VGND VPWR VPWR sky130_fd_sc_hd__decap_6
XFILLER_49_15 VPWR VGND VPWR VGND sky130_ef_sc_hd__decap_12
XFILLER_176_1195 VPWR VGND VPWR VGND sky130_ef_sc_hd__decap_12
XFILLER_28_1485 VPWR VGND VPWR VGND sky130_ef_sc_hd__decap_12
XFILLER_115_1433 VPWR VGND VPWR VGND sky130_ef_sc_hd__decap_12
XFILLER_150_1313 VPWR VGND VPWR VGND sky130_ef_sc_hd__decap_12
XFILLER_213_1045 VPWR VGND VPWR VGND sky130_ef_sc_hd__decap_12
XFILLER_24_1349 VGND VGND VPWR VPWR sky130_fd_sc_hd__decap_6
XFILLER_150_1368 VPWR VGND VPWR VGND sky130_ef_sc_hd__decap_12
XFILLER_115_1488 VPWR VGND VPWR VGND sky130_ef_sc_hd__decap_12
XTAP_TAPCELL_ROW_2_930 VGND VPWR sky130_fd_sc_hd__tapvpwrvgnd_1
XFILLER_6_1281 VPWR VGND VPWR VGND sky130_ef_sc_hd__decap_12
XTAP_TAPCELL_ROW_2_941 VGND VPWR sky130_fd_sc_hd__tapvpwrvgnd_1
XFILLER_206_409 VPWR VGND VPWR VGND sky130_ef_sc_hd__decap_12
XTAP_TAPCELL_ROW_2_952 VGND VPWR sky130_fd_sc_hd__tapvpwrvgnd_1
XPHY_EDGE_ROW_122_1_Right_778 VGND VGND VPWR VPWR sky130_fd_sc_hd__decap_3
XTAP_TAPCELL_ROW_2_963 VGND VPWR sky130_fd_sc_hd__tapvpwrvgnd_1
XFILLER_233_228 VPWR VGND VPWR VGND sky130_ef_sc_hd__decap_12
XFILLER_148_1220 VGND VGND VPWR VPWR sky130_fd_sc_hd__decap_6
XFILLER_183_1100 VPWR VGND VPWR VGND sky130_ef_sc_hd__decap_12
X_420_ net106 net120 net127 VGND VGND VPWR VPWR _209_ sky130_fd_sc_hd__a21oi_1
XFILLER_226_280 VPWR VGND VPWR VGND sky130_ef_sc_hd__decap_12
XFILLER_187_1291 VPWR VGND VPWR VGND sky130_ef_sc_hd__decap_12
XFILLER_96_1196 VPWR VGND VPWR VGND sky130_ef_sc_hd__decap_12
XFILLER_198_132 VPWR VGND VPWR VGND sky130_ef_sc_hd__decap_12
XFILLER_214_464 VPWR VGND VPWR VGND sky130_ef_sc_hd__decap_12
XFILLER_157_3 VPWR VGND VPWR VGND sky130_ef_sc_hd__decap_12
XFILLER_183_1155 VGND VGND VPWR VPWR sky130_fd_sc_hd__decap_6
X_351_ net594 net573 net543 VGND VGND VPWR VPWR _140_ sky130_fd_sc_hd__a21oi_1
XFILLER_241_283 VPWR VGND VPWR VGND sky130_ef_sc_hd__decap_12
XFILLER_186_316 VGND VGND VPWR VPWR sky130_fd_sc_hd__decap_6
XFILLER_202_648 VPWR VGND VPWR VGND sky130_ef_sc_hd__decap_12
XFILLER_81_68 VGND VGND VPWR VPWR sky130_fd_sc_hd__decap_3
XFILLER_198_187 VGND VGND VPWR VPWR sky130_fd_sc_hd__decap_6
XFILLER_230_968 VPWR VGND VPWR VGND sky130_ef_sc_hd__decap_12
XFILLER_70_1325 VPWR VGND VPWR VGND sky130_ef_sc_hd__decap_12
XFILLER_35_1445 VPWR VGND VPWR VGND sky130_ef_sc_hd__decap_12
XFILLER_224_1152 VPWR VGND VPWR VGND sky130_ef_sc_hd__decap_12
XTAP_TAPCELL_ROW_113_1_1399 VGND VPWR sky130_fd_sc_hd__tapvpwrvgnd_1
XFILLER_197_68 VPWR VGND VPWR VGND sky130_ef_sc_hd__decap_12
XFILLER_167_541 VPWR VGND VPWR VGND sky130_ef_sc_hd__decap_12
XFILLER_161_1464 VPWR VGND VPWR VGND sky130_ef_sc_hd__decap_12
XFILLER_195_861 VPWR VGND VPWR VGND sky130_ef_sc_hd__decap_12
XFILLER_6_702 VGND VGND VPWR VPWR sky130_fd_sc_hd__decap_6
XTAP_TAPCELL_ROW_192_2480 VGND VPWR sky130_fd_sc_hd__tapvpwrvgnd_1
XFILLER_6_713 VPWR VGND VPWR VGND sky130_ef_sc_hd__decap_12
XFILLER_167_596 VGND VGND VPWR VPWR sky130_fd_sc_hd__decap_6
XTAP_TAPCELL_ROW_192_2491 VGND VPWR sky130_fd_sc_hd__tapvpwrvgnd_1
XPHY_EDGE_ROW_102_2_Left_604 VGND VGND VPWR VPWR sky130_fd_sc_hd__decap_3
XFILLER_6_779 VPWR VGND VPWR VGND sky130_ef_sc_hd__decap_12
XFILLER_159_1371 VGND VGND VPWR VPWR sky130_fd_sc_hd__decap_6
XFILLER_194_1262 VGND VGND VPWR VPWR sky130_fd_sc_hd__decap_6
XFILLER_29_1249 VPWR VGND VPWR VGND sky130_ef_sc_hd__decap_12
XFILLER_116_1208 VPWR VGND VPWR VGND sky130_ef_sc_hd__decap_12
XFILLER_81_1421 VPWR VGND VPWR VGND sky130_ef_sc_hd__decap_12
XTAP_TAPCELL_ROW_186_2251 VGND VPWR sky130_fd_sc_hd__tapvpwrvgnd_1
XFILLER_133_1500 VGND VGND VPWR VPWR sky130_fd_sc_hd__decap_6
XTAP_TAPCELL_ROW_186_2262 VGND VPWR sky130_fd_sc_hd__tapvpwrvgnd_1
XTAP_TAPCELL_ROW_186_2273 VGND VPWR sky130_fd_sc_hd__tapvpwrvgnd_1
XTAP_TAPCELL_ROW_145_2_5825 VGND VPWR sky130_fd_sc_hd__tapvpwrvgnd_1
XTAP_TAPCELL_ROW_182_2115 VGND VPWR sky130_fd_sc_hd__tapvpwrvgnd_1
XFILLER_231_1112 VGND VGND VPWR VPWR sky130_fd_sc_hd__decap_6
XPHY_EDGE_ROW_84_1_Right_740 VGND VGND VPWR VPWR sky130_fd_sc_hd__decap_3
XTAP_TAPCELL_ROW_182_2126 VGND VPWR sky130_fd_sc_hd__tapvpwrvgnd_1
XFILLER_81_1476 VPWR VGND VPWR VGND sky130_ef_sc_hd__decap_12
XTAP_TAPCELL_ROW_114_2_5572 VGND VPWR sky130_fd_sc_hd__tapvpwrvgnd_1
XFILLER_7_1045 VPWR VGND VPWR VGND sky130_ef_sc_hd__decap_12
XTAP_TAPCELL_ROW_182_2137 VGND VPWR sky130_fd_sc_hd__tapvpwrvgnd_1
XFILLER_188_1011 VPWR VGND VPWR VGND sky130_ef_sc_hd__decap_12
XFILLER_224_206 VPWR VGND VPWR VGND sky130_ef_sc_hd__decap_12
XFILLER_188_1066 VPWR VGND VPWR VGND sky130_ef_sc_hd__decap_12
XFILLER_40_1184 VPWR VGND VPWR VGND sky130_ef_sc_hd__decap_12
X_618_ clknet_3_7__leaf_clk dout0\[16\] _026_ VGND VGND VPWR VPWR dout0_q\[16\] sky130_fd_sc_hd__dfrtp_1
XFILLER_205_431 VPWR VGND VPWR VGND sky130_ef_sc_hd__decap_12
XTAP_TAPCELL_ROW_63_2_5169 VGND VPWR sky130_fd_sc_hd__tapvpwrvgnd_1
XFILLER_127_1304 VPWR VGND VPWR VGND sky130_ef_sc_hd__decap_12
XTAP_TAPCELL_ROW_106_2_5509 VGND VPWR sky130_fd_sc_hd__tapvpwrvgnd_1
XFILLER_189_154 VPWR VGND VPWR VGND sky130_ef_sc_hd__decap_12
XFILLER_232_261 VPWR VGND VPWR VGND sky130_ef_sc_hd__decap_12
X_549_ net669 VGND VGND VPWR VPWR _031_ sky130_fd_sc_hd__inv_2
XFILLER_205_486 VPWR VGND VPWR VGND sky130_ef_sc_hd__decap_12
XFILLER_178_839 VPWR VGND VPWR VGND sky130_ef_sc_hd__decap_12
XFILLER_162_1239 VPWR VGND VPWR VGND sky130_ef_sc_hd__decap_12
XFILLER_127_1359 VPWR VGND VPWR VGND sky130_ef_sc_hd__decap_12
XFILLER_177_338 VGND VGND VPWR VPWR sky130_fd_sc_hd__decap_6
XFILLER_220_445 VGND VGND VPWR VPWR sky130_fd_sc_hd__decap_6
XTAP_TAPCELL_ROW_30_2_4899 VGND VPWR sky130_fd_sc_hd__tapvpwrvgnd_1
XFILLER_201_670 VPWR VGND VPWR VGND sky130_ef_sc_hd__decap_12
XPHY_EDGE_ROW_34_2_Left_536 VGND VGND VPWR VPWR sky130_fd_sc_hd__decap_3
XFILLER_72_3 VPWR VGND VPWR VGND sky130_ef_sc_hd__decap_12
XFILLER_186_894 VPWR VGND VPWR VGND sky130_ef_sc_hd__decap_12
XTAP_TAPCELL_ROW_231_3830 VGND VPWR sky130_fd_sc_hd__tapvpwrvgnd_1
XTAP_TAPCELL_ROW_231_3841 VGND VPWR sky130_fd_sc_hd__tapvpwrvgnd_1
XFILLER_12_1220 VGND VGND VPWR VPWR sky130_fd_sc_hd__decap_6
XFILLER_199_1162 VPWR VGND VPWR VGND sky130_ef_sc_hd__decap_12
XTAP_TAPCELL_ROW_231_3852 VGND VPWR sky130_fd_sc_hd__tapvpwrvgnd_1
XTAP_TAPCELL_ROW_10_2_4742 VGND VPWR sky130_fd_sc_hd__tapvpwrvgnd_1
XFILLER_195_1026 VGND VGND VPWR VPWR sky130_fd_sc_hd__decap_6
XPHY_EDGE_ROW_159_2_Left_661 VGND VGND VPWR VPWR sky130_fd_sc_hd__decap_3
XFILLER_138_1411 VPWR VGND VPWR VGND sky130_ef_sc_hd__decap_12
XFILLER_47_1316 VPWR VGND VPWR VGND sky130_ef_sc_hd__decap_12
XFILLER_236_1023 VPWR VGND VPWR VGND sky130_ef_sc_hd__decap_12
XFILLER_138_1466 VPWR VGND VPWR VGND sky130_ef_sc_hd__decap_12
XFILLER_173_1346 VPWR VGND VPWR VGND sky130_ef_sc_hd__decap_12
XFILLER_236_1078 VPWR VGND VPWR VGND sky130_ef_sc_hd__decap_12
XTAP_TAPCELL_ROW_229_3770 VGND VPWR sky130_fd_sc_hd__tapvpwrvgnd_1
XFILLER_253_1370 VGND VGND VPWR VPWR sky130_fd_sc_hd__decap_6
XPHY_EDGE_ROW_20_2_Right_111 VGND VGND VPWR VPWR sky130_fd_sc_hd__decap_3
XTAP_TAPCELL_ROW_229_3781 VGND VPWR sky130_fd_sc_hd__tapvpwrvgnd_1
XTAP_TAPCELL_ROW_225_3623 VGND VPWR sky130_fd_sc_hd__tapvpwrvgnd_1
XTAP_TAPCELL_ROW_225_3634 VGND VPWR sky130_fd_sc_hd__tapvpwrvgnd_1
XTAP_TAPCELL_ROW_225_3645 VGND VPWR sky130_fd_sc_hd__tapvpwrvgnd_1
XFILLER_210_1207 VPWR VGND VPWR VGND sky130_ef_sc_hd__decap_12
XFILLER_214_1398 VPWR VGND VPWR VGND sky130_ef_sc_hd__decap_12
XFILLER_3_1432 VPWR VGND VPWR VGND sky130_ef_sc_hd__decap_12
XFILLER_23_1371 VGND VGND VPWR VPWR sky130_fd_sc_hd__decap_6
XFILLER_215_228 VPWR VGND VPWR VGND sky130_ef_sc_hd__decap_12
XFILLER_208_280 VPWR VGND VPWR VGND sky130_ef_sc_hd__decap_12
XFILLER_58_1423 VPWR VGND VPWR VGND sky130_ef_sc_hd__decap_12
XPHY_EDGE_ROW_48_1_Left_303 VGND VGND VPWR VPWR sky130_fd_sc_hd__decap_3
XFILLER_35_39 VGND VGND VPWR VPWR sky130_fd_sc_hd__decap_4
XFILLER_3_1487 VPWR VGND VPWR VGND sky130_ef_sc_hd__decap_12
XTAP_TAPCELL_ROW_219_3405 VGND VPWR sky130_fd_sc_hd__tapvpwrvgnd_1
XFILLER_184_1453 VPWR VGND VPWR VGND sky130_ef_sc_hd__decap_12
XTAP_TAPCELL_ROW_219_3416 VGND VPWR sky130_fd_sc_hd__tapvpwrvgnd_1
XFILLER_247_1174 VPWR VGND VPWR VGND sky130_ef_sc_hd__decap_12
XFILLER_93_1347 VPWR VGND VPWR VGND sky130_ef_sc_hd__decap_12
XTAP_TAPCELL_ROW_219_3427 VGND VPWR sky130_fd_sc_hd__tapvpwrvgnd_1
XFILLER_58_1478 VGND VGND VPWR VPWR sky130_fd_sc_hd__decap_6
XPHY_EDGE_ROW_100_1_Left_355 VGND VGND VPWR VPWR sky130_fd_sc_hd__decap_3
XFILLER_211_412 VPWR VGND VPWR VGND sky130_ef_sc_hd__decap_12
XTAP_TAPCELL_ROW_219_3438 VGND VPWR sky130_fd_sc_hd__tapvpwrvgnd_1
XFILLER_168_316 VGND VGND VPWR VPWR sky130_fd_sc_hd__decap_6
XFILLER_223_283 VPWR VGND VPWR VGND sky130_ef_sc_hd__decap_12
XFILLER_196_636 VPWR VGND VPWR VGND sky130_ef_sc_hd__decap_12
XFILLER_212_968 VPWR VGND VPWR VGND sky130_ef_sc_hd__decap_12
XFILLER_221_1303 VPWR VGND VPWR VGND sky130_ef_sc_hd__decap_12
XFILLER_51_27 VPWR VGND VPWR VGND sky130_ef_sc_hd__decap_12
XFILLER_211_467 VGND VGND VPWR VPWR sky130_fd_sc_hd__decap_6
Xwire408 net409 VGND VGND VPWR VPWR net408 sky130_fd_sc_hd__clkbuf_1
XFILLER_108_1270 VPWR VGND VPWR VGND sky130_ef_sc_hd__decap_12
XFILLER_177_861 VPWR VGND VPWR VGND sky130_ef_sc_hd__decap_12
Xwire419 net420 VGND VGND VPWR VPWR net419 sky130_fd_sc_hd__clkbuf_1
XFILLER_167_27 VPWR VGND VPWR VGND sky130_ef_sc_hd__decap_12
XFILLER_192_820 VPWR VGND VPWR VGND sky130_ef_sc_hd__decap_12
XFILLER_221_1358 VPWR VGND VPWR VGND sky130_ef_sc_hd__decap_12
XTAP_TAPCELL_ROW_151_2_5868 VGND VPWR sky130_fd_sc_hd__tapvpwrvgnd_1
XFILLER_192_875 VGND VGND VPWR VPWR sky130_fd_sc_hd__decap_6
XTAP_TAPCELL_ROW_87_2_5354 VGND VPWR sky130_fd_sc_hd__tapvpwrvgnd_1
XFILLER_183_15 VPWR VGND VPWR VGND sky130_ef_sc_hd__decap_12
XFILLER_3_738 VGND VGND VPWR VPWR sky130_fd_sc_hd__fill_1
XFILLER_191_1413 VGND VGND VPWR VPWR sky130_fd_sc_hd__decap_6
XFILLER_2_237 VPWR VGND VPWR VGND sky130_ef_sc_hd__decap_12
XTAP_TAPCELL_ROW_131_2_5711 VGND VPWR sky130_fd_sc_hd__tapvpwrvgnd_1
XPHY_EDGE_ROW_80_2_Left_582 VGND VGND VPWR VPWR sky130_fd_sc_hd__decap_3
XFILLER_232_1410 VPWR VGND VPWR VGND sky130_ef_sc_hd__decap_12
XFILLER_28_1282 VPWR VGND VPWR VGND sky130_ef_sc_hd__decap_12
XFILLER_115_1230 VPWR VGND VPWR VGND sky130_ef_sc_hd__decap_12
XFILLER_76_46 VPWR VGND VPWR VGND sky130_ef_sc_hd__decap_12
XFILLER_232_1465 VPWR VGND VPWR VGND sky130_ef_sc_hd__decap_12
XFILLER_4_1207 VPWR VGND VPWR VGND sky130_ef_sc_hd__decap_12
XFILLER_247_854 VGND VGND VPWR VPWR sky130_fd_sc_hd__decap_6
XTAP_TAPCELL_ROW_241_4181 VGND VPWR sky130_fd_sc_hd__tapvpwrvgnd_1
XFILLER_8_1398 VPWR VGND VPWR VGND sky130_ef_sc_hd__decap_12
Xfanout596 net598 VGND VGND VPWR VPWR net596 sky130_fd_sc_hd__clkbuf_2
XTAP_TAPCELL_ROW_241_4192 VGND VPWR sky130_fd_sc_hd__tapvpwrvgnd_1
XFILLER_115_1285 VGND VGND VPWR VPWR sky130_fd_sc_hd__decap_6
XFILLER_150_1165 VPWR VGND VPWR VGND sky130_ef_sc_hd__decap_12
XFILLER_206_206 VPWR VGND VPWR VGND sky130_ef_sc_hd__decap_12
XTAP_TAPCELL_ROW_48_2_5049 VGND VPWR sky130_fd_sc_hd__tapvpwrvgnd_1
XFILLER_185_1217 VPWR VGND VPWR VGND sky130_ef_sc_hd__decap_12
XFILLER_92_34 VPWR VGND VPWR VGND sky130_ef_sc_hd__decap_12
XPHY_EDGE_ROW_123_1_Right_779 VGND VGND VPWR VPWR sky130_fd_sc_hd__decap_3
XPHY_EDGE_ROW_32_1_Left_287 VGND VGND VPWR VPWR sky130_fd_sc_hd__decap_3
XFILLER_37_1507 VGND VGND VPWR VPWR sky130_fd_sc_hd__decap_8
XFILLER_221_209 VGND VGND VPWR VPWR sky130_fd_sc_hd__decap_6
X_403_ net571 net591 net590 VGND VGND VPWR VPWR _192_ sky130_fd_sc_hd__and3_1
XFILLER_187_603 VPWR VGND VPWR VGND sky130_ef_sc_hd__decap_12
XFILLER_214_261 VPWR VGND VPWR VGND sky130_ef_sc_hd__decap_12
XFILLER_230_710 VPWR VGND VPWR VGND sky130_ef_sc_hd__decap_12
XFILLER_242_581 VPWR VGND VPWR VGND sky130_ef_sc_hd__decap_12
XFILLER_199_474 VPWR VGND VPWR VGND sky130_ef_sc_hd__decap_12
XTAP_TAPCELL_ROW_15_2_4779 VGND VPWR sky130_fd_sc_hd__tapvpwrvgnd_1
XTAP_TAPCELL_ROW_194_2531 VGND VPWR sky130_fd_sc_hd__tapvpwrvgnd_1
XTAP_TAPCELL_ROW_194_2542 VGND VPWR sky130_fd_sc_hd__tapvpwrvgnd_1
XFILLER_202_445 VGND VGND VPWR VPWR sky130_fd_sc_hd__decap_6
XFILLER_226_1269 VPWR VGND VPWR VGND sky130_ef_sc_hd__decap_12
X_334_ net595 dout0_q\[18\] net538 VGND VGND VPWR VPWR _123_ sky130_fd_sc_hd__and3_1
XFILLER_187_658 VPWR VGND VPWR VGND sky130_ef_sc_hd__decap_12
XTAP_TAPCELL_ROW_194_2553 VGND VPWR sky130_fd_sc_hd__tapvpwrvgnd_1
XFILLER_230_765 VPWR VGND VPWR VGND sky130_ef_sc_hd__decap_12
XFILLER_35_1242 VGND VGND VPWR VPWR sky130_fd_sc_hd__decap_6
XTAP_TAPCELL_ROW_190_2406 VGND VPWR sky130_fd_sc_hd__tapvpwrvgnd_1
XTAP_TAPCELL_ROW_190_2417 VGND VPWR sky130_fd_sc_hd__tapvpwrvgnd_1
XFILLER_161_1261 VPWR VGND VPWR VGND sky130_ef_sc_hd__decap_12
XTAP_TAPCELL_ROW_47_1_1300 VGND VPWR sky130_fd_sc_hd__tapvpwrvgnd_1
XFILLER_211_990 VPWR VGND VPWR VGND sky130_ef_sc_hd__decap_12
XFILLER_126_1392 VGND VGND VPWR VPWR sky130_fd_sc_hd__decap_6
XFILLER_168_894 VPWR VGND VPWR VGND sky130_ef_sc_hd__decap_12
XFILLER_70_1177 VGND VGND VPWR VPWR sky130_fd_sc_hd__decap_6
XFILLER_183_842 VPWR VGND VPWR VGND sky130_ef_sc_hd__decap_12
XFILLER_196_1324 VPWR VGND VPWR VGND sky130_ef_sc_hd__decap_12
XFILLER_183_897 VGND VGND VPWR VPWR sky130_fd_sc_hd__decap_6
XFILLER_6_587 VGND VGND VPWR VPWR sky130_fd_sc_hd__fill_2
XFILLER_196_1379 VPWR VGND VPWR VGND sky130_ef_sc_hd__decap_12
XTAP_TAPCELL_ROW_188_2324 VGND VPWR sky130_fd_sc_hd__tapvpwrvgnd_1
XTAP_TAPCELL_ROW_188_2335 VGND VPWR sky130_fd_sc_hd__tapvpwrvgnd_1
XTAP_TAPCELL_ROW_188_2346 VGND VPWR sky130_fd_sc_hd__tapvpwrvgnd_1
XFILLER_170_1508 VGND VGND VPWR VPWR sky130_fd_sc_hd__decap_6
XFILLER_233_1229 VPWR VGND VPWR VGND sky130_ef_sc_hd__decap_12
XFILLER_81_1273 VPWR VGND VPWR VGND sky130_ef_sc_hd__decap_12
XFILLER_238_832 VGND VGND VPWR VPWR sky130_fd_sc_hd__decap_6
XPHY_EDGE_ROW_85_1_Right_741 VGND VGND VPWR VPWR sky130_fd_sc_hd__decap_3
XFILLER_2_65 VPWR VGND VPWR VGND sky130_ef_sc_hd__decap_12
XFILLER_252_323 VPWR VGND VPWR VGND sky130_ef_sc_hd__decap_12
XFILLER_209_1401 VPWR VGND VPWR VGND sky130_ef_sc_hd__decap_12
XFILLER_240_507 VPWR VGND VPWR VGND sky130_ef_sc_hd__decap_12
XFILLER_252_378 VPWR VGND VPWR VGND sky130_ef_sc_hd__decap_12
XFILLER_244_1336 VPWR VGND VPWR VGND sky130_ef_sc_hd__decap_12
XFILLER_90_1509 VGND VGND VPWR VPWR sky130_fd_sc_hd__decap_6
XFILLER_209_1456 VGND VGND VPWR VPWR sky130_fd_sc_hd__decap_6
XFILLER_205_283 VPWR VGND VPWR VGND sky130_ef_sc_hd__decap_12
XFILLER_221_732 VPWR VGND VPWR VGND sky130_ef_sc_hd__decap_12
XFILLER_166_1183 VPWR VGND VPWR VGND sky130_ef_sc_hd__decap_12
XFILLER_178_636 VPWR VGND VPWR VGND sky130_ef_sc_hd__decap_12
XTAP_TAPCELL_ROW_233_3903 VGND VPWR sky130_fd_sc_hd__tapvpwrvgnd_1
XFILLER_92_1380 VPWR VGND VPWR VGND sky130_ef_sc_hd__decap_12
XTAP_TAPCELL_ROW_82_1_1352 VGND VPWR sky130_fd_sc_hd__tapvpwrvgnd_1
XFILLER_221_787 VPWR VGND VPWR VGND sky130_ef_sc_hd__decap_12
XTAP_TAPCELL_ROW_233_3914 VGND VPWR sky130_fd_sc_hd__tapvpwrvgnd_1
XFILLER_127_1189 VPWR VGND VPWR VGND sky130_ef_sc_hd__decap_12
XTAP_TAPCELL_ROW_233_3925 VGND VPWR sky130_fd_sc_hd__tapvpwrvgnd_1
XFILLER_105_1421 VPWR VGND VPWR VGND sky130_ef_sc_hd__decap_12
XFILLER_193_639 VGND VGND VPWR VPWR sky130_fd_sc_hd__decap_6
XFILLER_203_1033 VPWR VGND VPWR VGND sky130_ef_sc_hd__decap_12
XFILLER_14_1337 VPWR VGND VPWR VGND sky130_ef_sc_hd__decap_12
XTAP_TAPCELL_ROW_136_2_5748 VGND VPWR sky130_fd_sc_hd__tapvpwrvgnd_1
XFILLER_174_820 VPWR VGND VPWR VGND sky130_ef_sc_hd__decap_12
XFILLER_9_370 VGND VGND VPWR VPWR sky130_fd_sc_hd__decap_8
XFILLER_186_691 VPWR VGND VPWR VGND sky130_ef_sc_hd__decap_12
XFILLER_105_1476 VPWR VGND VPWR VGND sky130_ef_sc_hd__decap_12
XFILLER_140_1356 VPWR VGND VPWR VGND sky130_ef_sc_hd__decap_12
XFILLER_203_1088 VPWR VGND VPWR VGND sky130_ef_sc_hd__decap_12
XFILLER_174_875 VGND VGND VPWR VPWR sky130_fd_sc_hd__decap_6
XFILLER_220_1391 VGND VGND VPWR VPWR sky130_fd_sc_hd__decap_6
XTAP_TAPCELL_ROW_227_3707 VGND VPWR sky130_fd_sc_hd__tapvpwrvgnd_1
XFILLER_86_1184 VPWR VGND VPWR VGND sky130_ef_sc_hd__decap_12
XTAP_TAPCELL_ROW_227_3718 VGND VPWR sky130_fd_sc_hd__tapvpwrvgnd_1
XTAP_TAPCELL_ROW_40_2_4981 VGND VPWR sky130_fd_sc_hd__tapvpwrvgnd_1
XFILLER_173_1143 VPWR VGND VPWR VGND sky130_ef_sc_hd__decap_12
XTAP_TAPCELL_ROW_39_2_4975 VGND VPWR sky130_fd_sc_hd__tapvpwrvgnd_1
XFILLER_138_1263 VGND VGND VPWR VPWR sky130_fd_sc_hd__decap_6
XFILLER_60_1313 VPWR VGND VPWR VGND sky130_ef_sc_hd__decap_12
XPHY_EDGE_ROW_21_2_Right_112 VGND VGND VPWR VPWR sky130_fd_sc_hd__decap_3
XFILLER_173_1198 VGND VGND VPWR VPWR sky130_fd_sc_hd__decap_6
XFILLER_214_1140 VPWR VGND VPWR VGND sky130_ef_sc_hd__decap_12
XFILLER_25_1433 VPWR VGND VPWR VGND sky130_ef_sc_hd__decap_12
XFILLER_210_1004 VGND VGND VPWR VPWR sky130_fd_sc_hd__decap_6
XFILLER_229_854 VGND VGND VPWR VPWR sky130_fd_sc_hd__decap_6
XFILLER_214_1195 VPWR VGND VPWR VGND sky130_ef_sc_hd__decap_12
XFILLER_60_1368 VPWR VGND VPWR VGND sky130_ef_sc_hd__decap_12
XFILLER_25_1488 VPWR VGND VPWR VGND sky130_ef_sc_hd__decap_12
XTAP_TAPCELL_ROW_165_1486 VGND VPWR sky130_fd_sc_hd__tapvpwrvgnd_1
XTAP_TAPCELL_ROW_32_2_4918 VGND VPWR sky130_fd_sc_hd__tapvpwrvgnd_1
XTAP_TAPCELL_ROW_165_1497 VGND VPWR sky130_fd_sc_hd__tapvpwrvgnd_1
XFILLER_243_345 VPWR VGND VPWR VGND sky130_ef_sc_hd__decap_12
XFILLER_58_1220 VGND VGND VPWR VPWR sky130_fd_sc_hd__decap_6
XFILLER_3_1284 VGND VGND VPWR VPWR sky130_fd_sc_hd__decap_6
XFILLER_102_22 VPWR VGND VPWR VGND sky130_ef_sc_hd__decap_12
XFILLER_203_209 VGND VGND VPWR VPWR sky130_fd_sc_hd__decap_6
XFILLER_145_1201 VGND VGND VPWR VPWR sky130_fd_sc_hd__decap_4
XFILLER_169_603 VPWR VGND VPWR VGND sky130_ef_sc_hd__decap_12
XFILLER_184_1250 VPWR VGND VPWR VGND sky130_ef_sc_hd__decap_12
XFILLER_212_710 VPWR VGND VPWR VGND sky130_ef_sc_hd__decap_12
XFILLER_231_529 VPWR VGND VPWR VGND sky130_ef_sc_hd__decap_12
XFILLER_224_581 VPWR VGND VPWR VGND sky130_ef_sc_hd__decap_12
XFILLER_93_1177 VPWR VGND VPWR VGND sky130_ef_sc_hd__decap_12
XFILLER_178_15 VGND VGND VPWR VPWR sky130_fd_sc_hd__decap_6
XFILLER_196_433 VPWR VGND VPWR VGND sky130_ef_sc_hd__decap_12
XFILLER_212_765 VPWR VGND VPWR VGND sky130_ef_sc_hd__decap_12
XFILLER_169_658 VPWR VGND VPWR VGND sky130_ef_sc_hd__decap_12
XFILLER_8_808 VPWR VGND VPWR VGND sky130_ef_sc_hd__decap_12
XFILLER_221_1100 VPWR VGND VPWR VGND sky130_ef_sc_hd__decap_12
XFILLER_184_617 VGND VGND VPWR VPWR sky130_fd_sc_hd__decap_6
XFILLER_200_949 VPWR VGND VPWR VGND sky130_ef_sc_hd__decap_12
XFILLER_71_1464 VPWR VGND VPWR VGND sky130_ef_sc_hd__decap_12
XFILLER_196_488 VGND VGND VPWR VPWR sky130_fd_sc_hd__decap_6
XFILLER_225_1291 VPWR VGND VPWR VGND sky130_ef_sc_hd__decap_12
Xwire227 net228 VGND VGND VPWR VPWR net227 sky130_fd_sc_hd__clkbuf_1
XFILLER_165_820 VPWR VGND VPWR VGND sky130_ef_sc_hd__decap_12
Xwire238 net239 VGND VGND VPWR VPWR net238 sky130_fd_sc_hd__clkbuf_1
XFILLER_221_1155 VGND VGND VPWR VPWR sky130_fd_sc_hd__decap_6
Xwire249 _151_ VGND VGND VPWR VPWR net249 sky130_fd_sc_hd__clkbuf_1
XFILLER_165_853 VGND VGND VPWR VPWR sky130_fd_sc_hd__decap_8
XFILLER_178_1054 VPWR VGND VPWR VGND sky130_ef_sc_hd__decap_12
XFILLER_194_58 VGND VGND VPWR VPWR sky130_fd_sc_hd__decap_6
XFILLER_69_1371 VGND VGND VPWR VPWR sky130_fd_sc_hd__decap_6
XTAP_TAPCELL_ROW_247_4390 VGND VPWR sky130_fd_sc_hd__tapvpwrvgnd_1
XFILLER_26_1208 VPWR VGND VPWR VGND sky130_ef_sc_hd__decap_12
XFILLER_87_56 VPWR VGND VPWR VGND sky130_ef_sc_hd__decap_12
XTAP_TAPCELL_ROW_243_4254 VGND VPWR sky130_fd_sc_hd__tapvpwrvgnd_1
XFILLER_43_1500 VGND VGND VPWR VPWR sky130_fd_sc_hd__decap_6
XFILLER_117_1347 VPWR VGND VPWR VGND sky130_ef_sc_hd__decap_12
XFILLER_152_1227 VPWR VGND VPWR VGND sky130_ef_sc_hd__decap_12
XTAP_TAPCELL_ROW_243_4265 VGND VPWR sky130_fd_sc_hd__tapvpwrvgnd_1
XTAP_TAPCELL_ROW_243_4276 VGND VPWR sky130_fd_sc_hd__tapvpwrvgnd_1
XFILLER_8_1140 VPWR VGND VPWR VGND sky130_ef_sc_hd__decap_12
XFILLER_4_1004 VGND VGND VPWR VPWR sky130_fd_sc_hd__decap_6
XTAP_TAPCELL_ROW_161_2_5950 VGND VPWR sky130_fd_sc_hd__tapvpwrvgnd_1
XFILLER_232_1262 VGND VGND VPWR VPWR sky130_fd_sc_hd__decap_6
XFILLER_8_1195 VPWR VGND VPWR VGND sky130_ef_sc_hd__decap_12
XTAP_TAPCELL_ROW_129_2_5691 VGND VPWR sky130_fd_sc_hd__tapvpwrvgnd_1
XTAP_TAPCELL_ROW_9_1190 VGND VPWR sky130_fd_sc_hd__tapvpwrvgnd_1
XTAP_TAPCELL_ROW_5_1043 VGND VPWR sky130_fd_sc_hd__tapvpwrvgnd_1
XFILLER_234_323 VPWR VGND VPWR VGND sky130_ef_sc_hd__decap_12
XFILLER_246_194 VPWR VGND VPWR VGND sky130_ef_sc_hd__decap_12
XTAP_TAPCELL_ROW_5_1054 VGND VPWR sky130_fd_sc_hd__tapvpwrvgnd_1
XFILLER_185_1014 VPWR VGND VPWR VGND sky130_ef_sc_hd__decap_12
XTAP_TAPCELL_ROW_5_1065 VGND VPWR sky130_fd_sc_hd__tapvpwrvgnd_1
XTAP_TAPCELL_ROW_196_2604 VGND VPWR sky130_fd_sc_hd__tapvpwrvgnd_1
XFILLER_222_507 VPWR VGND VPWR VGND sky130_ef_sc_hd__decap_12
XTAP_TAPCELL_ROW_196_2615 VGND VPWR sky130_fd_sc_hd__tapvpwrvgnd_1
XFILLER_234_378 VPWR VGND VPWR VGND sky130_ef_sc_hd__decap_12
XTAP_TAPCELL_ROW_237_4036 VGND VPWR sky130_fd_sc_hd__tapvpwrvgnd_1
XFILLER_185_1069 VGND VGND VPWR VPWR sky130_fd_sc_hd__decap_6
XTAP_TAPCELL_ROW_196_2626 VGND VPWR sky130_fd_sc_hd__tapvpwrvgnd_1
XFILLER_226_1011 VPWR VGND VPWR VGND sky130_ef_sc_hd__decap_12
XTAP_TAPCELL_ROW_237_4047 VGND VPWR sky130_fd_sc_hd__tapvpwrvgnd_1
XFILLER_37_1304 VPWR VGND VPWR VGND sky130_ef_sc_hd__decap_12
XTAP_TAPCELL_ROW_237_4058 VGND VPWR sky130_fd_sc_hd__tapvpwrvgnd_1
XFILLER_187_400 VPWR VGND VPWR VGND sky130_ef_sc_hd__decap_12
XFILLER_203_732 VPWR VGND VPWR VGND sky130_ef_sc_hd__decap_12
XFILLER_199_271 VPWR VGND VPWR VGND sky130_ef_sc_hd__decap_12
XTAP_TAPCELL_ROW_78_2_5288 VGND VPWR sky130_fd_sc_hd__tapvpwrvgnd_1
XFILLER_128_1454 VPWR VGND VPWR VGND sky130_ef_sc_hd__decap_12
XFILLER_37_1359 VPWR VGND VPWR VGND sky130_ef_sc_hd__decap_12
XFILLER_72_1239 VPWR VGND VPWR VGND sky130_ef_sc_hd__decap_12
XTAP_TAPCELL_ROW_122_2_5634 VGND VPWR sky130_fd_sc_hd__tapvpwrvgnd_1
XFILLER_226_1066 VPWR VGND VPWR VGND sky130_ef_sc_hd__decap_12
XFILLER_187_455 VPWR VGND VPWR VGND sky130_ef_sc_hd__decap_12
XFILLER_230_562 VPWR VGND VPWR VGND sky130_ef_sc_hd__decap_12
XFILLER_163_1378 VPWR VGND VPWR VGND sky130_ef_sc_hd__decap_12
XFILLER_203_787 VPWR VGND VPWR VGND sky130_ef_sc_hd__decap_12
X_317_ net507 _105_ VGND VGND VPWR VPWR _106_ sky130_fd_sc_hd__or2_1
XFILLER_175_639 VGND VGND VPWR VPWR sky130_fd_sc_hd__decap_6
Xinput13 wr_data[12] VGND VGND VPWR VPWR net13 sky130_fd_sc_hd__clkbuf_1
XFILLER_168_691 VPWR VGND VPWR VGND sky130_ef_sc_hd__decap_12
Xinput24 wr_data[22] VGND VGND VPWR VPWR net24 sky130_fd_sc_hd__clkbuf_1
Xinput35 wr_data[3] VGND VGND VPWR VPWR net35 sky130_fd_sc_hd__clkbuf_1
XFILLER_196_1121 VPWR VGND VPWR VGND sky130_ef_sc_hd__decap_12
Xmax_cap516 net517 VGND VGND VPWR VPWR net516 sky130_fd_sc_hd__clkbuf_1
XFILLER_7_885 VPWR VGND VPWR VGND sky130_ef_sc_hd__decap_12
Xmax_cap527 net64 VGND VGND VPWR VPWR net527 sky130_fd_sc_hd__clkbuf_1
Xmax_cap538 net52 VGND VGND VPWR VPWR net538 sky130_fd_sc_hd__clkbuf_1
XTAP_TAPCELL_ROW_25_2_4861 VGND VPWR sky130_fd_sc_hd__tapvpwrvgnd_1
XFILLER_196_1176 VGND VGND VPWR VPWR sky130_fd_sc_hd__decap_6
XFILLER_48_1411 VPWR VGND VPWR VGND sky130_ef_sc_hd__decap_12
Xmax_cap549 net550 VGND VGND VPWR VPWR net549 sky130_fd_sc_hd__clkbuf_1
XFILLER_170_366 VPWR VGND VPWR VGND sky130_ef_sc_hd__decap_12
XFILLER_174_1441 VPWR VGND VPWR VGND sky130_ef_sc_hd__decap_12
XFILLER_83_1335 VPWR VGND VPWR VGND sky130_ef_sc_hd__decap_12
XFILLER_237_1162 VPWR VGND VPWR VGND sky130_ef_sc_hd__decap_12
XFILLER_48_1466 VPWR VGND VPWR VGND sky130_ef_sc_hd__decap_12
XFILLER_135_1414 VGND VGND VPWR VPWR sky130_fd_sc_hd__decap_6
XFILLER_170_1305 VGND VGND VPWR VPWR sky130_fd_sc_hd__decap_6
XFILLER_233_1026 VGND VGND VPWR VPWR sky130_fd_sc_hd__decap_6
XFILLER_35_3 VPWR VGND VPWR VGND sky130_ef_sc_hd__decap_12
XFILLER_174_1496 VPWR VGND VPWR VGND sky130_ef_sc_hd__decap_12
XPHY_EDGE_ROW_86_1_Right_742 VGND VGND VPWR VPWR sky130_fd_sc_hd__decap_3
XFILLER_211_1346 VPWR VGND VPWR VGND sky130_ef_sc_hd__decap_12
XFILLER_252_120 VPWR VGND VPWR VGND sky130_ef_sc_hd__decap_12
XFILLER_225_345 VPWR VGND VPWR VGND sky130_ef_sc_hd__decap_12
XFILLER_129_1218 VPWR VGND VPWR VGND sky130_ef_sc_hd__decap_12
XFILLER_203_87 VPWR VGND VPWR VGND sky130_ef_sc_hd__decap_12
XFILLER_240_304 VPWR VGND VPWR VGND sky130_ef_sc_hd__decap_12
XFILLER_94_1442 VPWR VGND VPWR VGND sky130_ef_sc_hd__decap_12
XFILLER_213_529 VPWR VGND VPWR VGND sky130_ef_sc_hd__decap_12
XFILLER_252_175 VPWR VGND VPWR VGND sky130_ef_sc_hd__decap_12
XFILLER_181_1401 VPWR VGND VPWR VGND sky130_ef_sc_hd__decap_12
XFILLER_206_581 VPWR VGND VPWR VGND sky130_ef_sc_hd__decap_12
XFILLER_244_1133 VGND VGND VPWR VPWR sky130_fd_sc_hd__decap_6
XFILLER_90_1306 VGND VGND VPWR VPWR sky130_fd_sc_hd__decap_6
XFILLER_240_359 VGND VGND VPWR VPWR sky130_fd_sc_hd__decap_6
XFILLER_94_1497 VPWR VGND VPWR VGND sky130_ef_sc_hd__decap_12
XFILLER_178_433 VPWR VGND VPWR VGND sky130_ef_sc_hd__decap_12
XFILLER_181_1456 VGND VGND VPWR VPWR sky130_fd_sc_hd__decap_6
XFILLER_166_617 VGND VGND VPWR VPWR sky130_fd_sc_hd__decap_6
XFILLER_221_584 VPWR VGND VPWR VGND sky130_ef_sc_hd__decap_12
XFILLER_18_1270 VPWR VGND VPWR VGND sky130_ef_sc_hd__decap_12
XFILLER_178_488 VGND VGND VPWR VPWR sky130_fd_sc_hd__decap_6
XFILLER_194_937 VPWR VGND VPWR VGND sky130_ef_sc_hd__decap_12
XFILLER_165_127 VPWR VGND VPWR VGND sky130_ef_sc_hd__decap_12
XFILLER_222_1453 VPWR VGND VPWR VGND sky130_ef_sc_hd__decap_12
XFILLER_105_1273 VPWR VGND VPWR VGND sky130_ef_sc_hd__decap_12
XFILLER_180_108 VPWR VGND VPWR VGND sky130_ef_sc_hd__decap_12
XFILLER_175_1205 VPWR VGND VPWR VGND sky130_ef_sc_hd__decap_12
XTAP_TAPCELL_ROW_173_1799 VGND VPWR sky130_fd_sc_hd__tapvpwrvgnd_1
XFILLER_255_1240 VPWR VGND VPWR VGND sky130_ef_sc_hd__decap_12
XFILLER_255_1273 VGND VGND VPWR VPWR sky130_fd_sc_hd__decap_8
XFILLER_249_916 VPWR VGND VPWR VGND sky130_ef_sc_hd__decap_12
XTAP_TAPCELL_ROW_146_2_5830 VGND VPWR sky130_fd_sc_hd__tapvpwrvgnd_1
XFILLER_57_15 VPWR VGND VPWR VGND sky130_ef_sc_hd__decap_12
XFILLER_114_1509 VGND VGND VPWR VPWR sky130_fd_sc_hd__decap_6
XFILLER_25_1230 VPWR VGND VPWR VGND sky130_ef_sc_hd__decap_12
XFILLER_9_1471 VPWR VGND VPWR VGND sky130_ef_sc_hd__decap_12
XPHY_EDGE_ROW_22_2_Right_113 VGND VGND VPWR VPWR sky130_fd_sc_hd__decap_3
XFILLER_116_1380 VPWR VGND VPWR VGND sky130_ef_sc_hd__decap_12
XFILLER_5_1346 VPWR VGND VPWR VGND sky130_ef_sc_hd__decap_12
XFILLER_60_1165 VPWR VGND VPWR VGND sky130_ef_sc_hd__decap_12
XFILLER_25_1285 VGND VGND VPWR VPWR sky130_fd_sc_hd__decap_6
XFILLER_186_1312 VPWR VGND VPWR VGND sky130_ef_sc_hd__decap_12
XFILLER_216_323 VPWR VGND VPWR VGND sky130_ef_sc_hd__decap_12
XFILLER_249_1033 VPWR VGND VPWR VGND sky130_ef_sc_hd__decap_12
XFILLER_95_1206 VPWR VGND VPWR VGND sky130_ef_sc_hd__decap_12
XFILLER_228_194 VPWR VGND VPWR VGND sky130_ef_sc_hd__decap_12
XPHY_EDGE_ROW_111_2_Left_613 VGND VGND VPWR VPWR sky130_fd_sc_hd__decap_3
XFILLER_243_142 VPWR VGND VPWR VGND sky130_ef_sc_hd__decap_12
XFILLER_204_507 VPWR VGND VPWR VGND sky130_ef_sc_hd__decap_12
XTAP_TAPCELL_ROW_64_2_5174 VGND VPWR sky130_fd_sc_hd__tapvpwrvgnd_1
XFILLER_186_1367 VPWR VGND VPWR VGND sky130_ef_sc_hd__decap_12
XFILLER_216_378 VPWR VGND VPWR VGND sky130_ef_sc_hd__decap_12
XFILLER_249_1088 VPWR VGND VPWR VGND sky130_ef_sc_hd__decap_12
XTAP_TAPCELL_ROW_107_2_5514 VGND VPWR sky130_fd_sc_hd__tapvpwrvgnd_1
XFILLER_231_326 VPWR VGND VPWR VGND sky130_ef_sc_hd__decap_12
XFILLER_169_400 VPWR VGND VPWR VGND sky130_ef_sc_hd__decap_12
XFILLER_243_197 VPWR VGND VPWR VGND sky130_ef_sc_hd__decap_12
XTAP_TAPCELL_ROW_255_4670 VGND VPWR sky130_fd_sc_hd__tapvpwrvgnd_1
XTAP_TAPCELL_ROW_255_4681 VGND VPWR sky130_fd_sc_hd__tapvpwrvgnd_1
XTAP_TAPCELL_ROW_255_4692 VGND VPWR sky130_fd_sc_hd__tapvpwrvgnd_1
XFILLER_196_230 VGND VGND VPWR VPWR sky130_fd_sc_hd__decap_6
XFILLER_223_1217 VPWR VGND VPWR VGND sky130_ef_sc_hd__decap_12
XTAP_TAPCELL_ROW_251_4534 VGND VPWR sky130_fd_sc_hd__tapvpwrvgnd_1
XFILLER_169_455 VPWR VGND VPWR VGND sky130_ef_sc_hd__decap_12
XFILLER_185_904 VPWR VGND VPWR VGND sky130_ef_sc_hd__decap_12
XFILLER_212_562 VPWR VGND VPWR VGND sky130_ef_sc_hd__decap_12
XTAP_TAPCELL_ROW_251_4545 VGND VPWR sky130_fd_sc_hd__tapvpwrvgnd_1
XFILLER_240_882 VPWR VGND VPWR VGND sky130_ef_sc_hd__decap_12
XFILLER_197_775 VPWR VGND VPWR VGND sky130_ef_sc_hd__decap_12
XTAP_TAPCELL_ROW_251_4556 VGND VPWR sky130_fd_sc_hd__tapvpwrvgnd_1
XFILLER_237_3 VPWR VGND VPWR VGND sky130_ef_sc_hd__decap_12
XFILLER_200_746 VGND VGND VPWR VPWR sky130_fd_sc_hd__decap_6
XFILLER_71_1261 VPWR VGND VPWR VGND sky130_ef_sc_hd__decap_12
XFILLER_185_959 VPWR VGND VPWR VGND sky130_ef_sc_hd__decap_12
XFILLER_36_1392 VGND VGND VPWR VPWR sky130_fd_sc_hd__decap_6
XFILLER_7_148 VGND VGND VPWR VPWR sky130_fd_sc_hd__fill_1
XFILLER_197_1463 VPWR VGND VPWR VGND sky130_ef_sc_hd__decap_12
XFILLER_165_694 VPWR VGND VPWR VGND sky130_ef_sc_hd__decap_12
XFILLER_98_22 VPWR VGND VPWR VGND sky130_ef_sc_hd__decap_12
XTAP_TAPCELL_ROW_249_4463 VGND VPWR sky130_fd_sc_hd__tapvpwrvgnd_1
XTAP_TAPCELL_ROW_249_4474 VGND VPWR sky130_fd_sc_hd__tapvpwrvgnd_1
XFILLER_193_1327 VGND VGND VPWR VPWR sky130_fd_sc_hd__decap_6
XTAP_TAPCELL_ROW_249_4485 VGND VPWR sky130_fd_sc_hd__tapvpwrvgnd_1
XTAP_TAPCELL_ROW_245_4316 VGND VPWR sky130_fd_sc_hd__tapvpwrvgnd_1
XTAP_TAPCELL_ROW_245_4327 VGND VPWR sky130_fd_sc_hd__tapvpwrvgnd_1
XTAP_TAPCELL_ROW_245_4338 VGND VPWR sky130_fd_sc_hd__tapvpwrvgnd_1
XFILLER_234_1324 VPWR VGND VPWR VGND sky130_ef_sc_hd__decap_12
XFILLER_234_1379 VPWR VGND VPWR VGND sky130_ef_sc_hd__decap_12
XFILLER_117_1177 VPWR VGND VPWR VGND sky130_ef_sc_hd__decap_12
XTAP_TAPCELL_ROW_7_1105 VGND VPWR sky130_fd_sc_hd__tapvpwrvgnd_1
XTAP_TAPCELL_ROW_7_1116 VGND VPWR sky130_fd_sc_hd__tapvpwrvgnd_1
XTAP_TAPCELL_ROW_7_1127 VGND VPWR sky130_fd_sc_hd__tapvpwrvgnd_1
XTAP_TAPCELL_ROW_7_1138 VGND VPWR sky130_fd_sc_hd__tapvpwrvgnd_1
XPHY_EDGE_ROW_43_2_Left_545 VGND VGND VPWR VPWR sky130_fd_sc_hd__decap_3
XTAP_TAPCELL_ROW_239_4109 VGND VPWR sky130_fd_sc_hd__tapvpwrvgnd_1
XFILLER_234_120 VPWR VGND VPWR VGND sky130_ef_sc_hd__decap_12
XFILLER_207_345 VPWR VGND VPWR VGND sky130_ef_sc_hd__decap_12
XFILLER_130_1399 VPWR VGND VPWR VGND sky130_ef_sc_hd__decap_12
XFILLER_222_304 VPWR VGND VPWR VGND sky130_ef_sc_hd__decap_12
XFILLER_250_624 VPWR VGND VPWR VGND sky130_ef_sc_hd__decap_12
XFILLER_165_1429 VPWR VGND VPWR VGND sky130_ef_sc_hd__decap_12
XFILLER_234_175 VPWR VGND VPWR VGND sky130_ef_sc_hd__decap_12
XFILLER_245_1420 VPWR VGND VPWR VGND sky130_ef_sc_hd__decap_12
XFILLER_222_359 VGND VGND VPWR VPWR sky130_fd_sc_hd__decap_6
XFILLER_250_679 VPWR VGND VPWR VGND sky130_ef_sc_hd__decap_12
XFILLER_128_1251 VPWR VGND VPWR VGND sky130_ef_sc_hd__decap_12
XFILLER_245_1475 VPWR VGND VPWR VGND sky130_ef_sc_hd__decap_12
XFILLER_188_753 VPWR VGND VPWR VGND sky130_ef_sc_hd__decap_12
XFILLER_249_39 VGND VGND VPWR VPWR sky130_fd_sc_hd__decap_4
XFILLER_187_252 VGND VGND VPWR VPWR sky130_fd_sc_hd__decap_6
XFILLER_179_80 VGND VGND VPWR VPWR sky130_fd_sc_hd__decap_6
XFILLER_203_584 VPWR VGND VPWR VGND sky130_ef_sc_hd__decap_12
XFILLER_37_1189 VPWR VGND VPWR VGND sky130_ef_sc_hd__decap_12
XFILLER_176_937 VPWR VGND VPWR VGND sky130_ef_sc_hd__decap_12
XFILLER_15_1421 VPWR VGND VPWR VGND sky130_ef_sc_hd__decap_12
XFILLER_89_1500 VGND VGND VPWR VPWR sky130_fd_sc_hd__decap_6
XFILLER_198_1238 VPWR VGND VPWR VGND sky130_ef_sc_hd__decap_12
XFILLER_50_1356 VPWR VGND VPWR VGND sky130_ef_sc_hd__decap_12
XFILLER_15_1476 VPWR VGND VPWR VGND sky130_ef_sc_hd__decap_12
XFILLER_204_1183 VPWR VGND VPWR VGND sky130_ef_sc_hd__decap_12
XFILLER_102_1435 VGND VGND VPWR VPWR sky130_fd_sc_hd__decap_6
XFILLER_7_660 VGND VGND VPWR VPWR sky130_fd_sc_hd__fill_2
XFILLER_200_1047 VGND VGND VPWR VPWR sky130_fd_sc_hd__decap_6
XFILLER_176_1514 VGND VGND VPWR VPWR sky130_fd_sc_hd__fill_1
XFILLER_184_992 VPWR VGND VPWR VGND sky130_ef_sc_hd__decap_12
XFILLER_7_682 VGND VGND VPWR VPWR sky130_fd_sc_hd__decap_6
Xmax_cap335 _140_ VGND VGND VPWR VPWR net335 sky130_fd_sc_hd__clkbuf_1
XPHY_EDGE_ROW_57_1_Left_312 VGND VGND VPWR VPWR sky130_fd_sc_hd__decap_3
XFILLER_170_163 VPWR VGND VPWR VGND sky130_ef_sc_hd__decap_12
XFILLER_48_1263 VGND VGND VPWR VPWR sky130_fd_sc_hd__decap_6
XFILLER_83_1165 VPWR VGND VPWR VGND sky130_ef_sc_hd__decap_12
XFILLER_174_1293 VPWR VGND VPWR VGND sky130_ef_sc_hd__decap_12
XFILLER_239_971 VPWR VGND VPWR VGND sky130_ef_sc_hd__decap_12
XTAP_TAPCELL_ROW_113_2_5568 VGND VPWR sky130_fd_sc_hd__tapvpwrvgnd_1
XTAP_TAPCELL_ROW_81_2_5313 VGND VPWR sky130_fd_sc_hd__tapvpwrvgnd_1
XFILLER_2_1508 VGND VGND VPWR VPWR sky130_fd_sc_hd__decap_6
XTAP_TAPCELL_ROW_166_1570 VGND VPWR sky130_fd_sc_hd__tapvpwrvgnd_1
XFILLER_211_1143 VPWR VGND VPWR VGND sky130_ef_sc_hd__decap_12
XTAP_TAPCELL_ROW_50_2_5060 VGND VPWR sky130_fd_sc_hd__tapvpwrvgnd_1
XTAP_TAPCELL_ROW_166_1581 VGND VPWR sky130_fd_sc_hd__tapvpwrvgnd_1
XTAP_TAPCELL_ROW_49_2_5054 VGND VPWR sky130_fd_sc_hd__tapvpwrvgnd_1
XPHY_EDGE_ROW_87_1_Right_743 VGND VGND VPWR VPWR sky130_fd_sc_hd__decap_3
XTAP_TAPCELL_ROW_70_1_1334 VGND VPWR sky130_fd_sc_hd__tapvpwrvgnd_1
XFILLER_0_1210 VGND VGND VPWR VPWR sky130_fd_sc_hd__decap_8
XFILLER_211_1198 VGND VGND VPWR VPWR sky130_fd_sc_hd__decap_6
XFILLER_225_142 VPWR VGND VPWR VGND sky130_ef_sc_hd__decap_12
XFILLER_240_101 VGND VGND VPWR VPWR sky130_fd_sc_hd__decap_6
XFILLER_213_326 VPWR VGND VPWR VGND sky130_ef_sc_hd__decap_12
XFILLER_241_646 VPWR VGND VPWR VGND sky130_ef_sc_hd__decap_12
XFILLER_55_1201 VGND VGND VPWR VPWR sky130_fd_sc_hd__decap_4
XFILLER_168_1097 VPWR VGND VPWR VGND sky130_ef_sc_hd__decap_12
XFILLER_225_197 VPWR VGND VPWR VGND sky130_ef_sc_hd__decap_12
XFILLER_43_39 VGND VGND VPWR VPWR sky130_fd_sc_hd__decap_4
XFILLER_94_1294 VPWR VGND VPWR VGND sky130_ef_sc_hd__decap_12
XFILLER_167_904 VPWR VGND VPWR VGND sky130_ef_sc_hd__decap_12
XFILLER_178_230 VGND VGND VPWR VPWR sky130_fd_sc_hd__decap_6
XFILLER_159_39 VGND VGND VPWR VPWR sky130_fd_sc_hd__decap_4
XFILLER_179_775 VPWR VGND VPWR VGND sky130_ef_sc_hd__decap_12
XFILLER_222_882 VPWR VGND VPWR VGND sky130_ef_sc_hd__decap_12
XFILLER_107_1335 VPWR VGND VPWR VGND sky130_ef_sc_hd__decap_12
XFILLER_221_381 VGND VGND VPWR VPWR sky130_fd_sc_hd__decap_6
XFILLER_194_734 VPWR VGND VPWR VGND sky130_ef_sc_hd__decap_12
XFILLER_167_959 VPWR VGND VPWR VGND sky130_ef_sc_hd__decap_12
XFILLER_222_1250 VPWR VGND VPWR VGND sky130_ef_sc_hd__decap_12
XFILLER_182_918 VGND VGND VPWR VPWR sky130_fd_sc_hd__decap_6
XFILLER_194_789 VGND VGND VPWR VPWR sky130_fd_sc_hd__decap_6
XFILLER_175_27 VPWR VGND VPWR VGND sky130_ef_sc_hd__decap_12
XFILLER_175_1002 VPWR VGND VPWR VGND sky130_ef_sc_hd__decap_12
XFILLER_175_1057 VPWR VGND VPWR VGND sky130_ef_sc_hd__decap_12
XFILLER_108_65 VGND VGND VPWR VPWR sky130_fd_sc_hd__decap_6
XPHY_EDGE_ROW_41_1_Left_296 VGND VGND VPWR VPWR sky130_fd_sc_hd__decap_3
XFILLER_249_713 VPWR VGND VPWR VGND sky130_ef_sc_hd__decap_12
XFILLER_191_15 VPWR VGND VPWR VGND sky130_ef_sc_hd__decap_12
XFILLER_118_1442 VPWR VGND VPWR VGND sky130_ef_sc_hd__decap_12
XFILLER_68_58 VGND VGND VPWR VPWR sky130_fd_sc_hd__decap_6
XFILLER_1_858 VGND VGND VPWR VPWR sky130_fd_sc_hd__fill_2
XFILLER_62_1227 VPWR VGND VPWR VGND sky130_ef_sc_hd__decap_12
XFILLER_27_1347 VPWR VGND VPWR VGND sky130_ef_sc_hd__decap_12
XFILLER_216_1054 VPWR VGND VPWR VGND sky130_ef_sc_hd__decap_12
XFILLER_114_1306 VGND VGND VPWR VPWR sky130_fd_sc_hd__decap_6
XFILLER_249_768 VGND VGND VPWR VPWR sky130_fd_sc_hd__decap_6
XFILLER_118_1497 VPWR VGND VPWR VGND sky130_ef_sc_hd__decap_12
XFILLER_5_1143 VPWR VGND VPWR VGND sky130_ef_sc_hd__decap_12
XFILLER_187_3 VPWR VGND VPWR VGND sky130_ef_sc_hd__decap_12
XPHY_EDGE_ROW_23_2_Right_114 VGND VGND VPWR VPWR sky130_fd_sc_hd__decap_3
X_651_ clknet_3_6__leaf_clk acc_core.adder.cla_blocks\[4\].block.sum\[1\] _059_ VGND
+ VGND VPWR VPWR net51 sky130_fd_sc_hd__dfrtp_1
XTAP_TAPCELL_ROW_205_2920 VGND VPWR sky130_fd_sc_hd__tapvpwrvgnd_1
XTAP_TAPCELL_ROW_205_2931 VGND VPWR sky130_fd_sc_hd__tapvpwrvgnd_1
XFILLER_84_46 VPWR VGND VPWR VGND sky130_ef_sc_hd__decap_12
XTAP_TAPCELL_ROW_205_2942 VGND VPWR sky130_fd_sc_hd__tapvpwrvgnd_1
XFILLER_216_120 VPWR VGND VPWR VGND sky130_ef_sc_hd__decap_12
XFILLER_5_1198 VGND VGND VPWR VPWR sky130_fd_sc_hd__decap_6
X_582_ net670 VGND VGND VPWR VPWR _064_ sky130_fd_sc_hd__inv_2
XTAP_TAPCELL_ROW_201_2806 VGND VPWR sky130_fd_sc_hd__tapvpwrvgnd_1
XFILLER_17_62 VGND VGND VPWR VPWR sky130_fd_sc_hd__fill_1
XFILLER_204_304 VPWR VGND VPWR VGND sky130_ef_sc_hd__decap_12
XFILLER_186_1164 VPWR VGND VPWR VGND sky130_ef_sc_hd__decap_12
XFILLER_189_517 VPWR VGND VPWR VGND sky130_ef_sc_hd__decap_12
XFILLER_216_175 VPWR VGND VPWR VGND sky130_ef_sc_hd__decap_12
XFILLER_232_624 VPWR VGND VPWR VGND sky130_ef_sc_hd__decap_12
XTAP_TAPCELL_ROW_253_4607 VGND VPWR sky130_fd_sc_hd__tapvpwrvgnd_1
XFILLER_244_495 VPWR VGND VPWR VGND sky130_ef_sc_hd__decap_12
XTAP_TAPCELL_ROW_253_4618 VGND VPWR sky130_fd_sc_hd__tapvpwrvgnd_1
XTAP_TAPCELL_ROW_0_880 VGND VPWR sky130_fd_sc_hd__tapvpwrvgnd_1
XFILLER_231_123 VGND VGND VPWR VPWR sky130_fd_sc_hd__decap_6
XTAP_TAPCELL_ROW_0_891 VGND VPWR sky130_fd_sc_hd__tapvpwrvgnd_1
XFILLER_220_808 VPWR VGND VPWR VGND sky130_ef_sc_hd__decap_12
XFILLER_204_359 VGND VGND VPWR VPWR sky130_fd_sc_hd__decap_6
XFILLER_232_679 VPWR VGND VPWR VGND sky130_ef_sc_hd__decap_12
XFILLER_38_1454 VPWR VGND VPWR VGND sky130_ef_sc_hd__decap_12
XFILLER_125_1402 VPWR VGND VPWR VGND sky130_ef_sc_hd__decap_12
XFILLER_185_701 VPWR VGND VPWR VGND sky130_ef_sc_hd__decap_12
XFILLER_223_1014 VPWR VGND VPWR VGND sky130_ef_sc_hd__decap_12
XFILLER_169_252 VGND VGND VPWR VPWR sky130_fd_sc_hd__decap_6
XFILLER_73_1378 VPWR VGND VPWR VGND sky130_ef_sc_hd__decap_12
XFILLER_197_572 VPWR VGND VPWR VGND sky130_ef_sc_hd__decap_12
XFILLER_9_925 VPWR VGND VPWR VGND sky130_ef_sc_hd__decap_12
XFILLER_125_1457 VGND VGND VPWR VPWR sky130_fd_sc_hd__decap_6
XFILLER_160_1337 VPWR VGND VPWR VGND sky130_ef_sc_hd__decap_12
XFILLER_199_1514 VGND VGND VPWR VPWR sky130_fd_sc_hd__fill_1
XFILLER_185_756 VPWR VGND VPWR VGND sky130_ef_sc_hd__decap_12
XFILLER_223_1069 VGND VGND VPWR VPWR sky130_fd_sc_hd__decap_6
XFILLER_9_958 VGND VGND VPWR VPWR sky130_fd_sc_hd__decap_8
XFILLER_201_1334 VPWR VGND VPWR VGND sky130_ef_sc_hd__decap_12
XFILLER_166_992 VPWR VGND VPWR VGND sky130_ef_sc_hd__decap_12
XFILLER_197_1260 VPWR VGND VPWR VGND sky130_ef_sc_hd__decap_12
XFILLER_181_940 VGND VGND VPWR VPWR sky130_fd_sc_hd__decap_6
XFILLER_201_1389 VPWR VGND VPWR VGND sky130_ef_sc_hd__decap_12
XFILLER_119_1206 VPWR VGND VPWR VGND sky130_ef_sc_hd__decap_12
XFILLER_4_685 VGND VGND VPWR VPWR sky130_fd_sc_hd__fill_1
XFILLER_45_1414 VGND VGND VPWR VPWR sky130_fd_sc_hd__decap_6
XFILLER_4_696 VGND VGND VPWR VPWR sky130_fd_sc_hd__fill_2
XFILLER_234_1121 VPWR VGND VPWR VGND sky130_ef_sc_hd__decap_12
XFILLER_84_1485 VPWR VGND VPWR VGND sky130_ef_sc_hd__decap_12
XFILLER_171_1444 VPWR VGND VPWR VGND sky130_ef_sc_hd__decap_12
XFILLER_80_1349 VGND VGND VPWR VPWR sky130_fd_sc_hd__decap_6
XFILLER_234_1176 VGND VGND VPWR VPWR sky130_fd_sc_hd__decap_6
XFILLER_255_727 VGND VGND VPWR VPWR sky130_fd_sc_hd__decap_8
Xhold2 rd_addr\[1\] VGND VGND VPWR VPWR net690 sky130_fd_sc_hd__dlygate4sd3_1
XFILLER_0_891 VGND VGND VPWR VPWR sky130_fd_sc_hd__fill_2
XFILLER_171_1499 VGND VGND VPWR VPWR sky130_fd_sc_hd__decap_6
XFILLER_212_1441 VPWR VGND VPWR VGND sky130_ef_sc_hd__decap_12
XFILLER_254_237 VPWR VGND VPWR VGND sky130_ef_sc_hd__decap_12
XTAP_TAPCELL_ROW_33_2_4923 VGND VPWR sky130_fd_sc_hd__tapvpwrvgnd_1
XFILLER_212_1496 VPWR VGND VPWR VGND sky130_ef_sc_hd__decap_12
XFILLER_207_142 VPWR VGND VPWR VGND sky130_ef_sc_hd__decap_12
XFILLER_130_1196 VPWR VGND VPWR VGND sky130_ef_sc_hd__decap_12
XFILLER_39_1218 VPWR VGND VPWR VGND sky130_ef_sc_hd__decap_12
XFILLER_222_101 VGND VGND VPWR VPWR sky130_fd_sc_hd__decap_6
XFILLER_250_421 VPWR VGND VPWR VGND sky130_ef_sc_hd__decap_12
XFILLER_207_197 VPWR VGND VPWR VGND sky130_ef_sc_hd__decap_12
XFILLER_223_646 VPWR VGND VPWR VGND sky130_ef_sc_hd__decap_12
XFILLER_200_22 VPWR VGND VPWR VGND sky130_ef_sc_hd__decap_12
XFILLER_250_476 VPWR VGND VPWR VGND sky130_ef_sc_hd__decap_12
XFILLER_245_1272 VPWR VGND VPWR VGND sky130_ef_sc_hd__decap_12
XFILLER_91_1445 VPWR VGND VPWR VGND sky130_ef_sc_hd__decap_12
XFILLER_188_550 VPWR VGND VPWR VGND sky130_ef_sc_hd__decap_12
XFILLER_204_882 VPWR VGND VPWR VGND sky130_ef_sc_hd__decap_12
XFILLER_203_381 VGND VGND VPWR VPWR sky130_fd_sc_hd__decap_6
XFILLER_176_734 VPWR VGND VPWR VGND sky130_ef_sc_hd__decap_12
XFILLER_200_77 VPWR VGND VPWR VGND sky130_ef_sc_hd__decap_12
XFILLER_202_1109 VPWR VGND VPWR VGND sky130_ef_sc_hd__decap_12
XFILLER_176_789 VGND VGND VPWR VPWR sky130_fd_sc_hd__decap_6
XFILLER_198_1035 VPWR VGND VPWR VGND sky130_ef_sc_hd__decap_12
XTAP_TAPCELL_ROW_174_1850 VGND VPWR sky130_fd_sc_hd__tapvpwrvgnd_1
XTAP_TAPCELL_ROW_215_3271 VGND VPWR sky130_fd_sc_hd__tapvpwrvgnd_1
XFILLER_15_1273 VPWR VGND VPWR VGND sky130_ef_sc_hd__decap_12
XTAP_TAPCELL_ROW_174_1861 VGND VPWR sky130_fd_sc_hd__tapvpwrvgnd_1
XTAP_TAPCELL_ROW_215_3282 VGND VPWR sky130_fd_sc_hd__tapvpwrvgnd_1
XTAP_TAPCELL_ROW_170_1703 VGND VPWR sky130_fd_sc_hd__tapvpwrvgnd_1
XTAP_TAPCELL_ROW_211_3124 VGND VPWR sky130_fd_sc_hd__tapvpwrvgnd_1
XTAP_TAPCELL_ROW_215_3293 VGND VPWR sky130_fd_sc_hd__tapvpwrvgnd_1
XFILLER_8_980 VPWR VGND VPWR VGND sky130_ef_sc_hd__decap_12
XFILLER_141_1292 VPWR VGND VPWR VGND sky130_ef_sc_hd__decap_12
XTAP_TAPCELL_ROW_170_1714 VGND VPWR sky130_fd_sc_hd__tapvpwrvgnd_1
XTAP_TAPCELL_ROW_211_3135 VGND VPWR sky130_fd_sc_hd__tapvpwrvgnd_1
XTAP_TAPCELL_ROW_211_3146 VGND VPWR sky130_fd_sc_hd__tapvpwrvgnd_1
Xmax_cap110 net111 VGND VGND VPWR VPWR net110 sky130_fd_sc_hd__clkbuf_1
XTAP_TAPCELL_ROW_211_3157 VGND VPWR sky130_fd_sc_hd__tapvpwrvgnd_1
Xmax_cap121 _204_ VGND VGND VPWR VPWR net121 sky130_fd_sc_hd__clkbuf_1
Xmax_cap132 _196_ VGND VGND VPWR VPWR net132 sky130_fd_sc_hd__clkbuf_1
XFILLER_254_1508 VGND VGND VPWR VPWR sky130_fd_sc_hd__decap_6
XFILLER_239_1076 VPWR VGND VPWR VGND sky130_ef_sc_hd__decap_12
XFILLER_176_1355 VPWR VGND VPWR VGND sky130_ef_sc_hd__decap_12
XFILLER_85_1249 VPWR VGND VPWR VGND sky130_ef_sc_hd__decap_12
Xmax_cap176 net177 VGND VGND VPWR VPWR net176 sky130_fd_sc_hd__clkbuf_1
XFILLER_137_1328 VGND VGND VPWR VPWR sky130_fd_sc_hd__decap_6
XFILLER_172_1219 VGND VGND VPWR VPWR sky130_fd_sc_hd__decap_6
Xmax_cap187 _261_ VGND VGND VPWR VPWR net187 sky130_fd_sc_hd__clkbuf_1
Xmax_cap198 net199 VGND VGND VPWR VPWR net198 sky130_fd_sc_hd__clkbuf_1
XTAP_TAPCELL_ROW_168_1621 VGND VPWR sky130_fd_sc_hd__tapvpwrvgnd_1
XTAP_TAPCELL_ROW_168_1632 VGND VPWR sky130_fd_sc_hd__tapvpwrvgnd_1
XFILLER_174_1090 VGND VGND VPWR VPWR sky130_fd_sc_hd__decap_6
XFILLER_213_1205 VPWR VGND VPWR VGND sky130_ef_sc_hd__decap_12
XFILLER_24_1509 VGND VGND VPWR VPWR sky130_fd_sc_hd__decap_6
XTAP_TAPCELL_ROW_168_1643 VGND VPWR sky130_fd_sc_hd__tapvpwrvgnd_1
XTAP_TAPCELL_ROW_209_3064 VGND VPWR sky130_fd_sc_hd__tapvpwrvgnd_1
XTAP_TAPCELL_ROW_209_3075 VGND VPWR sky130_fd_sc_hd__tapvpwrvgnd_1
XTAP_TAPCELL_ROW_209_3086 VGND VPWR sky130_fd_sc_hd__tapvpwrvgnd_1
XFILLER_6_1441 VPWR VGND VPWR VGND sky130_ef_sc_hd__decap_12
XPHY_EDGE_ROW_150_2_Right_241 VGND VGND VPWR VPWR sky130_fd_sc_hd__decap_3
XFILLER_26_1380 VPWR VGND VPWR VGND sky130_ef_sc_hd__decap_12
XTAP_TAPCELL_ROW_88_1_1361 VGND VPWR sky130_fd_sc_hd__tapvpwrvgnd_1
XFILLER_2_1305 VGND VGND VPWR VPWR sky130_fd_sc_hd__decap_6
XFILLER_245_259 VPWR VGND VPWR VGND sky130_ef_sc_hd__decap_12
XFILLER_6_1496 VPWR VGND VPWR VGND sky130_ef_sc_hd__decap_12
XPHY_EDGE_ROW_88_1_Right_744 VGND VGND VPWR VPWR sky130_fd_sc_hd__decap_3
XFILLER_96_1356 VPWR VGND VPWR VGND sky130_ef_sc_hd__decap_12
XFILLER_214_624 VPWR VGND VPWR VGND sky130_ef_sc_hd__decap_12
XFILLER_148_1435 VGND VGND VPWR VPWR sky130_fd_sc_hd__decap_6
XFILLER_183_1315 VPWR VGND VPWR VGND sky130_ef_sc_hd__decap_12
XFILLER_226_495 VPWR VGND VPWR VGND sky130_ef_sc_hd__decap_12
XFILLER_246_1047 VGND VGND VPWR VPWR sky130_fd_sc_hd__decap_6
XFILLER_213_123 VGND VGND VPWR VPWR sky130_fd_sc_hd__decap_6
XFILLER_241_443 VPWR VGND VPWR VGND sky130_ef_sc_hd__decap_12
XFILLER_0_1051 VPWR VGND VPWR VGND sky130_ef_sc_hd__decap_12
XFILLER_202_808 VPWR VGND VPWR VGND sky130_ef_sc_hd__decap_12
XTAP_TAPCELL_ROW_79_2_5293 VGND VPWR sky130_fd_sc_hd__tapvpwrvgnd_1
XFILLER_198_347 VPWR VGND VPWR VGND sky130_ef_sc_hd__decap_12
XFILLER_214_679 VPWR VGND VPWR VGND sky130_ef_sc_hd__decap_12
XFILLER_0_1084 VGND VGND VPWR VPWR sky130_fd_sc_hd__decap_8
XFILLER_110_22 VPWR VGND VPWR VGND sky130_ef_sc_hd__decap_12
XFILLER_224_1312 VPWR VGND VPWR VGND sky130_ef_sc_hd__decap_12
XFILLER_167_701 VPWR VGND VPWR VGND sky130_ef_sc_hd__decap_12
XFILLER_241_498 VPWR VGND VPWR VGND sky130_ef_sc_hd__decap_12
XFILLER_179_572 VPWR VGND VPWR VGND sky130_ef_sc_hd__decap_12
XFILLER_70_15 VGND VGND VPWR VPWR sky130_fd_sc_hd__decap_6
XFILLER_224_1367 VPWR VGND VPWR VGND sky130_ef_sc_hd__decap_12
XFILLER_194_531 VGND VGND VPWR VPWR sky130_fd_sc_hd__decap_6
XFILLER_107_1165 VPWR VGND VPWR VGND sky130_ef_sc_hd__decap_12
XFILLER_167_756 VPWR VGND VPWR VGND sky130_ef_sc_hd__decap_12
XFILLER_186_15 VGND VGND VPWR VPWR sky130_fd_sc_hd__decap_6
XFILLER_210_863 VPWR VGND VPWR VGND sky130_ef_sc_hd__decap_12
XFILLER_6_906 VPWR VGND VPWR VGND sky130_ef_sc_hd__decap_12
XFILLER_177_1119 VPWR VGND VPWR VGND sky130_ef_sc_hd__decap_12
XTAP_TAPCELL_ROW_72_2_5236 VGND VPWR sky130_fd_sc_hd__tapvpwrvgnd_1
XFILLER_194_1422 VPWR VGND VPWR VGND sky130_ef_sc_hd__decap_12
XFILLER_102_3 VPWR VGND VPWR VGND sky130_ef_sc_hd__decap_12
XFILLER_79_68 VGND VGND VPWR VPWR sky130_fd_sc_hd__decap_3
XFILLER_194_1477 VGND VGND VPWR VPWR sky130_fd_sc_hd__decap_6
XFILLER_249_510 VGND VGND VPWR VPWR sky130_fd_sc_hd__decap_6
XFILLER_235_1463 VPWR VGND VPWR VGND sky130_ef_sc_hd__decap_12
XFILLER_7_1205 VPWR VGND VPWR VGND sky130_ef_sc_hd__decap_12
XFILLER_1_666 VGND VGND VPWR VPWR sky130_fd_sc_hd__fill_1
XFILLER_231_1327 VGND VGND VPWR VPWR sky130_fd_sc_hd__decap_6
XFILLER_27_1177 VPWR VGND VPWR VGND sky130_ef_sc_hd__decap_12
XFILLER_118_1294 VPWR VGND VPWR VGND sky130_ef_sc_hd__decap_12
XFILLER_95_56 VPWR VGND VPWR VGND sky130_ef_sc_hd__decap_12
XTAP_TAPCELL_ROW_18_2_4803 VGND VPWR sky130_fd_sc_hd__tapvpwrvgnd_1
XTAP_TAPCELL_ROW_184_2190 VGND VPWR sky130_fd_sc_hd__tapvpwrvgnd_1
XTAP_TAPCELL_ROW_180_2043 VGND VPWR sky130_fd_sc_hd__tapvpwrvgnd_1
XFILLER_188_1226 VPWR VGND VPWR VGND sky130_ef_sc_hd__decap_12
XFILLER_236_237 VPWR VGND VPWR VGND sky130_ef_sc_hd__decap_12
XTAP_TAPCELL_ROW_180_2054 VGND VPWR sky130_fd_sc_hd__tapvpwrvgnd_1
XTAP_TAPCELL_ROW_180_2065 VGND VPWR sky130_fd_sc_hd__tapvpwrvgnd_1
XPHY_EDGE_ROW_24_2_Right_115 VGND VGND VPWR VPWR sky130_fd_sc_hd__decap_3
X_634_ clknet_3_3__leaf_clk acc_core.adder.cla_blocks\[0\].block.p\[0\] _042_ VGND
+ VGND VPWR VPWR net43 sky130_fd_sc_hd__dfrtp_1
XFILLER_40_1399 VPWR VGND VPWR VGND sky130_ef_sc_hd__decap_12
XFILLER_204_101 VGND VGND VPWR VPWR sky130_fd_sc_hd__decap_6
XFILLER_232_421 VPWR VGND VPWR VGND sky130_ef_sc_hd__decap_12
X_565_ net664 VGND VGND VPWR VPWR _047_ sky130_fd_sc_hd__inv_2
XFILLER_189_314 VPWR VGND VPWR VGND sky130_ef_sc_hd__decap_12
XFILLER_205_646 VPWR VGND VPWR VGND sky130_ef_sc_hd__decap_12
XFILLER_244_292 VPWR VGND VPWR VGND sky130_ef_sc_hd__decap_12
XFILLER_220_605 VPWR VGND VPWR VGND sky130_ef_sc_hd__decap_12
XFILLER_232_476 VPWR VGND VPWR VGND sky130_ef_sc_hd__decap_12
XFILLER_38_1251 VPWR VGND VPWR VGND sky130_ef_sc_hd__decap_12
X_496_ net146 _254_ VGND VGND VPWR VPWR acc_core.adder.cla_blocks\[5\].block.sum\[3\]
+ sky130_fd_sc_hd__xor2_1
XFILLER_189_369 VPWR VGND VPWR VGND sky130_ef_sc_hd__decap_12
XFILLER_242_1434 VGND VGND VPWR VPWR sky130_fd_sc_hd__decap_6
XFILLER_129_1390 VPWR VGND VPWR VGND sky130_ef_sc_hd__decap_12
XFILLER_164_1270 VPWR VGND VPWR VGND sky130_ef_sc_hd__decap_12
XFILLER_201_830 VPWR VGND VPWR VGND sky130_ef_sc_hd__decap_12
XFILLER_8_232 VGND VGND VPWR VPWR sky130_fd_sc_hd__fill_1
XFILLER_185_553 VGND VGND VPWR VPWR sky130_fd_sc_hd__decap_6
XFILLER_201_885 VPWR VGND VPWR VGND sky130_ef_sc_hd__decap_12
XFILLER_201_1131 VPWR VGND VPWR VGND sky130_ef_sc_hd__decap_12
XFILLER_9_799 VPWR VGND VPWR VGND sky130_ef_sc_hd__decap_12
XFILLER_199_1377 VPWR VGND VPWR VGND sky130_ef_sc_hd__decap_12
XFILLER_12_1435 VGND VGND VPWR VPWR sky130_fd_sc_hd__decap_6
XFILLER_201_1186 VPWR VGND VPWR VGND sky130_ef_sc_hd__decap_12
XTAP_TAPCELL_ROW_94_1_1371 VGND VPWR sky130_fd_sc_hd__tapvpwrvgnd_1
XFILLER_173_1506 VGND VGND VPWR VPWR sky130_fd_sc_hd__decap_8
XFILLER_5_983 VGND VGND VPWR VPWR sky130_fd_sc_hd__decap_6
XFILLER_236_1238 VPWR VGND VPWR VGND sky130_ef_sc_hd__decap_12
XFILLER_180_280 VPWR VGND VPWR VGND sky130_ef_sc_hd__decap_12
XFILLER_5_87 VPWR VGND VPWR VGND sky130_ef_sc_hd__decap_12
XFILLER_84_1282 VPWR VGND VPWR VGND sky130_ef_sc_hd__decap_12
XFILLER_214_1514 VGND VGND VPWR VPWR sky130_fd_sc_hd__fill_1
XFILLER_171_1241 VGND VGND VPWR VPWR sky130_fd_sc_hd__decap_6
XTAP_TAPCELL_ROW_223_3551 VGND VPWR sky130_fd_sc_hd__tapvpwrvgnd_1
XTAP_TAPCELL_ROW_223_3562 VGND VPWR sky130_fd_sc_hd__tapvpwrvgnd_1
XFILLER_255_568 VPWR VGND VPWR VGND sky130_ef_sc_hd__decap_12
XTAP_TAPCELL_ROW_128_2_5687 VGND VPWR sky130_fd_sc_hd__tapvpwrvgnd_1
XTAP_TAPCELL_ROW_223_3573 VGND VPWR sky130_fd_sc_hd__tapvpwrvgnd_1
XFILLER_227_259 VPWR VGND VPWR VGND sky130_ef_sc_hd__decap_12
XTAP_TAPCELL_ROW_96_2_5432 VGND VPWR sky130_fd_sc_hd__tapvpwrvgnd_1
XFILLER_212_1293 VPWR VGND VPWR VGND sky130_ef_sc_hd__decap_12
XFILLER_242_218 VPWR VGND VPWR VGND sky130_ef_sc_hd__decap_12
XFILLER_247_1334 VPWR VGND VPWR VGND sky130_ef_sc_hd__decap_12
XFILLER_93_1507 VGND VGND VPWR VPWR sky130_fd_sc_hd__decap_8
XFILLER_208_495 VPWR VGND VPWR VGND sky130_ef_sc_hd__decap_12
XFILLER_223_443 VPWR VGND VPWR VGND sky130_ef_sc_hd__decap_12
XFILLER_247_1389 VPWR VGND VPWR VGND sky130_ef_sc_hd__decap_12
XFILLER_211_87 VPWR VGND VPWR VGND sky130_ef_sc_hd__decap_12
XFILLER_250_273 VGND VGND VPWR VPWR sky130_fd_sc_hd__decap_6
XFILLER_211_627 VPWR VGND VPWR VGND sky130_ef_sc_hd__decap_12
XFILLER_91_1242 VGND VGND VPWR VPWR sky130_fd_sc_hd__decap_6
XTAP_TAPCELL_ROW_176_1901 VGND VPWR sky130_fd_sc_hd__tapvpwrvgnd_1
XFILLER_223_498 VPWR VGND VPWR VGND sky130_ef_sc_hd__decap_12
XTAP_TAPCELL_ROW_176_1912 VGND VPWR sky130_fd_sc_hd__tapvpwrvgnd_1
XFILLER_17_1335 VPWR VGND VPWR VGND sky130_ef_sc_hd__decap_12
XTAP_TAPCELL_ROW_176_1923 VGND VPWR sky130_fd_sc_hd__tapvpwrvgnd_1
XTAP_TAPCELL_ROW_217_3344 VGND VPWR sky130_fd_sc_hd__tapvpwrvgnd_1
XTAP_TAPCELL_ROW_217_3355 VGND VPWR sky130_fd_sc_hd__tapvpwrvgnd_1
XFILLER_176_531 VGND VGND VPWR VPWR sky130_fd_sc_hd__decap_6
XTAP_TAPCELL_ROW_217_3366 VGND VPWR sky130_fd_sc_hd__tapvpwrvgnd_1
XTAP_TAPCELL_ROW_213_3208 VGND VPWR sky130_fd_sc_hd__tapvpwrvgnd_1
XFILLER_108_1485 VPWR VGND VPWR VGND sky130_ef_sc_hd__decap_12
XTAP_TAPCELL_ROW_213_3219 VGND VPWR sky130_fd_sc_hd__tapvpwrvgnd_1
XTAP_TAPCELL_ROW_57_2_5116 VGND VPWR sky130_fd_sc_hd__tapvpwrvgnd_1
XFILLER_206_1097 VPWR VGND VPWR VGND sky130_ef_sc_hd__decap_12
XFILLER_104_1349 VGND VGND VPWR VPWR sky130_fd_sc_hd__decap_6
XFILLER_254_1305 VGND VGND VPWR VPWR sky130_fd_sc_hd__decap_6
XTAP_TAPCELL_ROW_24_2_4857 VGND VPWR sky130_fd_sc_hd__tapvpwrvgnd_1
XPHY_EDGE_ROW_120_2_Left_622 VGND VGND VPWR VPWR sky130_fd_sc_hd__decap_3
XFILLER_176_1152 VPWR VGND VPWR VGND sky130_ef_sc_hd__decap_12
XFILLER_49_27 VPWR VGND VPWR VGND sky130_ef_sc_hd__decap_12
XFILLER_28_1442 VPWR VGND VPWR VGND sky130_ef_sc_hd__decap_12
XFILLER_8_1514 VGND VGND VPWR VPWR sky130_fd_sc_hd__fill_1
XFILLER_213_1002 VPWR VGND VPWR VGND sky130_ef_sc_hd__decap_12
XFILLER_24_1306 VGND VGND VPWR VPWR sky130_fd_sc_hd__decap_6
XFILLER_28_1497 VPWR VGND VPWR VGND sky130_ef_sc_hd__decap_12
XFILLER_115_1445 VPWR VGND VPWR VGND sky130_ef_sc_hd__decap_12
XFILLER_150_1325 VPWR VGND VPWR VGND sky130_ef_sc_hd__decap_12
XFILLER_105_44 VPWR VGND VPWR VGND sky130_ef_sc_hd__decap_12
XFILLER_213_1057 VPWR VGND VPWR VGND sky130_ef_sc_hd__decap_12
XFILLER_218_237 VPWR VGND VPWR VGND sky130_ef_sc_hd__decap_12
XPHY_EDGE_ROW_151_2_Right_242 VGND VGND VPWR VPWR sky130_fd_sc_hd__decap_3
XFILLER_248_1109 VPWR VGND VPWR VGND sky130_ef_sc_hd__decap_12
XTAP_TAPCELL_ROW_2_931 VGND VPWR sky130_fd_sc_hd__tapvpwrvgnd_1
XTAP_TAPCELL_ROW_2_942 VGND VPWR sky130_fd_sc_hd__tapvpwrvgnd_1
XFILLER_6_1293 VPWR VGND VPWR VGND sky130_ef_sc_hd__decap_12
XTAP_TAPCELL_ROW_2_953 VGND VPWR sky130_fd_sc_hd__tapvpwrvgnd_1
XFILLER_214_421 VPWR VGND VPWR VGND sky130_ef_sc_hd__decap_12
XFILLER_183_1112 VGND VGND VPWR VPWR sky130_fd_sc_hd__decap_6
XFILLER_226_292 VPWR VGND VPWR VGND sky130_ef_sc_hd__decap_12
XPHY_EDGE_ROW_89_1_Right_745 VGND VGND VPWR VPWR sky130_fd_sc_hd__decap_3
XFILLER_241_240 VPWR VGND VPWR VGND sky130_ef_sc_hd__decap_12
X_350_ _136_ _137_ VGND VGND VPWR VPWR _139_ sky130_fd_sc_hd__or2_1
XFILLER_202_605 VPWR VGND VPWR VGND sky130_ef_sc_hd__decap_12
XFILLER_187_818 VPWR VGND VPWR VGND sky130_ef_sc_hd__decap_12
XFILLER_198_144 VGND VGND VPWR VPWR sky130_fd_sc_hd__decap_6
XFILLER_214_476 VPWR VGND VPWR VGND sky130_ef_sc_hd__decap_12
XFILLER_230_925 VPWR VGND VPWR VGND sky130_ef_sc_hd__decap_12
XFILLER_242_796 VPWR VGND VPWR VGND sky130_ef_sc_hd__decap_12
XFILLER_35_1402 VPWR VGND VPWR VGND sky130_ef_sc_hd__decap_12
XFILLER_109_1249 VPWR VGND VPWR VGND sky130_ef_sc_hd__decap_12
XFILLER_199_689 VPWR VGND VPWR VGND sky130_ef_sc_hd__decap_12
XFILLER_241_295 VGND VGND VPWR VPWR sky130_fd_sc_hd__decap_6
XFILLER_161_1421 VPWR VGND VPWR VGND sky130_ef_sc_hd__decap_12
XFILLER_70_1337 VPWR VGND VPWR VGND sky130_ef_sc_hd__decap_12
XFILLER_35_1457 VGND VGND VPWR VPWR sky130_fd_sc_hd__decap_6
XFILLER_14_63 VGND VGND VPWR VPWR sky130_fd_sc_hd__fill_1
XFILLER_224_1164 VPWR VGND VPWR VGND sky130_ef_sc_hd__decap_12
XFILLER_210_660 VGND VGND VPWR VPWR sky130_fd_sc_hd__decap_6
XFILLER_161_1476 VPWR VGND VPWR VGND sky130_ef_sc_hd__decap_12
XFILLER_167_553 VGND VGND VPWR VPWR sky130_fd_sc_hd__decap_6
XFILLER_195_873 VPWR VGND VPWR VGND sky130_ef_sc_hd__decap_12
XTAP_TAPCELL_ROW_192_2470 VGND VPWR sky130_fd_sc_hd__tapvpwrvgnd_1
XTAP_TAPCELL_ROW_192_2481 VGND VPWR sky130_fd_sc_hd__tapvpwrvgnd_1
XTAP_TAPCELL_ROW_192_2492 VGND VPWR sky130_fd_sc_hd__tapvpwrvgnd_1
XPHY_EDGE_ROW_52_2_Left_554 VGND VGND VPWR VPWR sky130_fd_sc_hd__decap_3
XFILLER_202_1484 VPWR VGND VPWR VGND sky130_ef_sc_hd__decap_12
XFILLER_237_1514 VGND VGND VPWR VPWR sky130_fd_sc_hd__fill_1
XFILLER_5_268 VPWR VGND VPWR VGND sky130_ef_sc_hd__decap_12
XFILLER_120_1184 VPWR VGND VPWR VGND sky130_ef_sc_hd__decap_12
XFILLER_29_1206 VPWR VGND VPWR VGND sky130_ef_sc_hd__decap_12
XPHY_EDGE_ROW_229_Right_74 VGND VGND VPWR VPWR sky130_fd_sc_hd__decap_3
XTAP_TAPCELL_ROW_186_2252 VGND VPWR sky130_fd_sc_hd__tapvpwrvgnd_1
XFILLER_81_1433 VPWR VGND VPWR VGND sky130_ef_sc_hd__decap_12
XTAP_TAPCELL_ROW_186_2263 VGND VPWR sky130_fd_sc_hd__tapvpwrvgnd_1
XFILLER_235_1260 VPWR VGND VPWR VGND sky130_ef_sc_hd__decap_12
XFILLER_7_1002 VPWR VGND VPWR VGND sky130_ef_sc_hd__decap_12
XFILLER_1_474 VGND VGND VPWR VPWR sky130_fd_sc_hd__fill_1
XTAP_TAPCELL_ROW_186_2274 VGND VPWR sky130_fd_sc_hd__tapvpwrvgnd_1
XTAP_TAPCELL_ROW_182_2116 VGND VPWR sky130_fd_sc_hd__tapvpwrvgnd_1
XTAP_TAPCELL_ROW_182_2127 VGND VPWR sky130_fd_sc_hd__tapvpwrvgnd_1
XTAP_TAPCELL_ROW_114_2_5573 VGND VPWR sky130_fd_sc_hd__tapvpwrvgnd_1
XTAP_TAPCELL_ROW_182_2138 VGND VPWR sky130_fd_sc_hd__tapvpwrvgnd_1
XFILLER_81_1488 VPWR VGND VPWR VGND sky130_ef_sc_hd__decap_12
XFILLER_7_1057 VPWR VGND VPWR VGND sky130_ef_sc_hd__decap_12
XFILLER_188_1023 VPWR VGND VPWR VGND sky130_ef_sc_hd__decap_12
XFILLER_209_259 VPWR VGND VPWR VGND sky130_ef_sc_hd__decap_12
XPHY_EDGE_ROW_129_1_Left_384 VGND VGND VPWR VPWR sky130_fd_sc_hd__decap_3
XFILLER_224_218 VPWR VGND VPWR VGND sky130_ef_sc_hd__decap_12
XFILLER_252_538 VPWR VGND VPWR VGND sky130_ef_sc_hd__decap_12
XFILLER_188_1078 VPWR VGND VPWR VGND sky130_ef_sc_hd__decap_12
XFILLER_40_1196 VPWR VGND VPWR VGND sky130_ef_sc_hd__decap_12
XPHY_EDGE_ROW_25_2_Right_116 VGND VGND VPWR VPWR sky130_fd_sc_hd__decap_3
X_617_ clknet_3_7__leaf_clk dout0\[15\] _025_ VGND VGND VPWR VPWR dout0_q\[15\] sky130_fd_sc_hd__dfrtp_1
XFILLER_189_111 VPWR VGND VPWR VGND sky130_ef_sc_hd__decap_12
XPHY_EDGE_ROW_238_Right_83 VGND VGND VPWR VPWR sky130_fd_sc_hd__decap_3
XFILLER_205_443 VPWR VGND VPWR VGND sky130_ef_sc_hd__decap_12
XFILLER_127_1316 VPWR VGND VPWR VGND sky130_ef_sc_hd__decap_12
X_548_ net669 VGND VGND VPWR VPWR _030_ sky130_fd_sc_hd__inv_2
XFILLER_220_402 VGND VGND VPWR VPWR sky130_fd_sc_hd__decap_6
XFILLER_189_166 VGND VGND VPWR VPWR sky130_fd_sc_hd__decap_6
XFILLER_232_273 VGND VGND VPWR VPWR sky130_fd_sc_hd__decap_6
XPHY_EDGE_ROW_66_1_Left_321 VGND VGND VPWR VPWR sky130_fd_sc_hd__decap_3
XFILLER_166_1398 VPWR VGND VPWR VGND sky130_ef_sc_hd__decap_12
XFILLER_205_498 VPWR VGND VPWR VGND sky130_ef_sc_hd__decap_12
XFILLER_221_947 VPWR VGND VPWR VGND sky130_ef_sc_hd__decap_12
XTAP_TAPCELL_ROW_43_2_5002 VGND VPWR sky130_fd_sc_hd__tapvpwrvgnd_1
X_479_ _141_ _245_ net333 VGND VGND VPWR VPWR _246_ sky130_fd_sc_hd__a21o_1
XFILLER_186_851 VPWR VGND VPWR VGND sky130_ef_sc_hd__decap_12
XFILLER_201_682 VGND VGND VPWR VPWR sky130_fd_sc_hd__decap_6
XFILLER_203_1248 VPWR VGND VPWR VGND sky130_ef_sc_hd__decap_12
XFILLER_187_80 VGND VGND VPWR VPWR sky130_fd_sc_hd__decap_6
XTAP_TAPCELL_ROW_231_3831 VGND VPWR sky130_fd_sc_hd__tapvpwrvgnd_1
XTAP_TAPCELL_ROW_231_3842 VGND VPWR sky130_fd_sc_hd__tapvpwrvgnd_1
XTAP_TAPCELL_ROW_231_3853 VGND VPWR sky130_fd_sc_hd__tapvpwrvgnd_1
XTAP_TAPCELL_ROW_10_2_4743 VGND VPWR sky130_fd_sc_hd__tapvpwrvgnd_1
XFILLER_199_1174 VPWR VGND VPWR VGND sky130_ef_sc_hd__decap_12
XFILLER_51_1292 VPWR VGND VPWR VGND sky130_ef_sc_hd__decap_12
XFILLER_103_1371 VGND VGND VPWR VPWR sky130_fd_sc_hd__decap_6
XPHY_EDGE_ROW_247_Right_92 VGND VGND VPWR VPWR sky130_fd_sc_hd__decap_3
XFILLER_138_1423 VPWR VGND VPWR VGND sky130_ef_sc_hd__decap_12
XFILLER_173_1303 VPWR VGND VPWR VGND sky130_ef_sc_hd__decap_12
XFILLER_47_1328 VGND VGND VPWR VPWR sky130_fd_sc_hd__decap_6
XFILLER_82_1208 VPWR VGND VPWR VGND sky130_ef_sc_hd__decap_12
XFILLER_236_1035 VPWR VGND VPWR VGND sky130_ef_sc_hd__decap_12
XFILLER_4_290 VGND VGND VPWR VPWR sky130_fd_sc_hd__fill_2
XFILLER_86_1399 VPWR VGND VPWR VGND sky130_ef_sc_hd__decap_12
XFILLER_138_1478 VGND VGND VPWR VPWR sky130_fd_sc_hd__decap_6
XFILLER_173_1358 VPWR VGND VPWR VGND sky130_ef_sc_hd__decap_12
XTAP_TAPCELL_ROW_229_3760 VGND VPWR sky130_fd_sc_hd__tapvpwrvgnd_1
XTAP_TAPCELL_ROW_229_3771 VGND VPWR sky130_fd_sc_hd__tapvpwrvgnd_1
XTAP_TAPCELL_ROW_229_3782 VGND VPWR sky130_fd_sc_hd__tapvpwrvgnd_1
XTAP_TAPCELL_ROW_225_3624 VGND VPWR sky130_fd_sc_hd__tapvpwrvgnd_1
XFILLER_206_65 VPWR VGND VPWR VGND sky130_ef_sc_hd__decap_12
XTAP_TAPCELL_ROW_225_3635 VGND VPWR sky130_fd_sc_hd__tapvpwrvgnd_1
XTAP_TAPCELL_ROW_225_3646 VGND VPWR sky130_fd_sc_hd__tapvpwrvgnd_1
XFILLER_214_1355 VPWR VGND VPWR VGND sky130_ef_sc_hd__decap_12
XFILLER_210_1219 VGND VGND VPWR VPWR sky130_fd_sc_hd__decap_6
XFILLER_3_1444 VPWR VGND VPWR VGND sky130_ef_sc_hd__decap_12
XFILLER_212_1090 VGND VGND VPWR VPWR sky130_fd_sc_hd__decap_6
XFILLER_184_1410 VPWR VGND VPWR VGND sky130_ef_sc_hd__decap_12
XFILLER_247_1131 VPWR VGND VPWR VGND sky130_ef_sc_hd__decap_12
XFILLER_93_1304 VPWR VGND VPWR VGND sky130_ef_sc_hd__decap_12
XFILLER_208_292 VPWR VGND VPWR VGND sky130_ef_sc_hd__decap_12
XFILLER_58_1435 VGND VGND VPWR VPWR sky130_fd_sc_hd__decap_6
XFILLER_3_1499 VGND VGND VPWR VPWR sky130_fd_sc_hd__decap_6
XTAP_TAPCELL_ROW_219_3406 VGND VPWR sky130_fd_sc_hd__tapvpwrvgnd_1
XTAP_TAPCELL_ROW_219_3417 VGND VPWR sky130_fd_sc_hd__tapvpwrvgnd_1
XFILLER_223_240 VPWR VGND VPWR VGND sky130_ef_sc_hd__decap_12
XFILLER_251_560 VPWR VGND VPWR VGND sky130_ef_sc_hd__decap_12
XFILLER_184_1465 VPWR VGND VPWR VGND sky130_ef_sc_hd__decap_12
XFILLER_212_925 VPWR VGND VPWR VGND sky130_ef_sc_hd__decap_12
XTAP_TAPCELL_ROW_219_3428 VGND VPWR sky130_fd_sc_hd__tapvpwrvgnd_1
XFILLER_247_1186 VPWR VGND VPWR VGND sky130_ef_sc_hd__decap_12
XFILLER_93_1359 VPWR VGND VPWR VGND sky130_ef_sc_hd__decap_12
XFILLER_169_818 VPWR VGND VPWR VGND sky130_ef_sc_hd__decap_12
XFILLER_224_796 VPWR VGND VPWR VGND sky130_ef_sc_hd__decap_12
XFILLER_211_424 VGND VGND VPWR VPWR sky130_fd_sc_hd__decap_6
XFILLER_223_295 VGND VGND VPWR VPWR sky130_fd_sc_hd__decap_6
XFILLER_196_648 VPWR VGND VPWR VGND sky130_ef_sc_hd__decap_12
XFILLER_221_1315 VPWR VGND VPWR VGND sky130_ef_sc_hd__decap_12
XFILLER_51_39 VGND VGND VPWR VPWR sky130_fd_sc_hd__decap_4
Xwire409 net410 VGND VGND VPWR VPWR net409 sky130_fd_sc_hd__clkbuf_1
XFILLER_17_1165 VPWR VGND VPWR VGND sky130_ef_sc_hd__decap_12
XFILLER_108_1282 VPWR VGND VPWR VGND sky130_ef_sc_hd__decap_12
XFILLER_177_873 VPWR VGND VPWR VGND sky130_ef_sc_hd__decap_12
XFILLER_220_980 VPWR VGND VPWR VGND sky130_ef_sc_hd__decap_12
XFILLER_167_39 VGND VGND VPWR VPWR sky130_fd_sc_hd__decap_4
XFILLER_192_832 VGND VGND VPWR VPWR sky130_fd_sc_hd__decap_6
XTAP_TAPCELL_ROW_151_2_5869 VGND VPWR sky130_fd_sc_hd__tapvpwrvgnd_1
XFILLER_178_1269 VPWR VGND VPWR VGND sky130_ef_sc_hd__decap_12
XTAP_TAPCELL_ROW_87_2_5355 VGND VPWR sky130_fd_sc_hd__tapvpwrvgnd_1
XFILLER_183_27 VPWR VGND VPWR VGND sky130_ef_sc_hd__decap_12
XTAP_TAPCELL_ROW_76_1_1343 VGND VPWR sky130_fd_sc_hd__tapvpwrvgnd_1
XFILLER_4_7 VPWR VGND VPWR VGND sky130_ef_sc_hd__decap_12
XTAP_TAPCELL_ROW_131_2_5712 VGND VPWR sky130_fd_sc_hd__tapvpwrvgnd_1
XFILLER_2_249 VGND VGND VPWR VPWR sky130_fd_sc_hd__decap_4
XFILLER_117_1507 VGND VGND VPWR VPWR sky130_fd_sc_hd__decap_8
XFILLER_215_1119 VPWR VGND VPWR VGND sky130_ef_sc_hd__decap_12
XFILLER_116_65 VGND VGND VPWR VPWR sky130_fd_sc_hd__decap_6
XFILLER_232_1422 VPWR VGND VPWR VGND sky130_ef_sc_hd__decap_12
XFILLER_247_811 VGND VGND VPWR VPWR sky130_fd_sc_hd__decap_6
XFILLER_8_1355 VPWR VGND VPWR VGND sky130_ef_sc_hd__decap_12
XFILLER_28_1294 VPWR VGND VPWR VGND sky130_ef_sc_hd__decap_12
XFILLER_115_1242 VGND VGND VPWR VPWR sky130_fd_sc_hd__decap_6
XFILLER_76_58 VGND VGND VPWR VPWR sky130_fd_sc_hd__decap_6
XFILLER_4_1219 VGND VGND VPWR VPWR sky130_fd_sc_hd__decap_6
XFILLER_232_1477 VGND VGND VPWR VPWR sky130_fd_sc_hd__decap_6
XTAP_TAPCELL_ROW_241_4182 VGND VPWR sky130_fd_sc_hd__tapvpwrvgnd_1
Xfanout597 net598 VGND VGND VPWR VPWR net597 sky130_fd_sc_hd__clkbuf_2
XTAP_TAPCELL_ROW_241_4193 VGND VPWR sky130_fd_sc_hd__tapvpwrvgnd_1
XFILLER_150_1177 VGND VGND VPWR VPWR sky130_fd_sc_hd__decap_6
XFILLER_6_1090 VGND VGND VPWR VPWR sky130_fd_sc_hd__decap_6
XPHY_EDGE_ROW_152_2_Right_243 VGND VGND VPWR VPWR sky130_fd_sc_hd__decap_3
XFILLER_206_218 VPWR VGND VPWR VGND sky130_ef_sc_hd__decap_12
XFILLER_234_538 VPWR VGND VPWR VGND sky130_ef_sc_hd__decap_12
XFILLER_185_1229 VPWR VGND VPWR VGND sky130_ef_sc_hd__decap_12
XFILLER_92_46 VPWR VGND VPWR VGND sky130_ef_sc_hd__decap_12
XFILLER_199_431 VPWR VGND VPWR VGND sky130_ef_sc_hd__decap_12
X_402_ net591 net589 net569 VGND VGND VPWR VPWR _191_ sky130_fd_sc_hd__and3_1
XFILLER_202_402 VGND VGND VPWR VPWR sky130_fd_sc_hd__decap_6
XFILLER_226_1226 VPWR VGND VPWR VGND sky130_ef_sc_hd__decap_12
XFILLER_230_722 VPWR VGND VPWR VGND sky130_ef_sc_hd__decap_12
XFILLER_187_615 VPWR VGND VPWR VGND sky130_ef_sc_hd__decap_12
XFILLER_203_947 VPWR VGND VPWR VGND sky130_ef_sc_hd__decap_12
XFILLER_214_273 VGND VGND VPWR VPWR sky130_fd_sc_hd__decap_6
XFILLER_242_593 VPWR VGND VPWR VGND sky130_ef_sc_hd__decap_12
XTAP_TAPCELL_ROW_198_2690 VGND VPWR sky130_fd_sc_hd__tapvpwrvgnd_1
XFILLER_199_486 VPWR VGND VPWR VGND sky130_ef_sc_hd__decap_12
X_333_ net498 VGND VGND VPWR VPWR _122_ sky130_fd_sc_hd__inv_2
XTAP_TAPCELL_ROW_194_2532 VGND VPWR sky130_fd_sc_hd__tapvpwrvgnd_1
XTAP_TAPCELL_ROW_194_2543 VGND VPWR sky130_fd_sc_hd__tapvpwrvgnd_1
XFILLER_39_1390 VPWR VGND VPWR VGND sky130_ef_sc_hd__decap_12
XFILLER_74_1270 VPWR VGND VPWR VGND sky130_ef_sc_hd__decap_12
XTAP_TAPCELL_ROW_194_2554 VGND VPWR sky130_fd_sc_hd__tapvpwrvgnd_1
XFILLER_230_777 VPWR VGND VPWR VGND sky130_ef_sc_hd__decap_12
XFILLER_168_851 VPWR VGND VPWR VGND sky130_ef_sc_hd__decap_12
XTAP_TAPCELL_ROW_190_2407 VGND VPWR sky130_fd_sc_hd__tapvpwrvgnd_1
XTAP_TAPCELL_ROW_190_2418 VGND VPWR sky130_fd_sc_hd__tapvpwrvgnd_1
XFILLER_161_1273 VPWR VGND VPWR VGND sky130_ef_sc_hd__decap_12
XFILLER_195_670 VPWR VGND VPWR VGND sky130_ef_sc_hd__decap_12
XFILLER_183_854 VGND VGND VPWR VPWR sky130_fd_sc_hd__decap_6
XFILLER_196_1336 VPWR VGND VPWR VGND sky130_ef_sc_hd__decap_12
XFILLER_202_1281 VPWR VGND VPWR VGND sky130_ef_sc_hd__decap_12
XTAP_TAPCELL_ROW_188_2325 VGND VPWR sky130_fd_sc_hd__tapvpwrvgnd_1
XTAP_TAPCELL_ROW_188_2336 VGND VPWR sky130_fd_sc_hd__tapvpwrvgnd_1
XTAP_TAPCELL_ROW_188_2347 VGND VPWR sky130_fd_sc_hd__tapvpwrvgnd_1
XFILLER_237_1377 VPWR VGND VPWR VGND sky130_ef_sc_hd__decap_12
XFILLER_81_1230 VPWR VGND VPWR VGND sky130_ef_sc_hd__decap_12
XFILLER_2_22 VPWR VGND VPWR VGND sky130_ef_sc_hd__decap_12
XFILLER_211_1506 VGND VGND VPWR VPWR sky130_fd_sc_hd__decap_8
XFILLER_172_1391 VGND VGND VPWR VPWR sky130_fd_sc_hd__decap_6
XFILLER_81_1285 VGND VGND VPWR VPWR sky130_fd_sc_hd__decap_6
XFILLER_2_77 VPWR VGND VPWR VGND sky130_ef_sc_hd__decap_12
XFILLER_252_335 VPWR VGND VPWR VGND sky130_ef_sc_hd__decap_12
XFILLER_209_1413 VGND VGND VPWR VPWR sky130_fd_sc_hd__decap_6
XFILLER_205_240 VPWR VGND VPWR VGND sky130_ef_sc_hd__decap_12
XPHY_EDGE_ROW_26_2_Right_117 VGND VGND VPWR VPWR sky130_fd_sc_hd__decap_3
XFILLER_166_1140 VPWR VGND VPWR VGND sky130_ef_sc_hd__decap_12
XFILLER_233_560 VPWR VGND VPWR VGND sky130_ef_sc_hd__decap_12
XFILLER_240_519 VPWR VGND VPWR VGND sky130_ef_sc_hd__decap_12
XFILLER_248_1484 VPWR VGND VPWR VGND sky130_ef_sc_hd__decap_12
XFILLER_206_796 VPWR VGND VPWR VGND sky130_ef_sc_hd__decap_12
XFILLER_244_1348 VGND VGND VPWR VPWR sky130_fd_sc_hd__decap_6
XFILLER_205_295 VGND VGND VPWR VPWR sky130_fd_sc_hd__decap_6
XFILLER_221_744 VPWR VGND VPWR VGND sky130_ef_sc_hd__decap_12
XFILLER_166_1195 VPWR VGND VPWR VGND sky130_ef_sc_hd__decap_12
XFILLER_178_648 VPWR VGND VPWR VGND sky130_ef_sc_hd__decap_12
XTAP_TAPCELL_ROW_233_3904 VGND VPWR sky130_fd_sc_hd__tapvpwrvgnd_1
XTAP_TAPCELL_ROW_82_1_1353 VGND VPWR sky130_fd_sc_hd__tapvpwrvgnd_1
XTAP_TAPCELL_ROW_233_3915 VGND VPWR sky130_fd_sc_hd__tapvpwrvgnd_1
XFILLER_92_1392 VGND VGND VPWR VPWR sky130_fd_sc_hd__decap_6
XTAP_TAPCELL_ROW_233_3926 VGND VPWR sky130_fd_sc_hd__tapvpwrvgnd_1
XFILLER_221_799 VPWR VGND VPWR VGND sky130_ef_sc_hd__decap_12
XFILLER_202_980 VPWR VGND VPWR VGND sky130_ef_sc_hd__decap_12
XFILLER_18_1485 VPWR VGND VPWR VGND sky130_ef_sc_hd__decap_12
XFILLER_105_1433 VPWR VGND VPWR VGND sky130_ef_sc_hd__decap_12
XFILLER_140_1313 VPWR VGND VPWR VGND sky130_ef_sc_hd__decap_12
XTAP_TAPCELL_ROW_136_2_5749 VGND VPWR sky130_fd_sc_hd__tapvpwrvgnd_1
XFILLER_203_1045 VPWR VGND VPWR VGND sky130_ef_sc_hd__decap_12
XFILLER_14_1349 VGND VGND VPWR VPWR sky130_fd_sc_hd__decap_6
XFILLER_174_832 VGND VGND VPWR VPWR sky130_fd_sc_hd__decap_6
XFILLER_105_1488 VPWR VGND VPWR VGND sky130_ef_sc_hd__decap_12
XFILLER_140_1368 VPWR VGND VPWR VGND sky130_ef_sc_hd__decap_12
XFILLER_138_1220 VGND VGND VPWR VPWR sky130_fd_sc_hd__decap_6
XFILLER_173_1100 VPWR VGND VPWR VGND sky130_ef_sc_hd__decap_12
XFILLER_177_1291 VPWR VGND VPWR VGND sky130_ef_sc_hd__decap_12
XTAP_TAPCELL_ROW_227_3708 VGND VPWR sky130_fd_sc_hd__tapvpwrvgnd_1
XTAP_TAPCELL_ROW_40_2_4982 VGND VPWR sky130_fd_sc_hd__tapvpwrvgnd_1
XFILLER_86_1196 VPWR VGND VPWR VGND sky130_ef_sc_hd__decap_12
XTAP_TAPCELL_ROW_39_2_4976 VGND VPWR sky130_fd_sc_hd__tapvpwrvgnd_1
XFILLER_173_1155 VGND VGND VPWR VPWR sky130_fd_sc_hd__decap_6
XFILLER_229_811 VGND VGND VPWR VPWR sky130_fd_sc_hd__decap_6
XFILLER_60_1325 VPWR VGND VPWR VGND sky130_ef_sc_hd__decap_12
XFILLER_25_1445 VPWR VGND VPWR VGND sky130_ef_sc_hd__decap_12
XFILLER_5_1506 VGND VGND VPWR VPWR sky130_fd_sc_hd__decap_8
XFILLER_214_1152 VPWR VGND VPWR VGND sky130_ef_sc_hd__decap_12
XFILLER_151_1464 VPWR VGND VPWR VGND sky130_ef_sc_hd__decap_12
XFILLER_243_302 VPWR VGND VPWR VGND sky130_ef_sc_hd__decap_12
XFILLER_3_1241 VGND VGND VPWR VPWR sky130_fd_sc_hd__decap_6
XTAP_TAPCELL_ROW_165_1487 VGND VPWR sky130_fd_sc_hd__tapvpwrvgnd_1
XFILLER_249_1248 VPWR VGND VPWR VGND sky130_ef_sc_hd__decap_12
XTAP_TAPCELL_ROW_165_1498 VGND VPWR sky130_fd_sc_hd__tapvpwrvgnd_1
XFILLER_216_538 VPWR VGND VPWR VGND sky130_ef_sc_hd__decap_12
XTAP_TAPCELL_ROW_32_2_4919 VGND VPWR sky130_fd_sc_hd__tapvpwrvgnd_1
XFILLER_243_357 VPWR VGND VPWR VGND sky130_ef_sc_hd__decap_12
XFILLER_102_34 VPWR VGND VPWR VGND sky130_ef_sc_hd__decap_12
XFILLER_97_1292 VPWR VGND VPWR VGND sky130_ef_sc_hd__decap_12
XFILLER_149_1371 VGND VGND VPWR VPWR sky130_fd_sc_hd__decap_6
XFILLER_169_615 VPWR VGND VPWR VGND sky130_ef_sc_hd__decap_12
XFILLER_184_1262 VGND VGND VPWR VPWR sky130_fd_sc_hd__decap_6
XFILLER_212_722 VPWR VGND VPWR VGND sky130_ef_sc_hd__decap_12
XFILLER_224_593 VPWR VGND VPWR VGND sky130_ef_sc_hd__decap_12
XFILLER_19_1249 VPWR VGND VPWR VGND sky130_ef_sc_hd__decap_12
XFILLER_93_1189 VPWR VGND VPWR VGND sky130_ef_sc_hd__decap_12
XFILLER_106_1208 VPWR VGND VPWR VGND sky130_ef_sc_hd__decap_12
XFILLER_200_906 VPWR VGND VPWR VGND sky130_ef_sc_hd__decap_12
XFILLER_71_1421 VPWR VGND VPWR VGND sky130_ef_sc_hd__decap_12
XFILLER_196_445 VGND VGND VPWR VPWR sky130_fd_sc_hd__decap_6
XFILLER_212_777 VPWR VGND VPWR VGND sky130_ef_sc_hd__decap_12
XFILLER_123_1500 VGND VGND VPWR VPWR sky130_fd_sc_hd__decap_6
XFILLER_221_1112 VGND VGND VPWR VPWR sky130_fd_sc_hd__decap_6
XFILLER_177_670 VPWR VGND VPWR VGND sky130_ef_sc_hd__decap_12
XFILLER_71_1476 VPWR VGND VPWR VGND sky130_ef_sc_hd__decap_12
Xwire228 net229 VGND VGND VPWR VPWR net228 sky130_fd_sc_hd__clkbuf_1
Xwire239 net240 VGND VGND VPWR VPWR net239 sky130_fd_sc_hd__clkbuf_1
XFILLER_165_832 VGND VGND VPWR VPWR sky130_fd_sc_hd__decap_8
XFILLER_178_1011 VPWR VGND VPWR VGND sky130_ef_sc_hd__decap_12
XFILLER_194_15 VGND VGND VPWR VPWR sky130_fd_sc_hd__decap_6
XFILLER_178_1066 VPWR VGND VPWR VGND sky130_ef_sc_hd__decap_12
XFILLER_30_1184 VPWR VGND VPWR VGND sky130_ef_sc_hd__decap_12
XFILLER_117_1304 VPWR VGND VPWR VGND sky130_ef_sc_hd__decap_12
XTAP_TAPCELL_ROW_247_4391 VGND VPWR sky130_fd_sc_hd__tapvpwrvgnd_1
XTAP_TAPCELL_ROW_243_4244 VGND VPWR sky130_fd_sc_hd__tapvpwrvgnd_1
XFILLER_87_68 VGND VGND VPWR VPWR sky130_fd_sc_hd__decap_3
XTAP_TAPCELL_ROW_243_4255 VGND VPWR sky130_fd_sc_hd__tapvpwrvgnd_1
XTAP_TAPCELL_ROW_243_4266 VGND VPWR sky130_fd_sc_hd__tapvpwrvgnd_1
XFILLER_117_1359 VPWR VGND VPWR VGND sky130_ef_sc_hd__decap_12
XFILLER_152_1239 VPWR VGND VPWR VGND sky130_ef_sc_hd__decap_12
XTAP_TAPCELL_ROW_243_4277 VGND VPWR sky130_fd_sc_hd__tapvpwrvgnd_1
XFILLER_8_1152 VPWR VGND VPWR VGND sky130_ef_sc_hd__decap_12
XTAP_TAPCELL_ROW_161_2_5951 VGND VPWR sky130_fd_sc_hd__tapvpwrvgnd_1
XPHY_EDGE_ROW_14_1_Right_670 VGND VGND VPWR VPWR sky130_fd_sc_hd__decap_3
XFILLER_246_151 VPWR VGND VPWR VGND sky130_ef_sc_hd__decap_12
XTAP_TAPCELL_ROW_9_1180 VGND VPWR sky130_fd_sc_hd__tapvpwrvgnd_1
XTAP_TAPCELL_ROW_129_2_5692 VGND VPWR sky130_fd_sc_hd__tapvpwrvgnd_1
XTAP_TAPCELL_ROW_9_1191 VGND VPWR sky130_fd_sc_hd__tapvpwrvgnd_1
XFILLER_189_1162 VPWR VGND VPWR VGND sky130_ef_sc_hd__decap_12
XTAP_TAPCELL_ROW_5_1044 VGND VPWR sky130_fd_sc_hd__tapvpwrvgnd_1
XTAP_TAPCELL_ROW_5_1055 VGND VPWR sky130_fd_sc_hd__tapvpwrvgnd_1
XFILLER_185_1026 VGND VGND VPWR VPWR sky130_fd_sc_hd__decap_6
XFILLER_234_335 VPWR VGND VPWR VGND sky130_ef_sc_hd__decap_12
XTAP_TAPCELL_ROW_5_1066 VGND VPWR sky130_fd_sc_hd__tapvpwrvgnd_1
XPHY_EDGE_ROW_153_2_Right_244 VGND VGND VPWR VPWR sky130_fd_sc_hd__decap_3
XTAP_TAPCELL_ROW_196_2605 VGND VPWR sky130_fd_sc_hd__tapvpwrvgnd_1
XTAP_TAPCELL_ROW_196_2616 VGND VPWR sky130_fd_sc_hd__tapvpwrvgnd_1
XFILLER_222_519 VPWR VGND VPWR VGND sky130_ef_sc_hd__decap_12
XTAP_TAPCELL_ROW_237_4037 VGND VPWR sky130_fd_sc_hd__tapvpwrvgnd_1
XFILLER_250_839 VPWR VGND VPWR VGND sky130_ef_sc_hd__decap_12
XFILLER_128_1411 VPWR VGND VPWR VGND sky130_ef_sc_hd__decap_12
XTAP_TAPCELL_ROW_196_2627 VGND VPWR sky130_fd_sc_hd__tapvpwrvgnd_1
XFILLER_215_560 VPWR VGND VPWR VGND sky130_ef_sc_hd__decap_12
XTAP_TAPCELL_ROW_237_4048 VGND VPWR sky130_fd_sc_hd__tapvpwrvgnd_1
XFILLER_226_1023 VPWR VGND VPWR VGND sky130_ef_sc_hd__decap_12
XTAP_TAPCELL_ROW_237_4059 VGND VPWR sky130_fd_sc_hd__tapvpwrvgnd_1
XFILLER_37_1316 VPWR VGND VPWR VGND sky130_ef_sc_hd__decap_12
XFILLER_187_412 VPWR VGND VPWR VGND sky130_ef_sc_hd__decap_12
XFILLER_242_390 VPWR VGND VPWR VGND sky130_ef_sc_hd__decap_12
XFILLER_163_1335 VPWR VGND VPWR VGND sky130_ef_sc_hd__decap_12
XFILLER_203_744 VPWR VGND VPWR VGND sky130_ef_sc_hd__decap_12
XTAP_TAPCELL_ROW_78_2_5289 VGND VPWR sky130_fd_sc_hd__tapvpwrvgnd_1
XFILLER_128_1466 VPWR VGND VPWR VGND sky130_ef_sc_hd__decap_12
XFILLER_199_283 VPWR VGND VPWR VGND sky130_ef_sc_hd__decap_12
XFILLER_188_968 VPWR VGND VPWR VGND sky130_ef_sc_hd__decap_12
XTAP_TAPCELL_ROW_122_2_5635 VGND VPWR sky130_fd_sc_hd__tapvpwrvgnd_1
XFILLER_226_1078 VPWR VGND VPWR VGND sky130_ef_sc_hd__decap_12
XFILLER_187_467 VGND VGND VPWR VPWR sky130_fd_sc_hd__decap_6
XFILLER_230_574 VGND VGND VPWR VPWR sky130_fd_sc_hd__decap_6
XFILLER_243_1370 VGND VGND VPWR VPWR sky130_fd_sc_hd__decap_6
X_316_ net596 dout0_q\[26\] net61 VGND VGND VPWR VPWR _105_ sky130_fd_sc_hd__a21oi_1
XFILLER_203_799 VPWR VGND VPWR VGND sky130_ef_sc_hd__decap_12
Xinput14 wr_data[13] VGND VGND VPWR VPWR net14 sky130_fd_sc_hd__clkbuf_1
Xinput25 wr_data[23] VGND VGND VPWR VPWR net25 sky130_fd_sc_hd__clkbuf_1
XFILLER_200_1207 VPWR VGND VPWR VGND sky130_ef_sc_hd__decap_12
Xinput36 wr_data[4] VGND VGND VPWR VPWR net36 sky130_fd_sc_hd__clkbuf_1
XFILLER_204_1398 VPWR VGND VPWR VGND sky130_ef_sc_hd__decap_12
XFILLER_6_330 VGND VGND VPWR VPWR sky130_fd_sc_hd__decap_4
Xmax_cap506 _112_ VGND VGND VPWR VPWR net506 sky130_fd_sc_hd__clkbuf_1
XFILLER_196_1133 VGND VGND VPWR VPWR sky130_fd_sc_hd__decap_6
XFILLER_13_1371 VGND VGND VPWR VPWR sky130_fd_sc_hd__decap_6
Xmax_cap517 _091_ VGND VGND VPWR VPWR net517 sky130_fd_sc_hd__clkbuf_1
XFILLER_7_897 VGND VGND VPWR VPWR sky130_fd_sc_hd__decap_6
Xmax_cap528 net63 VGND VGND VPWR VPWR net528 sky130_fd_sc_hd__clkbuf_1
Xmax_cap539 net51 VGND VGND VPWR VPWR net539 sky130_fd_sc_hd__clkbuf_1
XTAP_TAPCELL_ROW_25_2_4862 VGND VPWR sky130_fd_sc_hd__tapvpwrvgnd_1
XFILLER_170_323 VPWR VGND VPWR VGND sky130_ef_sc_hd__decap_12
XFILLER_182_194 VPWR VGND VPWR VGND sky130_ef_sc_hd__decap_12
XFILLER_48_1423 VPWR VGND VPWR VGND sky130_ef_sc_hd__decap_12
XFILLER_170_378 VPWR VGND VPWR VGND sky130_ef_sc_hd__decap_12
XFILLER_174_1453 VPWR VGND VPWR VGND sky130_ef_sc_hd__decap_12
XFILLER_83_1347 VPWR VGND VPWR VGND sky130_ef_sc_hd__decap_12
XFILLER_237_1174 VPWR VGND VPWR VGND sky130_ef_sc_hd__decap_12
XFILLER_48_1478 VGND VGND VPWR VPWR sky130_fd_sc_hd__decap_6
XPHY_EDGE_ROW_15_2_Left_517 VGND VGND VPWR VPWR sky130_fd_sc_hd__decap_3
XFILLER_28_3 VPWR VGND VPWR VGND sky130_ef_sc_hd__decap_12
XFILLER_211_1303 VPWR VGND VPWR VGND sky130_ef_sc_hd__decap_12
XTAP_TAPCELL_ROW_134_1_1430 VGND VPWR sky130_fd_sc_hd__tapvpwrvgnd_1
XFILLER_211_1358 VPWR VGND VPWR VGND sky130_ef_sc_hd__decap_12
XFILLER_225_302 VPWR VGND VPWR VGND sky130_ef_sc_hd__decap_12
XFILLER_237_173 VPWR VGND VPWR VGND sky130_ef_sc_hd__decap_12
XFILLER_203_44 VPWR VGND VPWR VGND sky130_ef_sc_hd__decap_12
XFILLER_252_132 VPWR VGND VPWR VGND sky130_ef_sc_hd__decap_12
XFILLER_225_357 VPWR VGND VPWR VGND sky130_ef_sc_hd__decap_12
XFILLER_203_99 VPWR VGND VPWR VGND sky130_ef_sc_hd__decap_12
XFILLER_197_209 VGND VGND VPWR VPWR sky130_fd_sc_hd__decap_6
XFILLER_240_316 VGND VGND VPWR VPWR sky130_fd_sc_hd__decap_6
XFILLER_248_1281 VPWR VGND VPWR VGND sky130_ef_sc_hd__decap_12
XFILLER_94_1454 VPWR VGND VPWR VGND sky130_ef_sc_hd__decap_12
XFILLER_252_187 VGND VGND VPWR VPWR sky130_fd_sc_hd__decap_6
XFILLER_181_1413 VGND VGND VPWR VPWR sky130_fd_sc_hd__decap_6
XFILLER_206_593 VPWR VGND VPWR VGND sky130_ef_sc_hd__decap_12
XPHY_EDGE_ROW_27_2_Right_118 VGND VGND VPWR VPWR sky130_fd_sc_hd__decap_3
XFILLER_221_541 VPWR VGND VPWR VGND sky130_ef_sc_hd__decap_12
XFILLER_178_445 VGND VGND VPWR VPWR sky130_fd_sc_hd__decap_6
XFILLER_222_1410 VPWR VGND VPWR VGND sky130_ef_sc_hd__decap_12
XFILLER_165_106 VPWR VGND VPWR VGND sky130_ef_sc_hd__decap_12
XFILLER_221_596 VGND VGND VPWR VPWR sky130_fd_sc_hd__decap_6
XFILLER_18_1282 VPWR VGND VPWR VGND sky130_ef_sc_hd__decap_12
XFILLER_105_1230 VPWR VGND VPWR VGND sky130_ef_sc_hd__decap_12
XFILLER_194_949 VPWR VGND VPWR VGND sky130_ef_sc_hd__decap_12
XFILLER_187_990 VPWR VGND VPWR VGND sky130_ef_sc_hd__decap_12
XFILLER_222_1465 VPWR VGND VPWR VGND sky130_ef_sc_hd__decap_12
XFILLER_165_139 VGND VGND VPWR VPWR sky130_fd_sc_hd__decap_8
XFILLER_105_1285 VGND VGND VPWR VPWR sky130_fd_sc_hd__decap_6
XFILLER_140_1165 VPWR VGND VPWR VGND sky130_ef_sc_hd__decap_12
XFILLER_175_1217 VPWR VGND VPWR VGND sky130_ef_sc_hd__decap_12
XFILLER_255_1252 VGND VGND VPWR VPWR sky130_fd_sc_hd__decap_8
XFILLER_27_1507 VGND VGND VPWR VPWR sky130_fd_sc_hd__decap_8
XFILLER_249_928 VPWR VGND VPWR VGND sky130_ef_sc_hd__decap_12
XTAP_TAPCELL_ROW_146_2_5831 VGND VPWR sky130_fd_sc_hd__tapvpwrvgnd_1
XFILLER_216_1269 VPWR VGND VPWR VGND sky130_ef_sc_hd__decap_12
XFILLER_9_1450 VPWR VGND VPWR VGND sky130_ef_sc_hd__decap_12
XFILLER_57_27 VPWR VGND VPWR VGND sky130_ef_sc_hd__decap_12
XFILLER_5_1303 VPWR VGND VPWR VGND sky130_ef_sc_hd__decap_12
XFILLER_25_1242 VGND VGND VPWR VPWR sky130_fd_sc_hd__decap_6
XFILLER_9_1483 VGND VGND VPWR VPWR sky130_fd_sc_hd__decap_8
XFILLER_151_1261 VPWR VGND VPWR VGND sky130_ef_sc_hd__decap_12
XFILLER_116_1392 VGND VGND VPWR VPWR sky130_fd_sc_hd__decap_6
XFILLER_5_1358 VPWR VGND VPWR VGND sky130_ef_sc_hd__decap_12
XFILLER_228_151 VPWR VGND VPWR VGND sky130_ef_sc_hd__decap_12
XFILLER_60_1177 VGND VGND VPWR VPWR sky130_fd_sc_hd__decap_6
XFILLER_113_44 VPWR VGND VPWR VGND sky130_ef_sc_hd__decap_12
XFILLER_186_1324 VPWR VGND VPWR VGND sky130_ef_sc_hd__decap_12
XFILLER_216_335 VPWR VGND VPWR VGND sky130_ef_sc_hd__decap_12
XFILLER_249_1045 VPWR VGND VPWR VGND sky130_ef_sc_hd__decap_12
XFILLER_73_15 VPWR VGND VPWR VGND sky130_ef_sc_hd__decap_12
XFILLER_95_1218 VPWR VGND VPWR VGND sky130_ef_sc_hd__decap_12
XFILLER_243_154 VPWR VGND VPWR VGND sky130_ef_sc_hd__decap_12
XTAP_TAPCELL_ROW_64_2_5175 VGND VPWR sky130_fd_sc_hd__tapvpwrvgnd_1
XPHY_EDGE_ROW_61_2_Left_563 VGND VGND VPWR VPWR sky130_fd_sc_hd__decap_3
XFILLER_189_15 VPWR VGND VPWR VGND sky130_ef_sc_hd__decap_12
XFILLER_204_519 VPWR VGND VPWR VGND sky130_ef_sc_hd__decap_12
XFILLER_186_1379 VPWR VGND VPWR VGND sky130_ef_sc_hd__decap_12
XFILLER_232_839 VPWR VGND VPWR VGND sky130_ef_sc_hd__decap_12
XTAP_TAPCELL_ROW_203_2870 VGND VPWR sky130_fd_sc_hd__tapvpwrvgnd_1
XTAP_TAPCELL_ROW_107_2_5515 VGND VPWR sky130_fd_sc_hd__tapvpwrvgnd_1
Xwire82 _236_ VGND VGND VPWR VPWR net82 sky130_fd_sc_hd__clkbuf_1
XFILLER_231_338 VGND VGND VPWR VPWR sky130_fd_sc_hd__decap_6
XFILLER_169_412 VPWR VGND VPWR VGND sky130_ef_sc_hd__decap_12
XTAP_TAPCELL_ROW_255_4671 VGND VPWR sky130_fd_sc_hd__tapvpwrvgnd_1
XFILLER_197_732 VPWR VGND VPWR VGND sky130_ef_sc_hd__decap_12
XFILLER_224_390 VPWR VGND VPWR VGND sky130_ef_sc_hd__decap_12
XTAP_TAPCELL_ROW_255_4682 VGND VPWR sky130_fd_sc_hd__tapvpwrvgnd_1
XTAP_TAPCELL_ROW_255_4693 VGND VPWR sky130_fd_sc_hd__tapvpwrvgnd_1
XTAP_TAPCELL_ROW_251_4524 VGND VPWR sky130_fd_sc_hd__tapvpwrvgnd_1
XTAP_TAPCELL_ROW_251_4535 VGND VPWR sky130_fd_sc_hd__tapvpwrvgnd_1
XFILLER_200_703 VGND VGND VPWR VPWR sky130_fd_sc_hd__decap_6
XTAP_TAPCELL_ROW_251_4546 VGND VPWR sky130_fd_sc_hd__tapvpwrvgnd_1
XFILLER_223_1229 VPWR VGND VPWR VGND sky130_ef_sc_hd__decap_12
XFILLER_169_467 VGND VGND VPWR VPWR sky130_fd_sc_hd__decap_6
XFILLER_185_916 VPWR VGND VPWR VGND sky130_ef_sc_hd__decap_12
XFILLER_212_574 VGND VGND VPWR VPWR sky130_fd_sc_hd__decap_6
XTAP_TAPCELL_ROW_251_4557 VGND VPWR sky130_fd_sc_hd__tapvpwrvgnd_1
XFILLER_240_894 VPWR VGND VPWR VGND sky130_ef_sc_hd__decap_12
XFILLER_197_787 VPWR VGND VPWR VGND sky130_ef_sc_hd__decap_12
XTAP_TAPCELL_ROW_64_1_1325 VGND VPWR sky130_fd_sc_hd__tapvpwrvgnd_1
XFILLER_132_3 VPWR VGND VPWR VGND sky130_ef_sc_hd__decap_12
XFILLER_71_1273 VPWR VGND VPWR VGND sky130_ef_sc_hd__decap_12
XFILLER_197_1420 VPWR VGND VPWR VGND sky130_ef_sc_hd__decap_12
XPHY_EDGE_ROW_13_1_Left_268 VGND VGND VPWR VPWR sky130_fd_sc_hd__decap_3
XFILLER_193_971 VPWR VGND VPWR VGND sky130_ef_sc_hd__decap_12
XFILLER_165_673 VPWR VGND VPWR VGND sky130_ef_sc_hd__decap_12
XTAP_TAPCELL_ROW_140_1_1440 VGND VPWR sky130_fd_sc_hd__tapvpwrvgnd_1
XFILLER_197_1475 VPWR VGND VPWR VGND sky130_ef_sc_hd__decap_12
XFILLER_3_300 VGND VGND VPWR VPWR sky130_fd_sc_hd__fill_1
XTAP_TAPCELL_ROW_249_4464 VGND VPWR sky130_fd_sc_hd__tapvpwrvgnd_1
XFILLER_98_34 VPWR VGND VPWR VGND sky130_ef_sc_hd__decap_12
XTAP_TAPCELL_ROW_249_4475 VGND VPWR sky130_fd_sc_hd__tapvpwrvgnd_1
XFILLER_3_322 VGND VGND VPWR VPWR sky130_fd_sc_hd__decap_4
XFILLER_4_845 VGND VGND VPWR VPWR sky130_fd_sc_hd__fill_1
XPHY_EDGE_ROW_138_1_Left_393 VGND VGND VPWR VPWR sky130_fd_sc_hd__decap_3
XTAP_TAPCELL_ROW_249_4486 VGND VPWR sky130_fd_sc_hd__tapvpwrvgnd_1
XTAP_TAPCELL_ROW_245_4317 VGND VPWR sky130_fd_sc_hd__tapvpwrvgnd_1
XTAP_TAPCELL_ROW_245_4328 VGND VPWR sky130_fd_sc_hd__tapvpwrvgnd_1
XTAP_TAPCELL_ROW_245_4339 VGND VPWR sky130_fd_sc_hd__tapvpwrvgnd_1
XFILLER_3_388 VGND VGND VPWR VPWR sky130_fd_sc_hd__fill_1
XFILLER_234_1336 VPWR VGND VPWR VGND sky130_ef_sc_hd__decap_12
XFILLER_80_1509 VGND VGND VPWR VPWR sky130_fd_sc_hd__decap_6
XPHY_EDGE_ROW_75_1_Left_330 VGND VGND VPWR VPWR sky130_fd_sc_hd__decap_3
XTAP_TAPCELL_ROW_7_1106 VGND VPWR sky130_fd_sc_hd__tapvpwrvgnd_1
XFILLER_82_1380 VPWR VGND VPWR VGND sky130_ef_sc_hd__decap_12
XTAP_TAPCELL_ROW_7_1117 VGND VPWR sky130_fd_sc_hd__tapvpwrvgnd_1
XFILLER_117_1189 VPWR VGND VPWR VGND sky130_ef_sc_hd__decap_12
XFILLER_248_961 VGND VGND VPWR VPWR sky130_fd_sc_hd__decap_6
XTAP_TAPCELL_ROW_7_1128 VGND VPWR sky130_fd_sc_hd__tapvpwrvgnd_1
XFILLER_207_302 VPWR VGND VPWR VGND sky130_ef_sc_hd__decap_12
XFILLER_219_173 VPWR VGND VPWR VGND sky130_ef_sc_hd__decap_12
XFILLER_130_1356 VPWR VGND VPWR VGND sky130_ef_sc_hd__decap_12
XPHY_EDGE_ROW_15_1_Right_671 VGND VGND VPWR VPWR sky130_fd_sc_hd__decap_3
XPHY_EDGE_ROW_179_Right_24 VGND VGND VPWR VPWR sky130_fd_sc_hd__decap_3
XFILLER_234_132 VPWR VGND VPWR VGND sky130_ef_sc_hd__decap_12
XFILLER_207_357 VPWR VGND VPWR VGND sky130_ef_sc_hd__decap_12
XFILLER_165_1408 VPWR VGND VPWR VGND sky130_ef_sc_hd__decap_12
XFILLER_210_1391 VGND VGND VPWR VPWR sky130_fd_sc_hd__decap_6
XFILLER_179_209 VGND VGND VPWR VPWR sky130_fd_sc_hd__decap_6
XFILLER_222_316 VGND VGND VPWR VPWR sky130_fd_sc_hd__decap_6
XFILLER_250_636 VPWR VGND VPWR VGND sky130_ef_sc_hd__decap_12
XPHY_EDGE_ROW_154_2_Right_245 VGND VGND VPWR VPWR sky130_fd_sc_hd__decap_3
XFILLER_234_187 VGND VGND VPWR VPWR sky130_fd_sc_hd__decap_6
XFILLER_245_1432 VPWR VGND VPWR VGND sky130_ef_sc_hd__decap_12
XFILLER_188_710 VPWR VGND VPWR VGND sky130_ef_sc_hd__decap_12
XFILLER_203_541 VPWR VGND VPWR VGND sky130_ef_sc_hd__decap_12
XFILLER_76_1184 VPWR VGND VPWR VGND sky130_ef_sc_hd__decap_12
XFILLER_231_861 VPWR VGND VPWR VGND sky130_ef_sc_hd__decap_12
XFILLER_128_1263 VGND VGND VPWR VPWR sky130_fd_sc_hd__decap_6
XFILLER_245_1487 VPWR VGND VPWR VGND sky130_ef_sc_hd__decap_12
XFILLER_188_765 VPWR VGND VPWR VGND sky130_ef_sc_hd__decap_12
XFILLER_163_1165 VPWR VGND VPWR VGND sky130_ef_sc_hd__decap_12
XFILLER_203_596 VGND VGND VPWR VPWR sky130_fd_sc_hd__decap_6
XFILLER_169_990 VPWR VGND VPWR VGND sky130_ef_sc_hd__decap_12
XFILLER_176_949 VPWR VGND VPWR VGND sky130_ef_sc_hd__decap_12
XFILLER_50_1313 VPWR VGND VPWR VGND sky130_ef_sc_hd__decap_12
XFILLER_15_1433 VPWR VGND VPWR VGND sky130_ef_sc_hd__decap_12
XFILLER_204_1140 VPWR VGND VPWR VGND sky130_ef_sc_hd__decap_12
XFILLER_8_65 VPWR VGND VPWR VGND sky130_ef_sc_hd__decap_12
XFILLER_200_1004 VGND VGND VPWR VPWR sky130_fd_sc_hd__decap_6
XPHY_EDGE_ROW_188_Right_33 VGND VGND VPWR VPWR sky130_fd_sc_hd__decap_3
XFILLER_50_1368 VPWR VGND VPWR VGND sky130_ef_sc_hd__decap_12
XFILLER_15_1488 VPWR VGND VPWR VGND sky130_ef_sc_hd__decap_12
XTAP_TAPCELL_ROW_152_2_5874 VGND VPWR sky130_fd_sc_hd__tapvpwrvgnd_1
XFILLER_204_1195 VPWR VGND VPWR VGND sky130_ef_sc_hd__decap_12
Xwire570 net43 VGND VGND VPWR VPWR net570 sky130_fd_sc_hd__clkbuf_1
Xwire581 net582 VGND VGND VPWR VPWR net581 sky130_fd_sc_hd__clkbuf_1
XFILLER_195_80 VGND VGND VPWR VPWR sky130_fd_sc_hd__decap_6
XFILLER_6_171 VGND VGND VPWR VPWR sky130_fd_sc_hd__fill_2
Xmax_cap336 net337 VGND VGND VPWR VPWR net336 sky130_fd_sc_hd__clkbuf_1
XFILLER_170_120 VPWR VGND VPWR VGND sky130_ef_sc_hd__decap_12
XFILLER_48_1220 VGND VGND VPWR VPWR sky130_fd_sc_hd__decap_6
XFILLER_135_1201 VGND VGND VPWR VPWR sky130_fd_sc_hd__decap_4
XFILLER_170_175 VPWR VGND VPWR VGND sky130_ef_sc_hd__decap_12
XFILLER_174_1250 VPWR VGND VPWR VGND sky130_ef_sc_hd__decap_12
XFILLER_83_1177 VPWR VGND VPWR VGND sky130_ef_sc_hd__decap_12
XFILLER_211_1100 VPWR VGND VPWR VGND sky130_ef_sc_hd__decap_12
XTAP_TAPCELL_ROW_113_2_5569 VGND VPWR sky130_fd_sc_hd__tapvpwrvgnd_1
XFILLER_61_1464 VPWR VGND VPWR VGND sky130_ef_sc_hd__decap_12
XPHY_EDGE_ROW_197_Right_42 VGND VGND VPWR VPWR sky130_fd_sc_hd__decap_3
XFILLER_215_1291 VPWR VGND VPWR VGND sky130_ef_sc_hd__decap_12
XFILLER_239_983 VGND VGND VPWR VPWR sky130_fd_sc_hd__decap_6
XTAP_TAPCELL_ROW_166_1560 VGND VPWR sky130_fd_sc_hd__tapvpwrvgnd_1
XFILLER_214_65 VPWR VGND VPWR VGND sky130_ef_sc_hd__decap_12
XTAP_TAPCELL_ROW_50_2_5061 VGND VPWR sky130_fd_sc_hd__tapvpwrvgnd_1
XTAP_TAPCELL_ROW_166_1571 VGND VPWR sky130_fd_sc_hd__tapvpwrvgnd_1
XFILLER_211_1155 VGND VGND VPWR VPWR sky130_fd_sc_hd__decap_6
XTAP_TAPCELL_ROW_49_2_5055 VGND VPWR sky130_fd_sc_hd__tapvpwrvgnd_1
XTAP_TAPCELL_ROW_166_1582 VGND VPWR sky130_fd_sc_hd__tapvpwrvgnd_1
XTAP_TAPCELL_ROW_70_1_1335 VGND VPWR sky130_fd_sc_hd__tapvpwrvgnd_1
XFILLER_246_1207 VPWR VGND VPWR VGND sky130_ef_sc_hd__decap_12
XFILLER_241_603 VPWR VGND VPWR VGND sky130_ef_sc_hd__decap_12
XFILLER_4_1391 VGND VGND VPWR VPWR sky130_fd_sc_hd__decap_6
XFILLER_168_1054 VPWR VGND VPWR VGND sky130_ef_sc_hd__decap_12
XFILLER_225_154 VPWR VGND VPWR VGND sky130_ef_sc_hd__decap_12
XFILLER_253_474 VPWR VGND VPWR VGND sky130_ef_sc_hd__decap_12
XFILLER_198_507 VPWR VGND VPWR VGND sky130_ef_sc_hd__decap_12
XFILLER_214_839 VPWR VGND VPWR VGND sky130_ef_sc_hd__decap_12
XFILLER_59_1371 VGND VGND VPWR VPWR sky130_fd_sc_hd__decap_6
XFILLER_94_1251 VPWR VGND VPWR VGND sky130_ef_sc_hd__decap_12
XFILLER_213_338 VGND VGND VPWR VPWR sky130_fd_sc_hd__decap_6
XFILLER_241_658 VPWR VGND VPWR VGND sky130_ef_sc_hd__decap_12
XFILLER_179_732 VPWR VGND VPWR VGND sky130_ef_sc_hd__decap_12
XFILLER_206_390 VPWR VGND VPWR VGND sky130_ef_sc_hd__decap_12
XPHY_EDGE_ROW_28_2_Right_119 VGND VGND VPWR VPWR sky130_fd_sc_hd__decap_3
XFILLER_16_1208 VPWR VGND VPWR VGND sky130_ef_sc_hd__decap_12
XFILLER_167_916 VPWR VGND VPWR VGND sky130_ef_sc_hd__decap_12
XFILLER_222_894 VPWR VGND VPWR VGND sky130_ef_sc_hd__decap_12
XFILLER_33_1500 VGND VGND VPWR VPWR sky130_fd_sc_hd__decap_6
XFILLER_107_1347 VPWR VGND VPWR VGND sky130_ef_sc_hd__decap_12
XFILLER_142_1227 VPWR VGND VPWR VGND sky130_ef_sc_hd__decap_12
XFILLER_179_787 VPWR VGND VPWR VGND sky130_ef_sc_hd__decap_12
XFILLER_194_746 VGND VGND VPWR VPWR sky130_fd_sc_hd__decap_6
XFILLER_222_1262 VGND VGND VPWR VPWR sky130_fd_sc_hd__decap_6
XFILLER_175_971 VPWR VGND VPWR VGND sky130_ef_sc_hd__decap_12
XFILLER_4_108 VPWR VGND VPWR VGND sky130_ef_sc_hd__decap_12
XFILLER_175_39 VGND VGND VPWR VPWR sky130_fd_sc_hd__decap_4
XFILLER_175_1014 VPWR VGND VPWR VGND sky130_ef_sc_hd__decap_12
XFILLER_108_22 VPWR VGND VPWR VGND sky130_ef_sc_hd__decap_12
XFILLER_68_15 VGND VGND VPWR VPWR sky130_fd_sc_hd__decap_6
XFILLER_175_1069 VGND VGND VPWR VPWR sky130_fd_sc_hd__decap_6
XFILLER_27_1304 VPWR VGND VPWR VGND sky130_ef_sc_hd__decap_12
XFILLER_216_1011 VPWR VGND VPWR VGND sky130_ef_sc_hd__decap_12
XFILLER_255_1093 VPWR VGND VPWR VGND sky130_ef_sc_hd__decap_12
XFILLER_249_725 VGND VGND VPWR VPWR sky130_fd_sc_hd__decap_6
XFILLER_191_27 VPWR VGND VPWR VGND sky130_ef_sc_hd__decap_12
XFILLER_118_1454 VPWR VGND VPWR VGND sky130_ef_sc_hd__decap_12
XFILLER_62_1239 VPWR VGND VPWR VGND sky130_ef_sc_hd__decap_12
XFILLER_27_1359 VPWR VGND VPWR VGND sky130_ef_sc_hd__decap_12
XFILLER_0_358 VGND VGND VPWR VPWR sky130_fd_sc_hd__fill_1
XFILLER_216_1066 VPWR VGND VPWR VGND sky130_ef_sc_hd__decap_12
XFILLER_5_1100 VPWR VGND VPWR VGND sky130_ef_sc_hd__decap_12
XFILLER_153_1378 VPWR VGND VPWR VGND sky130_ef_sc_hd__decap_12
XFILLER_124_65 VGND VGND VPWR VPWR sky130_fd_sc_hd__decap_6
X_650_ clknet_3_6__leaf_clk acc_core.adder.cla_blocks\[4\].block.sum\[0\] _058_ VGND
+ VGND VPWR VPWR net50 sky130_fd_sc_hd__dfrtp_1
XTAP_TAPCELL_ROW_205_2921 VGND VPWR sky130_fd_sc_hd__tapvpwrvgnd_1
XFILLER_5_1155 VGND VGND VPWR VPWR sky130_fd_sc_hd__decap_6
XTAP_TAPCELL_ROW_205_2932 VGND VPWR sky130_fd_sc_hd__tapvpwrvgnd_1
XFILLER_84_58 VGND VGND VPWR VPWR sky130_fd_sc_hd__decap_6
XTAP_TAPCELL_ROW_205_2943 VGND VPWR sky130_fd_sc_hd__tapvpwrvgnd_1
XFILLER_186_1121 VPWR VGND VPWR VGND sky130_ef_sc_hd__decap_12
XFILLER_216_132 VPWR VGND VPWR VGND sky130_ef_sc_hd__decap_12
XFILLER_244_452 VPWR VGND VPWR VGND sky130_ef_sc_hd__decap_12
X_581_ net669 VGND VGND VPWR VPWR _063_ sky130_fd_sc_hd__inv_2
XTAP_TAPCELL_ROW_201_2807 VGND VPWR sky130_fd_sc_hd__tapvpwrvgnd_1
XFILLER_204_316 VGND VGND VPWR VPWR sky130_fd_sc_hd__decap_6
XTAP_TAPCELL_ROW_253_4608 VGND VPWR sky130_fd_sc_hd__tapvpwrvgnd_1
XFILLER_186_1176 VGND VGND VPWR VPWR sky130_fd_sc_hd__decap_6
XPHY_EDGE_ROW_201_Right_46 VGND VGND VPWR VPWR sky130_fd_sc_hd__decap_3
XFILLER_189_529 VPWR VGND VPWR VGND sky130_ef_sc_hd__decap_12
XFILLER_216_187 VGND VGND VPWR VPWR sky130_fd_sc_hd__decap_6
XFILLER_232_636 VPWR VGND VPWR VGND sky130_ef_sc_hd__decap_12
XTAP_TAPCELL_ROW_253_4619 VGND VPWR sky130_fd_sc_hd__tapvpwrvgnd_1
XFILLER_38_1411 VPWR VGND VPWR VGND sky130_ef_sc_hd__decap_12
XTAP_TAPCELL_ROW_0_870 VGND VPWR sky130_fd_sc_hd__tapvpwrvgnd_1
XTAP_TAPCELL_ROW_0_881 VGND VPWR sky130_fd_sc_hd__tapvpwrvgnd_1
XTAP_TAPCELL_ROW_0_892 VGND VPWR sky130_fd_sc_hd__tapvpwrvgnd_1
XFILLER_73_1335 VPWR VGND VPWR VGND sky130_ef_sc_hd__decap_12
XFILLER_213_861 VPWR VGND VPWR VGND sky130_ef_sc_hd__decap_12
XFILLER_227_1162 VPWR VGND VPWR VGND sky130_ef_sc_hd__decap_12
XFILLER_38_1466 VPWR VGND VPWR VGND sky130_ef_sc_hd__decap_12
XFILLER_125_1414 VGND VGND VPWR VPWR sky130_fd_sc_hd__decap_6
XFILLER_9_904 VPWR VGND VPWR VGND sky130_ef_sc_hd__decap_12
XFILLER_164_1485 VPWR VGND VPWR VGND sky130_ef_sc_hd__decap_12
XFILLER_185_713 VPWR VGND VPWR VGND sky130_ef_sc_hd__decap_12
XFILLER_223_1026 VGND VGND VPWR VPWR sky130_fd_sc_hd__decap_6
XFILLER_240_691 VPWR VGND VPWR VGND sky130_ef_sc_hd__decap_12
XFILLER_8_403 VGND VGND VPWR VPWR sky130_fd_sc_hd__fill_2
XFILLER_197_584 VPWR VGND VPWR VGND sky130_ef_sc_hd__decap_12
XFILLER_9_937 VGND VGND VPWR VPWR sky130_fd_sc_hd__decap_8
XFILLER_160_1349 VGND VGND VPWR VPWR sky130_fd_sc_hd__decap_6
XFILLER_8_425 VGND VGND VPWR VPWR sky130_fd_sc_hd__fill_2
XTAP_TAPCELL_ROW_137_2_5754 VGND VPWR sky130_fd_sc_hd__tapvpwrvgnd_1
XFILLER_185_768 VGND VGND VPWR VPWR sky130_fd_sc_hd__decap_6
XFILLER_201_1346 VPWR VGND VPWR VGND sky130_ef_sc_hd__decap_12
XFILLER_197_1272 VPWR VGND VPWR VGND sky130_ef_sc_hd__decap_12
XPHY_EDGE_ROW_210_Right_55 VGND VGND VPWR VPWR sky130_fd_sc_hd__decap_3
XFILLER_3_130 VPWR VGND VPWR VGND sky130_ef_sc_hd__decap_12
XFILLER_119_1218 VPWR VGND VPWR VGND sky130_ef_sc_hd__decap_12
XFILLER_84_1442 VPWR VGND VPWR VGND sky130_ef_sc_hd__decap_12
XTAP_TAPCELL_ROW_55_2_5098 VGND VPWR sky130_fd_sc_hd__tapvpwrvgnd_1
XFILLER_171_1401 VPWR VGND VPWR VGND sky130_ef_sc_hd__decap_12
XFILLER_180_495 VPWR VGND VPWR VGND sky130_ef_sc_hd__decap_12
XFILLER_80_1306 VGND VGND VPWR VPWR sky130_fd_sc_hd__decap_6
XFILLER_234_1133 VGND VGND VPWR VPWR sky130_fd_sc_hd__decap_6
XFILLER_84_1497 VPWR VGND VPWR VGND sky130_ef_sc_hd__decap_12
XFILLER_171_1456 VGND VGND VPWR VPWR sky130_fd_sc_hd__decap_6
XFILLER_255_706 VGND VGND VPWR VPWR sky130_fd_sc_hd__decap_8
XFILLER_0_881 VGND VGND VPWR VPWR sky130_fd_sc_hd__fill_1
Xhold3 rd_addr\[5\] VGND VGND VPWR VPWR net691 sky130_fd_sc_hd__dlygate4sd3_1
XFILLER_212_1453 VPWR VGND VPWR VGND sky130_ef_sc_hd__decap_12
XFILLER_254_249 VPWR VGND VPWR VGND sky130_ef_sc_hd__decap_12
XTAP_TAPCELL_ROW_33_2_4924 VGND VPWR sky130_fd_sc_hd__tapvpwrvgnd_1
XFILLER_207_154 VPWR VGND VPWR VGND sky130_ef_sc_hd__decap_12
XFILLER_223_603 VPWR VGND VPWR VGND sky130_ef_sc_hd__decap_12
XPHY_EDGE_ROW_16_1_Right_672 VGND VGND VPWR VPWR sky130_fd_sc_hd__decap_3
XFILLER_235_474 VPWR VGND VPWR VGND sky130_ef_sc_hd__decap_12
XTAP_TAPCELL_ROW_221_3490 VGND VPWR sky130_fd_sc_hd__tapvpwrvgnd_1
XFILLER_250_433 VPWR VGND VPWR VGND sky130_ef_sc_hd__decap_12
XFILLER_91_1402 VPWR VGND VPWR VGND sky130_ef_sc_hd__decap_12
XFILLER_223_658 VPWR VGND VPWR VGND sky130_ef_sc_hd__decap_12
XPHY_EDGE_ROW_155_2_Right_246 VGND VGND VPWR VPWR sky130_fd_sc_hd__decap_3
XFILLER_95_3 VPWR VGND VPWR VGND sky130_ef_sc_hd__decap_12
XFILLER_200_34 VPWR VGND VPWR VGND sky130_ef_sc_hd__decap_12
XFILLER_250_488 VGND VGND VPWR VPWR sky130_fd_sc_hd__decap_6
XFILLER_245_1284 VGND VGND VPWR VPWR sky130_fd_sc_hd__decap_6
XFILLER_91_1457 VGND VGND VPWR VPWR sky130_fd_sc_hd__decap_6
XFILLER_188_562 VPWR VGND VPWR VGND sky130_ef_sc_hd__decap_12
XFILLER_204_894 VPWR VGND VPWR VGND sky130_ef_sc_hd__decap_12
XFILLER_104_1509 VGND VGND VPWR VPWR sky130_fd_sc_hd__decap_6
XFILLER_176_746 VGND VGND VPWR VPWR sky130_fd_sc_hd__decap_6
XFILLER_200_89 VPWR VGND VPWR VGND sky130_ef_sc_hd__decap_12
XTAP_TAPCELL_ROW_34_1_1280 VGND VPWR sky130_fd_sc_hd__tapvpwrvgnd_1
XFILLER_15_1230 VPWR VGND VPWR VGND sky130_ef_sc_hd__decap_12
XTAP_TAPCELL_ROW_174_1840 VGND VPWR sky130_fd_sc_hd__tapvpwrvgnd_1
XFILLER_106_1380 VPWR VGND VPWR VGND sky130_ef_sc_hd__decap_12
XTAP_TAPCELL_ROW_174_1851 VGND VPWR sky130_fd_sc_hd__tapvpwrvgnd_1
XTAP_TAPCELL_ROW_215_3272 VGND VPWR sky130_fd_sc_hd__tapvpwrvgnd_1
XTAP_TAPCELL_ROW_174_1862 VGND VPWR sky130_fd_sc_hd__tapvpwrvgnd_1
XFILLER_198_1047 VGND VGND VPWR VPWR sky130_fd_sc_hd__decap_6
XTAP_TAPCELL_ROW_215_3283 VGND VPWR sky130_fd_sc_hd__tapvpwrvgnd_1
XFILLER_50_1165 VPWR VGND VPWR VGND sky130_ef_sc_hd__decap_12
XTAP_TAPCELL_ROW_170_1704 VGND VPWR sky130_fd_sc_hd__tapvpwrvgnd_1
XTAP_TAPCELL_ROW_211_3125 VGND VPWR sky130_fd_sc_hd__tapvpwrvgnd_1
XFILLER_15_1285 VGND VGND VPWR VPWR sky130_fd_sc_hd__decap_6
XTAP_TAPCELL_ROW_215_3294 VGND VPWR sky130_fd_sc_hd__tapvpwrvgnd_1
XTAP_TAPCELL_ROW_170_1715 VGND VPWR sky130_fd_sc_hd__tapvpwrvgnd_1
XTAP_TAPCELL_ROW_211_3136 VGND VPWR sky130_fd_sc_hd__tapvpwrvgnd_1
XFILLER_8_992 VPWR VGND VPWR VGND sky130_ef_sc_hd__decap_12
XFILLER_176_1312 VPWR VGND VPWR VGND sky130_ef_sc_hd__decap_12
XFILLER_190_237 VPWR VGND VPWR VGND sky130_ef_sc_hd__decap_12
XTAP_TAPCELL_ROW_211_3147 VGND VPWR sky130_fd_sc_hd__tapvpwrvgnd_1
XFILLER_239_1033 VPWR VGND VPWR VGND sky130_ef_sc_hd__decap_12
XFILLER_85_1206 VPWR VGND VPWR VGND sky130_ef_sc_hd__decap_12
XTAP_TAPCELL_ROW_211_3158 VGND VPWR sky130_fd_sc_hd__tapvpwrvgnd_1
Xmax_cap122 _201_ VGND VGND VPWR VPWR net122 sky130_fd_sc_hd__clkbuf_1
Xmax_cap133 net134 VGND VGND VPWR VPWR net133 sky130_fd_sc_hd__clkbuf_1
Xmax_cap144 net145 VGND VGND VPWR VPWR net144 sky130_fd_sc_hd__clkbuf_1
XTAP_TAPCELL_ROW_122_1_1412 VGND VPWR sky130_fd_sc_hd__tapvpwrvgnd_1
XFILLER_209_87 VPWR VGND VPWR VGND sky130_ef_sc_hd__decap_12
XFILLER_176_1367 VPWR VGND VPWR VGND sky130_ef_sc_hd__decap_12
XFILLER_239_1088 VPWR VGND VPWR VGND sky130_ef_sc_hd__decap_12
Xmax_cap166 _143_ VGND VGND VPWR VPWR net166 sky130_fd_sc_hd__clkbuf_1
Xmax_cap177 _106_ VGND VGND VPWR VPWR net177 sky130_fd_sc_hd__clkbuf_1
XTAP_TAPCELL_ROW_168_1622 VGND VPWR sky130_fd_sc_hd__tapvpwrvgnd_1
XTAP_TAPCELL_ROW_168_1633 VGND VPWR sky130_fd_sc_hd__tapvpwrvgnd_1
XTAP_TAPCELL_ROW_209_3054 VGND VPWR sky130_fd_sc_hd__tapvpwrvgnd_1
XFILLER_213_1217 VPWR VGND VPWR VGND sky130_ef_sc_hd__decap_12
XTAP_TAPCELL_ROW_168_1644 VGND VPWR sky130_fd_sc_hd__tapvpwrvgnd_1
XTAP_TAPCELL_ROW_209_3065 VGND VPWR sky130_fd_sc_hd__tapvpwrvgnd_1
XTAP_TAPCELL_ROW_209_3076 VGND VPWR sky130_fd_sc_hd__tapvpwrvgnd_1
XTAP_TAPCELL_ROW_209_3087 VGND VPWR sky130_fd_sc_hd__tapvpwrvgnd_1
XFILLER_245_216 VPWR VGND VPWR VGND sky130_ef_sc_hd__decap_12
XFILLER_61_1261 VPWR VGND VPWR VGND sky130_ef_sc_hd__decap_12
XFILLER_6_1453 VPWR VGND VPWR VGND sky130_ef_sc_hd__decap_12
XFILLER_26_1392 VGND VGND VPWR VPWR sky130_fd_sc_hd__decap_6
XTAP_TAPCELL_ROW_88_1_1362 VGND VPWR sky130_fd_sc_hd__tapvpwrvgnd_1
XFILLER_96_1313 VPWR VGND VPWR VGND sky130_ef_sc_hd__decap_12
XFILLER_226_452 VPWR VGND VPWR VGND sky130_ef_sc_hd__decap_12
XFILLER_246_1004 VGND VGND VPWR VPWR sky130_fd_sc_hd__decap_6
XFILLER_241_400 VPWR VGND VPWR VGND sky130_ef_sc_hd__decap_12
XFILLER_187_1463 VPWR VGND VPWR VGND sky130_ef_sc_hd__decap_12
XFILLER_253_271 VPWR VGND VPWR VGND sky130_ef_sc_hd__decap_12
XFILLER_0_1030 VPWR VGND VPWR VGND sky130_ef_sc_hd__decap_12
XFILLER_96_1368 VPWR VGND VPWR VGND sky130_ef_sc_hd__decap_12
XFILLER_198_304 VPWR VGND VPWR VGND sky130_ef_sc_hd__decap_12
XFILLER_214_636 VPWR VGND VPWR VGND sky130_ef_sc_hd__decap_12
XFILLER_183_1327 VGND VGND VPWR VPWR sky130_fd_sc_hd__decap_6
XFILLER_0_1063 VGND VGND VPWR VPWR sky130_fd_sc_hd__decap_8
XFILLER_241_455 VPWR VGND VPWR VGND sky130_ef_sc_hd__decap_12
XTAP_TAPCELL_ROW_79_2_5294 VGND VPWR sky130_fd_sc_hd__tapvpwrvgnd_1
XFILLER_198_359 VGND VGND VPWR VPWR sky130_fd_sc_hd__decap_6
XFILLER_110_34 VPWR VGND VPWR VGND sky130_ef_sc_hd__decap_12
XFILLER_224_1324 VPWR VGND VPWR VGND sky130_ef_sc_hd__decap_12
XFILLER_167_713 VPWR VGND VPWR VGND sky130_ef_sc_hd__decap_12
XFILLER_210_820 VPWR VGND VPWR VGND sky130_ef_sc_hd__decap_12
XFILLER_179_584 VPWR VGND VPWR VGND sky130_ef_sc_hd__decap_12
XFILLER_222_691 VPWR VGND VPWR VGND sky130_ef_sc_hd__decap_12
XFILLER_224_1379 VPWR VGND VPWR VGND sky130_ef_sc_hd__decap_12
XFILLER_107_1177 VPWR VGND VPWR VGND sky130_ef_sc_hd__decap_12
XFILLER_167_768 VGND VGND VPWR VPWR sky130_fd_sc_hd__decap_6
XFILLER_210_875 VGND VGND VPWR VPWR sky130_fd_sc_hd__decap_6
XFILLER_6_918 VGND VGND VPWR VPWR sky130_fd_sc_hd__decap_6
XTAP_TAPCELL_ROW_72_2_5237 VGND VPWR sky130_fd_sc_hd__tapvpwrvgnd_1
XFILLER_181_259 VPWR VGND VPWR VGND sky130_ef_sc_hd__decap_12
XFILLER_194_1434 VGND VGND VPWR VPWR sky130_fd_sc_hd__decap_6
XFILLER_120_1399 VPWR VGND VPWR VGND sky130_ef_sc_hd__decap_12
XFILLER_235_1420 VPWR VGND VPWR VGND sky130_ef_sc_hd__decap_12
XFILLER_118_1251 VPWR VGND VPWR VGND sky130_ef_sc_hd__decap_12
XFILLER_235_1475 VPWR VGND VPWR VGND sky130_ef_sc_hd__decap_12
XFILLER_7_1217 VPWR VGND VPWR VGND sky130_ef_sc_hd__decap_12
XFILLER_1_689 VGND VGND VPWR VPWR sky130_fd_sc_hd__fill_2
XFILLER_27_1189 VPWR VGND VPWR VGND sky130_ef_sc_hd__decap_12
XTAP_TAPCELL_ROW_18_2_4804 VGND VPWR sky130_fd_sc_hd__tapvpwrvgnd_1
XFILLER_95_68 VGND VGND VPWR VPWR sky130_fd_sc_hd__decap_3
XTAP_TAPCELL_ROW_184_2180 VGND VPWR sky130_fd_sc_hd__tapvpwrvgnd_1
XTAP_TAPCELL_ROW_184_2191 VGND VPWR sky130_fd_sc_hd__tapvpwrvgnd_1
XFILLER_79_1500 VGND VGND VPWR VPWR sky130_fd_sc_hd__decap_6
XTAP_TAPCELL_ROW_180_2044 VGND VPWR sky130_fd_sc_hd__tapvpwrvgnd_1
XFILLER_188_1238 VPWR VGND VPWR VGND sky130_ef_sc_hd__decap_12
XTAP_TAPCELL_ROW_180_2055 VGND VPWR sky130_fd_sc_hd__tapvpwrvgnd_1
XFILLER_236_249 VPWR VGND VPWR VGND sky130_ef_sc_hd__decap_12
XFILLER_40_1356 VPWR VGND VPWR VGND sky130_ef_sc_hd__decap_12
XTAP_TAPCELL_ROW_180_2066 VGND VPWR sky130_fd_sc_hd__tapvpwrvgnd_1
X_633_ clknet_3_5__leaf_clk dout0\[31\] _041_ VGND VGND VPWR VPWR dout0_q\[31\] sky130_fd_sc_hd__dfrtp_1
XTAP_TAPCELL_ROW_40_1_1290 VGND VPWR sky130_fd_sc_hd__tapvpwrvgnd_1
XFILLER_205_603 VPWR VGND VPWR VGND sky130_ef_sc_hd__decap_12
XTAP_TAPCELL_ROW_52_1_1307 VGND VPWR sky130_fd_sc_hd__tapvpwrvgnd_1
XFILLER_166_1514 VGND VGND VPWR VPWR sky130_fd_sc_hd__fill_1
XFILLER_217_474 VPWR VGND VPWR VGND sky130_ef_sc_hd__decap_12
X_564_ net664 VGND VGND VPWR VPWR _046_ sky130_fd_sc_hd__inv_2
XFILLER_189_326 VPWR VGND VPWR VGND sky130_ef_sc_hd__decap_12
XFILLER_232_433 VPWR VGND VPWR VGND sky130_ef_sc_hd__decap_12
XFILLER_205_658 VPWR VGND VPWR VGND sky130_ef_sc_hd__decap_12
XFILLER_44_61 VGND VGND VPWR VPWR sky130_fd_sc_hd__decap_3
X_495_ net195 net78 net192 VGND VGND VPWR VPWR _254_ sky130_fd_sc_hd__o21ba_1
XFILLER_220_617 VGND VGND VPWR VPWR sky130_fd_sc_hd__decap_6
XFILLER_232_488 VGND VGND VPWR VPWR sky130_fd_sc_hd__decap_6
XFILLER_38_1263 VGND VGND VPWR VPWR sky130_fd_sc_hd__decap_6
XFILLER_198_882 VPWR VGND VPWR VGND sky130_ef_sc_hd__decap_12
XFILLER_73_1165 VPWR VGND VPWR VGND sky130_ef_sc_hd__decap_12
XPHY_EDGE_ROW_24_2_Left_526 VGND VGND VPWR VPWR sky130_fd_sc_hd__decap_3
XFILLER_164_1282 VPWR VGND VPWR VGND sky130_ef_sc_hd__decap_12
XFILLER_185_510 VGND VGND VPWR VPWR sky130_fd_sc_hd__decap_6
XFILLER_201_842 VPWR VGND VPWR VGND sky130_ef_sc_hd__decap_12
XFILLER_197_381 VGND VGND VPWR VPWR sky130_fd_sc_hd__decap_6
XFILLER_199_1334 VPWR VGND VPWR VGND sky130_ef_sc_hd__decap_12
XFILLER_201_897 VGND VGND VPWR VPWR sky130_fd_sc_hd__decap_6
XFILLER_9_778 VPWR VGND VPWR VGND sky130_ef_sc_hd__decap_12
XPHY_EDGE_ROW_149_2_Left_651 VGND VGND VPWR VPWR sky130_fd_sc_hd__decap_3
XFILLER_201_1143 VPWR VGND VPWR VGND sky130_ef_sc_hd__decap_12
XFILLER_199_1389 VPWR VGND VPWR VGND sky130_ef_sc_hd__decap_12
XFILLER_172_237 VPWR VGND VPWR VGND sky130_ef_sc_hd__decap_12
XFILLER_5_940 VGND VGND VPWR VPWR sky130_fd_sc_hd__decap_6
XFILLER_201_1198 VGND VGND VPWR VPWR sky130_fd_sc_hd__decap_6
XFILLER_5_44 VPWR VGND VPWR VGND sky130_ef_sc_hd__decap_12
XFILLER_180_292 VPWR VGND VPWR VGND sky130_ef_sc_hd__decap_12
XFILLER_5_99 VPWR VGND VPWR VGND sky130_ef_sc_hd__decap_12
XFILLER_84_1294 VPWR VGND VPWR VGND sky130_ef_sc_hd__decap_12
XFILLER_227_216 VPWR VGND VPWR VGND sky130_ef_sc_hd__decap_12
XFILLER_212_1250 VPWR VGND VPWR VGND sky130_ef_sc_hd__decap_12
XFILLER_255_547 VPWR VGND VPWR VGND sky130_ef_sc_hd__decap_12
XTAP_TAPCELL_ROW_223_3552 VGND VPWR sky130_fd_sc_hd__tapvpwrvgnd_1
XTAP_TAPCELL_ROW_223_3563 VGND VPWR sky130_fd_sc_hd__tapvpwrvgnd_1
XTAP_TAPCELL_ROW_223_3574 VGND VPWR sky130_fd_sc_hd__tapvpwrvgnd_1
XTAP_TAPCELL_ROW_128_2_5688 VGND VPWR sky130_fd_sc_hd__tapvpwrvgnd_1
XTAP_TAPCELL_ROW_96_2_5433 VGND VPWR sky130_fd_sc_hd__tapvpwrvgnd_1
XFILLER_208_452 VPWR VGND VPWR VGND sky130_ef_sc_hd__decap_12
XTAP_TAPCELL_ROW_65_2_5180 VGND VPWR sky130_fd_sc_hd__tapvpwrvgnd_1
XFILLER_223_400 VPWR VGND VPWR VGND sky130_ef_sc_hd__decap_12
XFILLER_235_271 VPWR VGND VPWR VGND sky130_ef_sc_hd__decap_12
XFILLER_247_1346 VPWR VGND VPWR VGND sky130_ef_sc_hd__decap_12
XPHY_EDGE_ROW_17_1_Right_673 VGND VGND VPWR VPWR sky130_fd_sc_hd__decap_3
XPHY_EDGE_ROW_207_Left_462 VGND VGND VPWR VPWR sky130_fd_sc_hd__decap_3
XFILLER_211_44 VPWR VGND VPWR VGND sky130_ef_sc_hd__decap_12
XFILLER_250_230 VGND VGND VPWR VPWR sky130_fd_sc_hd__decap_6
XFILLER_223_455 VPWR VGND VPWR VGND sky130_ef_sc_hd__decap_12
XFILLER_251_775 VPWR VGND VPWR VGND sky130_ef_sc_hd__decap_12
XFILLER_196_808 VPWR VGND VPWR VGND sky130_ef_sc_hd__decap_12
XFILLER_95_1390 VPWR VGND VPWR VGND sky130_ef_sc_hd__decap_12
XFILLER_165_1079 VPWR VGND VPWR VGND sky130_ef_sc_hd__decap_12
XFILLER_211_99 VPWR VGND VPWR VGND sky130_ef_sc_hd__decap_12
XTAP_TAPCELL_ROW_176_1902 VGND VPWR sky130_fd_sc_hd__tapvpwrvgnd_1
XFILLER_211_639 VGND VGND VPWR VPWR sky130_fd_sc_hd__decap_6
XFILLER_108_1442 VPWR VGND VPWR VGND sky130_ef_sc_hd__decap_12
XPHY_EDGE_ROW_156_2_Right_247 VGND VGND VPWR VPWR sky130_fd_sc_hd__decap_3
XTAP_TAPCELL_ROW_176_1913 VGND VPWR sky130_fd_sc_hd__tapvpwrvgnd_1
XTAP_TAPCELL_ROW_217_3334 VGND VPWR sky130_fd_sc_hd__tapvpwrvgnd_1
XFILLER_204_691 VPWR VGND VPWR VGND sky130_ef_sc_hd__decap_12
XTAP_TAPCELL_ROW_217_3345 VGND VPWR sky130_fd_sc_hd__tapvpwrvgnd_1
XFILLER_52_1227 VPWR VGND VPWR VGND sky130_ef_sc_hd__decap_12
XTAP_TAPCELL_ROW_176_1924 VGND VPWR sky130_fd_sc_hd__tapvpwrvgnd_1
XFILLER_206_1054 VPWR VGND VPWR VGND sky130_ef_sc_hd__decap_12
XFILLER_17_1347 VPWR VGND VPWR VGND sky130_ef_sc_hd__decap_12
XTAP_TAPCELL_ROW_217_3356 VGND VPWR sky130_fd_sc_hd__tapvpwrvgnd_1
XFILLER_104_1306 VGND VGND VPWR VPWR sky130_fd_sc_hd__decap_6
XTAP_TAPCELL_ROW_217_3367 VGND VPWR sky130_fd_sc_hd__tapvpwrvgnd_1
XTAP_TAPCELL_ROW_213_3209 VGND VPWR sky130_fd_sc_hd__tapvpwrvgnd_1
XFILLER_108_1497 VPWR VGND VPWR VGND sky130_ef_sc_hd__decap_12
XTAP_TAPCELL_ROW_57_2_5117 VGND VPWR sky130_fd_sc_hd__tapvpwrvgnd_1
XPHY_EDGE_ROW_216_Left_471 VGND VGND VPWR VPWR sky130_fd_sc_hd__decap_3
XFILLER_176_1164 VPWR VGND VPWR VGND sky130_ef_sc_hd__decap_12
XPHY_EDGE_ROW_70_2_Left_572 VGND VGND VPWR VPWR sky130_fd_sc_hd__decap_3
XFILLER_49_39 VGND VGND VPWR VPWR sky130_fd_sc_hd__decap_4
XFILLER_28_1454 VPWR VGND VPWR VGND sky130_ef_sc_hd__decap_12
XFILLER_115_1402 VPWR VGND VPWR VGND sky130_ef_sc_hd__decap_12
XFILLER_213_1014 VPWR VGND VPWR VGND sky130_ef_sc_hd__decap_12
XFILLER_63_1378 VPWR VGND VPWR VGND sky130_ef_sc_hd__decap_12
XFILLER_115_1457 VGND VGND VPWR VPWR sky130_fd_sc_hd__decap_6
XFILLER_150_1337 VPWR VGND VPWR VGND sky130_ef_sc_hd__decap_12
XFILLER_189_1514 VGND VGND VPWR VPWR sky130_fd_sc_hd__fill_1
XFILLER_105_56 VPWR VGND VPWR VGND sky130_ef_sc_hd__decap_12
XFILLER_213_1069 VGND VGND VPWR VPWR sky130_fd_sc_hd__decap_6
XFILLER_6_1250 VPWR VGND VPWR VGND sky130_ef_sc_hd__decap_12
XFILLER_218_249 VPWR VGND VPWR VGND sky130_ef_sc_hd__decap_12
XTAP_TAPCELL_ROW_2_932 VGND VPWR sky130_fd_sc_hd__tapvpwrvgnd_1
XTAP_TAPCELL_ROW_2_943 VGND VPWR sky130_fd_sc_hd__tapvpwrvgnd_1
XTAP_TAPCELL_ROW_2_954 VGND VPWR sky130_fd_sc_hd__tapvpwrvgnd_1
XPHY_EDGE_ROW_22_1_Left_277 VGND VGND VPWR VPWR sky130_fd_sc_hd__decap_3
XPHY_EDGE_ROW_225_Left_480 VGND VGND VPWR VPWR sky130_fd_sc_hd__decap_3
XFILLER_187_1260 VPWR VGND VPWR VGND sky130_ef_sc_hd__decap_12
XFILLER_96_1165 VPWR VGND VPWR VGND sky130_ef_sc_hd__decap_12
XFILLER_198_101 VGND VGND VPWR VPWR sky130_fd_sc_hd__decap_6
XFILLER_121_44 VPWR VGND VPWR VGND sky130_ef_sc_hd__decap_12
XFILLER_214_433 VPWR VGND VPWR VGND sky130_ef_sc_hd__decap_12
XFILLER_242_753 VPWR VGND VPWR VGND sky130_ef_sc_hd__decap_12
XFILLER_199_646 VPWR VGND VPWR VGND sky130_ef_sc_hd__decap_12
XFILLER_109_1206 VPWR VGND VPWR VGND sky130_ef_sc_hd__decap_12
XFILLER_81_15 VPWR VGND VPWR VGND sky130_ef_sc_hd__decap_12
XFILLER_241_252 VGND VGND VPWR VPWR sky130_fd_sc_hd__decap_6
XFILLER_202_617 VGND VGND VPWR VPWR sky130_fd_sc_hd__decap_6
XFILLER_197_15 VPWR VGND VPWR VGND sky130_ef_sc_hd__decap_12
XFILLER_214_488 VGND VGND VPWR VPWR sky130_fd_sc_hd__decap_6
XFILLER_230_937 VPWR VGND VPWR VGND sky130_ef_sc_hd__decap_12
XFILLER_224_1121 VPWR VGND VPWR VGND sky130_ef_sc_hd__decap_12
XFILLER_35_1414 VGND VGND VPWR VPWR sky130_fd_sc_hd__decap_6
XFILLER_167_510 VGND VGND VPWR VPWR sky130_fd_sc_hd__decap_6
XFILLER_74_1485 VPWR VGND VPWR VGND sky130_ef_sc_hd__decap_12
XFILLER_161_1433 VPWR VGND VPWR VGND sky130_ef_sc_hd__decap_12
XFILLER_179_381 VGND VGND VPWR VPWR sky130_fd_sc_hd__decap_6
XFILLER_195_830 VPWR VGND VPWR VGND sky130_ef_sc_hd__decap_12
XFILLER_70_1349 VGND VGND VPWR VPWR sky130_fd_sc_hd__decap_6
XFILLER_224_1176 VGND VGND VPWR VPWR sky130_fd_sc_hd__decap_6
XTAP_TAPCELL_ROW_192_2460 VGND VPWR sky130_fd_sc_hd__tapvpwrvgnd_1
XFILLER_161_1488 VPWR VGND VPWR VGND sky130_ef_sc_hd__decap_12
XTAP_TAPCELL_ROW_192_2471 VGND VPWR sky130_fd_sc_hd__tapvpwrvgnd_1
XFILLER_195_885 VPWR VGND VPWR VGND sky130_ef_sc_hd__decap_12
XTAP_TAPCELL_ROW_192_2482 VGND VPWR sky130_fd_sc_hd__tapvpwrvgnd_1
XFILLER_202_1441 VPWR VGND VPWR VGND sky130_ef_sc_hd__decap_12
XTAP_TAPCELL_ROW_192_2493 VGND VPWR sky130_fd_sc_hd__tapvpwrvgnd_1
XFILLER_212_3 VPWR VGND VPWR VGND sky130_ef_sc_hd__decap_12
XFILLER_202_1496 VPWR VGND VPWR VGND sky130_ef_sc_hd__decap_12
XFILLER_120_1196 VPWR VGND VPWR VGND sky130_ef_sc_hd__decap_12
XFILLER_155_1204 VGND VGND VPWR VPWR sky130_fd_sc_hd__fill_1
XFILLER_29_1218 VPWR VGND VPWR VGND sky130_ef_sc_hd__decap_12
XFILLER_1_431 VGND VGND VPWR VPWR sky130_fd_sc_hd__fill_2
XTAP_TAPCELL_ROW_186_2253 VGND VPWR sky130_fd_sc_hd__tapvpwrvgnd_1
XTAP_TAPCELL_ROW_186_2264 VGND VPWR sky130_fd_sc_hd__tapvpwrvgnd_1
XFILLER_7_1014 VPWR VGND VPWR VGND sky130_ef_sc_hd__decap_12
XFILLER_81_1445 VPWR VGND VPWR VGND sky130_ef_sc_hd__decap_12
XTAP_TAPCELL_ROW_186_2275 VGND VPWR sky130_fd_sc_hd__tapvpwrvgnd_1
XFILLER_235_1272 VPWR VGND VPWR VGND sky130_ef_sc_hd__decap_12
XTAP_TAPCELL_ROW_182_2117 VGND VPWR sky130_fd_sc_hd__tapvpwrvgnd_1
XFILLER_39_61 VGND VGND VPWR VPWR sky130_fd_sc_hd__decap_8
XTAP_TAPCELL_ROW_182_2128 VGND VPWR sky130_fd_sc_hd__tapvpwrvgnd_1
XTAP_TAPCELL_ROW_114_2_5574 VGND VPWR sky130_fd_sc_hd__tapvpwrvgnd_1
XTAP_TAPCELL_ROW_182_2139 VGND VPWR sky130_fd_sc_hd__tapvpwrvgnd_1
XFILLER_209_216 VPWR VGND VPWR VGND sky130_ef_sc_hd__decap_12
XFILLER_7_1069 VGND VGND VPWR VPWR sky130_fd_sc_hd__decap_6
XFILLER_188_1035 VPWR VGND VPWR VGND sky130_ef_sc_hd__decap_12
XFILLER_131_1292 VPWR VGND VPWR VGND sky130_ef_sc_hd__decap_12
XFILLER_205_400 VPWR VGND VPWR VGND sky130_ef_sc_hd__decap_12
X_616_ clknet_3_7__leaf_clk dout0\[14\] _024_ VGND VGND VPWR VPWR dout0_q\[14\] sky130_fd_sc_hd__dfrtp_1
XFILLER_217_271 VPWR VGND VPWR VGND sky130_ef_sc_hd__decap_12
XFILLER_55_60 VGND VGND VPWR VPWR sky130_fd_sc_hd__decap_8
XFILLER_244_1508 VGND VGND VPWR VPWR sky130_fd_sc_hd__decap_6
XFILLER_189_123 VGND VGND VPWR VPWR sky130_fd_sc_hd__decap_6
XFILLER_221_904 VPWR VGND VPWR VGND sky130_ef_sc_hd__decap_12
XFILLER_232_230 VGND VGND VPWR VPWR sky130_fd_sc_hd__decap_6
XFILLER_166_1355 VPWR VGND VPWR VGND sky130_ef_sc_hd__decap_12
XFILLER_205_455 VPWR VGND VPWR VGND sky130_ef_sc_hd__decap_12
X_547_ net669 VGND VGND VPWR VPWR _029_ sky130_fd_sc_hd__inv_2
XFILLER_75_1249 VPWR VGND VPWR VGND sky130_ef_sc_hd__decap_12
XFILLER_178_808 VPWR VGND VPWR VGND sky130_ef_sc_hd__decap_12
XFILLER_229_1076 VPWR VGND VPWR VGND sky130_ef_sc_hd__decap_12
XFILLER_233_775 VPWR VGND VPWR VGND sky130_ef_sc_hd__decap_12
XFILLER_127_1328 VGND VGND VPWR VPWR sky130_fd_sc_hd__decap_6
XFILLER_162_1208 VPWR VGND VPWR VGND sky130_ef_sc_hd__decap_12
XFILLER_221_959 VPWR VGND VPWR VGND sky130_ef_sc_hd__decap_12
XTAP_TAPCELL_ROW_43_2_5003 VGND VPWR sky130_fd_sc_hd__tapvpwrvgnd_1
X_478_ net339 _244_ VGND VGND VPWR VPWR _245_ sky130_fd_sc_hd__or2_1
XFILLER_203_1205 VPWR VGND VPWR VGND sky130_ef_sc_hd__decap_12
XFILLER_14_1509 VGND VGND VPWR VPWR sky130_fd_sc_hd__decap_6
XFILLER_186_863 VPWR VGND VPWR VGND sky130_ef_sc_hd__decap_12
XFILLER_199_1131 VPWR VGND VPWR VGND sky130_ef_sc_hd__decap_12
XTAP_TAPCELL_ROW_235_3990 VGND VPWR sky130_fd_sc_hd__tapvpwrvgnd_1
XTAP_TAPCELL_ROW_231_3832 VGND VPWR sky130_fd_sc_hd__tapvpwrvgnd_1
XFILLER_16_1380 VPWR VGND VPWR VGND sky130_ef_sc_hd__decap_12
XPHY_EDGE_ROW_80_2_Right_171 VGND VGND VPWR VPWR sky130_fd_sc_hd__decap_3
XTAP_TAPCELL_ROW_231_3843 VGND VPWR sky130_fd_sc_hd__tapvpwrvgnd_1
XTAP_TAPCELL_ROW_231_3854 VGND VPWR sky130_fd_sc_hd__tapvpwrvgnd_1
XTAP_TAPCELL_ROW_10_2_4744 VGND VPWR sky130_fd_sc_hd__tapvpwrvgnd_1
XFILLER_199_1186 VPWR VGND VPWR VGND sky130_ef_sc_hd__decap_12
XFILLER_58_3 VPWR VGND VPWR VGND sky130_ef_sc_hd__decap_12
XFILLER_86_1356 VPWR VGND VPWR VGND sky130_ef_sc_hd__decap_12
XFILLER_138_1435 VGND VGND VPWR VPWR sky130_fd_sc_hd__decap_6
XFILLER_173_1315 VPWR VGND VPWR VGND sky130_ef_sc_hd__decap_12
XFILLER_4_280 VGND VGND VPWR VPWR sky130_fd_sc_hd__fill_1
XFILLER_236_1047 VGND VGND VPWR VPWR sky130_fd_sc_hd__decap_6
XFILLER_206_22 VPWR VGND VPWR VGND sky130_ef_sc_hd__decap_12
XTAP_TAPCELL_ROW_229_3761 VGND VPWR sky130_fd_sc_hd__tapvpwrvgnd_1
XFILLER_214_1312 VPWR VGND VPWR VGND sky130_ef_sc_hd__decap_12
XTAP_TAPCELL_ROW_229_3772 VGND VPWR sky130_fd_sc_hd__tapvpwrvgnd_1
XTAP_TAPCELL_ROW_225_3614 VGND VPWR sky130_fd_sc_hd__tapvpwrvgnd_1
XTAP_TAPCELL_ROW_229_3783 VGND VPWR sky130_fd_sc_hd__tapvpwrvgnd_1
XTAP_TAPCELL_ROW_225_3625 VGND VPWR sky130_fd_sc_hd__tapvpwrvgnd_1
XTAP_TAPCELL_ROW_225_3636 VGND VPWR sky130_fd_sc_hd__tapvpwrvgnd_1
XFILLER_206_77 VPWR VGND VPWR VGND sky130_ef_sc_hd__decap_12
XTAP_TAPCELL_ROW_225_3647 VGND VPWR sky130_fd_sc_hd__tapvpwrvgnd_1
XFILLER_214_1367 VPWR VGND VPWR VGND sky130_ef_sc_hd__decap_12
XFILLER_3_1401 VPWR VGND VPWR VGND sky130_ef_sc_hd__decap_12
XFILLER_243_517 VPWR VGND VPWR VGND sky130_ef_sc_hd__decap_12
XFILLER_3_1456 VGND VGND VPWR VPWR sky130_fd_sc_hd__decap_6
XFILLER_167_1119 VPWR VGND VPWR VGND sky130_ef_sc_hd__decap_12
XFILLER_222_65 VPWR VGND VPWR VGND sky130_ef_sc_hd__decap_12
XTAP_TAPCELL_ROW_22_1_1262 VGND VPWR sky130_fd_sc_hd__tapvpwrvgnd_1
XFILLER_184_1422 VPWR VGND VPWR VGND sky130_ef_sc_hd__decap_12
XFILLER_247_1143 VPWR VGND VPWR VGND sky130_ef_sc_hd__decap_12
XFILLER_93_1316 VPWR VGND VPWR VGND sky130_ef_sc_hd__decap_12
XTAP_TAPCELL_ROW_219_3407 VGND VPWR sky130_fd_sc_hd__tapvpwrvgnd_1
XFILLER_224_753 VPWR VGND VPWR VGND sky130_ef_sc_hd__decap_12
XTAP_TAPCELL_ROW_219_3418 VGND VPWR sky130_fd_sc_hd__tapvpwrvgnd_1
XFILLER_223_252 VGND VGND VPWR VPWR sky130_fd_sc_hd__decap_6
XPHY_EDGE_ROW_18_1_Right_674 VGND VGND VPWR VPWR sky130_fd_sc_hd__decap_3
XTAP_TAPCELL_ROW_219_3429 VGND VPWR sky130_fd_sc_hd__tapvpwrvgnd_1
XFILLER_251_572 VPWR VGND VPWR VGND sky130_ef_sc_hd__decap_12
XFILLER_184_1477 VGND VGND VPWR VPWR sky130_fd_sc_hd__decap_6
XFILLER_196_605 VPWR VGND VPWR VGND sky130_ef_sc_hd__decap_12
XFILLER_212_937 VPWR VGND VPWR VGND sky130_ef_sc_hd__decap_12
XFILLER_247_1198 VGND VGND VPWR VPWR sky130_fd_sc_hd__decap_6
XFILLER_177_830 VPWR VGND VPWR VGND sky130_ef_sc_hd__decap_12
XFILLER_225_1463 VPWR VGND VPWR VGND sky130_ef_sc_hd__decap_12
XPHY_EDGE_ROW_157_2_Right_248 VGND VGND VPWR VPWR sky130_fd_sc_hd__decap_3
XFILLER_221_1327 VGND VGND VPWR VPWR sky130_fd_sc_hd__decap_6
XFILLER_17_1177 VPWR VGND VPWR VGND sky130_ef_sc_hd__decap_12
XFILLER_108_1294 VPWR VGND VPWR VGND sky130_ef_sc_hd__decap_12
XFILLER_177_885 VPWR VGND VPWR VGND sky130_ef_sc_hd__decap_12
XFILLER_220_992 VPWR VGND VPWR VGND sky130_ef_sc_hd__decap_12
XFILLER_178_1226 VPWR VGND VPWR VGND sky130_ef_sc_hd__decap_12
XFILLER_3_729 VGND VGND VPWR VPWR sky130_fd_sc_hd__fill_2
XFILLER_30_1399 VPWR VGND VPWR VGND sky130_ef_sc_hd__decap_12
XTAP_TAPCELL_ROW_87_2_5356 VGND VPWR sky130_fd_sc_hd__tapvpwrvgnd_1
XTAP_TAPCELL_ROW_76_1_1344 VGND VPWR sky130_fd_sc_hd__tapvpwrvgnd_1
XFILLER_183_39 VGND VGND VPWR VPWR sky130_fd_sc_hd__decap_4
XTAP_TAPCELL_ROW_131_2_5713 VGND VPWR sky130_fd_sc_hd__tapvpwrvgnd_1
XTAP_TAPCELL_ROW_100_2_5460 VGND VPWR sky130_fd_sc_hd__tapvpwrvgnd_1
XFILLER_116_22 VPWR VGND VPWR VGND sky130_ef_sc_hd__decap_12
XFILLER_8_1312 VPWR VGND VPWR VGND sky130_ef_sc_hd__decap_12
XFILLER_28_1251 VPWR VGND VPWR VGND sky130_ef_sc_hd__decap_12
XFILLER_76_15 VGND VGND VPWR VPWR sky130_fd_sc_hd__decap_6
XFILLER_119_1390 VPWR VGND VPWR VGND sky130_ef_sc_hd__decap_12
XFILLER_154_1270 VPWR VGND VPWR VGND sky130_ef_sc_hd__decap_12
XFILLER_232_1434 VGND VGND VPWR VPWR sky130_fd_sc_hd__decap_6
XFILLER_8_1367 VPWR VGND VPWR VGND sky130_ef_sc_hd__decap_12
XTAP_TAPCELL_ROW_241_4183 VGND VPWR sky130_fd_sc_hd__tapvpwrvgnd_1
Xfanout598 net599 VGND VGND VPWR VPWR net598 sky130_fd_sc_hd__clkbuf_2
XTAP_TAPCELL_ROW_241_4194 VGND VPWR sky130_fd_sc_hd__tapvpwrvgnd_1
XFILLER_98_1227 VPWR VGND VPWR VGND sky130_ef_sc_hd__decap_12
XFILLER_246_366 VPWR VGND VPWR VGND sky130_ef_sc_hd__decap_12
XFILLER_189_1377 VPWR VGND VPWR VGND sky130_ef_sc_hd__decap_12
XFILLER_132_65 VGND VGND VPWR VPWR sky130_fd_sc_hd__decap_6
XFILLER_162_3 VPWR VGND VPWR VGND sky130_ef_sc_hd__decap_12
XFILLER_214_230 VGND VGND VPWR VPWR sky130_fd_sc_hd__decap_6
X_401_ net201 _189_ VGND VGND VPWR VPWR _190_ sky130_fd_sc_hd__nand2_1
XFILLER_92_58 VGND VGND VPWR VPWR sky130_fd_sc_hd__decap_6
XFILLER_203_904 VPWR VGND VPWR VGND sky130_ef_sc_hd__decap_12
XFILLER_242_550 VPWR VGND VPWR VGND sky130_ef_sc_hd__decap_12
XFILLER_199_443 VPWR VGND VPWR VGND sky130_ef_sc_hd__decap_12
XFILLER_215_775 VPWR VGND VPWR VGND sky130_ef_sc_hd__decap_12
XTAP_TAPCELL_ROW_198_2680 VGND VPWR sky130_fd_sc_hd__tapvpwrvgnd_1
XFILLER_226_1238 VPWR VGND VPWR VGND sky130_ef_sc_hd__decap_12
XFILLER_187_627 VPWR VGND VPWR VGND sky130_ef_sc_hd__decap_12
XTAP_TAPCELL_ROW_198_2691 VGND VPWR sky130_fd_sc_hd__tapvpwrvgnd_1
XFILLER_230_734 VPWR VGND VPWR VGND sky130_ef_sc_hd__decap_12
X_332_ net595 dout0_q\[18\] net52 VGND VGND VPWR VPWR _121_ sky130_fd_sc_hd__a21oi_1
XTAP_TAPCELL_ROW_194_2533 VGND VPWR sky130_fd_sc_hd__tapvpwrvgnd_1
XFILLER_203_959 VPWR VGND VPWR VGND sky130_ef_sc_hd__decap_12
XFILLER_199_498 VPWR VGND VPWR VGND sky130_ef_sc_hd__decap_12
XTAP_TAPCELL_ROW_194_2544 VGND VPWR sky130_fd_sc_hd__tapvpwrvgnd_1
XTAP_TAPCELL_ROW_194_2555 VGND VPWR sky130_fd_sc_hd__tapvpwrvgnd_1
XFILLER_74_1282 VPWR VGND VPWR VGND sky130_ef_sc_hd__decap_12
XFILLER_161_1230 VPWR VGND VPWR VGND sky130_ef_sc_hd__decap_12
XFILLER_204_1514 VGND VGND VPWR VPWR sky130_fd_sc_hd__fill_1
XTAP_TAPCELL_ROW_190_2408 VGND VPWR sky130_fd_sc_hd__tapvpwrvgnd_1
XFILLER_230_789 VGND VGND VPWR VPWR sky130_fd_sc_hd__decap_6
XFILLER_168_863 VPWR VGND VPWR VGND sky130_ef_sc_hd__decap_12
XTAP_TAPCELL_ROW_190_2419 VGND VPWR sky130_fd_sc_hd__tapvpwrvgnd_1
XFILLER_183_811 VGND VGND VPWR VPWR sky130_fd_sc_hd__decap_6
XFILLER_161_1285 VGND VGND VPWR VPWR sky130_fd_sc_hd__decap_6
XFILLER_195_682 VGND VGND VPWR VPWR sky130_fd_sc_hd__decap_6
XFILLER_196_1348 VGND VGND VPWR VPWR sky130_fd_sc_hd__decap_6
XFILLER_6_567 VGND VGND VPWR VPWR sky130_fd_sc_hd__fill_1
XFILLER_202_1293 VPWR VGND VPWR VGND sky130_ef_sc_hd__decap_12
XFILLER_170_538 VPWR VGND VPWR VGND sky130_ef_sc_hd__decap_12
XTAP_TAPCELL_ROW_188_2326 VGND VPWR sky130_fd_sc_hd__tapvpwrvgnd_1
XFILLER_83_1507 VGND VGND VPWR VPWR sky130_fd_sc_hd__decap_8
XTAP_TAPCELL_ROW_188_2337 VGND VPWR sky130_fd_sc_hd__tapvpwrvgnd_1
XFILLER_237_1334 VPWR VGND VPWR VGND sky130_ef_sc_hd__decap_12
XTAP_TAPCELL_ROW_188_2348 VGND VPWR sky130_fd_sc_hd__tapvpwrvgnd_1
XFILLER_2_751 VGND VGND VPWR VPWR sky130_fd_sc_hd__fill_1
XPHY_EDGE_ROW_119_2_Right_210 VGND VGND VPWR VPWR sky130_fd_sc_hd__decap_3
XFILLER_237_1389 VPWR VGND VPWR VGND sky130_ef_sc_hd__decap_12
XFILLER_81_1242 VGND VGND VPWR VPWR sky130_fd_sc_hd__decap_6
XFILLER_2_34 VPWR VGND VPWR VGND sky130_ef_sc_hd__decap_12
XFILLER_2_89 VPWR VGND VPWR VGND sky130_ef_sc_hd__decap_12
XFILLER_225_517 VPWR VGND VPWR VGND sky130_ef_sc_hd__decap_12
XFILLER_237_388 VPWR VGND VPWR VGND sky130_ef_sc_hd__decap_12
XFILLER_248_1441 VPWR VGND VPWR VGND sky130_ef_sc_hd__decap_12
XFILLER_252_347 VPWR VGND VPWR VGND sky130_ef_sc_hd__decap_12
XFILLER_206_753 VPWR VGND VPWR VGND sky130_ef_sc_hd__decap_12
XFILLER_244_1305 VGND VGND VPWR VPWR sky130_fd_sc_hd__decap_6
XFILLER_166_1152 VPWR VGND VPWR VGND sky130_ef_sc_hd__decap_12
XFILLER_205_252 VGND VGND VPWR VPWR sky130_fd_sc_hd__decap_6
XFILLER_221_701 VPWR VGND VPWR VGND sky130_ef_sc_hd__decap_12
XFILLER_248_1496 VPWR VGND VPWR VGND sky130_ef_sc_hd__decap_12
XFILLER_178_605 VPWR VGND VPWR VGND sky130_ef_sc_hd__decap_12
XFILLER_233_572 VPWR VGND VPWR VGND sky130_ef_sc_hd__decap_12
XFILLER_221_756 VPWR VGND VPWR VGND sky130_ef_sc_hd__decap_12
XFILLER_18_1442 VPWR VGND VPWR VGND sky130_ef_sc_hd__decap_12
XTAP_TAPCELL_ROW_233_3905 VGND VPWR sky130_fd_sc_hd__tapvpwrvgnd_1
XFILLER_203_1002 VPWR VGND VPWR VGND sky130_ef_sc_hd__decap_12
XTAP_TAPCELL_ROW_233_3916 VGND VPWR sky130_fd_sc_hd__tapvpwrvgnd_1
XTAP_TAPCELL_ROW_233_3927 VGND VPWR sky130_fd_sc_hd__tapvpwrvgnd_1
XFILLER_14_1306 VGND VGND VPWR VPWR sky130_fd_sc_hd__decap_6
XFILLER_186_660 VGND VGND VPWR VPWR sky130_fd_sc_hd__decap_6
XFILLER_140_1325 VPWR VGND VPWR VGND sky130_ef_sc_hd__decap_12
XFILLER_202_992 VPWR VGND VPWR VGND sky130_ef_sc_hd__decap_12
XFILLER_18_1497 VPWR VGND VPWR VGND sky130_ef_sc_hd__decap_12
XFILLER_105_1445 VPWR VGND VPWR VGND sky130_ef_sc_hd__decap_12
XFILLER_203_1057 VPWR VGND VPWR VGND sky130_ef_sc_hd__decap_12
XTAP_TAPCELL_ROW_73_2_5242 VGND VPWR sky130_fd_sc_hd__tapvpwrvgnd_1
XPHY_EDGE_ROW_81_2_Right_172 VGND VGND VPWR VPWR sky130_fd_sc_hd__decap_3
XFILLER_238_1109 VPWR VGND VPWR VGND sky130_ef_sc_hd__decap_12
XFILLER_173_1112 VGND VGND VPWR VPWR sky130_fd_sc_hd__decap_6
XTAP_TAPCELL_ROW_227_3709 VGND VPWR sky130_fd_sc_hd__tapvpwrvgnd_1
XTAP_TAPCELL_ROW_40_2_4983 VGND VPWR sky130_fd_sc_hd__tapvpwrvgnd_1
XFILLER_217_87 VPWR VGND VPWR VGND sky130_ef_sc_hd__decap_12
XTAP_TAPCELL_ROW_39_2_4977 VGND VPWR sky130_fd_sc_hd__tapvpwrvgnd_1
XFILLER_25_1402 VPWR VGND VPWR VGND sky130_ef_sc_hd__decap_12
XFILLER_151_1421 VPWR VGND VPWR VGND sky130_ef_sc_hd__decap_12
XFILLER_60_1337 VPWR VGND VPWR VGND sky130_ef_sc_hd__decap_12
XFILLER_25_1457 VGND VGND VPWR VPWR sky130_fd_sc_hd__decap_6
XFILLER_214_1164 VPWR VGND VPWR VGND sky130_ef_sc_hd__decap_12
XFILLER_151_1476 VPWR VGND VPWR VGND sky130_ef_sc_hd__decap_12
XFILLER_249_1205 VPWR VGND VPWR VGND sky130_ef_sc_hd__decap_12
XPHY_EDGE_ROW_101_2_Left_603 VGND VGND VPWR VPWR sky130_fd_sc_hd__decap_3
XFILLER_228_366 VPWR VGND VPWR VGND sky130_ef_sc_hd__decap_12
XTAP_TAPCELL_ROW_165_1477 VGND VPWR sky130_fd_sc_hd__tapvpwrvgnd_1
XFILLER_243_314 VPWR VGND VPWR VGND sky130_ef_sc_hd__decap_12
XTAP_TAPCELL_ROW_165_1488 VGND VPWR sky130_fd_sc_hd__tapvpwrvgnd_1
XTAP_TAPCELL_ROW_165_1499 VGND VPWR sky130_fd_sc_hd__tapvpwrvgnd_1
XFILLER_243_369 VPWR VGND VPWR VGND sky130_ef_sc_hd__decap_12
XFILLER_102_46 VPWR VGND VPWR VGND sky130_ef_sc_hd__decap_12
XFILLER_224_550 VPWR VGND VPWR VGND sky130_ef_sc_hd__decap_12
XFILLER_227_1514 VGND VGND VPWR VPWR sky130_fd_sc_hd__fill_1
XFILLER_110_1184 VPWR VGND VPWR VGND sky130_ef_sc_hd__decap_12
XFILLER_19_1206 VPWR VGND VPWR VGND sky130_ef_sc_hd__decap_12
XFILLER_196_402 VGND VGND VPWR VPWR sky130_fd_sc_hd__decap_6
XFILLER_169_627 VPWR VGND VPWR VGND sky130_ef_sc_hd__decap_12
XFILLER_212_734 VPWR VGND VPWR VGND sky130_ef_sc_hd__decap_12
XFILLER_197_947 VPWR VGND VPWR VGND sky130_ef_sc_hd__decap_12
XPHY_EDGE_ROW_19_1_Right_675 VGND VGND VPWR VPWR sky130_fd_sc_hd__decap_3
XTAP_TAPCELL_ROW_128_1_1421 VGND VPWR sky130_fd_sc_hd__tapvpwrvgnd_1
XFILLER_200_918 VGND VGND VPWR VPWR sky130_fd_sc_hd__decap_6
XFILLER_71_1433 VPWR VGND VPWR VGND sky130_ef_sc_hd__decap_12
XFILLER_225_1260 VPWR VGND VPWR VGND sky130_ef_sc_hd__decap_12
XFILLER_212_789 VGND VGND VPWR VPWR sky130_fd_sc_hd__decap_6
XFILLER_7_309 VGND VGND VPWR VPWR sky130_fd_sc_hd__fill_1
XFILLER_165_811 VGND VGND VPWR VPWR sky130_fd_sc_hd__decap_8
XFILLER_71_1488 VPWR VGND VPWR VGND sky130_ef_sc_hd__decap_12
Xwire229 net230 VGND VGND VPWR VPWR net229 sky130_fd_sc_hd__clkbuf_1
XPHY_EDGE_ROW_158_2_Right_249 VGND VGND VPWR VPWR sky130_fd_sc_hd__decap_3
XFILLER_177_682 VGND VGND VPWR VPWR sky130_fd_sc_hd__decap_6
XFILLER_178_1023 VPWR VGND VPWR VGND sky130_ef_sc_hd__decap_12
XFILLER_191_173 VPWR VGND VPWR VGND sky130_ef_sc_hd__decap_12
XFILLER_178_1078 VPWR VGND VPWR VGND sky130_ef_sc_hd__decap_12
XFILLER_30_1196 VPWR VGND VPWR VGND sky130_ef_sc_hd__decap_12
XFILLER_195_1370 VGND VGND VPWR VPWR sky130_fd_sc_hd__decap_6
XTAP_TAPCELL_ROW_247_4392 VGND VPWR sky130_fd_sc_hd__tapvpwrvgnd_1
XFILLER_117_1316 VPWR VGND VPWR VGND sky130_ef_sc_hd__decap_12
XTAP_TAPCELL_ROW_243_4245 VGND VPWR sky130_fd_sc_hd__tapvpwrvgnd_1
XTAP_TAPCELL_ROW_243_4256 VGND VPWR sky130_fd_sc_hd__tapvpwrvgnd_1
XFILLER_238_108 VPWR VGND VPWR VGND sky130_ef_sc_hd__decap_12
XTAP_TAPCELL_ROW_243_4267 VGND VPWR sky130_fd_sc_hd__tapvpwrvgnd_1
XTAP_TAPCELL_ROW_243_4278 VGND VPWR sky130_fd_sc_hd__tapvpwrvgnd_1
XFILLER_8_1164 VPWR VGND VPWR VGND sky130_ef_sc_hd__decap_12
XPHY_EDGE_ROW_33_2_Left_535 VGND VGND VPWR VPWR sky130_fd_sc_hd__decap_3
XTAP_TAPCELL_ROW_161_2_5952 VGND VPWR sky130_fd_sc_hd__tapvpwrvgnd_1
XTAP_TAPCELL_ROW_9_1181 VGND VPWR sky130_fd_sc_hd__tapvpwrvgnd_1
XTAP_TAPCELL_ROW_129_2_5693 VGND VPWR sky130_fd_sc_hd__tapvpwrvgnd_1
XFILLER_207_517 VPWR VGND VPWR VGND sky130_ef_sc_hd__decap_12
XFILLER_246_163 VPWR VGND VPWR VGND sky130_ef_sc_hd__decap_12
XTAP_TAPCELL_ROW_9_1192 VGND VPWR sky130_fd_sc_hd__tapvpwrvgnd_1
XTAP_TAPCELL_ROW_5_1034 VGND VPWR sky130_fd_sc_hd__tapvpwrvgnd_1
XFILLER_219_388 VPWR VGND VPWR VGND sky130_ef_sc_hd__decap_12
XTAP_TAPCELL_ROW_5_1045 VGND VPWR sky130_fd_sc_hd__tapvpwrvgnd_1
XPHY_EDGE_ROW_158_2_Left_660 VGND VGND VPWR VPWR sky130_fd_sc_hd__decap_3
XFILLER_189_1174 VPWR VGND VPWR VGND sky130_ef_sc_hd__decap_12
XTAP_TAPCELL_ROW_5_1056 VGND VPWR sky130_fd_sc_hd__tapvpwrvgnd_1
XFILLER_41_1292 VPWR VGND VPWR VGND sky130_ef_sc_hd__decap_12
XTAP_TAPCELL_ROW_5_1067 VGND VPWR sky130_fd_sc_hd__tapvpwrvgnd_1
XFILLER_234_347 VPWR VGND VPWR VGND sky130_ef_sc_hd__decap_12
XFILLER_36_62 VGND VGND VPWR VPWR sky130_fd_sc_hd__fill_2
XTAP_TAPCELL_ROW_196_2606 VGND VPWR sky130_fd_sc_hd__tapvpwrvgnd_1
XTAP_TAPCELL_ROW_196_2617 VGND VPWR sky130_fd_sc_hd__tapvpwrvgnd_1
XFILLER_203_701 VPWR VGND VPWR VGND sky130_ef_sc_hd__decap_12
XTAP_TAPCELL_ROW_237_4038 VGND VPWR sky130_fd_sc_hd__tapvpwrvgnd_1
XTAP_TAPCELL_ROW_196_2628 VGND VPWR sky130_fd_sc_hd__tapvpwrvgnd_1
XFILLER_199_240 VPWR VGND VPWR VGND sky130_ef_sc_hd__decap_12
XTAP_TAPCELL_ROW_237_4049 VGND VPWR sky130_fd_sc_hd__tapvpwrvgnd_1
XFILLER_128_1423 VPWR VGND VPWR VGND sky130_ef_sc_hd__decap_12
XFILLER_215_572 VPWR VGND VPWR VGND sky130_ef_sc_hd__decap_12
XFILLER_188_925 VPWR VGND VPWR VGND sky130_ef_sc_hd__decap_12
XFILLER_37_1328 VGND VGND VPWR VPWR sky130_fd_sc_hd__decap_6
XFILLER_72_1208 VPWR VGND VPWR VGND sky130_ef_sc_hd__decap_12
XFILLER_226_1035 VPWR VGND VPWR VGND sky130_ef_sc_hd__decap_12
XFILLER_187_424 VGND VGND VPWR VPWR sky130_fd_sc_hd__decap_6
XFILLER_230_531 VGND VGND VPWR VPWR sky130_fd_sc_hd__decap_6
XFILLER_76_1399 VPWR VGND VPWR VGND sky130_ef_sc_hd__decap_12
XFILLER_163_1347 VPWR VGND VPWR VGND sky130_ef_sc_hd__decap_12
XFILLER_199_295 VGND VGND VPWR VPWR sky130_fd_sc_hd__decap_6
XFILLER_203_756 VPWR VGND VPWR VGND sky130_ef_sc_hd__decap_12
XTAP_TAPCELL_ROW_122_2_5636 VGND VPWR sky130_fd_sc_hd__tapvpwrvgnd_1
XFILLER_128_1478 VGND VGND VPWR VPWR sky130_fd_sc_hd__decap_6
X_315_ net596 dout0_q\[26\] net530 VGND VGND VPWR VPWR _104_ sky130_fd_sc_hd__and3_1
XTAP_TAPCELL_ROW_58_2_5122 VGND VPWR sky130_fd_sc_hd__tapvpwrvgnd_1
XFILLER_168_660 VGND VGND VPWR VPWR sky130_fd_sc_hd__decap_6
XFILLER_196_980 VPWR VGND VPWR VGND sky130_ef_sc_hd__decap_12
XFILLER_204_1355 VPWR VGND VPWR VGND sky130_ef_sc_hd__decap_12
XFILLER_7_821 VGND VGND VPWR VPWR sky130_fd_sc_hd__fill_1
Xinput15 wr_data[14] VGND VGND VPWR VPWR net15 sky130_fd_sc_hd__clkbuf_1
Xinput26 wr_data[24] VGND VGND VPWR VPWR net26 sky130_fd_sc_hd__clkbuf_1
XFILLER_200_1219 VGND VGND VPWR VPWR sky130_fd_sc_hd__decap_6
Xinput37 wr_data[5] VGND VGND VPWR VPWR net37 sky130_fd_sc_hd__clkbuf_1
Xmax_cap507 _104_ VGND VGND VPWR VPWR net507 sky130_fd_sc_hd__clkbuf_1
Xmax_cap518 net519 VGND VGND VPWR VPWR net518 sky130_fd_sc_hd__clkbuf_1
XFILLER_182_151 VPWR VGND VPWR VGND sky130_ef_sc_hd__decap_12
Xmax_cap529 net62 VGND VGND VPWR VPWR net529 sky130_fd_sc_hd__clkbuf_1
XFILLER_202_1090 VGND VGND VPWR VPWR sky130_fd_sc_hd__decap_6
XPHY_EDGE_ROW_47_1_Left_302 VGND VGND VPWR VPWR sky130_fd_sc_hd__decap_3
XTAP_TAPCELL_ROW_25_2_4863 VGND VPWR sky130_fd_sc_hd__tapvpwrvgnd_1
XFILLER_174_1410 VPWR VGND VPWR VGND sky130_ef_sc_hd__decap_12
XFILLER_83_1304 VPWR VGND VPWR VGND sky130_ef_sc_hd__decap_12
XFILLER_170_335 VPWR VGND VPWR VGND sky130_ef_sc_hd__decap_12
XFILLER_237_1131 VPWR VGND VPWR VGND sky130_ef_sc_hd__decap_12
XFILLER_48_1435 VGND VGND VPWR VPWR sky130_fd_sc_hd__decap_6
XTAP_TAPCELL_ROW_58_1_1316 VGND VPWR sky130_fd_sc_hd__tapvpwrvgnd_1
XFILLER_174_1465 VPWR VGND VPWR VGND sky130_ef_sc_hd__decap_12
XFILLER_237_1186 VPWR VGND VPWR VGND sky130_ef_sc_hd__decap_12
XFILLER_83_1359 VPWR VGND VPWR VGND sky130_ef_sc_hd__decap_12
XFILLER_2_581 VGND VGND VPWR VPWR sky130_fd_sc_hd__fill_2
XFILLER_211_1315 VPWR VGND VPWR VGND sky130_ef_sc_hd__decap_12
XTAP_TAPCELL_ROW_134_1_1431 VGND VPWR sky130_fd_sc_hd__tapvpwrvgnd_1
XFILLER_237_130 VPWR VGND VPWR VGND sky130_ef_sc_hd__decap_12
XFILLER_225_314 VPWR VGND VPWR VGND sky130_ef_sc_hd__decap_12
XFILLER_203_56 VPWR VGND VPWR VGND sky130_ef_sc_hd__decap_12
XFILLER_237_185 VPWR VGND VPWR VGND sky130_ef_sc_hd__decap_12
XFILLER_252_144 VGND VGND VPWR VPWR sky130_fd_sc_hd__decap_6
XFILLER_94_1411 VPWR VGND VPWR VGND sky130_ef_sc_hd__decap_12
XFILLER_241_818 VPWR VGND VPWR VGND sky130_ef_sc_hd__decap_12
XFILLER_168_1269 VPWR VGND VPWR VGND sky130_ef_sc_hd__decap_12
XFILLER_225_369 VPWR VGND VPWR VGND sky130_ef_sc_hd__decap_12
XFILLER_253_689 VPWR VGND VPWR VGND sky130_ef_sc_hd__decap_12
XFILLER_206_550 VPWR VGND VPWR VGND sky130_ef_sc_hd__decap_12
XFILLER_248_1293 VPWR VGND VPWR VGND sky130_ef_sc_hd__decap_12
XFILLER_94_1466 VPWR VGND VPWR VGND sky130_ef_sc_hd__decap_12
XFILLER_178_402 VGND VGND VPWR VPWR sky130_fd_sc_hd__decap_6
XFILLER_179_947 VPWR VGND VPWR VGND sky130_ef_sc_hd__decap_12
XFILLER_107_1507 VGND VGND VPWR VPWR sky130_fd_sc_hd__decap_8
XFILLER_221_553 VGND VGND VPWR VPWR sky130_fd_sc_hd__decap_6
XFILLER_205_1119 VPWR VGND VPWR VGND sky130_ef_sc_hd__decap_12
XFILLER_194_906 VPWR VGND VPWR VGND sky130_ef_sc_hd__decap_12
XFILLER_222_1422 VPWR VGND VPWR VGND sky130_ef_sc_hd__decap_12
XFILLER_165_118 VGND VGND VPWR VPWR sky130_fd_sc_hd__decap_8
XFILLER_18_1294 VPWR VGND VPWR VGND sky130_ef_sc_hd__decap_12
XFILLER_105_1242 VGND VGND VPWR VPWR sky130_fd_sc_hd__decap_6
XFILLER_222_1477 VGND VGND VPWR VPWR sky130_fd_sc_hd__decap_6
XFILLER_140_1177 VGND VGND VPWR VPWR sky130_fd_sc_hd__decap_6
XPHY_EDGE_ROW_82_2_Right_173 VGND VGND VPWR VPWR sky130_fd_sc_hd__decap_3
XFILLER_173_173 VPWR VGND VPWR VGND sky130_ef_sc_hd__decap_12
XFILLER_175_1229 VPWR VGND VPWR VGND sky130_ef_sc_hd__decap_12
XPHY_EDGE_ROW_31_1_Left_286 VGND VGND VPWR VPWR sky130_fd_sc_hd__decap_3
XFILLER_255_1231 VGND VGND VPWR VPWR sky130_fd_sc_hd__decap_8
XFILLER_216_1226 VPWR VGND VPWR VGND sky130_ef_sc_hd__decap_12
XTAP_TAPCELL_ROW_146_2_5832 VGND VPWR sky130_fd_sc_hd__tapvpwrvgnd_1
XFILLER_64_1270 VPWR VGND VPWR VGND sky130_ef_sc_hd__decap_12
XFILLER_29_1390 VPWR VGND VPWR VGND sky130_ef_sc_hd__decap_12
XFILLER_9_1462 VGND VGND VPWR VPWR sky130_fd_sc_hd__decap_8
XFILLER_57_39 VGND VGND VPWR VPWR sky130_fd_sc_hd__decap_4
XFILLER_5_1315 VPWR VGND VPWR VGND sky130_ef_sc_hd__decap_12
XFILLER_151_1273 VPWR VGND VPWR VGND sky130_ef_sc_hd__decap_12
XPHY_EDGE_ROW_166_Left_421 VGND VGND VPWR VPWR sky130_fd_sc_hd__decap_3
XFILLER_249_1002 VPWR VGND VPWR VGND sky130_ef_sc_hd__decap_12
XFILLER_228_163 VPWR VGND VPWR VGND sky130_ef_sc_hd__decap_12
XFILLER_243_111 VPWR VGND VPWR VGND sky130_ef_sc_hd__decap_12
XTAP_TAPCELL_ROW_95_2_5418 VGND VPWR sky130_fd_sc_hd__tapvpwrvgnd_1
XFILLER_113_56 VPWR VGND VPWR VGND sky130_ef_sc_hd__decap_12
XFILLER_186_1336 VPWR VGND VPWR VGND sky130_ef_sc_hd__decap_12
XFILLER_216_347 VPWR VGND VPWR VGND sky130_ef_sc_hd__decap_12
XFILLER_249_1057 VPWR VGND VPWR VGND sky130_ef_sc_hd__decap_12
XFILLER_244_667 VPWR VGND VPWR VGND sky130_ef_sc_hd__decap_12
XFILLER_73_27 VPWR VGND VPWR VGND sky130_ef_sc_hd__decap_12
XTAP_TAPCELL_ROW_64_2_5176 VGND VPWR sky130_fd_sc_hd__tapvpwrvgnd_1
XFILLER_243_166 VGND VGND VPWR VPWR sky130_fd_sc_hd__decap_6
XTAP_TAPCELL_ROW_203_2860 VGND VPWR sky130_fd_sc_hd__tapvpwrvgnd_1
XFILLER_189_27 VPWR VGND VPWR VGND sky130_ef_sc_hd__decap_12
XTAP_TAPCELL_ROW_203_2871 VGND VPWR sky130_fd_sc_hd__tapvpwrvgnd_1
XTAP_TAPCELL_ROW_107_2_5516 VGND VPWR sky130_fd_sc_hd__tapvpwrvgnd_1
Xwire83 _235_ VGND VGND VPWR VPWR net83 sky130_fd_sc_hd__clkbuf_1
XTAP_TAPCELL_ROW_255_4672 VGND VPWR sky130_fd_sc_hd__tapvpwrvgnd_1
XFILLER_212_531 VGND VGND VPWR VPWR sky130_fd_sc_hd__decap_6
XFILLER_169_424 VGND VGND VPWR VPWR sky130_fd_sc_hd__decap_6
XTAP_TAPCELL_ROW_255_4683 VGND VPWR sky130_fd_sc_hd__tapvpwrvgnd_1
XFILLER_240_851 VPWR VGND VPWR VGND sky130_ef_sc_hd__decap_12
XFILLER_197_744 VPWR VGND VPWR VGND sky130_ef_sc_hd__decap_12
XFILLER_227_1377 VPWR VGND VPWR VGND sky130_ef_sc_hd__decap_12
XTAP_TAPCELL_ROW_255_4694 VGND VPWR sky130_fd_sc_hd__tapvpwrvgnd_1
XTAP_TAPCELL_ROW_251_4525 VGND VPWR sky130_fd_sc_hd__tapvpwrvgnd_1
XTAP_TAPCELL_ROW_251_4536 VGND VPWR sky130_fd_sc_hd__tapvpwrvgnd_1
XFILLER_160_1509 VGND VGND VPWR VPWR sky130_fd_sc_hd__decap_6
XTAP_TAPCELL_ROW_251_4547 VGND VPWR sky130_fd_sc_hd__tapvpwrvgnd_1
XTAP_TAPCELL_ROW_251_4558 VGND VPWR sky130_fd_sc_hd__tapvpwrvgnd_1
XFILLER_71_1230 VPWR VGND VPWR VGND sky130_ef_sc_hd__decap_12
XFILLER_185_928 VPWR VGND VPWR VGND sky130_ef_sc_hd__decap_12
XFILLER_197_799 VPWR VGND VPWR VGND sky130_ef_sc_hd__decap_12
XTAP_TAPCELL_ROW_64_1_1326 VGND VPWR sky130_fd_sc_hd__tapvpwrvgnd_1
XFILLER_178_980 VPWR VGND VPWR VGND sky130_ef_sc_hd__decap_12
XFILLER_162_1380 VPWR VGND VPWR VGND sky130_ef_sc_hd__decap_12
XPHY_EDGE_ROW_175_Left_430 VGND VGND VPWR VPWR sky130_fd_sc_hd__decap_3
XFILLER_201_1506 VGND VGND VPWR VPWR sky130_fd_sc_hd__decap_8
XFILLER_71_1285 VGND VGND VPWR VPWR sky130_fd_sc_hd__decap_6
XFILLER_7_128 VGND VGND VPWR VPWR sky130_fd_sc_hd__fill_1
XFILLER_125_3 VPWR VGND VPWR VGND sky130_ef_sc_hd__decap_12
XFILLER_165_652 VPWR VGND VPWR VGND sky130_ef_sc_hd__decap_12
XFILLER_197_1432 VPWR VGND VPWR VGND sky130_ef_sc_hd__decap_12
XFILLER_4_802 VGND VGND VPWR VPWR sky130_fd_sc_hd__decap_6
XFILLER_193_983 VGND VGND VPWR VPWR sky130_fd_sc_hd__decap_6
XFILLER_165_685 VGND VGND VPWR VPWR sky130_fd_sc_hd__decap_8
XTAP_TAPCELL_ROW_249_4454 VGND VPWR sky130_fd_sc_hd__tapvpwrvgnd_1
XTAP_TAPCELL_ROW_249_4465 VGND VPWR sky130_fd_sc_hd__tapvpwrvgnd_1
XFILLER_197_1487 VPWR VGND VPWR VGND sky130_ef_sc_hd__decap_12
XTAP_TAPCELL_ROW_249_4476 VGND VPWR sky130_fd_sc_hd__tapvpwrvgnd_1
XTAP_TAPCELL_ROW_245_4318 VGND VPWR sky130_fd_sc_hd__tapvpwrvgnd_1
XFILLER_98_46 VPWR VGND VPWR VGND sky130_ef_sc_hd__decap_12
XTAP_TAPCELL_ROW_249_4487 VGND VPWR sky130_fd_sc_hd__tapvpwrvgnd_1
XTAP_TAPCELL_ROW_245_4329 VGND VPWR sky130_fd_sc_hd__tapvpwrvgnd_1
XFILLER_3_345 VGND VGND VPWR VPWR sky130_fd_sc_hd__fill_2
XFILLER_238_1484 VPWR VGND VPWR VGND sky130_ef_sc_hd__decap_12
XFILLER_234_1348 VGND VGND VPWR VPWR sky130_fd_sc_hd__decap_6
XFILLER_156_1184 VPWR VGND VPWR VGND sky130_ef_sc_hd__decap_12
XTAP_TAPCELL_ROW_7_1107 VGND VPWR sky130_fd_sc_hd__tapvpwrvgnd_1
XFILLER_82_1392 VGND VGND VPWR VPWR sky130_fd_sc_hd__decap_6
XTAP_TAPCELL_ROW_7_1118 VGND VPWR sky130_fd_sc_hd__tapvpwrvgnd_1
XFILLER_254_409 VPWR VGND VPWR VGND sky130_ef_sc_hd__decap_12
XTAP_TAPCELL_ROW_7_1129 VGND VPWR sky130_fd_sc_hd__tapvpwrvgnd_1
XFILLER_219_130 VPWR VGND VPWR VGND sky130_ef_sc_hd__decap_12
XFILLER_130_1313 VPWR VGND VPWR VGND sky130_ef_sc_hd__decap_12
XFILLER_207_314 VPWR VGND VPWR VGND sky130_ef_sc_hd__decap_12
XFILLER_219_185 VPWR VGND VPWR VGND sky130_ef_sc_hd__decap_12
XFILLER_130_1368 VPWR VGND VPWR VGND sky130_ef_sc_hd__decap_12
XFILLER_234_144 VGND VGND VPWR VPWR sky130_fd_sc_hd__decap_6
XFILLER_207_369 VPWR VGND VPWR VGND sky130_ef_sc_hd__decap_12
XFILLER_223_818 VPWR VGND VPWR VGND sky130_ef_sc_hd__decap_12
XFILLER_235_689 VPWR VGND VPWR VGND sky130_ef_sc_hd__decap_12
XFILLER_250_648 VPWR VGND VPWR VGND sky130_ef_sc_hd__decap_12
XFILLER_128_1220 VGND VGND VPWR VPWR sky130_fd_sc_hd__decap_6
XFILLER_245_1444 VPWR VGND VPWR VGND sky130_ef_sc_hd__decap_12
XFILLER_188_722 VPWR VGND VPWR VGND sky130_ef_sc_hd__decap_12
XFILLER_167_1291 VPWR VGND VPWR VGND sky130_ef_sc_hd__decap_12
Xclkbuf_3_4__f_clk clknet_0_clk VGND VGND VPWR VPWR clknet_3_4__leaf_clk sky130_fd_sc_hd__clkbuf_16
XFILLER_76_1196 VPWR VGND VPWR VGND sky130_ef_sc_hd__decap_12
XFILLER_203_553 VGND VGND VPWR VPWR sky130_fd_sc_hd__decap_6
XFILLER_176_906 VPWR VGND VPWR VGND sky130_ef_sc_hd__decap_12
XFILLER_231_873 VPWR VGND VPWR VGND sky130_ef_sc_hd__decap_12
XFILLER_245_1499 VGND VGND VPWR VPWR sky130_fd_sc_hd__decap_6
XFILLER_188_777 VPWR VGND VPWR VGND sky130_ef_sc_hd__decap_12
XFILLER_163_1177 VPWR VGND VPWR VGND sky130_ef_sc_hd__decap_12
XFILLER_8_22 VPWR VGND VPWR VGND sky130_ef_sc_hd__decap_12
XFILLER_198_1207 VPWR VGND VPWR VGND sky130_ef_sc_hd__decap_12
XFILLER_204_1152 VPWR VGND VPWR VGND sky130_ef_sc_hd__decap_12
XFILLER_50_1325 VPWR VGND VPWR VGND sky130_ef_sc_hd__decap_12
XFILLER_15_1445 VPWR VGND VPWR VGND sky130_ef_sc_hd__decap_12
XFILLER_8_77 VPWR VGND VPWR VGND sky130_ef_sc_hd__decap_12
XFILLER_141_1464 VPWR VGND VPWR VGND sky130_ef_sc_hd__decap_12
XFILLER_184_961 VGND VGND VPWR VPWR sky130_fd_sc_hd__decap_6
Xwire560 net69 VGND VGND VPWR VPWR net560 sky130_fd_sc_hd__clkbuf_1
XTAP_TAPCELL_ROW_152_2_5875 VGND VPWR sky130_fd_sc_hd__tapvpwrvgnd_1
Xwire582 dout0_q\[7\] VGND VGND VPWR VPWR net582 sky130_fd_sc_hd__clkbuf_1
XFILLER_239_1248 VPWR VGND VPWR VGND sky130_ef_sc_hd__decap_12
Xmax_cap337 _137_ VGND VGND VPWR VPWR net337 sky130_fd_sc_hd__clkbuf_1
XFILLER_6_194 VGND VGND VPWR VPWR sky130_fd_sc_hd__fill_1
XFILLER_170_132 VPWR VGND VPWR VGND sky130_ef_sc_hd__decap_12
XTAP_TAPCELL_ROW_172_1790 VGND VPWR sky130_fd_sc_hd__tapvpwrvgnd_1
XFILLER_40_3 VPWR VGND VPWR VGND sky130_ef_sc_hd__decap_12
XFILLER_87_1292 VPWR VGND VPWR VGND sky130_ef_sc_hd__decap_12
XFILLER_139_1371 VGND VGND VPWR VPWR sky130_fd_sc_hd__decap_6
XFILLER_170_187 VGND VGND VPWR VPWR sky130_fd_sc_hd__decap_6
XFILLER_174_1262 VGND VGND VPWR VPWR sky130_fd_sc_hd__decap_6
XFILLER_83_1189 VPWR VGND VPWR VGND sky130_ef_sc_hd__decap_12
XFILLER_61_1421 VPWR VGND VPWR VGND sky130_ef_sc_hd__decap_12
XFILLER_239_940 VGND VGND VPWR VPWR sky130_fd_sc_hd__decap_6
XFILLER_113_1500 VGND VGND VPWR VPWR sky130_fd_sc_hd__decap_6
XFILLER_214_22 VPWR VGND VPWR VGND sky130_ef_sc_hd__decap_12
XFILLER_211_1112 VGND VGND VPWR VPWR sky130_fd_sc_hd__decap_6
XTAP_TAPCELL_ROW_166_1550 VGND VPWR sky130_fd_sc_hd__tapvpwrvgnd_1
XFILLER_250_1183 VPWR VGND VPWR VGND sky130_ef_sc_hd__decap_12
XFILLER_61_1476 VPWR VGND VPWR VGND sky130_ef_sc_hd__decap_12
XTAP_TAPCELL_ROW_166_1561 VGND VPWR sky130_fd_sc_hd__tapvpwrvgnd_1
XTAP_TAPCELL_ROW_166_1572 VGND VPWR sky130_fd_sc_hd__tapvpwrvgnd_1
XFILLER_214_77 VPWR VGND VPWR VGND sky130_ef_sc_hd__decap_12
XTAP_TAPCELL_ROW_50_2_5062 VGND VPWR sky130_fd_sc_hd__tapvpwrvgnd_1
XTAP_TAPCELL_ROW_49_2_5056 VGND VPWR sky130_fd_sc_hd__tapvpwrvgnd_1
XTAP_TAPCELL_ROW_166_1583 VGND VPWR sky130_fd_sc_hd__tapvpwrvgnd_1
XFILLER_168_1011 VPWR VGND VPWR VGND sky130_ef_sc_hd__decap_12
XFILLER_225_111 VPWR VGND VPWR VGND sky130_ef_sc_hd__decap_12
XFILLER_253_431 VPWR VGND VPWR VGND sky130_ef_sc_hd__decap_12
XFILLER_226_667 VPWR VGND VPWR VGND sky130_ef_sc_hd__decap_12
XFILLER_246_1219 VGND VGND VPWR VPWR sky130_fd_sc_hd__decap_6
XFILLER_241_615 VPWR VGND VPWR VGND sky130_ef_sc_hd__decap_12
XFILLER_168_1066 VPWR VGND VPWR VGND sky130_ef_sc_hd__decap_12
XFILLER_225_166 VGND VGND VPWR VPWR sky130_fd_sc_hd__decap_6
XFILLER_253_486 VPWR VGND VPWR VGND sky130_ef_sc_hd__decap_12
XFILLER_198_519 VPWR VGND VPWR VGND sky130_ef_sc_hd__decap_12
XFILLER_20_1184 VPWR VGND VPWR VGND sky130_ef_sc_hd__decap_12
XFILLER_230_65 VPWR VGND VPWR VGND sky130_ef_sc_hd__decap_12
XFILLER_248_1090 VGND VGND VPWR VPWR sky130_fd_sc_hd__decap_6
XTAP_TAPCELL_ROW_16_2_4786 VGND VPWR sky130_fd_sc_hd__tapvpwrvgnd_1
XFILLER_94_1263 VGND VGND VPWR VPWR sky130_fd_sc_hd__decap_6
XFILLER_179_744 VPWR VGND VPWR VGND sky130_ef_sc_hd__decap_12
XFILLER_222_851 VPWR VGND VPWR VGND sky130_ef_sc_hd__decap_12
XFILLER_107_1304 VPWR VGND VPWR VGND sky130_ef_sc_hd__decap_12
XFILLER_194_703 VGND VGND VPWR VPWR sky130_fd_sc_hd__decap_6
XFILLER_167_928 VPWR VGND VPWR VGND sky130_ef_sc_hd__decap_12
XFILLER_107_1359 VPWR VGND VPWR VGND sky130_ef_sc_hd__decap_12
XFILLER_142_1239 VPWR VGND VPWR VGND sky130_ef_sc_hd__decap_12
XFILLER_179_799 VPWR VGND VPWR VGND sky130_ef_sc_hd__decap_12
XFILLER_175_983 VGND VGND VPWR VPWR sky130_fd_sc_hd__decap_6
XFILLER_179_1162 VPWR VGND VPWR VGND sky130_ef_sc_hd__decap_12
XFILLER_175_1026 VGND VGND VPWR VPWR sky130_fd_sc_hd__decap_6
XPHY_EDGE_ROW_83_2_Right_174 VGND VGND VPWR VPWR sky130_fd_sc_hd__decap_3
XFILLER_108_34 VPWR VGND VPWR VGND sky130_ef_sc_hd__decap_12
XFILLER_118_1411 VPWR VGND VPWR VGND sky130_ef_sc_hd__decap_12
XTAP_TAPCELL_ROW_28_1_1271 VGND VPWR sky130_fd_sc_hd__tapvpwrvgnd_1
XFILLER_255_1072 VPWR VGND VPWR VGND sky130_ef_sc_hd__decap_12
XFILLER_27_1316 VPWR VGND VPWR VGND sky130_ef_sc_hd__decap_12
XFILLER_216_1023 VPWR VGND VPWR VGND sky130_ef_sc_hd__decap_12
XFILLER_0_326 VGND VGND VPWR VPWR sky130_fd_sc_hd__fill_1
XFILLER_153_1335 VPWR VGND VPWR VGND sky130_ef_sc_hd__decap_12
XFILLER_191_39 VGND VGND VPWR VPWR sky130_fd_sc_hd__decap_4
XFILLER_118_1466 VPWR VGND VPWR VGND sky130_ef_sc_hd__decap_12
XFILLER_124_22 VPWR VGND VPWR VGND sky130_ef_sc_hd__decap_12
XFILLER_216_1078 VPWR VGND VPWR VGND sky130_ef_sc_hd__decap_12
XFILLER_233_1370 VGND VGND VPWR VPWR sky130_fd_sc_hd__decap_6
XFILLER_5_1112 VGND VGND VPWR VPWR sky130_fd_sc_hd__decap_6
XFILLER_236_409 VPWR VGND VPWR VGND sky130_ef_sc_hd__decap_12
XFILLER_84_15 VGND VGND VPWR VPWR sky130_fd_sc_hd__decap_6
XTAP_TAPCELL_ROW_116_1_1403 VGND VPWR sky130_fd_sc_hd__tapvpwrvgnd_1
XTAP_TAPCELL_ROW_205_2922 VGND VPWR sky130_fd_sc_hd__tapvpwrvgnd_1
XTAP_TAPCELL_ROW_205_2933 VGND VPWR sky130_fd_sc_hd__tapvpwrvgnd_1
XTAP_TAPCELL_ROW_205_2944 VGND VPWR sky130_fd_sc_hd__tapvpwrvgnd_1
X_580_ net669 VGND VGND VPWR VPWR _062_ sky130_fd_sc_hd__inv_2
XTAP_TAPCELL_ROW_238_4100 VGND VPWR sky130_fd_sc_hd__tapvpwrvgnd_1
XFILLER_186_1133 VGND VGND VPWR VPWR sky130_fd_sc_hd__decap_6
XTAP_TAPCELL_ROW_201_2808 VGND VPWR sky130_fd_sc_hd__tapvpwrvgnd_1
XFILLER_205_818 VPWR VGND VPWR VGND sky130_ef_sc_hd__decap_12
XFILLER_216_144 VGND VGND VPWR VPWR sky130_fd_sc_hd__decap_6
XFILLER_244_464 VPWR VGND VPWR VGND sky130_ef_sc_hd__decap_12
XFILLER_217_689 VPWR VGND VPWR VGND sky130_ef_sc_hd__decap_12
XTAP_TAPCELL_ROW_253_4609 VGND VPWR sky130_fd_sc_hd__tapvpwrvgnd_1
XTAP_TAPCELL_ROW_0_860 VGND VPWR sky130_fd_sc_hd__tapvpwrvgnd_1
XTAP_TAPCELL_ROW_0_871 VGND VPWR sky130_fd_sc_hd__tapvpwrvgnd_1
XFILLER_232_648 VPWR VGND VPWR VGND sky130_ef_sc_hd__decap_12
XFILLER_38_1423 VPWR VGND VPWR VGND sky130_ef_sc_hd__decap_12
XTAP_TAPCELL_ROW_0_882 VGND VPWR sky130_fd_sc_hd__tapvpwrvgnd_1
XFILLER_140_65 VGND VGND VPWR VPWR sky130_fd_sc_hd__decap_6
XTAP_TAPCELL_ROW_0_893 VGND VPWR sky130_fd_sc_hd__tapvpwrvgnd_1
XFILLER_164_1442 VPWR VGND VPWR VGND sky130_ef_sc_hd__decap_12
XFILLER_242_3 VPWR VGND VPWR VGND sky130_ef_sc_hd__decap_12
XFILLER_197_541 VPWR VGND VPWR VGND sky130_ef_sc_hd__decap_12
XFILLER_73_1347 VPWR VGND VPWR VGND sky130_ef_sc_hd__decap_12
XFILLER_213_873 VPWR VGND VPWR VGND sky130_ef_sc_hd__decap_12
XFILLER_227_1174 VPWR VGND VPWR VGND sky130_ef_sc_hd__decap_12
XFILLER_38_1478 VGND VGND VPWR VPWR sky130_fd_sc_hd__decap_6
XFILLER_160_1306 VGND VGND VPWR VPWR sky130_fd_sc_hd__decap_6
XFILLER_9_916 VGND VGND VPWR VPWR sky130_fd_sc_hd__decap_8
XFILLER_164_1497 VPWR VGND VPWR VGND sky130_ef_sc_hd__decap_12
XFILLER_185_725 VGND VGND VPWR VPWR sky130_fd_sc_hd__decap_6
XFILLER_33_63 VGND VGND VPWR VPWR sky130_fd_sc_hd__decap_8
XFILLER_197_596 VGND VGND VPWR VPWR sky130_fd_sc_hd__decap_6
XTAP_TAPCELL_ROW_137_2_5755 VGND VPWR sky130_fd_sc_hd__tapvpwrvgnd_1
XFILLER_201_1303 VPWR VGND VPWR VGND sky130_ef_sc_hd__decap_12
XFILLER_166_961 VGND VGND VPWR VPWR sky130_fd_sc_hd__decap_6
XFILLER_201_1358 VPWR VGND VPWR VGND sky130_ef_sc_hd__decap_12
XFILLER_197_1284 VGND VGND VPWR VPWR sky130_fd_sc_hd__decap_6
XFILLER_4_654 VGND VGND VPWR VPWR sky130_fd_sc_hd__fill_1
XFILLER_180_452 VPWR VGND VPWR VGND sky130_ef_sc_hd__decap_12
XFILLER_3_142 VPWR VGND VPWR VGND sky130_ef_sc_hd__decap_12
XFILLER_238_1281 VPWR VGND VPWR VGND sky130_ef_sc_hd__decap_12
XTAP_TAPCELL_ROW_55_2_5099 VGND VPWR sky130_fd_sc_hd__tapvpwrvgnd_1
XFILLER_84_1454 VPWR VGND VPWR VGND sky130_ef_sc_hd__decap_12
XFILLER_171_1413 VGND VGND VPWR VPWR sky130_fd_sc_hd__decap_6
XFILLER_212_1410 VPWR VGND VPWR VGND sky130_ef_sc_hd__decap_12
Xhold4 rd_addr\[4\] VGND VGND VPWR VPWR net692 sky130_fd_sc_hd__dlygate4sd3_1
XFILLER_254_206 VPWR VGND VPWR VGND sky130_ef_sc_hd__decap_12
XFILLER_212_1465 VPWR VGND VPWR VGND sky130_ef_sc_hd__decap_12
XFILLER_207_111 VPWR VGND VPWR VGND sky130_ef_sc_hd__decap_12
XFILLER_235_431 VPWR VGND VPWR VGND sky130_ef_sc_hd__decap_12
XTAP_TAPCELL_ROW_33_2_4925 VGND VPWR sky130_fd_sc_hd__tapvpwrvgnd_1
XFILLER_130_1165 VPWR VGND VPWR VGND sky130_ef_sc_hd__decap_12
XFILLER_247_1506 VGND VGND VPWR VPWR sky130_fd_sc_hd__decap_8
XFILLER_208_667 VPWR VGND VPWR VGND sky130_ef_sc_hd__decap_12
XFILLER_207_166 VGND VGND VPWR VPWR sky130_fd_sc_hd__decap_6
XTAP_TAPCELL_ROW_221_3480 VGND VPWR sky130_fd_sc_hd__tapvpwrvgnd_1
XFILLER_223_615 VPWR VGND VPWR VGND sky130_ef_sc_hd__decap_12
XTAP_TAPCELL_ROW_221_3491 VGND VPWR sky130_fd_sc_hd__tapvpwrvgnd_1
XFILLER_235_486 VPWR VGND VPWR VGND sky130_ef_sc_hd__decap_12
XFILLER_250_445 VGND VGND VPWR VPWR sky130_fd_sc_hd__decap_6
XFILLER_245_1241 VGND VGND VPWR VPWR sky130_fd_sc_hd__decap_6
XFILLER_91_1414 VGND VGND VPWR VPWR sky130_fd_sc_hd__decap_6
XFILLER_204_851 VPWR VGND VPWR VGND sky130_ef_sc_hd__decap_12
XFILLER_17_1507 VGND VGND VPWR VPWR sky130_fd_sc_hd__decap_8
XFILLER_200_46 VPWR VGND VPWR VGND sky130_ef_sc_hd__decap_12
XFILLER_176_703 VGND VGND VPWR VPWR sky130_fd_sc_hd__decap_6
XFILLER_231_670 VPWR VGND VPWR VGND sky130_ef_sc_hd__decap_12
XFILLER_188_574 VGND VGND VPWR VPWR sky130_fd_sc_hd__decap_6
XFILLER_88_3 VPWR VGND VPWR VGND sky130_ef_sc_hd__decap_12
XFILLER_206_1269 VPWR VGND VPWR VGND sky130_ef_sc_hd__decap_12
XTAP_TAPCELL_ROW_34_1_1281 VGND VPWR sky130_fd_sc_hd__tapvpwrvgnd_1
XFILLER_198_1004 VGND VGND VPWR VPWR sky130_fd_sc_hd__decap_6
XFILLER_15_1242 VGND VGND VPWR VPWR sky130_fd_sc_hd__decap_6
XTAP_TAPCELL_ROW_174_1830 VGND VPWR sky130_fd_sc_hd__tapvpwrvgnd_1
XTAP_TAPCELL_ROW_174_1841 VGND VPWR sky130_fd_sc_hd__tapvpwrvgnd_1
XFILLER_141_1261 VPWR VGND VPWR VGND sky130_ef_sc_hd__decap_12
XTAP_TAPCELL_ROW_174_1852 VGND VPWR sky130_fd_sc_hd__tapvpwrvgnd_1
XTAP_TAPCELL_ROW_215_3273 VGND VPWR sky130_fd_sc_hd__tapvpwrvgnd_1
XFILLER_106_1392 VGND VGND VPWR VPWR sky130_fd_sc_hd__decap_6
XTAP_TAPCELL_ROW_174_1863 VGND VPWR sky130_fd_sc_hd__tapvpwrvgnd_1
XTAP_TAPCELL_ROW_215_3284 VGND VPWR sky130_fd_sc_hd__tapvpwrvgnd_1
XTAP_TAPCELL_ROW_170_1705 VGND VPWR sky130_fd_sc_hd__tapvpwrvgnd_1
XTAP_TAPCELL_ROW_211_3126 VGND VPWR sky130_fd_sc_hd__tapvpwrvgnd_1
XTAP_TAPCELL_ROW_215_3295 VGND VPWR sky130_fd_sc_hd__tapvpwrvgnd_1
XFILLER_50_1177 VGND VGND VPWR VPWR sky130_fd_sc_hd__decap_6
XTAP_TAPCELL_ROW_170_1716 VGND VPWR sky130_fd_sc_hd__tapvpwrvgnd_1
XFILLER_209_44 VPWR VGND VPWR VGND sky130_ef_sc_hd__decap_12
XTAP_TAPCELL_ROW_211_3137 VGND VPWR sky130_fd_sc_hd__tapvpwrvgnd_1
Xmax_cap101 net102 VGND VGND VPWR VPWR net101 sky130_fd_sc_hd__clkbuf_1
XTAP_TAPCELL_ROW_211_3148 VGND VPWR sky130_fd_sc_hd__tapvpwrvgnd_1
Xmax_cap112 _129_ VGND VGND VPWR VPWR net112 sky130_fd_sc_hd__clkbuf_1
XPHY_EDGE_ROW_110_2_Left_612 VGND VGND VPWR VPWR sky130_fd_sc_hd__decap_3
Xwire390 net391 VGND VGND VPWR VPWR net390 sky130_fd_sc_hd__clkbuf_1
XFILLER_176_1324 VPWR VGND VPWR VGND sky130_ef_sc_hd__decap_12
XFILLER_190_249 VPWR VGND VPWR VGND sky130_ef_sc_hd__decap_12
XFILLER_239_1045 VPWR VGND VPWR VGND sky130_ef_sc_hd__decap_12
XFILLER_85_1218 VPWR VGND VPWR VGND sky130_ef_sc_hd__decap_12
Xmax_cap145 _223_ VGND VGND VPWR VPWR net145 sky130_fd_sc_hd__clkbuf_1
XTAP_TAPCELL_ROW_122_1_1413 VGND VPWR sky130_fd_sc_hd__tapvpwrvgnd_1
Xmax_cap156 net157 VGND VGND VPWR VPWR net156 sky130_fd_sc_hd__clkbuf_1
XFILLER_209_99 VPWR VGND VPWR VGND sky130_ef_sc_hd__decap_12
XFILLER_171_474 VPWR VGND VPWR VGND sky130_ef_sc_hd__decap_12
XFILLER_176_1379 VPWR VGND VPWR VGND sky130_ef_sc_hd__decap_12
Xmax_cap178 _102_ VGND VGND VPWR VPWR net178 sky130_fd_sc_hd__clkbuf_1
Xmax_cap189 net190 VGND VGND VPWR VPWR net189 sky130_fd_sc_hd__clkbuf_1
XTAP_TAPCELL_ROW_168_1623 VGND VPWR sky130_fd_sc_hd__tapvpwrvgnd_1
XTAP_TAPCELL_ROW_168_1634 VGND VPWR sky130_fd_sc_hd__tapvpwrvgnd_1
XTAP_TAPCELL_ROW_209_3055 VGND VPWR sky130_fd_sc_hd__tapvpwrvgnd_1
XTAP_TAPCELL_ROW_168_1645 VGND VPWR sky130_fd_sc_hd__tapvpwrvgnd_1
XTAP_TAPCELL_ROW_209_3066 VGND VPWR sky130_fd_sc_hd__tapvpwrvgnd_1
XFILLER_213_1229 VPWR VGND VPWR VGND sky130_ef_sc_hd__decap_12
XFILLER_6_1410 VPWR VGND VPWR VGND sky130_ef_sc_hd__decap_12
XTAP_TAPCELL_ROW_209_3077 VGND VPWR sky130_fd_sc_hd__tapvpwrvgnd_1
XFILLER_225_87 VPWR VGND VPWR VGND sky130_ef_sc_hd__decap_12
XTAP_TAPCELL_ROW_209_3088 VGND VPWR sky130_fd_sc_hd__tapvpwrvgnd_1
XFILLER_218_409 VPWR VGND VPWR VGND sky130_ef_sc_hd__decap_12
XFILLER_61_1273 VPWR VGND VPWR VGND sky130_ef_sc_hd__decap_12
XFILLER_245_228 VPWR VGND VPWR VGND sky130_ef_sc_hd__decap_12
XFILLER_6_1465 VPWR VGND VPWR VGND sky130_ef_sc_hd__decap_12
XFILLER_187_1420 VPWR VGND VPWR VGND sky130_ef_sc_hd__decap_12
XFILLER_238_280 VPWR VGND VPWR VGND sky130_ef_sc_hd__decap_12
XFILLER_96_1325 VPWR VGND VPWR VGND sky130_ef_sc_hd__decap_12
XFILLER_226_464 VPWR VGND VPWR VGND sky130_ef_sc_hd__decap_12
XFILLER_187_1475 VPWR VGND VPWR VGND sky130_ef_sc_hd__decap_12
XFILLER_241_412 VPWR VGND VPWR VGND sky130_ef_sc_hd__decap_12
XFILLER_253_283 VPWR VGND VPWR VGND sky130_ef_sc_hd__decap_12
XFILLER_0_1042 VGND VGND VPWR VPWR sky130_fd_sc_hd__decap_8
XFILLER_198_316 VGND VGND VPWR VPWR sky130_fd_sc_hd__decap_6
XFILLER_214_648 VPWR VGND VPWR VGND sky130_ef_sc_hd__decap_12
XFILLER_242_968 VPWR VGND VPWR VGND sky130_ef_sc_hd__decap_12
XFILLER_241_467 VGND VGND VPWR VPWR sky130_fd_sc_hd__decap_6
XTAP_TAPCELL_ROW_79_2_5295 VGND VPWR sky130_fd_sc_hd__tapvpwrvgnd_1
XFILLER_179_541 VPWR VGND VPWR VGND sky130_ef_sc_hd__decap_12
XFILLER_110_46 VPWR VGND VPWR VGND sky130_ef_sc_hd__decap_12
XFILLER_70_1509 VGND VGND VPWR VPWR sky130_fd_sc_hd__decap_6
XFILLER_224_1336 VPWR VGND VPWR VGND sky130_ef_sc_hd__decap_12
XFILLER_210_832 VGND VGND VPWR VPWR sky130_fd_sc_hd__decap_6
XFILLER_167_725 VGND VGND VPWR VPWR sky130_fd_sc_hd__decap_6
XFILLER_179_596 VGND VGND VPWR VPWR sky130_fd_sc_hd__decap_6
XFILLER_72_1380 VPWR VGND VPWR VGND sky130_ef_sc_hd__decap_12
XFILLER_107_1189 VPWR VGND VPWR VGND sky130_ef_sc_hd__decap_12
XPHY_EDGE_ROW_42_2_Left_544 VGND VGND VPWR VPWR sky130_fd_sc_hd__decap_3
XFILLER_159_1500 VGND VGND VPWR VPWR sky130_fd_sc_hd__decap_6
XFILLER_181_216 VPWR VGND VPWR VGND sky130_ef_sc_hd__decap_12
XFILLER_119_44 VPWR VGND VPWR VGND sky130_ef_sc_hd__decap_12
XTAP_TAPCELL_ROW_72_2_5238 VGND VPWR sky130_fd_sc_hd__tapvpwrvgnd_1
XFILLER_120_1356 VPWR VGND VPWR VGND sky130_ef_sc_hd__decap_12
XFILLER_79_15 VPWR VGND VPWR VGND sky130_ef_sc_hd__decap_12
XPHY_EDGE_ROW_2_Left_258 VGND VGND VPWR VPWR sky130_fd_sc_hd__decap_3
XFILLER_200_1391 VGND VGND VPWR VPWR sky130_fd_sc_hd__decap_6
XPHY_EDGE_ROW_84_2_Right_175 VGND VGND VPWR VPWR sky130_fd_sc_hd__decap_3
XFILLER_235_1432 VPWR VGND VPWR VGND sky130_ef_sc_hd__decap_12
XFILLER_66_1184 VPWR VGND VPWR VGND sky130_ef_sc_hd__decap_12
XFILLER_118_1263 VGND VGND VPWR VPWR sky130_fd_sc_hd__decap_6
XFILLER_235_1487 VPWR VGND VPWR VGND sky130_ef_sc_hd__decap_12
XFILLER_7_1229 VPWR VGND VPWR VGND sky130_ef_sc_hd__decap_12
XFILLER_153_1165 VPWR VGND VPWR VGND sky130_ef_sc_hd__decap_12
XFILLER_192_3 VPWR VGND VPWR VGND sky130_ef_sc_hd__decap_12
XTAP_TAPCELL_ROW_18_2_4805 VGND VPWR sky130_fd_sc_hd__tapvpwrvgnd_1
XTAP_TAPCELL_ROW_184_2181 VGND VPWR sky130_fd_sc_hd__tapvpwrvgnd_1
XFILLER_236_206 VPWR VGND VPWR VGND sky130_ef_sc_hd__decap_12
XFILLER_40_1313 VPWR VGND VPWR VGND sky130_ef_sc_hd__decap_12
XTAP_TAPCELL_ROW_184_2192 VGND VPWR sky130_fd_sc_hd__tapvpwrvgnd_1
XPHY_EDGE_ROW_119_1_Left_374 VGND VGND VPWR VPWR sky130_fd_sc_hd__decap_3
XTAP_TAPCELL_ROW_180_2045 VGND VPWR sky130_fd_sc_hd__tapvpwrvgnd_1
X_632_ clknet_3_5__leaf_clk dout0\[30\] _040_ VGND VGND VPWR VPWR dout0_q\[30\] sky130_fd_sc_hd__dfrtp_1
XTAP_TAPCELL_ROW_180_2056 VGND VPWR sky130_fd_sc_hd__tapvpwrvgnd_1
XFILLER_217_431 VPWR VGND VPWR VGND sky130_ef_sc_hd__decap_12
XTAP_TAPCELL_ROW_180_2067 VGND VPWR sky130_fd_sc_hd__tapvpwrvgnd_1
XFILLER_40_1368 VPWR VGND VPWR VGND sky130_ef_sc_hd__decap_12
XFILLER_251_209 VGND VGND VPWR VPWR sky130_fd_sc_hd__decap_6
XFILLER_244_261 VPWR VGND VPWR VGND sky130_ef_sc_hd__decap_12
XTAP_TAPCELL_ROW_52_1_1308 VGND VPWR sky130_fd_sc_hd__tapvpwrvgnd_1
XFILLER_205_615 VPWR VGND VPWR VGND sky130_ef_sc_hd__decap_12
X_563_ net664 VGND VGND VPWR VPWR _045_ sky130_fd_sc_hd__inv_2
XFILLER_217_486 VPWR VGND VPWR VGND sky130_ef_sc_hd__decap_12
XPHY_EDGE_ROW_56_1_Left_311 VGND VGND VPWR VPWR sky130_fd_sc_hd__decap_3
XFILLER_189_338 VGND VGND VPWR VPWR sky130_fd_sc_hd__decap_6
XFILLER_232_445 VGND VGND VPWR VPWR sky130_fd_sc_hd__decap_6
XFILLER_38_1220 VGND VGND VPWR VPWR sky130_fd_sc_hd__decap_6
X_494_ net145 net85 net191 VGND VGND VPWR VPWR _253_ sky130_fd_sc_hd__o21ba_1
XFILLER_125_1201 VGND VGND VPWR VPWR sky130_fd_sc_hd__decap_4
XFILLER_213_670 VPWR VGND VPWR VGND sky130_ef_sc_hd__decap_12
XFILLER_241_990 VPWR VGND VPWR VGND sky130_ef_sc_hd__decap_12
XFILLER_198_894 VPWR VGND VPWR VGND sky130_ef_sc_hd__decap_12
XFILLER_73_1177 VPWR VGND VPWR VGND sky130_ef_sc_hd__decap_12
XFILLER_164_1294 VPWR VGND VPWR VGND sky130_ef_sc_hd__decap_12
XFILLER_201_854 VGND VGND VPWR VPWR sky130_fd_sc_hd__decap_6
XFILLER_9_757 VPWR VGND VPWR VGND sky130_ef_sc_hd__decap_12
XFILLER_201_1100 VPWR VGND VPWR VGND sky130_ef_sc_hd__decap_12
XFILLER_8_245 VPWR VGND VPWR VGND sky130_ef_sc_hd__decap_12
XFILLER_199_1346 VPWR VGND VPWR VGND sky130_ef_sc_hd__decap_12
XFILLER_51_1464 VPWR VGND VPWR VGND sky130_ef_sc_hd__decap_12
XFILLER_205_1291 VPWR VGND VPWR VGND sky130_ef_sc_hd__decap_12
XFILLER_201_1155 VGND VGND VPWR VPWR sky130_fd_sc_hd__decap_6
XFILLER_172_249 VPWR VGND VPWR VGND sky130_ef_sc_hd__decap_12
XFILLER_236_1207 VPWR VGND VPWR VGND sky130_ef_sc_hd__decap_12
XFILLER_5_56 VPWR VGND VPWR VGND sky130_ef_sc_hd__decap_12
XFILLER_49_1371 VGND VGND VPWR VPWR sky130_fd_sc_hd__decap_6
XFILLER_84_1251 VPWR VGND VPWR VGND sky130_ef_sc_hd__decap_12
XFILLER_23_1500 VGND VGND VPWR VPWR sky130_fd_sc_hd__decap_6
XFILLER_132_1227 VPWR VGND VPWR VGND sky130_ef_sc_hd__decap_12
XFILLER_255_526 VPWR VGND VPWR VGND sky130_ef_sc_hd__decap_12
XFILLER_227_228 VPWR VGND VPWR VGND sky130_ef_sc_hd__decap_12
XTAP_TAPCELL_ROW_223_3553 VGND VPWR sky130_fd_sc_hd__tapvpwrvgnd_1
XFILLER_212_1262 VGND VGND VPWR VPWR sky130_fd_sc_hd__decap_6
XFILLER_255_559 VGND VGND VPWR VPWR sky130_fd_sc_hd__decap_8
XTAP_TAPCELL_ROW_223_3564 VGND VPWR sky130_fd_sc_hd__tapvpwrvgnd_1
XTAP_TAPCELL_ROW_223_3575 VGND VPWR sky130_fd_sc_hd__tapvpwrvgnd_1
XTAP_TAPCELL_ROW_128_2_5689 VGND VPWR sky130_fd_sc_hd__tapvpwrvgnd_1
XFILLER_247_1303 VPWR VGND VPWR VGND sky130_ef_sc_hd__decap_12
XFILLER_208_464 VPWR VGND VPWR VGND sky130_ef_sc_hd__decap_12
XTAP_TAPCELL_ROW_65_2_5181 VGND VPWR sky130_fd_sc_hd__tapvpwrvgnd_1
XFILLER_223_412 VPWR VGND VPWR VGND sky130_ef_sc_hd__decap_12
XFILLER_251_732 VPWR VGND VPWR VGND sky130_ef_sc_hd__decap_12
XFILLER_235_283 VPWR VGND VPWR VGND sky130_ef_sc_hd__decap_12
XFILLER_247_1358 VPWR VGND VPWR VGND sky130_ef_sc_hd__decap_12
XFILLER_224_968 VPWR VGND VPWR VGND sky130_ef_sc_hd__decap_12
XFILLER_211_56 VPWR VGND VPWR VGND sky130_ef_sc_hd__decap_12
XPHY_EDGE_ROW_40_1_Left_295 VGND VGND VPWR VPWR sky130_fd_sc_hd__decap_3
XFILLER_223_467 VGND VGND VPWR VPWR sky130_fd_sc_hd__decap_6
XFILLER_251_787 VPWR VGND VPWR VGND sky130_ef_sc_hd__decap_12
XFILLER_17_1304 VPWR VGND VPWR VGND sky130_ef_sc_hd__decap_12
XFILLER_189_861 VPWR VGND VPWR VGND sky130_ef_sc_hd__decap_12
XFILLER_206_1011 VPWR VGND VPWR VGND sky130_ef_sc_hd__decap_12
XTAP_TAPCELL_ROW_176_1903 VGND VPWR sky130_fd_sc_hd__tapvpwrvgnd_1
XTAP_TAPCELL_ROW_176_1914 VGND VPWR sky130_fd_sc_hd__tapvpwrvgnd_1
XTAP_TAPCELL_ROW_217_3335 VGND VPWR sky130_fd_sc_hd__tapvpwrvgnd_1
XFILLER_108_1454 VPWR VGND VPWR VGND sky130_ef_sc_hd__decap_12
XTAP_TAPCELL_ROW_176_1925 VGND VPWR sky130_fd_sc_hd__tapvpwrvgnd_1
XTAP_TAPCELL_ROW_217_3346 VGND VPWR sky130_fd_sc_hd__tapvpwrvgnd_1
XTAP_TAPCELL_ROW_217_3357 VGND VPWR sky130_fd_sc_hd__tapvpwrvgnd_1
XFILLER_52_1239 VPWR VGND VPWR VGND sky130_ef_sc_hd__decap_12
XFILLER_17_1359 VPWR VGND VPWR VGND sky130_ef_sc_hd__decap_12
XFILLER_206_1066 VPWR VGND VPWR VGND sky130_ef_sc_hd__decap_12
XTAP_TAPCELL_ROW_217_3368 VGND VPWR sky130_fd_sc_hd__tapvpwrvgnd_1
XFILLER_143_1378 VPWR VGND VPWR VGND sky130_ef_sc_hd__decap_12
XTAP_TAPCELL_ROW_57_2_5118 VGND VPWR sky130_fd_sc_hd__tapvpwrvgnd_1
XFILLER_176_1121 VPWR VGND VPWR VGND sky130_ef_sc_hd__decap_12
XFILLER_171_271 VPWR VGND VPWR VGND sky130_ef_sc_hd__decap_12
XFILLER_176_1176 VGND VGND VPWR VPWR sky130_fd_sc_hd__decap_6
XFILLER_28_1411 VPWR VGND VPWR VGND sky130_ef_sc_hd__decap_12
XFILLER_63_1335 VPWR VGND VPWR VGND sky130_ef_sc_hd__decap_12
XFILLER_217_1162 VPWR VGND VPWR VGND sky130_ef_sc_hd__decap_12
XFILLER_28_1466 VPWR VGND VPWR VGND sky130_ef_sc_hd__decap_12
XFILLER_115_1414 VGND VGND VPWR VPWR sky130_fd_sc_hd__decap_6
XFILLER_154_1485 VPWR VGND VPWR VGND sky130_ef_sc_hd__decap_12
XFILLER_213_1026 VGND VGND VPWR VPWR sky130_fd_sc_hd__decap_6
XFILLER_252_1097 VPWR VGND VPWR VGND sky130_ef_sc_hd__decap_12
XFILLER_218_206 VPWR VGND VPWR VGND sky130_ef_sc_hd__decap_12
XFILLER_150_1349 VGND VGND VPWR VPWR sky130_fd_sc_hd__decap_6
XFILLER_105_68 VGND VGND VPWR VPWR sky130_fd_sc_hd__decap_3
XFILLER_6_1262 VGND VGND VPWR VPWR sky130_fd_sc_hd__decap_6
XTAP_TAPCELL_ROW_2_933 VGND VPWR sky130_fd_sc_hd__tapvpwrvgnd_1
XTAP_TAPCELL_ROW_2_944 VGND VPWR sky130_fd_sc_hd__tapvpwrvgnd_1
XTAP_TAPCELL_ROW_2_955 VGND VPWR sky130_fd_sc_hd__tapvpwrvgnd_1
XFILLER_233_209 VGND VGND VPWR VPWR sky130_fd_sc_hd__decap_6
XFILLER_242_710 VPWR VGND VPWR VGND sky130_ef_sc_hd__decap_12
XFILLER_199_603 VPWR VGND VPWR VGND sky130_ef_sc_hd__decap_12
XFILLER_226_261 VPWR VGND VPWR VGND sky130_ef_sc_hd__decap_12
XFILLER_254_581 VPWR VGND VPWR VGND sky130_ef_sc_hd__decap_12
XFILLER_187_1272 VPWR VGND VPWR VGND sky130_ef_sc_hd__decap_12
XFILLER_96_1177 VGND VGND VPWR VPWR sky130_fd_sc_hd__decap_6
XFILLER_121_56 VPWR VGND VPWR VGND sky130_ef_sc_hd__decap_12
XFILLER_214_445 VGND VGND VPWR VPWR sky130_fd_sc_hd__decap_6
XFILLER_242_765 VPWR VGND VPWR VGND sky130_ef_sc_hd__decap_12
XFILLER_199_658 VPWR VGND VPWR VGND sky130_ef_sc_hd__decap_12
XFILLER_81_27 VPWR VGND VPWR VGND sky130_ef_sc_hd__decap_12
XFILLER_109_1218 VPWR VGND VPWR VGND sky130_ef_sc_hd__decap_12
XFILLER_74_1442 VPWR VGND VPWR VGND sky130_ef_sc_hd__decap_12
XFILLER_230_949 VPWR VGND VPWR VGND sky130_ef_sc_hd__decap_12
XFILLER_197_27 VPWR VGND VPWR VGND sky130_ef_sc_hd__decap_12
XFILLER_223_990 VPWR VGND VPWR VGND sky130_ef_sc_hd__decap_12
XFILLER_70_1306 VGND VGND VPWR VPWR sky130_fd_sc_hd__decap_6
XFILLER_224_1133 VGND VGND VPWR VPWR sky130_fd_sc_hd__decap_6
XFILLER_74_1497 VPWR VGND VPWR VGND sky130_ef_sc_hd__decap_12
XFILLER_161_1445 VPWR VGND VPWR VGND sky130_ef_sc_hd__decap_12
XFILLER_195_842 VPWR VGND VPWR VGND sky130_ef_sc_hd__decap_12
XFILLER_14_65 VGND VGND VPWR VPWR sky130_fd_sc_hd__decap_6
XTAP_TAPCELL_ROW_192_2461 VGND VPWR sky130_fd_sc_hd__tapvpwrvgnd_1
XTAP_TAPCELL_ROW_192_2472 VGND VPWR sky130_fd_sc_hd__tapvpwrvgnd_1
XTAP_TAPCELL_ROW_16_1_1253 VGND VPWR sky130_fd_sc_hd__tapvpwrvgnd_1
XTAP_TAPCELL_ROW_192_2483 VGND VPWR sky130_fd_sc_hd__tapvpwrvgnd_1
XFILLER_196_1508 VGND VGND VPWR VPWR sky130_fd_sc_hd__decap_6
XFILLER_195_897 VGND VGND VPWR VPWR sky130_fd_sc_hd__decap_6
XFILLER_202_1453 VPWR VGND VPWR VGND sky130_ef_sc_hd__decap_12
XFILLER_5_226 VGND VGND VPWR VPWR sky130_fd_sc_hd__decap_6
XFILLER_205_3 VPWR VGND VPWR VGND sky130_ef_sc_hd__decap_12
XFILLER_81_1402 VPWR VGND VPWR VGND sky130_ef_sc_hd__decap_12
XFILLER_155_1249 VPWR VGND VPWR VGND sky130_ef_sc_hd__decap_12
XPHY_EDGE_ROW_85_2_Right_176 VGND VGND VPWR VPWR sky130_fd_sc_hd__decap_3
XTAP_TAPCELL_ROW_186_2254 VGND VPWR sky130_fd_sc_hd__tapvpwrvgnd_1
XTAP_TAPCELL_ROW_186_2265 VGND VPWR sky130_fd_sc_hd__tapvpwrvgnd_1
XTAP_TAPCELL_ROW_186_2276 VGND VPWR sky130_fd_sc_hd__tapvpwrvgnd_1
XFILLER_7_1026 VGND VGND VPWR VPWR sky130_fd_sc_hd__decap_6
XFILLER_81_1457 VGND VGND VPWR VPWR sky130_fd_sc_hd__decap_6
XTAP_TAPCELL_ROW_182_2118 VGND VPWR sky130_fd_sc_hd__tapvpwrvgnd_1
XFILLER_235_1284 VGND VGND VPWR VPWR sky130_fd_sc_hd__decap_6
XTAP_TAPCELL_ROW_182_2129 VGND VPWR sky130_fd_sc_hd__tapvpwrvgnd_1
XTAP_TAPCELL_ROW_114_2_5575 VGND VPWR sky130_fd_sc_hd__tapvpwrvgnd_1
XTAP_TAPCELL_ROW_82_2_5320 VGND VPWR sky130_fd_sc_hd__tapvpwrvgnd_1
XFILLER_209_228 VPWR VGND VPWR VGND sky130_ef_sc_hd__decap_12
XFILLER_252_507 VPWR VGND VPWR VGND sky130_ef_sc_hd__decap_12
XFILLER_188_1047 VGND VGND VPWR VPWR sky130_fd_sc_hd__decap_6
XFILLER_40_1165 VPWR VGND VPWR VGND sky130_ef_sc_hd__decap_12
X_615_ clknet_3_6__leaf_clk dout0\[13\] _023_ VGND VGND VPWR VPWR dout0_q\[13\] sky130_fd_sc_hd__dfrtp_1
XFILLER_205_412 VPWR VGND VPWR VGND sky130_ef_sc_hd__decap_12
XFILLER_166_1312 VPWR VGND VPWR VGND sky130_ef_sc_hd__decap_12
XFILLER_229_1033 VPWR VGND VPWR VGND sky130_ef_sc_hd__decap_12
XFILLER_75_1206 VPWR VGND VPWR VGND sky130_ef_sc_hd__decap_12
XFILLER_217_283 VPWR VGND VPWR VGND sky130_ef_sc_hd__decap_12
XFILLER_233_732 VPWR VGND VPWR VGND sky130_ef_sc_hd__decap_12
XFILLER_206_968 VPWR VGND VPWR VGND sky130_ef_sc_hd__decap_12
X_546_ net669 VGND VGND VPWR VPWR _028_ sky130_fd_sc_hd__inv_2
XFILLER_205_467 VGND VGND VPWR VPWR sky130_fd_sc_hd__decap_6
XFILLER_221_916 VPWR VGND VPWR VGND sky130_ef_sc_hd__decap_12
XFILLER_166_1367 VPWR VGND VPWR VGND sky130_ef_sc_hd__decap_12
XFILLER_229_1088 VPWR VGND VPWR VGND sky130_ef_sc_hd__decap_12
XFILLER_233_787 VPWR VGND VPWR VGND sky130_ef_sc_hd__decap_12
XFILLER_246_1391 VGND VGND VPWR VPWR sky130_fd_sc_hd__decap_6
XTAP_TAPCELL_ROW_43_2_5004 VGND VPWR sky130_fd_sc_hd__tapvpwrvgnd_1
X_477_ net332 net107 net168 VGND VGND VPWR VPWR _244_ sky130_fd_sc_hd__a21oi_1
XFILLER_186_820 VPWR VGND VPWR VGND sky130_ef_sc_hd__decap_12
XFILLER_198_691 VPWR VGND VPWR VGND sky130_ef_sc_hd__decap_12
XFILLER_203_1217 VPWR VGND VPWR VGND sky130_ef_sc_hd__decap_12
XFILLER_186_875 VGND VGND VPWR VPWR sky130_fd_sc_hd__decap_6
XTAP_TAPCELL_ROW_235_3980 VGND VPWR sky130_fd_sc_hd__tapvpwrvgnd_1
XFILLER_199_1143 VPWR VGND VPWR VGND sky130_ef_sc_hd__decap_12
XTAP_TAPCELL_ROW_235_3991 VGND VPWR sky130_fd_sc_hd__tapvpwrvgnd_1
XTAP_TAPCELL_ROW_231_3833 VGND VPWR sky130_fd_sc_hd__tapvpwrvgnd_1
XFILLER_51_1261 VPWR VGND VPWR VGND sky130_ef_sc_hd__decap_12
XFILLER_9_587 VGND VGND VPWR VPWR sky130_fd_sc_hd__fill_1
XTAP_TAPCELL_ROW_231_3844 VGND VPWR sky130_fd_sc_hd__tapvpwrvgnd_1
XFILLER_16_1392 VGND VGND VPWR VPWR sky130_fd_sc_hd__decap_6
XFILLER_200_194 VPWR VGND VPWR VGND sky130_ef_sc_hd__decap_12
XTAP_TAPCELL_ROW_231_3855 VGND VPWR sky130_fd_sc_hd__tapvpwrvgnd_1
XTAP_TAPCELL_ROW_10_2_4745 VGND VPWR sky130_fd_sc_hd__tapvpwrvgnd_1
XFILLER_199_1198 VGND VGND VPWR VPWR sky130_fd_sc_hd__decap_6
XFILLER_86_1313 VPWR VGND VPWR VGND sky130_ef_sc_hd__decap_12
XFILLER_236_1004 VGND VGND VPWR VPWR sky130_fd_sc_hd__decap_6
XFILLER_177_1463 VPWR VGND VPWR VGND sky130_ef_sc_hd__decap_12
XFILLER_86_1368 VPWR VGND VPWR VGND sky130_ef_sc_hd__decap_12
XFILLER_173_1327 VGND VGND VPWR VPWR sky130_fd_sc_hd__decap_6
XFILLER_206_34 VPWR VGND VPWR VGND sky130_ef_sc_hd__decap_12
XTAP_TAPCELL_ROW_229_3762 VGND VPWR sky130_fd_sc_hd__tapvpwrvgnd_1
XTAP_TAPCELL_ROW_229_3773 VGND VPWR sky130_fd_sc_hd__tapvpwrvgnd_1
XTAP_TAPCELL_ROW_225_3615 VGND VPWR sky130_fd_sc_hd__tapvpwrvgnd_1
XFILLER_214_1324 VPWR VGND VPWR VGND sky130_ef_sc_hd__decap_12
XTAP_TAPCELL_ROW_229_3784 VGND VPWR sky130_fd_sc_hd__tapvpwrvgnd_1
XTAP_TAPCELL_ROW_225_3626 VGND VPWR sky130_fd_sc_hd__tapvpwrvgnd_1
XTAP_TAPCELL_ROW_225_3637 VGND VPWR sky130_fd_sc_hd__tapvpwrvgnd_1
XTAP_TAPCELL_ROW_225_3648 VGND VPWR sky130_fd_sc_hd__tapvpwrvgnd_1
XFILLER_206_89 VPWR VGND VPWR VGND sky130_ef_sc_hd__decap_12
XFILLER_214_1379 VPWR VGND VPWR VGND sky130_ef_sc_hd__decap_12
XFILLER_3_1413 VGND VGND VPWR VPWR sky130_fd_sc_hd__decap_6
XFILLER_222_22 VPWR VGND VPWR VGND sky130_ef_sc_hd__decap_12
XFILLER_215_209 VGND VGND VPWR VPWR sky130_fd_sc_hd__decap_6
XFILLER_247_1100 VPWR VGND VPWR VGND sky130_ef_sc_hd__decap_12
XFILLER_243_529 VPWR VGND VPWR VGND sky130_ef_sc_hd__decap_12
XFILLER_224_710 VPWR VGND VPWR VGND sky130_ef_sc_hd__decap_12
XFILLER_208_261 VPWR VGND VPWR VGND sky130_ef_sc_hd__decap_12
XFILLER_97_1464 VPWR VGND VPWR VGND sky130_ef_sc_hd__decap_12
XFILLER_222_77 VPWR VGND VPWR VGND sky130_ef_sc_hd__decap_12
XFILLER_236_581 VPWR VGND VPWR VGND sky130_ef_sc_hd__decap_12
XTAP_TAPCELL_ROW_22_1_1263 VGND VPWR sky130_fd_sc_hd__tapvpwrvgnd_1
XFILLER_184_1434 VGND VGND VPWR VPWR sky130_fd_sc_hd__decap_6
XFILLER_247_1155 VGND VGND VPWR VPWR sky130_fd_sc_hd__decap_6
XFILLER_93_1328 VGND VGND VPWR VPWR sky130_fd_sc_hd__decap_6
XTAP_TAPCELL_ROW_219_3408 VGND VPWR sky130_fd_sc_hd__tapvpwrvgnd_1
XFILLER_224_765 VPWR VGND VPWR VGND sky130_ef_sc_hd__decap_12
XFILLER_110_1399 VPWR VGND VPWR VGND sky130_ef_sc_hd__decap_12
XTAP_TAPCELL_ROW_219_3419 VGND VPWR sky130_fd_sc_hd__tapvpwrvgnd_1
XFILLER_251_584 VPWR VGND VPWR VGND sky130_ef_sc_hd__decap_12
XFILLER_225_1420 VPWR VGND VPWR VGND sky130_ef_sc_hd__decap_12
XFILLER_196_617 VGND VGND VPWR VPWR sky130_fd_sc_hd__decap_6
XFILLER_212_949 VPWR VGND VPWR VGND sky130_ef_sc_hd__decap_12
XFILLER_205_990 VPWR VGND VPWR VGND sky130_ef_sc_hd__decap_12
XFILLER_108_1251 VPWR VGND VPWR VGND sky130_ef_sc_hd__decap_12
XFILLER_177_842 VPWR VGND VPWR VGND sky130_ef_sc_hd__decap_12
XFILLER_225_1475 VPWR VGND VPWR VGND sky130_ef_sc_hd__decap_12
XFILLER_17_1189 VPWR VGND VPWR VGND sky130_ef_sc_hd__decap_12
XFILLER_177_897 VGND VGND VPWR VPWR sky130_fd_sc_hd__decap_6
XFILLER_69_1500 VGND VGND VPWR VPWR sky130_fd_sc_hd__decap_6
XFILLER_178_1238 VPWR VGND VPWR VGND sky130_ef_sc_hd__decap_12
XFILLER_30_1356 VPWR VGND VPWR VGND sky130_ef_sc_hd__decap_12
XFILLER_191_388 VPWR VGND VPWR VGND sky130_ef_sc_hd__decap_12
XTAP_TAPCELL_ROW_87_2_5357 VGND VPWR sky130_fd_sc_hd__tapvpwrvgnd_1
XTAP_TAPCELL_ROW_100_2_5461 VGND VPWR sky130_fd_sc_hd__tapvpwrvgnd_1
XFILLER_116_34 VPWR VGND VPWR VGND sky130_ef_sc_hd__decap_12
XTAP_TAPCELL_ROW_67_2_5200 VGND VPWR sky130_fd_sc_hd__tapvpwrvgnd_1
XFILLER_28_1263 VGND VGND VPWR VPWR sky130_fd_sc_hd__decap_6
XFILLER_8_1324 VPWR VGND VPWR VGND sky130_ef_sc_hd__decap_12
XFILLER_63_1165 VPWR VGND VPWR VGND sky130_ef_sc_hd__decap_12
XFILLER_154_1282 VPWR VGND VPWR VGND sky130_ef_sc_hd__decap_12
XFILLER_246_323 VPWR VGND VPWR VGND sky130_ef_sc_hd__decap_12
XFILLER_8_1379 VPWR VGND VPWR VGND sky130_ef_sc_hd__decap_12
XTAP_TAPCELL_ROW_241_4184 VGND VPWR sky130_fd_sc_hd__tapvpwrvgnd_1
XFILLER_189_1334 VPWR VGND VPWR VGND sky130_ef_sc_hd__decap_12
XTAP_TAPCELL_ROW_241_4195 VGND VPWR sky130_fd_sc_hd__tapvpwrvgnd_1
XFILLER_132_22 VPWR VGND VPWR VGND sky130_ef_sc_hd__decap_12
XTAP_TAPCELL_ROW_34_2_4930 VGND VPWR sky130_fd_sc_hd__tapvpwrvgnd_1
XFILLER_98_1239 VPWR VGND VPWR VGND sky130_ef_sc_hd__decap_12
XFILLER_234_507 VPWR VGND VPWR VGND sky130_ef_sc_hd__decap_12
XFILLER_246_378 VPWR VGND VPWR VGND sky130_ef_sc_hd__decap_12
XFILLER_92_15 VGND VGND VPWR VPWR sky130_fd_sc_hd__decap_6
XFILLER_189_1389 VPWR VGND VPWR VGND sky130_ef_sc_hd__decap_12
XFILLER_199_400 VPWR VGND VPWR VGND sky130_ef_sc_hd__decap_12
XFILLER_215_732 VPWR VGND VPWR VGND sky130_ef_sc_hd__decap_12
X_400_ net591 net587 net565 VGND VGND VPWR VPWR _189_ sky130_fd_sc_hd__a21o_1
XFILLER_242_562 VPWR VGND VPWR VGND sky130_ef_sc_hd__decap_12
XFILLER_163_1507 VGND VGND VPWR VPWR sky130_fd_sc_hd__decap_8
XFILLER_203_916 VPWR VGND VPWR VGND sky130_ef_sc_hd__decap_12
XFILLER_199_455 VPWR VGND VPWR VGND sky130_ef_sc_hd__decap_12
XFILLER_215_787 VPWR VGND VPWR VGND sky130_ef_sc_hd__decap_12
XFILLER_155_3 VPWR VGND VPWR VGND sky130_ef_sc_hd__decap_12
XTAP_TAPCELL_ROW_198_2670 VGND VPWR sky130_fd_sc_hd__tapvpwrvgnd_1
X_331_ net500 _119_ VGND VGND VPWR VPWR _120_ sky130_fd_sc_hd__or2_1
XTAP_TAPCELL_ROW_198_2681 VGND VPWR sky130_fd_sc_hd__tapvpwrvgnd_1
XTAP_TAPCELL_ROW_198_2692 VGND VPWR sky130_fd_sc_hd__tapvpwrvgnd_1
XFILLER_35_1201 VGND VGND VPWR VPWR sky130_fd_sc_hd__decap_4
XFILLER_187_639 VGND VGND VPWR VPWR sky130_fd_sc_hd__decap_6
XTAP_TAPCELL_ROW_194_2534 VGND VPWR sky130_fd_sc_hd__tapvpwrvgnd_1
XFILLER_230_746 VGND VGND VPWR VPWR sky130_fd_sc_hd__decap_6
XFILLER_168_820 VPWR VGND VPWR VGND sky130_ef_sc_hd__decap_12
XTAP_TAPCELL_ROW_194_2545 VGND VPWR sky130_fd_sc_hd__tapvpwrvgnd_1
XTAP_TAPCELL_ROW_194_2556 VGND VPWR sky130_fd_sc_hd__tapvpwrvgnd_1
XFILLER_74_1294 VPWR VGND VPWR VGND sky130_ef_sc_hd__decap_12
XFILLER_161_1242 VGND VGND VPWR VPWR sky130_fd_sc_hd__decap_6
XTAP_TAPCELL_ROW_190_2409 VGND VPWR sky130_fd_sc_hd__tapvpwrvgnd_1
XFILLER_211_971 VPWR VGND VPWR VGND sky130_ef_sc_hd__decap_12
XFILLER_168_875 VGND VGND VPWR VPWR sky130_fd_sc_hd__decap_6
XFILLER_196_1305 VGND VGND VPWR VPWR sky130_fd_sc_hd__decap_6
XFILLER_202_1250 VPWR VGND VPWR VGND sky130_ef_sc_hd__decap_12
XFILLER_182_366 VPWR VGND VPWR VGND sky130_ef_sc_hd__decap_12
XTAP_TAPCELL_ROW_188_2327 VGND VPWR sky130_fd_sc_hd__tapvpwrvgnd_1
XTAP_TAPCELL_ROW_188_2338 VGND VPWR sky130_fd_sc_hd__tapvpwrvgnd_1
XTAP_TAPCELL_ROW_188_2349 VGND VPWR sky130_fd_sc_hd__tapvpwrvgnd_1
XFILLER_237_1346 VPWR VGND VPWR VGND sky130_ef_sc_hd__decap_12
XFILLER_85_1390 VPWR VGND VPWR VGND sky130_ef_sc_hd__decap_12
XPHY_EDGE_ROW_86_2_Right_177 VGND VGND VPWR VPWR sky130_fd_sc_hd__decap_3
XFILLER_42_1227 VPWR VGND VPWR VGND sky130_ef_sc_hd__decap_12
XFILLER_2_46 VPWR VGND VPWR VGND sky130_ef_sc_hd__decap_12
XFILLER_237_345 VPWR VGND VPWR VGND sky130_ef_sc_hd__decap_12
XFILLER_252_304 VPWR VGND VPWR VGND sky130_ef_sc_hd__decap_12
XFILLER_225_529 VPWR VGND VPWR VGND sky130_ef_sc_hd__decap_12
XFILLER_206_710 VPWR VGND VPWR VGND sky130_ef_sc_hd__decap_12
XFILLER_218_581 VPWR VGND VPWR VGND sky130_ef_sc_hd__decap_12
XFILLER_248_1453 VPWR VGND VPWR VGND sky130_ef_sc_hd__decap_12
XFILLER_252_359 VGND VGND VPWR VPWR sky130_fd_sc_hd__decap_6
XFILLER_206_765 VPWR VGND VPWR VGND sky130_ef_sc_hd__decap_12
XFILLER_166_1164 VPWR VGND VPWR VGND sky130_ef_sc_hd__decap_12
XFILLER_221_713 VPWR VGND VPWR VGND sky130_ef_sc_hd__decap_12
XFILLER_178_617 VGND VGND VPWR VPWR sky130_fd_sc_hd__decap_6
XFILLER_233_584 VPWR VGND VPWR VGND sky130_ef_sc_hd__decap_12
X_529_ net666 VGND VGND VPWR VPWR _011_ sky130_fd_sc_hd__inv_2
XPHY_EDGE_ROW_244_Left_499 VGND VGND VPWR VPWR sky130_fd_sc_hd__decap_3
XFILLER_221_768 VGND VGND VPWR VPWR sky130_fd_sc_hd__decap_6
XTAP_TAPCELL_ROW_233_3906 VGND VPWR sky130_fd_sc_hd__tapvpwrvgnd_1
XFILLER_18_1454 VPWR VGND VPWR VGND sky130_ef_sc_hd__decap_12
XFILLER_105_1402 VPWR VGND VPWR VGND sky130_ef_sc_hd__decap_12
XTAP_TAPCELL_ROW_233_3917 VGND VPWR sky130_fd_sc_hd__tapvpwrvgnd_1
XFILLER_203_1014 VPWR VGND VPWR VGND sky130_ef_sc_hd__decap_12
XTAP_TAPCELL_ROW_233_3928 VGND VPWR sky130_fd_sc_hd__tapvpwrvgnd_1
XFILLER_192_108 VPWR VGND VPWR VGND sky130_ef_sc_hd__decap_12
XFILLER_53_1378 VPWR VGND VPWR VGND sky130_ef_sc_hd__decap_12
XFILLER_105_1457 VGND VGND VPWR VPWR sky130_fd_sc_hd__decap_6
XFILLER_140_1337 VPWR VGND VPWR VGND sky130_ef_sc_hd__decap_12
XFILLER_70_3 VPWR VGND VPWR VGND sky130_ef_sc_hd__decap_12
XFILLER_179_1514 VGND VGND VPWR VPWR sky130_fd_sc_hd__fill_1
XFILLER_203_1069 VGND VGND VPWR VPWR sky130_fd_sc_hd__decap_6
XTAP_TAPCELL_ROW_105_2_5498 VGND VPWR sky130_fd_sc_hd__tapvpwrvgnd_1
XTAP_TAPCELL_ROW_73_2_5243 VGND VPWR sky130_fd_sc_hd__tapvpwrvgnd_1
XFILLER_173_388 VPWR VGND VPWR VGND sky130_ef_sc_hd__decap_12
XFILLER_177_1260 VPWR VGND VPWR VGND sky130_ef_sc_hd__decap_12
XFILLER_217_44 VPWR VGND VPWR VGND sky130_ef_sc_hd__decap_12
XFILLER_86_1165 VPWR VGND VPWR VGND sky130_ef_sc_hd__decap_12
XTAP_TAPCELL_ROW_40_2_4984 VGND VPWR sky130_fd_sc_hd__tapvpwrvgnd_1
XFILLER_217_99 VPWR VGND VPWR VGND sky130_ef_sc_hd__decap_12
XFILLER_25_1414 VGND VGND VPWR VPWR sky130_fd_sc_hd__decap_6
XFILLER_214_1121 VPWR VGND VPWR VGND sky130_ef_sc_hd__decap_12
XFILLER_64_1485 VPWR VGND VPWR VGND sky130_ef_sc_hd__decap_12
XFILLER_151_1433 VPWR VGND VPWR VGND sky130_ef_sc_hd__decap_12
XTAP_TAPCELL_ROW_19_2_4810 VGND VPWR sky130_fd_sc_hd__tapvpwrvgnd_1
XFILLER_228_323 VPWR VGND VPWR VGND sky130_ef_sc_hd__decap_12
XFILLER_60_1349 VGND VGND VPWR VPWR sky130_fd_sc_hd__decap_6
XFILLER_214_1176 VGND VGND VPWR VPWR sky130_fd_sc_hd__decap_6
XFILLER_151_1488 VPWR VGND VPWR VGND sky130_ef_sc_hd__decap_12
XFILLER_216_507 VPWR VGND VPWR VGND sky130_ef_sc_hd__decap_12
XFILLER_233_87 VPWR VGND VPWR VGND sky130_ef_sc_hd__decap_12
XFILLER_249_1217 VPWR VGND VPWR VGND sky130_ef_sc_hd__decap_12
XTAP_TAPCELL_ROW_165_1478 VGND VPWR sky130_fd_sc_hd__tapvpwrvgnd_1
XFILLER_228_378 VPWR VGND VPWR VGND sky130_ef_sc_hd__decap_12
XTAP_TAPCELL_ROW_165_1489 VGND VPWR sky130_fd_sc_hd__tapvpwrvgnd_1
XFILLER_243_326 VPWR VGND VPWR VGND sky130_ef_sc_hd__decap_12
XPHY_EDGE_ROW_51_2_Left_553 VGND VGND VPWR VPWR sky130_fd_sc_hd__decap_3
XFILLER_97_1261 VPWR VGND VPWR VGND sky130_ef_sc_hd__decap_12
XFILLER_102_58 VGND VGND VPWR VPWR sky130_fd_sc_hd__decap_6
XFILLER_110_1196 VPWR VGND VPWR VGND sky130_ef_sc_hd__decap_12
XFILLER_197_904 VPWR VGND VPWR VGND sky130_ef_sc_hd__decap_12
XFILLER_224_562 VPWR VGND VPWR VGND sky130_ef_sc_hd__decap_12
XFILLER_252_882 VPWR VGND VPWR VGND sky130_ef_sc_hd__decap_12
XFILLER_62_18 VGND VGND VPWR VPWR sky130_fd_sc_hd__decap_3
XFILLER_19_1218 VPWR VGND VPWR VGND sky130_ef_sc_hd__decap_12
XFILLER_251_381 VGND VGND VPWR VPWR sky130_fd_sc_hd__decap_6
XTAP_TAPCELL_ROW_128_1_1422 VGND VPWR sky130_fd_sc_hd__tapvpwrvgnd_1
XFILLER_169_639 VGND VGND VPWR VPWR sky130_fd_sc_hd__decap_6
XFILLER_212_746 VGND VGND VPWR VPWR sky130_fd_sc_hd__decap_6
XFILLER_197_959 VPWR VGND VPWR VGND sky130_ef_sc_hd__decap_12
XFILLER_71_1445 VPWR VGND VPWR VGND sky130_ef_sc_hd__decap_12
XFILLER_225_1272 VPWR VGND VPWR VGND sky130_ef_sc_hd__decap_12
XFILLER_178_1035 VPWR VGND VPWR VGND sky130_ef_sc_hd__decap_12
XFILLER_191_130 VPWR VGND VPWR VGND sky130_ef_sc_hd__decap_12
XPHY_EDGE_ROW_128_1_Left_383 VGND VGND VPWR VPWR sky130_fd_sc_hd__decap_3
XFILLER_11_44 VPWR VGND VPWR VGND sky130_ef_sc_hd__decap_12
XFILLER_121_1292 VPWR VGND VPWR VGND sky130_ef_sc_hd__decap_12
XFILLER_191_185 VPWR VGND VPWR VGND sky130_ef_sc_hd__decap_12
XFILLER_127_44 VPWR VGND VPWR VGND sky130_ef_sc_hd__decap_12
XFILLER_87_15 VPWR VGND VPWR VGND sky130_ef_sc_hd__decap_12
XFILLER_234_1508 VGND VGND VPWR VPWR sky130_fd_sc_hd__decap_6
XTAP_TAPCELL_ROW_247_4393 VGND VPWR sky130_fd_sc_hd__tapvpwrvgnd_1
XFILLER_65_1249 VPWR VGND VPWR VGND sky130_ef_sc_hd__decap_12
XFILLER_219_1076 VPWR VGND VPWR VGND sky130_ef_sc_hd__decap_12
XPHY_EDGE_ROW_65_1_Left_320 VGND VGND VPWR VPWR sky130_fd_sc_hd__decap_3
XFILLER_152_1208 VPWR VGND VPWR VGND sky130_ef_sc_hd__decap_12
XFILLER_117_1328 VGND VGND VPWR VPWR sky130_fd_sc_hd__decap_6
XTAP_TAPCELL_ROW_243_4246 VGND VPWR sky130_fd_sc_hd__tapvpwrvgnd_1
XTAP_TAPCELL_ROW_243_4257 VGND VPWR sky130_fd_sc_hd__tapvpwrvgnd_1
XFILLER_8_1121 VPWR VGND VPWR VGND sky130_ef_sc_hd__decap_12
XFILLER_156_1399 VPWR VGND VPWR VGND sky130_ef_sc_hd__decap_12
XTAP_TAPCELL_ROW_243_4268 VGND VPWR sky130_fd_sc_hd__tapvpwrvgnd_1
XFILLER_8_1176 VGND VGND VPWR VPWR sky130_fd_sc_hd__decap_6
XTAP_TAPCELL_ROW_161_2_5953 VGND VPWR sky130_fd_sc_hd__tapvpwrvgnd_1
XFILLER_246_120 VPWR VGND VPWR VGND sky130_ef_sc_hd__decap_12
XFILLER_219_345 VPWR VGND VPWR VGND sky130_ef_sc_hd__decap_12
XFILLER_189_1131 VPWR VGND VPWR VGND sky130_ef_sc_hd__decap_12
XTAP_TAPCELL_ROW_9_1182 VGND VPWR sky130_fd_sc_hd__tapvpwrvgnd_1
XTAP_TAPCELL_ROW_129_2_5694 VGND VPWR sky130_fd_sc_hd__tapvpwrvgnd_1
XTAP_TAPCELL_ROW_9_1193 VGND VPWR sky130_fd_sc_hd__tapvpwrvgnd_1
XFILLER_234_304 VPWR VGND VPWR VGND sky130_ef_sc_hd__decap_12
XTAP_TAPCELL_ROW_5_1035 VGND VPWR sky130_fd_sc_hd__tapvpwrvgnd_1
XFILLER_207_529 VPWR VGND VPWR VGND sky130_ef_sc_hd__decap_12
XFILLER_246_175 VPWR VGND VPWR VGND sky130_ef_sc_hd__decap_12
XTAP_TAPCELL_ROW_5_1046 VGND VPWR sky130_fd_sc_hd__tapvpwrvgnd_1
XTAP_TAPCELL_ROW_5_1057 VGND VPWR sky130_fd_sc_hd__tapvpwrvgnd_1
XFILLER_189_1186 VPWR VGND VPWR VGND sky130_ef_sc_hd__decap_12
XTAP_TAPCELL_ROW_5_1068 VGND VPWR sky130_fd_sc_hd__tapvpwrvgnd_1
XFILLER_250_808 VPWR VGND VPWR VGND sky130_ef_sc_hd__decap_12
XFILLER_234_359 VGND VGND VPWR VPWR sky130_fd_sc_hd__decap_6
XTAP_TAPCELL_ROW_196_2607 VGND VPWR sky130_fd_sc_hd__tapvpwrvgnd_1
XTAP_TAPCELL_ROW_196_2618 VGND VPWR sky130_fd_sc_hd__tapvpwrvgnd_1
XTAP_TAPCELL_ROW_237_4039 VGND VPWR sky130_fd_sc_hd__tapvpwrvgnd_1
XTAP_TAPCELL_ROW_196_2629 VGND VPWR sky130_fd_sc_hd__tapvpwrvgnd_1
XFILLER_203_713 VPWR VGND VPWR VGND sky130_ef_sc_hd__decap_12
XFILLER_76_1356 VPWR VGND VPWR VGND sky130_ef_sc_hd__decap_12
XTAP_TAPCELL_ROW_163_1_1474 VGND VPWR sky130_fd_sc_hd__tapvpwrvgnd_1
XFILLER_163_1304 VPWR VGND VPWR VGND sky130_ef_sc_hd__decap_12
XFILLER_199_252 VGND VGND VPWR VPWR sky130_fd_sc_hd__decap_6
XFILLER_128_1435 VGND VGND VPWR VPWR sky130_fd_sc_hd__decap_6
XFILLER_215_584 VPWR VGND VPWR VGND sky130_ef_sc_hd__decap_12
XFILLER_188_937 VPWR VGND VPWR VGND sky130_ef_sc_hd__decap_12
XFILLER_226_1047 VGND VGND VPWR VPWR sky130_fd_sc_hd__decap_6
XFILLER_203_768 VGND VGND VPWR VPWR sky130_fd_sc_hd__decap_6
X_314_ net178 VGND VGND VPWR VPWR _103_ sky130_fd_sc_hd__inv_2
XTAP_TAPCELL_ROW_122_2_5637 VGND VPWR sky130_fd_sc_hd__tapvpwrvgnd_1
XFILLER_163_1359 VPWR VGND VPWR VGND sky130_ef_sc_hd__decap_12
XFILLER_204_1312 VPWR VGND VPWR VGND sky130_ef_sc_hd__decap_12
XFILLER_52_62 VGND VGND VPWR VPWR sky130_fd_sc_hd__fill_2
XTAP_TAPCELL_ROW_58_2_5123 VGND VPWR sky130_fd_sc_hd__tapvpwrvgnd_1
XFILLER_174_108 VPWR VGND VPWR VGND sky130_ef_sc_hd__decap_12
XFILLER_196_992 VPWR VGND VPWR VGND sky130_ef_sc_hd__decap_12
Xinput16 wr_data[15] VGND VGND VPWR VPWR net16 sky130_fd_sc_hd__clkbuf_1
XFILLER_204_1367 VPWR VGND VPWR VGND sky130_ef_sc_hd__decap_12
Xinput27 wr_data[25] VGND VGND VPWR VPWR net27 sky130_fd_sc_hd__clkbuf_1
Xinput38 wr_data[6] VGND VGND VPWR VPWR net38 sky130_fd_sc_hd__clkbuf_1
Xmax_cap508 _101_ VGND VGND VPWR VPWR net508 sky130_fd_sc_hd__clkbuf_1
XFILLER_182_163 VPWR VGND VPWR VGND sky130_ef_sc_hd__decap_12
XTAP_TAPCELL_ROW_25_2_4864 VGND VPWR sky130_fd_sc_hd__tapvpwrvgnd_1
XFILLER_170_347 VPWR VGND VPWR VGND sky130_ef_sc_hd__decap_12
XFILLER_174_1422 VPWR VGND VPWR VGND sky130_ef_sc_hd__decap_12
XFILLER_83_1316 VPWR VGND VPWR VGND sky130_ef_sc_hd__decap_12
XFILLER_237_1143 VPWR VGND VPWR VGND sky130_ef_sc_hd__decap_12
XTAP_TAPCELL_ROW_58_1_1317 VGND VPWR sky130_fd_sc_hd__tapvpwrvgnd_1
XFILLER_174_1477 VGND VGND VPWR VPWR sky130_fd_sc_hd__decap_6
XFILLER_237_1198 VGND VGND VPWR VPWR sky130_fd_sc_hd__decap_6
XFILLER_215_1463 VPWR VGND VPWR VGND sky130_ef_sc_hd__decap_12
XPHY_EDGE_ROW_87_2_Right_178 VGND VGND VPWR VPWR sky130_fd_sc_hd__decap_3
XFILLER_211_1327 VGND VGND VPWR VPWR sky130_fd_sc_hd__decap_6
XFILLER_237_142 VPWR VGND VPWR VGND sky130_ef_sc_hd__decap_12
XFILLER_250_1398 VPWR VGND VPWR VGND sky130_ef_sc_hd__decap_12
XFILLER_252_101 VGND VGND VPWR VPWR sky130_fd_sc_hd__decap_6
XFILLER_168_1226 VPWR VGND VPWR VGND sky130_ef_sc_hd__decap_12
XFILLER_225_326 VPWR VGND VPWR VGND sky130_ef_sc_hd__decap_12
XFILLER_253_646 VPWR VGND VPWR VGND sky130_ef_sc_hd__decap_12
XFILLER_237_197 VPWR VGND VPWR VGND sky130_ef_sc_hd__decap_12
XFILLER_203_68 VPWR VGND VPWR VGND sky130_ef_sc_hd__decap_12
XFILLER_248_1250 VPWR VGND VPWR VGND sky130_ef_sc_hd__decap_12
XFILLER_94_1423 VPWR VGND VPWR VGND sky130_ef_sc_hd__decap_12
XFILLER_179_904 VPWR VGND VPWR VGND sky130_ef_sc_hd__decap_12
XFILLER_206_562 VPWR VGND VPWR VGND sky130_ef_sc_hd__decap_12
XPHY_EDGE_ROW_252_Left_507 VGND VGND VPWR VPWR sky130_fd_sc_hd__decap_3
XFILLER_20_1399 VPWR VGND VPWR VGND sky130_ef_sc_hd__decap_12
XFILLER_234_882 VPWR VGND VPWR VGND sky130_ef_sc_hd__decap_12
XFILLER_221_510 VGND VGND VPWR VPWR sky130_fd_sc_hd__decap_6
XFILLER_94_1478 VGND VGND VPWR VPWR sky130_fd_sc_hd__decap_6
XFILLER_233_381 VGND VGND VPWR VPWR sky130_fd_sc_hd__decap_6
XFILLER_179_959 VPWR VGND VPWR VGND sky130_ef_sc_hd__decap_12
XFILLER_18_1251 VPWR VGND VPWR VGND sky130_ef_sc_hd__decap_12
XFILLER_194_918 VGND VGND VPWR VPWR sky130_fd_sc_hd__decap_6
XFILLER_144_1270 VPWR VGND VPWR VGND sky130_ef_sc_hd__decap_12
XFILLER_222_1434 VGND VGND VPWR VPWR sky130_fd_sc_hd__decap_6
XFILLER_109_1390 VPWR VGND VPWR VGND sky130_ef_sc_hd__decap_12
XFILLER_9_181 VGND VGND VPWR VPWR sky130_fd_sc_hd__decap_8
XFILLER_88_1227 VPWR VGND VPWR VGND sky130_ef_sc_hd__decap_12
XFILLER_173_130 VPWR VGND VPWR VGND sky130_ef_sc_hd__decap_12
XFILLER_228_65 VPWR VGND VPWR VGND sky130_ef_sc_hd__decap_12
XFILLER_179_1377 VPWR VGND VPWR VGND sky130_ef_sc_hd__decap_12
XFILLER_255_1210 VGND VGND VPWR VPWR sky130_fd_sc_hd__decap_8
XFILLER_173_185 VPWR VGND VPWR VGND sky130_ef_sc_hd__decap_12
XTAP_TAPCELL_ROW_93_1_1369 VGND VPWR sky130_fd_sc_hd__tapvpwrvgnd_1
XFILLER_216_1238 VPWR VGND VPWR VGND sky130_ef_sc_hd__decap_12
XTAP_TAPCELL_ROW_146_2_5833 VGND VPWR sky130_fd_sc_hd__tapvpwrvgnd_1
XFILLER_9_1441 VGND VGND VPWR VPWR sky130_fd_sc_hd__decap_8
XTAP_TAPCELL_ROW_115_2_5580 VGND VPWR sky130_fd_sc_hd__tapvpwrvgnd_1
XFILLER_64_1282 VPWR VGND VPWR VGND sky130_ef_sc_hd__decap_12
XFILLER_151_1230 VPWR VGND VPWR VGND sky130_ef_sc_hd__decap_12
XFILLER_228_120 VPWR VGND VPWR VGND sky130_ef_sc_hd__decap_12
XFILLER_5_1327 VGND VGND VPWR VPWR sky130_fd_sc_hd__decap_6
XFILLER_151_1285 VGND VGND VPWR VPWR sky130_fd_sc_hd__decap_6
XFILLER_249_1014 VPWR VGND VPWR VGND sky130_ef_sc_hd__decap_12
XFILLER_216_304 VPWR VGND VPWR VGND sky130_ef_sc_hd__decap_12
XFILLER_244_624 VPWR VGND VPWR VGND sky130_ef_sc_hd__decap_12
XFILLER_228_175 VPWR VGND VPWR VGND sky130_ef_sc_hd__decap_12
XFILLER_99_1378 VPWR VGND VPWR VGND sky130_ef_sc_hd__decap_12
XFILLER_243_123 VGND VGND VPWR VPWR sky130_fd_sc_hd__decap_6
XTAP_TAPCELL_ROW_95_2_5419 VGND VPWR sky130_fd_sc_hd__tapvpwrvgnd_1
XFILLER_113_68 VGND VGND VPWR VPWR sky130_fd_sc_hd__decap_3
XFILLER_186_1348 VGND VGND VPWR VPWR sky130_fd_sc_hd__decap_6
XFILLER_249_1069 VGND VGND VPWR VPWR sky130_fd_sc_hd__decap_6
XFILLER_216_359 VGND VGND VPWR VPWR sky130_fd_sc_hd__decap_6
XFILLER_232_808 VPWR VGND VPWR VGND sky130_ef_sc_hd__decap_12
XFILLER_244_679 VPWR VGND VPWR VGND sky130_ef_sc_hd__decap_12
XFILLER_73_39 VGND VGND VPWR VPWR sky130_fd_sc_hd__decap_4
XTAP_TAPCELL_ROW_203_2850 VGND VPWR sky130_fd_sc_hd__tapvpwrvgnd_1
XTAP_TAPCELL_ROW_64_2_5177 VGND VPWR sky130_fd_sc_hd__tapvpwrvgnd_1
XTAP_TAPCELL_ROW_203_2861 VGND VPWR sky130_fd_sc_hd__tapvpwrvgnd_1
XTAP_TAPCELL_ROW_203_2872 VGND VPWR sky130_fd_sc_hd__tapvpwrvgnd_1
XFILLER_73_1507 VGND VGND VPWR VPWR sky130_fd_sc_hd__decap_8
XTAP_TAPCELL_ROW_107_2_5517 VGND VPWR sky130_fd_sc_hd__tapvpwrvgnd_1
XFILLER_189_39 VGND VGND VPWR VPWR sky130_fd_sc_hd__decap_4
XFILLER_197_701 VPWR VGND VPWR VGND sky130_ef_sc_hd__decap_12
XFILLER_227_1334 VPWR VGND VPWR VGND sky130_ef_sc_hd__decap_12
Xwire95 _229_ VGND VGND VPWR VPWR net95 sky130_fd_sc_hd__clkbuf_1
XTAP_TAPCELL_ROW_255_4673 VGND VPWR sky130_fd_sc_hd__tapvpwrvgnd_1
XTAP_TAPCELL_ROW_255_4684 VGND VPWR sky130_fd_sc_hd__tapvpwrvgnd_1
XTAP_TAPCELL_ROW_255_4695 VGND VPWR sky130_fd_sc_hd__tapvpwrvgnd_1
XTAP_TAPCELL_ROW_251_4526 VGND VPWR sky130_fd_sc_hd__tapvpwrvgnd_1
XFILLER_240_863 VPWR VGND VPWR VGND sky130_ef_sc_hd__decap_12
XPHY_EDGE_ROW_49_2_Right_140 VGND VGND VPWR VPWR sky130_fd_sc_hd__decap_3
XTAP_TAPCELL_ROW_251_4537 VGND VPWR sky130_fd_sc_hd__tapvpwrvgnd_1
XFILLER_197_756 VPWR VGND VPWR VGND sky130_ef_sc_hd__decap_12
XFILLER_227_1389 VPWR VGND VPWR VGND sky130_ef_sc_hd__decap_12
XTAP_TAPCELL_ROW_251_4548 VGND VPWR sky130_fd_sc_hd__tapvpwrvgnd_1
XFILLER_71_1242 VGND VGND VPWR VPWR sky130_fd_sc_hd__decap_6
XFILLER_8_619 VGND VGND VPWR VPWR sky130_fd_sc_hd__decap_4
XFILLER_178_992 VPWR VGND VPWR VGND sky130_ef_sc_hd__decap_12
XFILLER_162_1392 VGND VGND VPWR VPWR sky130_fd_sc_hd__decap_6
XFILLER_165_631 VPWR VGND VPWR VGND sky130_ef_sc_hd__decap_12
XFILLER_193_940 VGND VGND VPWR VPWR sky130_fd_sc_hd__decap_6
XTAP_TAPCELL_ROW_11_2_4750 VGND VPWR sky130_fd_sc_hd__tapvpwrvgnd_1
XFILLER_22_65 VGND VGND VPWR VPWR sky130_fd_sc_hd__decap_3
XFILLER_165_664 VGND VGND VPWR VPWR sky130_fd_sc_hd__decap_8
XFILLER_197_1444 VPWR VGND VPWR VGND sky130_ef_sc_hd__decap_12
XFILLER_118_3 VPWR VGND VPWR VGND sky130_ef_sc_hd__decap_12
XFILLER_138_65 VGND VGND VPWR VPWR sky130_fd_sc_hd__decap_6
XTAP_TAPCELL_ROW_249_4455 VGND VPWR sky130_fd_sc_hd__tapvpwrvgnd_1
XFILLER_3_302 VPWR VGND VPWR VGND sky130_ef_sc_hd__decap_12
XTAP_TAPCELL_ROW_249_4466 VGND VPWR sky130_fd_sc_hd__tapvpwrvgnd_1
XTAP_TAPCELL_ROW_249_4477 VGND VPWR sky130_fd_sc_hd__tapvpwrvgnd_1
XFILLER_197_1499 VGND VGND VPWR VPWR sky130_fd_sc_hd__decap_6
XTAP_TAPCELL_ROW_249_4488 VGND VPWR sky130_fd_sc_hd__tapvpwrvgnd_1
XTAP_TAPCELL_ROW_245_4319 VGND VPWR sky130_fd_sc_hd__tapvpwrvgnd_1
XFILLER_98_58 VGND VGND VPWR VPWR sky130_fd_sc_hd__decap_6
XFILLER_238_1441 VPWR VGND VPWR VGND sky130_ef_sc_hd__decap_12
XFILLER_180_667 VPWR VGND VPWR VGND sky130_ef_sc_hd__decap_12
XFILLER_234_1305 VGND VGND VPWR VPWR sky130_fd_sc_hd__decap_6
XFILLER_238_1496 VPWR VGND VPWR VGND sky130_ef_sc_hd__decap_12
XFILLER_191_1076 VPWR VGND VPWR VGND sky130_ef_sc_hd__decap_12
XFILLER_156_1196 VPWR VGND VPWR VGND sky130_ef_sc_hd__decap_12
XTAP_TAPCELL_ROW_7_1108 VGND VPWR sky130_fd_sc_hd__tapvpwrvgnd_1
XTAP_TAPCELL_ROW_7_1119 VGND VPWR sky130_fd_sc_hd__tapvpwrvgnd_1
XFILLER_219_142 VPWR VGND VPWR VGND sky130_ef_sc_hd__decap_12
XFILLER_130_1325 VPWR VGND VPWR VGND sky130_ef_sc_hd__decap_12
XFILLER_234_101 VGND VGND VPWR VPWR sky130_fd_sc_hd__decap_6
XFILLER_207_326 VPWR VGND VPWR VGND sky130_ef_sc_hd__decap_12
XFILLER_219_197 VPWR VGND VPWR VGND sky130_ef_sc_hd__decap_12
XFILLER_235_646 VPWR VGND VPWR VGND sky130_ef_sc_hd__decap_12
XFILLER_228_1109 VPWR VGND VPWR VGND sky130_ef_sc_hd__decap_12
XFILLER_250_605 VPWR VGND VPWR VGND sky130_ef_sc_hd__decap_12
XFILLER_245_1401 VPWR VGND VPWR VGND sky130_ef_sc_hd__decap_12
XFILLER_216_882 VPWR VGND VPWR VGND sky130_ef_sc_hd__decap_12
XFILLER_203_510 VGND VGND VPWR VPWR sky130_fd_sc_hd__decap_6
XFILLER_215_381 VGND VGND VPWR VPWR sky130_fd_sc_hd__decap_6
XFILLER_231_830 VPWR VGND VPWR VGND sky130_ef_sc_hd__decap_12
XFILLER_245_1456 VGND VGND VPWR VPWR sky130_fd_sc_hd__decap_6
XFILLER_188_734 VPWR VGND VPWR VGND sky130_ef_sc_hd__decap_12
XFILLER_176_918 VGND VGND VPWR VPWR sky130_fd_sc_hd__decap_6
XFILLER_231_885 VPWR VGND VPWR VGND sky130_ef_sc_hd__decap_12
XFILLER_15_1402 VPWR VGND VPWR VGND sky130_ef_sc_hd__decap_12
XFILLER_188_789 VGND VGND VPWR VPWR sky130_fd_sc_hd__decap_6
XFILLER_163_1189 VPWR VGND VPWR VGND sky130_ef_sc_hd__decap_12
XFILLER_8_34 VPWR VGND VPWR VGND sky130_ef_sc_hd__decap_12
XFILLER_141_1421 VPWR VGND VPWR VGND sky130_ef_sc_hd__decap_12
XFILLER_198_1219 VGND VGND VPWR VPWR sky130_fd_sc_hd__decap_6
XFILLER_50_1337 VPWR VGND VPWR VGND sky130_ef_sc_hd__decap_12
XFILLER_204_1164 VPWR VGND VPWR VGND sky130_ef_sc_hd__decap_12
XFILLER_15_1457 VGND VGND VPWR VPWR sky130_fd_sc_hd__decap_6
XFILLER_8_89 VPWR VGND VPWR VGND sky130_ef_sc_hd__decap_12
Xwire550 net44 VGND VGND VPWR VPWR net550 sky130_fd_sc_hd__clkbuf_1
XFILLER_141_1476 VPWR VGND VPWR VGND sky130_ef_sc_hd__decap_12
XFILLER_239_1205 VPWR VGND VPWR VGND sky130_ef_sc_hd__decap_12
XFILLER_7_652 VGND VGND VPWR VPWR sky130_fd_sc_hd__decap_8
XTAP_TAPCELL_ROW_152_2_5876 VGND VPWR sky130_fd_sc_hd__tapvpwrvgnd_1
XFILLER_190_409 VPWR VGND VPWR VGND sky130_ef_sc_hd__decap_12
Xwire572 dout0_q\[16\] VGND VGND VPWR VPWR net572 sky130_fd_sc_hd__clkbuf_1
XFILLER_6_151 VPWR VGND VPWR VGND sky130_ef_sc_hd__decap_12
Xwire583 dout0_q\[6\] VGND VGND VPWR VPWR net583 sky130_fd_sc_hd__clkbuf_1
Xmax_cap338 _136_ VGND VGND VPWR VPWR net338 sky130_fd_sc_hd__clkbuf_1
XTAP_TAPCELL_ROW_88_2_5362 VGND VPWR sky130_fd_sc_hd__tapvpwrvgnd_1
XTAP_TAPCELL_ROW_172_1780 VGND VPWR sky130_fd_sc_hd__tapvpwrvgnd_1
XTAP_TAPCELL_ROW_172_1791 VGND VPWR sky130_fd_sc_hd__tapvpwrvgnd_1
XFILLER_170_144 VGND VGND VPWR VPWR sky130_fd_sc_hd__decap_6
XFILLER_217_1514 VGND VGND VPWR VPWR sky130_fd_sc_hd__fill_1
XFILLER_100_1184 VPWR VGND VPWR VGND sky130_ef_sc_hd__decap_12
XFILLER_171_689 VPWR VGND VPWR VGND sky130_ef_sc_hd__decap_12
XFILLER_33_3 VPWR VGND VPWR VGND sky130_ef_sc_hd__decap_12
XFILLER_250_1140 VPWR VGND VPWR VGND sky130_ef_sc_hd__decap_12
XFILLER_61_1433 VPWR VGND VPWR VGND sky130_ef_sc_hd__decap_12
XFILLER_215_1260 VPWR VGND VPWR VGND sky130_ef_sc_hd__decap_12
XFILLER_214_34 VPWR VGND VPWR VGND sky130_ef_sc_hd__decap_12
XTAP_TAPCELL_ROW_166_1551 VGND VPWR sky130_fd_sc_hd__tapvpwrvgnd_1
XFILLER_250_1195 VPWR VGND VPWR VGND sky130_ef_sc_hd__decap_12
XPHY_EDGE_ROW_88_2_Right_179 VGND VGND VPWR VPWR sky130_fd_sc_hd__decap_3
XTAP_TAPCELL_ROW_166_1562 VGND VPWR sky130_fd_sc_hd__tapvpwrvgnd_1
XFILLER_61_1488 VPWR VGND VPWR VGND sky130_ef_sc_hd__decap_12
XTAP_TAPCELL_ROW_50_2_5063 VGND VPWR sky130_fd_sc_hd__tapvpwrvgnd_1
XTAP_TAPCELL_ROW_166_1573 VGND VPWR sky130_fd_sc_hd__tapvpwrvgnd_1
XFILLER_214_89 VPWR VGND VPWR VGND sky130_ef_sc_hd__decap_12
XFILLER_226_624 VPWR VGND VPWR VGND sky130_ef_sc_hd__decap_12
XTAP_TAPCELL_ROW_49_2_5057 VGND VPWR sky130_fd_sc_hd__tapvpwrvgnd_1
XFILLER_238_495 VPWR VGND VPWR VGND sky130_ef_sc_hd__decap_12
XFILLER_225_123 VGND VGND VPWR VPWR sky130_fd_sc_hd__decap_6
XFILLER_168_1023 VPWR VGND VPWR VGND sky130_ef_sc_hd__decap_12
XFILLER_253_443 VPWR VGND VPWR VGND sky130_ef_sc_hd__decap_12
XFILLER_214_808 VPWR VGND VPWR VGND sky130_ef_sc_hd__decap_12
XFILLER_226_679 VPWR VGND VPWR VGND sky130_ef_sc_hd__decap_12
XFILLER_230_22 VPWR VGND VPWR VGND sky130_ef_sc_hd__decap_12
XFILLER_94_1220 VGND VGND VPWR VPWR sky130_fd_sc_hd__decap_6
XFILLER_241_627 VPWR VGND VPWR VGND sky130_ef_sc_hd__decap_12
XFILLER_168_1078 VPWR VGND VPWR VGND sky130_ef_sc_hd__decap_12
XFILLER_179_701 VPWR VGND VPWR VGND sky130_ef_sc_hd__decap_12
XFILLER_253_498 VPWR VGND VPWR VGND sky130_ef_sc_hd__decap_12
XFILLER_20_1196 VPWR VGND VPWR VGND sky130_ef_sc_hd__decap_12
XFILLER_185_1370 VGND VGND VPWR VPWR sky130_fd_sc_hd__decap_6
XFILLER_230_77 VPWR VGND VPWR VGND sky130_ef_sc_hd__decap_12
XTAP_TAPCELL_ROW_16_2_4787 VGND VPWR sky130_fd_sc_hd__tapvpwrvgnd_1
XFILLER_179_756 VPWR VGND VPWR VGND sky130_ef_sc_hd__decap_12
XFILLER_222_863 VPWR VGND VPWR VGND sky130_ef_sc_hd__decap_12
XFILLER_107_1316 VPWR VGND VPWR VGND sky130_ef_sc_hd__decap_12
XFILLER_175_940 VGND VGND VPWR VPWR sky130_fd_sc_hd__decap_6
XFILLER_179_1174 VPWR VGND VPWR VGND sky130_ef_sc_hd__decap_12
XFILLER_31_1292 VPWR VGND VPWR VGND sky130_ef_sc_hd__decap_12
XFILLER_108_46 VPWR VGND VPWR VGND sky130_ef_sc_hd__decap_12
XFILLER_255_1051 VPWR VGND VPWR VGND sky130_ef_sc_hd__decap_12
XFILLER_255_85 VPWR VGND VPWR VGND sky130_ef_sc_hd__decap_12
XFILLER_118_1423 VPWR VGND VPWR VGND sky130_ef_sc_hd__decap_12
XTAP_TAPCELL_ROW_28_1_1272 VGND VPWR sky130_fd_sc_hd__tapvpwrvgnd_1
XFILLER_0_316 VGND VGND VPWR VPWR sky130_fd_sc_hd__fill_1
XFILLER_255_1084 VGND VGND VPWR VPWR sky130_fd_sc_hd__decap_8
XFILLER_216_1035 VPWR VGND VPWR VGND sky130_ef_sc_hd__decap_12
XFILLER_62_1208 VPWR VGND VPWR VGND sky130_ef_sc_hd__decap_12
XFILLER_27_1328 VGND VGND VPWR VPWR sky130_fd_sc_hd__decap_6
XFILLER_66_1399 VPWR VGND VPWR VGND sky130_ef_sc_hd__decap_12
XFILLER_153_1347 VPWR VGND VPWR VGND sky130_ef_sc_hd__decap_12
XFILLER_248_237 VPWR VGND VPWR VGND sky130_ef_sc_hd__decap_12
XFILLER_118_1478 VGND VGND VPWR VPWR sky130_fd_sc_hd__decap_6
XFILLER_124_34 VPWR VGND VPWR VGND sky130_ef_sc_hd__decap_12
XFILLER_9_1282 VPWR VGND VPWR VGND sky130_ef_sc_hd__decap_12
XTAP_TAPCELL_ROW_116_1_1404 VGND VPWR sky130_fd_sc_hd__tapvpwrvgnd_1
XTAP_TAPCELL_ROW_205_2923 VGND VPWR sky130_fd_sc_hd__tapvpwrvgnd_1
XFILLER_216_101 VGND VGND VPWR VPWR sky130_fd_sc_hd__decap_6
XTAP_TAPCELL_ROW_205_2934 VGND VPWR sky130_fd_sc_hd__tapvpwrvgnd_1
XFILLER_244_421 VPWR VGND VPWR VGND sky130_ef_sc_hd__decap_12
XTAP_TAPCELL_ROW_205_2945 VGND VPWR sky130_fd_sc_hd__tapvpwrvgnd_1
XFILLER_217_646 VPWR VGND VPWR VGND sky130_ef_sc_hd__decap_12
XTAP_TAPCELL_ROW_238_4101 VGND VPWR sky130_fd_sc_hd__tapvpwrvgnd_1
XFILLER_232_605 VPWR VGND VPWR VGND sky130_ef_sc_hd__decap_12
XFILLER_140_22 VPWR VGND VPWR VGND sky130_ef_sc_hd__decap_12
XFILLER_244_476 VPWR VGND VPWR VGND sky130_ef_sc_hd__decap_12
XTAP_TAPCELL_ROW_0_850 VGND VPWR sky130_fd_sc_hd__tapvpwrvgnd_1
XTAP_TAPCELL_ROW_0_861 VGND VPWR sky130_fd_sc_hd__tapvpwrvgnd_1
XTAP_TAPCELL_ROW_0_872 VGND VPWR sky130_fd_sc_hd__tapvpwrvgnd_1
XTAP_TAPCELL_ROW_0_883 VGND VPWR sky130_fd_sc_hd__tapvpwrvgnd_1
XFILLER_73_1304 VPWR VGND VPWR VGND sky130_ef_sc_hd__decap_12
XFILLER_213_830 VPWR VGND VPWR VGND sky130_ef_sc_hd__decap_12
XFILLER_227_1131 VPWR VGND VPWR VGND sky130_ef_sc_hd__decap_12
XFILLER_38_1435 VGND VGND VPWR VPWR sky130_fd_sc_hd__decap_6
XPHY_EDGE_ROW_14_2_Left_516 VGND VGND VPWR VPWR sky130_fd_sc_hd__decap_3
XFILLER_164_1454 VPWR VGND VPWR VGND sky130_ef_sc_hd__decap_12
XFILLER_197_553 VGND VGND VPWR VPWR sky130_fd_sc_hd__decap_6
XFILLER_240_660 VGND VGND VPWR VPWR sky130_fd_sc_hd__decap_6
XFILLER_73_1359 VPWR VGND VPWR VGND sky130_ef_sc_hd__decap_12
XFILLER_213_885 VPWR VGND VPWR VGND sky130_ef_sc_hd__decap_12
XFILLER_227_1186 VPWR VGND VPWR VGND sky130_ef_sc_hd__decap_12
XFILLER_235_3 VPWR VGND VPWR VGND sky130_ef_sc_hd__decap_12
XFILLER_199_1506 VGND VGND VPWR VPWR sky130_fd_sc_hd__decap_8
XTAP_TAPCELL_ROW_137_2_5756 VGND VPWR sky130_fd_sc_hd__tapvpwrvgnd_1
XPHY_EDGE_ROW_139_2_Left_641 VGND VGND VPWR VPWR sky130_fd_sc_hd__decap_3
XFILLER_201_1315 VPWR VGND VPWR VGND sky130_ef_sc_hd__decap_12
XFILLER_172_409 VPWR VGND VPWR VGND sky130_ef_sc_hd__decap_12
XFILLER_197_1241 VGND VGND VPWR VPWR sky130_fd_sc_hd__decap_6
XFILLER_192_280 VPWR VGND VPWR VGND sky130_ef_sc_hd__decap_12
XFILLER_84_1411 VPWR VGND VPWR VGND sky130_ef_sc_hd__decap_12
XFILLER_180_464 VPWR VGND VPWR VGND sky130_ef_sc_hd__decap_12
XFILLER_3_154 VPWR VGND VPWR VGND sky130_ef_sc_hd__decap_12
XFILLER_165_85 VPWR VGND VPWR VGND sky130_ef_sc_hd__decap_12
XFILLER_84_1466 VPWR VGND VPWR VGND sky130_ef_sc_hd__decap_12
XFILLER_238_1293 VPWR VGND VPWR VGND sky130_ef_sc_hd__decap_12
XFILLER_212_1422 VPWR VGND VPWR VGND sky130_ef_sc_hd__decap_12
XFILLER_239_259 VPWR VGND VPWR VGND sky130_ef_sc_hd__decap_12
XFILLER_0_883 VGND VGND VPWR VPWR sky130_fd_sc_hd__decap_8
XTAP_TAPCELL_ROW_151_1_1456 VGND VPWR sky130_fd_sc_hd__tapvpwrvgnd_1
Xhold5 rd_addr\[6\] VGND VGND VPWR VPWR net693 sky130_fd_sc_hd__dlygate4sd3_1
XFILLER_254_218 VPWR VGND VPWR VGND sky130_ef_sc_hd__decap_12
XFILLER_208_624 VPWR VGND VPWR VGND sky130_ef_sc_hd__decap_12
XFILLER_212_1477 VGND VGND VPWR VPWR sky130_fd_sc_hd__decap_6
XFILLER_207_123 VGND VGND VPWR VPWR sky130_fd_sc_hd__decap_6
XTAP_TAPCELL_ROW_33_2_4926 VGND VPWR sky130_fd_sc_hd__tapvpwrvgnd_1
XFILLER_235_443 VPWR VGND VPWR VGND sky130_ef_sc_hd__decap_12
XFILLER_130_1177 VGND VGND VPWR VPWR sky130_fd_sc_hd__decap_6
XFILLER_208_679 VPWR VGND VPWR VGND sky130_ef_sc_hd__decap_12
XFILLER_250_402 VGND VGND VPWR VPWR sky130_fd_sc_hd__decap_6
XTAP_TAPCELL_ROW_221_3481 VGND VPWR sky130_fd_sc_hd__tapvpwrvgnd_1
XTAP_TAPCELL_ROW_221_3492 VGND VPWR sky130_fd_sc_hd__tapvpwrvgnd_1
XFILLER_223_627 VPWR VGND VPWR VGND sky130_ef_sc_hd__decap_12
XFILLER_251_947 VPWR VGND VPWR VGND sky130_ef_sc_hd__decap_12
XFILLER_235_498 VPWR VGND VPWR VGND sky130_ef_sc_hd__decap_12
XFILLER_188_531 VGND VGND VPWR VPWR sky130_fd_sc_hd__decap_6
XFILLER_204_863 VPWR VGND VPWR VGND sky130_ef_sc_hd__decap_12
XFILLER_206_1226 VPWR VGND VPWR VGND sky130_ef_sc_hd__decap_12
XFILLER_200_58 VGND VGND VPWR VPWR sky130_fd_sc_hd__decap_6
XFILLER_231_682 VGND VGND VPWR VPWR sky130_fd_sc_hd__decap_6
XFILLER_54_1270 VPWR VGND VPWR VGND sky130_ef_sc_hd__decap_12
XFILLER_19_1390 VPWR VGND VPWR VGND sky130_ef_sc_hd__decap_12
XTAP_TAPCELL_ROW_174_1831 VGND VPWR sky130_fd_sc_hd__tapvpwrvgnd_1
XTAP_TAPCELL_ROW_174_1842 VGND VPWR sky130_fd_sc_hd__tapvpwrvgnd_1
XTAP_TAPCELL_ROW_174_1853 VGND VPWR sky130_fd_sc_hd__tapvpwrvgnd_1
XTAP_TAPCELL_ROW_215_3274 VGND VPWR sky130_fd_sc_hd__tapvpwrvgnd_1
XFILLER_8_961 VGND VGND VPWR VPWR sky130_fd_sc_hd__decap_6
XFILLER_141_1273 VPWR VGND VPWR VGND sky130_ef_sc_hd__decap_12
XFILLER_190_206 VPWR VGND VPWR VGND sky130_ef_sc_hd__decap_12
XTAP_TAPCELL_ROW_215_3285 VGND VPWR sky130_fd_sc_hd__tapvpwrvgnd_1
XFILLER_239_1002 VPWR VGND VPWR VGND sky130_ef_sc_hd__decap_12
XTAP_TAPCELL_ROW_170_1706 VGND VPWR sky130_fd_sc_hd__tapvpwrvgnd_1
XTAP_TAPCELL_ROW_211_3127 VGND VPWR sky130_fd_sc_hd__tapvpwrvgnd_1
XTAP_TAPCELL_ROW_215_3296 VGND VPWR sky130_fd_sc_hd__tapvpwrvgnd_1
XTAP_TAPCELL_ROW_170_1717 VGND VPWR sky130_fd_sc_hd__tapvpwrvgnd_1
XTAP_TAPCELL_ROW_211_3138 VGND VPWR sky130_fd_sc_hd__tapvpwrvgnd_1
XFILLER_209_56 VPWR VGND VPWR VGND sky130_ef_sc_hd__decap_12
XTAP_TAPCELL_ROW_211_3149 VGND VPWR sky130_fd_sc_hd__tapvpwrvgnd_1
Xwire380 net381 VGND VGND VPWR VPWR net380 sky130_fd_sc_hd__clkbuf_1
Xmax_cap113 net114 VGND VGND VPWR VPWR net113 sky130_fd_sc_hd__clkbuf_1
Xwire391 net392 VGND VGND VPWR VPWR net391 sky130_fd_sc_hd__clkbuf_1
Xmax_cap124 _198_ VGND VGND VPWR VPWR net124 sky130_fd_sc_hd__clkbuf_1
Xmax_cap135 _146_ VGND VGND VPWR VPWR net135 sky130_fd_sc_hd__clkbuf_1
XFILLER_171_431 VPWR VGND VPWR VGND sky130_ef_sc_hd__decap_12
XFILLER_176_1336 VPWR VGND VPWR VGND sky130_ef_sc_hd__decap_12
XFILLER_239_1057 VPWR VGND VPWR VGND sky130_ef_sc_hd__decap_12
XPHY_EDGE_ROW_60_2_Left_562 VGND VGND VPWR VPWR sky130_fd_sc_hd__decap_3
XPHY_EDGE_ROW_194_Left_449 VGND VGND VPWR VPWR sky130_fd_sc_hd__decap_3
XFILLER_171_486 VPWR VGND VPWR VGND sky130_ef_sc_hd__decap_12
XFILLER_225_44 VPWR VGND VPWR VGND sky130_ef_sc_hd__decap_12
XTAP_TAPCELL_ROW_168_1624 VGND VPWR sky130_fd_sc_hd__tapvpwrvgnd_1
XTAP_TAPCELL_ROW_168_1635 VGND VPWR sky130_fd_sc_hd__tapvpwrvgnd_1
XTAP_TAPCELL_ROW_209_3056 VGND VPWR sky130_fd_sc_hd__tapvpwrvgnd_1
XFILLER_217_1377 VPWR VGND VPWR VGND sky130_ef_sc_hd__decap_12
XFILLER_150_1509 VGND VGND VPWR VPWR sky130_fd_sc_hd__decap_6
XTAP_TAPCELL_ROW_168_1646 VGND VPWR sky130_fd_sc_hd__tapvpwrvgnd_1
XTAP_TAPCELL_ROW_209_3067 VGND VPWR sky130_fd_sc_hd__tapvpwrvgnd_1
XTAP_TAPCELL_ROW_209_3078 VGND VPWR sky130_fd_sc_hd__tapvpwrvgnd_1
XFILLER_61_1230 VPWR VGND VPWR VGND sky130_ef_sc_hd__decap_12
XFILLER_6_1422 VPWR VGND VPWR VGND sky130_ef_sc_hd__decap_12
XFILLER_225_99 VPWR VGND VPWR VGND sky130_ef_sc_hd__decap_12
XFILLER_152_1380 VPWR VGND VPWR VGND sky130_ef_sc_hd__decap_12
XFILLER_61_1285 VGND VGND VPWR VPWR sky130_fd_sc_hd__decap_6
XPHY_EDGE_ROW_12_1_Left_267 VGND VGND VPWR VPWR sky130_fd_sc_hd__decap_3
XFILLER_6_1477 VGND VGND VPWR VPWR sky130_fd_sc_hd__decap_6
XFILLER_226_421 VPWR VGND VPWR VGND sky130_ef_sc_hd__decap_12
XFILLER_187_1432 VPWR VGND VPWR VGND sky130_ef_sc_hd__decap_12
XFILLER_238_292 VPWR VGND VPWR VGND sky130_ef_sc_hd__decap_12
XFILLER_253_240 VPWR VGND VPWR VGND sky130_ef_sc_hd__decap_12
XFILLER_96_1337 VPWR VGND VPWR VGND sky130_ef_sc_hd__decap_12
XFILLER_214_605 VPWR VGND VPWR VGND sky130_ef_sc_hd__decap_12
XFILLER_242_925 VPWR VGND VPWR VGND sky130_ef_sc_hd__decap_12
XFILLER_199_818 VPWR VGND VPWR VGND sky130_ef_sc_hd__decap_12
XFILLER_226_476 VPWR VGND VPWR VGND sky130_ef_sc_hd__decap_12
XFILLER_254_796 VPWR VGND VPWR VGND sky130_ef_sc_hd__decap_12
XFILLER_241_87 VPWR VGND VPWR VGND sky130_ef_sc_hd__decap_12
XFILLER_0_1021 VGND VGND VPWR VPWR sky130_fd_sc_hd__decap_8
XPHY_EDGE_ROW_137_1_Left_392 VGND VGND VPWR VPWR sky130_fd_sc_hd__decap_3
XFILLER_187_1487 VPWR VGND VPWR VGND sky130_ef_sc_hd__decap_12
XFILLER_241_424 VGND VGND VPWR VPWR sky130_fd_sc_hd__decap_6
XFILLER_253_295 VGND VGND VPWR VPWR sky130_fd_sc_hd__decap_6
XTAP_TAPCELL_ROW_79_2_5296 VGND VPWR sky130_fd_sc_hd__tapvpwrvgnd_1
XTAP_TAPCELL_ROW_123_2_5642 VGND VPWR sky130_fd_sc_hd__tapvpwrvgnd_1
XFILLER_228_1484 VPWR VGND VPWR VGND sky130_ef_sc_hd__decap_12
XFILLER_179_553 VGND VGND VPWR VPWR sky130_fd_sc_hd__decap_6
XFILLER_222_660 VGND VGND VPWR VPWR sky130_fd_sc_hd__decap_6
XFILLER_250_980 VPWR VGND VPWR VGND sky130_ef_sc_hd__decap_12
XFILLER_110_58 VGND VGND VPWR VPWR sky130_fd_sc_hd__decap_6
XFILLER_146_1184 VPWR VGND VPWR VGND sky130_ef_sc_hd__decap_12
XFILLER_224_1348 VGND VGND VPWR VPWR sky130_fd_sc_hd__decap_6
XFILLER_72_1392 VGND VGND VPWR VPWR sky130_fd_sc_hd__decap_6
XFILLER_120_1313 VPWR VGND VPWR VGND sky130_ef_sc_hd__decap_12
XTAP_TAPCELL_ROW_72_2_5239 VGND VPWR sky130_fd_sc_hd__tapvpwrvgnd_1
XFILLER_181_228 VPWR VGND VPWR VGND sky130_ef_sc_hd__decap_12
XFILLER_119_56 VPWR VGND VPWR VGND sky130_ef_sc_hd__decap_12
XFILLER_120_1368 VPWR VGND VPWR VGND sky130_ef_sc_hd__decap_12
XFILLER_174_280 VPWR VGND VPWR VGND sky130_ef_sc_hd__decap_12
XFILLER_79_27 VPWR VGND VPWR VGND sky130_ef_sc_hd__decap_12
XFILLER_118_1220 VGND VGND VPWR VPWR sky130_fd_sc_hd__decap_6
XFILLER_235_1444 VPWR VGND VPWR VGND sky130_ef_sc_hd__decap_12
XFILLER_135_44 VPWR VGND VPWR VGND sky130_ef_sc_hd__decap_12
XFILLER_66_1196 VPWR VGND VPWR VGND sky130_ef_sc_hd__decap_12
XFILLER_95_15 VPWR VGND VPWR VGND sky130_ef_sc_hd__decap_12
XFILLER_235_1499 VGND VGND VPWR VPWR sky130_fd_sc_hd__decap_6
XFILLER_153_1177 VPWR VGND VPWR VGND sky130_ef_sc_hd__decap_12
XTAP_TAPCELL_ROW_18_2_4806 VGND VPWR sky130_fd_sc_hd__tapvpwrvgnd_1
XTAP_TAPCELL_ROW_184_2182 VGND VPWR sky130_fd_sc_hd__tapvpwrvgnd_1
XFILLER_188_1207 VPWR VGND VPWR VGND sky130_ef_sc_hd__decap_12
XFILLER_236_218 VPWR VGND VPWR VGND sky130_ef_sc_hd__decap_12
XTAP_TAPCELL_ROW_184_2193 VGND VPWR sky130_fd_sc_hd__tapvpwrvgnd_1
XFILLER_40_1325 VPWR VGND VPWR VGND sky130_ef_sc_hd__decap_12
XFILLER_28_42 VGND VGND VPWR VPWR sky130_fd_sc_hd__fill_2
XFILLER_185_3 VPWR VGND VPWR VGND sky130_ef_sc_hd__decap_12
XTAP_TAPCELL_ROW_180_2046 VGND VPWR sky130_fd_sc_hd__tapvpwrvgnd_1
X_631_ clknet_3_5__leaf_clk dout0\[29\] _039_ VGND VGND VPWR VPWR dout0_q\[29\] sky130_fd_sc_hd__dfrtp_1
XFILLER_131_1464 VPWR VGND VPWR VGND sky130_ef_sc_hd__decap_12
XTAP_TAPCELL_ROW_180_2057 VGND VPWR sky130_fd_sc_hd__tapvpwrvgnd_1
XTAP_TAPCELL_ROW_180_2068 VGND VPWR sky130_fd_sc_hd__tapvpwrvgnd_1
XFILLER_217_443 VPWR VGND VPWR VGND sky130_ef_sc_hd__decap_12
X_562_ net664 VGND VGND VPWR VPWR _044_ sky130_fd_sc_hd__inv_2
XFILLER_232_402 VGND VGND VPWR VPWR sky130_fd_sc_hd__decap_6
XFILLER_244_273 VGND VGND VPWR VPWR sky130_fd_sc_hd__decap_6
XFILLER_205_627 VPWR VGND VPWR VGND sky130_ef_sc_hd__decap_12
XFILLER_217_498 VPWR VGND VPWR VGND sky130_ef_sc_hd__decap_12
XFILLER_229_1248 VPWR VGND VPWR VGND sky130_ef_sc_hd__decap_12
XFILLER_233_947 VPWR VGND VPWR VGND sky130_ef_sc_hd__decap_12
X_493_ net97 net142 net189 VGND VGND VPWR VPWR _252_ sky130_fd_sc_hd__a21oi_1
XFILLER_77_1292 VPWR VGND VPWR VGND sky130_ef_sc_hd__decap_12
XFILLER_198_851 VPWR VGND VPWR VGND sky130_ef_sc_hd__decap_12
XFILLER_129_1371 VGND VGND VPWR VPWR sky130_fd_sc_hd__decap_6
XFILLER_164_1251 VPWR VGND VPWR VGND sky130_ef_sc_hd__decap_12
XFILLER_201_811 VGND VGND VPWR VPWR sky130_fd_sc_hd__decap_6
XFILLER_213_682 VGND VGND VPWR VPWR sky130_fd_sc_hd__decap_6
XFILLER_199_1303 VPWR VGND VPWR VGND sky130_ef_sc_hd__decap_12
XFILLER_9_736 VPWR VGND VPWR VGND sky130_ef_sc_hd__decap_12
XFILLER_8_202 VGND VGND VPWR VPWR sky130_fd_sc_hd__fill_1
XFILLER_73_1189 VPWR VGND VPWR VGND sky130_ef_sc_hd__decap_12
XFILLER_51_1421 VPWR VGND VPWR VGND sky130_ef_sc_hd__decap_12
XFILLER_103_1500 VGND VGND VPWR VPWR sky130_fd_sc_hd__decap_6
XFILLER_9_769 VGND VGND VPWR VPWR sky130_fd_sc_hd__decap_8
XFILLER_201_1112 VGND VGND VPWR VPWR sky130_fd_sc_hd__decap_6
XFILLER_199_1358 VPWR VGND VPWR VGND sky130_ef_sc_hd__decap_12
XFILLER_240_1183 VPWR VGND VPWR VGND sky130_ef_sc_hd__decap_12
XFILLER_51_1476 VPWR VGND VPWR VGND sky130_ef_sc_hd__decap_12
XFILLER_8_268 VGND VGND VPWR VPWR sky130_fd_sc_hd__fill_2
XFILLER_172_206 VPWR VGND VPWR VGND sky130_ef_sc_hd__decap_12
XFILLER_236_1219 VGND VGND VPWR VPWR sky130_fd_sc_hd__decap_6
XFILLER_180_261 VPWR VGND VPWR VGND sky130_ef_sc_hd__decap_12
XFILLER_5_68 VPWR VGND VPWR VGND sky130_ef_sc_hd__decap_12
XFILLER_10_1184 VPWR VGND VPWR VGND sky130_ef_sc_hd__decap_12
XFILLER_84_1263 VGND VGND VPWR VPWR sky130_fd_sc_hd__decap_6
XFILLER_238_1090 VGND VGND VPWR VPWR sky130_fd_sc_hd__decap_6
XFILLER_255_505 VPWR VGND VPWR VGND sky130_ef_sc_hd__decap_12
XFILLER_132_1239 VPWR VGND VPWR VGND sky130_ef_sc_hd__decap_12
XTAP_TAPCELL_ROW_227_3690 VGND VPWR sky130_fd_sc_hd__tapvpwrvgnd_1
XTAP_TAPCELL_ROW_160_2_5938 VGND VPWR sky130_fd_sc_hd__tapvpwrvgnd_1
XFILLER_255_538 VGND VGND VPWR VPWR sky130_fd_sc_hd__decap_8
XTAP_TAPCELL_ROW_223_3554 VGND VPWR sky130_fd_sc_hd__tapvpwrvgnd_1
XFILLER_208_421 VPWR VGND VPWR VGND sky130_ef_sc_hd__decap_12
XTAP_TAPCELL_ROW_223_3565 VGND VPWR sky130_fd_sc_hd__tapvpwrvgnd_1
XTAP_TAPCELL_ROW_223_3576 VGND VPWR sky130_fd_sc_hd__tapvpwrvgnd_1
XFILLER_235_240 VPWR VGND VPWR VGND sky130_ef_sc_hd__decap_12
XFILLER_247_1315 VPWR VGND VPWR VGND sky130_ef_sc_hd__decap_12
XTAP_TAPCELL_ROW_65_2_5182 VGND VPWR sky130_fd_sc_hd__tapvpwrvgnd_1
XFILLER_208_476 VPWR VGND VPWR VGND sky130_ef_sc_hd__decap_12
XFILLER_224_925 VPWR VGND VPWR VGND sky130_ef_sc_hd__decap_12
XFILLER_169_1162 VPWR VGND VPWR VGND sky130_ef_sc_hd__decap_12
XFILLER_236_796 VPWR VGND VPWR VGND sky130_ef_sc_hd__decap_12
XPHY_EDGE_ROW_70_1_Right_726 VGND VGND VPWR VPWR sky130_fd_sc_hd__decap_3
XFILLER_223_424 VGND VGND VPWR VPWR sky130_fd_sc_hd__decap_6
XTAP_TAPCELL_ROW_108_2_5522 VGND VPWR sky130_fd_sc_hd__tapvpwrvgnd_1
XFILLER_251_744 VPWR VGND VPWR VGND sky130_ef_sc_hd__decap_12
XFILLER_235_295 VGND VGND VPWR VPWR sky130_fd_sc_hd__decap_6
XFILLER_91_1201 VGND VGND VPWR VPWR sky130_fd_sc_hd__decap_4
XFILLER_211_68 VPWR VGND VPWR VGND sky130_ef_sc_hd__decap_12
XFILLER_108_1411 VPWR VGND VPWR VGND sky130_ef_sc_hd__decap_12
XFILLER_204_660 VGND VGND VPWR VPWR sky130_fd_sc_hd__decap_6
XFILLER_251_799 VPWR VGND VPWR VGND sky130_ef_sc_hd__decap_12
XFILLER_232_980 VPWR VGND VPWR VGND sky130_ef_sc_hd__decap_12
XFILLER_17_1316 VPWR VGND VPWR VGND sky130_ef_sc_hd__decap_12
XTAP_TAPCELL_ROW_176_1904 VGND VPWR sky130_fd_sc_hd__tapvpwrvgnd_1
XFILLER_189_873 VPWR VGND VPWR VGND sky130_ef_sc_hd__decap_12
XFILLER_206_1023 VPWR VGND VPWR VGND sky130_ef_sc_hd__decap_12
XTAP_TAPCELL_ROW_217_3336 VGND VPWR sky130_fd_sc_hd__tapvpwrvgnd_1
XTAP_TAPCELL_ROW_176_1915 VGND VPWR sky130_fd_sc_hd__tapvpwrvgnd_1
XFILLER_143_1335 VPWR VGND VPWR VGND sky130_ef_sc_hd__decap_12
XTAP_TAPCELL_ROW_176_1926 VGND VPWR sky130_fd_sc_hd__tapvpwrvgnd_1
XTAP_TAPCELL_ROW_217_3347 VGND VPWR sky130_fd_sc_hd__tapvpwrvgnd_1
XFILLER_108_1466 VPWR VGND VPWR VGND sky130_ef_sc_hd__decap_12
XTAP_TAPCELL_ROW_217_3358 VGND VPWR sky130_fd_sc_hd__tapvpwrvgnd_1
XFILLER_206_1078 VPWR VGND VPWR VGND sky130_ef_sc_hd__decap_12
XTAP_TAPCELL_ROW_57_2_5119 VGND VPWR sky130_fd_sc_hd__tapvpwrvgnd_1
XFILLER_223_1370 VGND VGND VPWR VPWR sky130_fd_sc_hd__decap_6
XFILLER_176_1133 VGND VGND VPWR VPWR sky130_fd_sc_hd__decap_6
XFILLER_236_65 VPWR VGND VPWR VGND sky130_ef_sc_hd__decap_12
XFILLER_171_283 VPWR VGND VPWR VGND sky130_ef_sc_hd__decap_12
XFILLER_28_1423 VPWR VGND VPWR VGND sky130_ef_sc_hd__decap_12
XFILLER_154_1442 VPWR VGND VPWR VGND sky130_ef_sc_hd__decap_12
XFILLER_252_1054 VPWR VGND VPWR VGND sky130_ef_sc_hd__decap_12
XFILLER_63_1347 VPWR VGND VPWR VGND sky130_ef_sc_hd__decap_12
XFILLER_217_1174 VPWR VGND VPWR VGND sky130_ef_sc_hd__decap_12
XFILLER_28_1478 VGND VGND VPWR VPWR sky130_fd_sc_hd__decap_6
XFILLER_150_1306 VGND VGND VPWR VPWR sky130_fd_sc_hd__decap_6
XFILLER_154_1497 VPWR VGND VPWR VGND sky130_ef_sc_hd__decap_12
XFILLER_218_218 VPWR VGND VPWR VGND sky130_ef_sc_hd__decap_12
XFILLER_246_538 VPWR VGND VPWR VGND sky130_ef_sc_hd__decap_12
XTAP_TAPCELL_ROW_2_934 VGND VPWR sky130_fd_sc_hd__tapvpwrvgnd_1
XTAP_TAPCELL_ROW_2_945 VGND VPWR sky130_fd_sc_hd__tapvpwrvgnd_1
XTAP_TAPCELL_ROW_2_956 VGND VPWR sky130_fd_sc_hd__tapvpwrvgnd_1
XFILLER_214_402 VGND VGND VPWR VPWR sky130_fd_sc_hd__decap_6
XFILLER_242_722 VPWR VGND VPWR VGND sky130_ef_sc_hd__decap_12
XFILLER_199_615 VPWR VGND VPWR VGND sky130_ef_sc_hd__decap_12
XFILLER_215_947 VPWR VGND VPWR VGND sky130_ef_sc_hd__decap_12
XFILLER_226_273 VGND VGND VPWR VPWR sky130_fd_sc_hd__decap_6
XFILLER_254_593 VPWR VGND VPWR VGND sky130_ef_sc_hd__decap_12
XFILLER_187_1284 VGND VGND VPWR VPWR sky130_fd_sc_hd__decap_6
XFILLER_230_906 VPWR VGND VPWR VGND sky130_ef_sc_hd__decap_12
XFILLER_121_68 VGND VGND VPWR VPWR sky130_fd_sc_hd__decap_3
XFILLER_242_777 VPWR VGND VPWR VGND sky130_ef_sc_hd__decap_12
XFILLER_81_39 VGND VGND VPWR VPWR sky130_fd_sc_hd__decap_4
XFILLER_74_1454 VPWR VGND VPWR VGND sky130_ef_sc_hd__decap_12
XFILLER_161_1402 VPWR VGND VPWR VGND sky130_ef_sc_hd__decap_12
XFILLER_228_1281 VPWR VGND VPWR VGND sky130_ef_sc_hd__decap_12
XFILLER_14_22 VPWR VGND VPWR VGND sky130_ef_sc_hd__decap_12
XTAP_TAPCELL_ROW_99_1_1378 VGND VPWR sky130_fd_sc_hd__tapvpwrvgnd_1
XFILLER_197_39 VGND VGND VPWR VPWR sky130_fd_sc_hd__decap_4
XFILLER_161_1457 VGND VGND VPWR VPWR sky130_fd_sc_hd__decap_6
XFILLER_195_854 VGND VGND VPWR VPWR sky130_fd_sc_hd__decap_6
XTAP_TAPCELL_ROW_192_2462 VGND VPWR sky130_fd_sc_hd__tapvpwrvgnd_1
XFILLER_202_1410 VPWR VGND VPWR VGND sky130_ef_sc_hd__decap_12
XTAP_TAPCELL_ROW_16_1_1254 VGND VPWR sky130_fd_sc_hd__tapvpwrvgnd_1
XTAP_TAPCELL_ROW_192_2473 VGND VPWR sky130_fd_sc_hd__tapvpwrvgnd_1
XTAP_TAPCELL_ROW_192_2484 VGND VPWR sky130_fd_sc_hd__tapvpwrvgnd_1
XFILLER_6_728 VGND VGND VPWR VPWR sky130_fd_sc_hd__decap_4
XFILLER_202_1465 VPWR VGND VPWR VGND sky130_ef_sc_hd__decap_12
XFILLER_120_1165 VPWR VGND VPWR VGND sky130_ef_sc_hd__decap_12
XFILLER_198_1391 VGND VGND VPWR VPWR sky130_fd_sc_hd__decap_6
XFILLER_237_1506 VGND VGND VPWR VPWR sky130_fd_sc_hd__decap_8
XFILLER_30_65 VGND VGND VPWR VPWR sky130_fd_sc_hd__fill_2
XFILLER_100_3 VPWR VGND VPWR VGND sky130_ef_sc_hd__decap_12
XFILLER_155_1206 VPWR VGND VPWR VGND sky130_ef_sc_hd__decap_12
XFILLER_190_581 VPWR VGND VPWR VGND sky130_ef_sc_hd__decap_12
XFILLER_146_65 VGND VGND VPWR VPWR sky130_fd_sc_hd__decap_6
XFILLER_81_1414 VGND VGND VPWR VPWR sky130_fd_sc_hd__decap_6
XFILLER_235_1241 VGND VGND VPWR VPWR sky130_fd_sc_hd__decap_6
XTAP_TAPCELL_ROW_186_2255 VGND VPWR sky130_fd_sc_hd__tapvpwrvgnd_1
XTAP_TAPCELL_ROW_186_2266 VGND VPWR sky130_fd_sc_hd__tapvpwrvgnd_1
XTAP_TAPCELL_ROW_145_2_5818 VGND VPWR sky130_fd_sc_hd__tapvpwrvgnd_1
XTAP_TAPCELL_ROW_186_2277 VGND VPWR sky130_fd_sc_hd__tapvpwrvgnd_1
XTAP_TAPCELL_ROW_182_2119 VGND VPWR sky130_fd_sc_hd__tapvpwrvgnd_1
XTAP_TAPCELL_ROW_114_2_5576 VGND VPWR sky130_fd_sc_hd__tapvpwrvgnd_1
XTAP_TAPCELL_ROW_82_2_5321 VGND VPWR sky130_fd_sc_hd__tapvpwrvgnd_1
XFILLER_188_1004 VGND VGND VPWR VPWR sky130_fd_sc_hd__decap_6
XFILLER_131_1261 VPWR VGND VPWR VGND sky130_ef_sc_hd__decap_12
XFILLER_217_240 VPWR VGND VPWR VGND sky130_ef_sc_hd__decap_12
XFILLER_252_519 VPWR VGND VPWR VGND sky130_ef_sc_hd__decap_12
XFILLER_245_560 VPWR VGND VPWR VGND sky130_ef_sc_hd__decap_12
XFILLER_40_1177 VGND VGND VPWR VPWR sky130_fd_sc_hd__decap_6
X_614_ clknet_3_6__leaf_clk dout0\[12\] _022_ VGND VGND VPWR VPWR dout0_q\[12\] sky130_fd_sc_hd__dfrtp_1
XFILLER_206_925 VPWR VGND VPWR VGND sky130_ef_sc_hd__decap_12
XFILLER_218_796 VPWR VGND VPWR VGND sky130_ef_sc_hd__decap_12
XFILLER_166_1324 VPWR VGND VPWR VGND sky130_ef_sc_hd__decap_12
XFILLER_205_424 VGND VGND VPWR VPWR sky130_fd_sc_hd__decap_6
XFILLER_75_1218 VPWR VGND VPWR VGND sky130_ef_sc_hd__decap_12
XFILLER_229_1045 VPWR VGND VPWR VGND sky130_ef_sc_hd__decap_12
XFILLER_233_744 VPWR VGND VPWR VGND sky130_ef_sc_hd__decap_12
XFILLER_217_295 VGND VGND VPWR VPWR sky130_fd_sc_hd__decap_6
X_545_ net669 VGND VGND VPWR VPWR _027_ sky130_fd_sc_hd__inv_2
XFILLER_166_1379 VPWR VGND VPWR VGND sky130_ef_sc_hd__decap_12
XFILLER_221_928 VPWR VGND VPWR VGND sky130_ef_sc_hd__decap_12
XFILLER_233_799 VPWR VGND VPWR VGND sky130_ef_sc_hd__decap_12
XFILLER_214_980 VPWR VGND VPWR VGND sky130_ef_sc_hd__decap_12
X_476_ net156 net115 VGND VGND VPWR VPWR acc_core.adder.cla_blocks\[2\].block.sum\[0\]
+ sky130_fd_sc_hd__xor2_1
XTAP_TAPCELL_ROW_43_2_5005 VGND VPWR sky130_fd_sc_hd__tapvpwrvgnd_1
XFILLER_186_832 VGND VGND VPWR VPWR sky130_fd_sc_hd__decap_6
XPHY_EDGE_ROW_207_Right_52 VGND VGND VPWR VPWR sky130_fd_sc_hd__decap_3
XFILLER_199_1100 VPWR VGND VPWR VGND sky130_ef_sc_hd__decap_12
XFILLER_203_1229 VPWR VGND VPWR VGND sky130_ef_sc_hd__decap_12
XTAP_TAPCELL_ROW_235_3970 VGND VPWR sky130_fd_sc_hd__tapvpwrvgnd_1
XFILLER_200_151 VPWR VGND VPWR VGND sky130_ef_sc_hd__decap_12
XTAP_TAPCELL_ROW_235_3981 VGND VPWR sky130_fd_sc_hd__tapvpwrvgnd_1
XTAP_TAPCELL_ROW_235_3992 VGND VPWR sky130_fd_sc_hd__tapvpwrvgnd_1
XTAP_TAPCELL_ROW_231_3834 VGND VPWR sky130_fd_sc_hd__tapvpwrvgnd_1
XFILLER_199_1155 VGND VGND VPWR VPWR sky130_fd_sc_hd__decap_6
XTAP_TAPCELL_ROW_231_3845 VGND VPWR sky130_fd_sc_hd__tapvpwrvgnd_1
XFILLER_51_1273 VPWR VGND VPWR VGND sky130_ef_sc_hd__decap_12
XTAP_TAPCELL_ROW_231_3856 VGND VPWR sky130_fd_sc_hd__tapvpwrvgnd_1
XFILLER_177_1420 VPWR VGND VPWR VGND sky130_ef_sc_hd__decap_12
XFILLER_86_1325 VPWR VGND VPWR VGND sky130_ef_sc_hd__decap_12
XFILLER_5_772 VGND VGND VPWR VPWR sky130_fd_sc_hd__fill_2
XFILLER_177_1475 VPWR VGND VPWR VGND sky130_ef_sc_hd__decap_12
XTAP_TAPCELL_ROW_229_3763 VGND VPWR sky130_fd_sc_hd__tapvpwrvgnd_1
XFILLER_206_46 VPWR VGND VPWR VGND sky130_ef_sc_hd__decap_12
XPHY_EDGE_ROW_216_Right_61 VGND VGND VPWR VPWR sky130_fd_sc_hd__decap_3
XTAP_TAPCELL_ROW_229_3774 VGND VPWR sky130_fd_sc_hd__tapvpwrvgnd_1
XTAP_TAPCELL_ROW_225_3616 VGND VPWR sky130_fd_sc_hd__tapvpwrvgnd_1
XTAP_TAPCELL_ROW_229_3785 VGND VPWR sky130_fd_sc_hd__tapvpwrvgnd_1
XTAP_TAPCELL_ROW_225_3627 VGND VPWR sky130_fd_sc_hd__tapvpwrvgnd_1
XFILLER_60_1509 VGND VGND VPWR VPWR sky130_fd_sc_hd__decap_6
XFILLER_214_1336 VPWR VGND VPWR VGND sky130_ef_sc_hd__decap_12
XTAP_TAPCELL_ROW_225_3638 VGND VPWR sky130_fd_sc_hd__tapvpwrvgnd_1
XFILLER_228_538 VPWR VGND VPWR VGND sky130_ef_sc_hd__decap_12
XFILLER_62_1380 VPWR VGND VPWR VGND sky130_ef_sc_hd__decap_12
XFILLER_97_1421 VPWR VGND VPWR VGND sky130_ef_sc_hd__decap_12
XFILLER_222_34 VPWR VGND VPWR VGND sky130_ef_sc_hd__decap_12
XFILLER_255_379 VPWR VGND VPWR VGND sky130_ef_sc_hd__decap_12
XFILLER_149_1500 VGND VGND VPWR VPWR sky130_fd_sc_hd__decap_6
XFILLER_247_1112 VGND VGND VPWR VPWR sky130_fd_sc_hd__decap_6
XFILLER_208_273 VGND VGND VPWR VPWR sky130_fd_sc_hd__decap_6
XFILLER_224_722 VPWR VGND VPWR VGND sky130_ef_sc_hd__decap_12
XFILLER_110_1356 VPWR VGND VPWR VGND sky130_ef_sc_hd__decap_12
XFILLER_97_1476 VPWR VGND VPWR VGND sky130_ef_sc_hd__decap_12
XFILLER_222_89 VPWR VGND VPWR VGND sky130_ef_sc_hd__decap_12
XFILLER_236_593 VPWR VGND VPWR VGND sky130_ef_sc_hd__decap_12
XFILLER_251_541 VPWR VGND VPWR VGND sky130_ef_sc_hd__decap_12
XFILLER_212_906 VPWR VGND VPWR VGND sky130_ef_sc_hd__decap_12
XTAP_TAPCELL_ROW_219_3409 VGND VPWR sky130_fd_sc_hd__tapvpwrvgnd_1
XPHY_EDGE_ROW_71_1_Right_727 VGND VGND VPWR VPWR sky130_fd_sc_hd__decap_3
XFILLER_224_777 VPWR VGND VPWR VGND sky130_ef_sc_hd__decap_12
XPHY_EDGE_ROW_225_Right_70 VGND VGND VPWR VPWR sky130_fd_sc_hd__decap_3
XFILLER_251_596 VGND VGND VPWR VPWR sky130_fd_sc_hd__decap_6
XFILLER_225_1432 VPWR VGND VPWR VGND sky130_ef_sc_hd__decap_12
XFILLER_189_670 VPWR VGND VPWR VGND sky130_ef_sc_hd__decap_12
XFILLER_56_1184 VPWR VGND VPWR VGND sky130_ef_sc_hd__decap_12
XFILLER_108_1263 VGND VGND VPWR VPWR sky130_fd_sc_hd__decap_6
XFILLER_177_854 VGND VGND VPWR VPWR sky130_fd_sc_hd__decap_6
XFILLER_220_961 VGND VGND VPWR VPWR sky130_fd_sc_hd__decap_6
XFILLER_225_1487 VPWR VGND VPWR VGND sky130_ef_sc_hd__decap_12
XFILLER_143_1165 VPWR VGND VPWR VGND sky130_ef_sc_hd__decap_12
XFILLER_30_1313 VPWR VGND VPWR VGND sky130_ef_sc_hd__decap_12
XFILLER_191_345 VPWR VGND VPWR VGND sky130_ef_sc_hd__decap_12
XFILLER_30_1368 VPWR VGND VPWR VGND sky130_ef_sc_hd__decap_12
XTAP_TAPCELL_ROW_87_2_5358 VGND VPWR sky130_fd_sc_hd__tapvpwrvgnd_1
XFILLER_172_581 VPWR VGND VPWR VGND sky130_ef_sc_hd__decap_12
XFILLER_28_1220 VGND VGND VPWR VPWR sky130_fd_sc_hd__decap_6
XTAP_TAPCELL_ROW_100_2_5462 VGND VPWR sky130_fd_sc_hd__tapvpwrvgnd_1
XTAP_TAPCELL_ROW_67_2_5201 VGND VPWR sky130_fd_sc_hd__tapvpwrvgnd_1
XFILLER_116_46 VPWR VGND VPWR VGND sky130_ef_sc_hd__decap_12
XFILLER_115_1201 VGND VGND VPWR VPWR sky130_fd_sc_hd__decap_4
XPHY_EDGE_ROW_23_2_Left_525 VGND VGND VPWR VPWR sky130_fd_sc_hd__decap_3
XFILLER_8_1336 VPWR VGND VPWR VGND sky130_ef_sc_hd__decap_12
XFILLER_63_1177 VPWR VGND VPWR VGND sky130_ef_sc_hd__decap_12
XFILLER_154_1294 VPWR VGND VPWR VGND sky130_ef_sc_hd__decap_12
XTAP_TAPCELL_ROW_241_4174 VGND VPWR sky130_fd_sc_hd__tapvpwrvgnd_1
XFILLER_246_335 VPWR VGND VPWR VGND sky130_ef_sc_hd__decap_12
XTAP_TAPCELL_ROW_241_4185 VGND VPWR sky130_fd_sc_hd__tapvpwrvgnd_1
XTAP_TAPCELL_ROW_241_4196 VGND VPWR sky130_fd_sc_hd__tapvpwrvgnd_1
XPHY_EDGE_ROW_148_2_Left_650 VGND VGND VPWR VPWR sky130_fd_sc_hd__decap_3
XFILLER_189_1346 VPWR VGND VPWR VGND sky130_ef_sc_hd__decap_12
XTAP_TAPCELL_ROW_34_2_4931 VGND VPWR sky130_fd_sc_hd__tapvpwrvgnd_1
XFILLER_132_34 VPWR VGND VPWR VGND sky130_ef_sc_hd__decap_12
XFILLER_41_1464 VPWR VGND VPWR VGND sky130_ef_sc_hd__decap_12
XFILLER_234_519 VPWR VGND VPWR VGND sky130_ef_sc_hd__decap_12
XFILLER_227_560 VPWR VGND VPWR VGND sky130_ef_sc_hd__decap_12
XFILLER_199_412 VPWR VGND VPWR VGND sky130_ef_sc_hd__decap_12
XFILLER_215_744 VPWR VGND VPWR VGND sky130_ef_sc_hd__decap_12
XFILLER_254_390 VPWR VGND VPWR VGND sky130_ef_sc_hd__decap_12
XFILLER_226_1207 VPWR VGND VPWR VGND sky130_ef_sc_hd__decap_12
XFILLER_230_703 VGND VGND VPWR VPWR sky130_fd_sc_hd__decap_6
XFILLER_242_574 VGND VGND VPWR VPWR sky130_fd_sc_hd__decap_6
XTAP_TAPCELL_ROW_198_2671 VGND VPWR sky130_fd_sc_hd__tapvpwrvgnd_1
XFILLER_203_928 VPWR VGND VPWR VGND sky130_ef_sc_hd__decap_12
X_330_ net595 dout0_q\[19\] net537 VGND VGND VPWR VPWR _119_ sky130_fd_sc_hd__a21oi_1
XTAP_TAPCELL_ROW_198_2682 VGND VPWR sky130_fd_sc_hd__tapvpwrvgnd_1
XFILLER_199_467 VGND VGND VPWR VPWR sky130_fd_sc_hd__decap_6
XFILLER_215_799 VPWR VGND VPWR VGND sky130_ef_sc_hd__decap_12
XFILLER_74_1251 VPWR VGND VPWR VGND sky130_ef_sc_hd__decap_12
XTAP_TAPCELL_ROW_198_2693 VGND VPWR sky130_fd_sc_hd__tapvpwrvgnd_1
XFILLER_39_1371 VGND VGND VPWR VPWR sky130_fd_sc_hd__decap_6
XTAP_TAPCELL_ROW_194_2535 VGND VPWR sky130_fd_sc_hd__tapvpwrvgnd_1
XFILLER_148_3 VPWR VGND VPWR VGND sky130_ef_sc_hd__decap_12
XTAP_TAPCELL_ROW_194_2546 VGND VPWR sky130_fd_sc_hd__tapvpwrvgnd_1
XFILLER_168_832 VGND VGND VPWR VPWR sky130_fd_sc_hd__decap_6
XTAP_TAPCELL_ROW_194_2557 VGND VPWR sky130_fd_sc_hd__tapvpwrvgnd_1
XFILLER_211_983 VGND VGND VPWR VPWR sky130_fd_sc_hd__decap_6
XFILLER_13_1500 VGND VGND VPWR VPWR sky130_fd_sc_hd__decap_6
XFILLER_122_1227 VPWR VGND VPWR VGND sky130_ef_sc_hd__decap_12
XFILLER_182_323 VPWR VGND VPWR VGND sky130_ef_sc_hd__decap_12
XFILLER_194_194 VPWR VGND VPWR VGND sky130_ef_sc_hd__decap_12
XFILLER_202_1262 VGND VGND VPWR VPWR sky130_fd_sc_hd__decap_6
XFILLER_170_507 VPWR VGND VPWR VGND sky130_ef_sc_hd__decap_12
XFILLER_237_1303 VPWR VGND VPWR VGND sky130_ef_sc_hd__decap_12
XFILLER_182_378 VPWR VGND VPWR VGND sky130_ef_sc_hd__decap_12
XTAP_TAPCELL_ROW_188_2328 VGND VPWR sky130_fd_sc_hd__tapvpwrvgnd_1
XTAP_TAPCELL_ROW_188_2339 VGND VPWR sky130_fd_sc_hd__tapvpwrvgnd_1
XFILLER_237_1358 VPWR VGND VPWR VGND sky130_ef_sc_hd__decap_12
XFILLER_2_753 VGND VGND VPWR VPWR sky130_fd_sc_hd__fill_1
XFILLER_250_1514 VGND VGND VPWR VPWR sky130_fd_sc_hd__fill_1
XFILLER_2_786 VGND VGND VPWR VPWR sky130_fd_sc_hd__fill_1
XFILLER_237_302 VPWR VGND VPWR VGND sky130_ef_sc_hd__decap_12
XFILLER_249_173 VPWR VGND VPWR VGND sky130_ef_sc_hd__decap_12
XFILLER_42_1239 VPWR VGND VPWR VGND sky130_ef_sc_hd__decap_12
XFILLER_2_58 VGND VGND VPWR VPWR sky130_fd_sc_hd__decap_6
XFILLER_133_1378 VPWR VGND VPWR VGND sky130_ef_sc_hd__decap_12
XFILLER_237_357 VPWR VGND VPWR VGND sky130_ef_sc_hd__decap_12
XFILLER_252_316 VGND VGND VPWR VPWR sky130_fd_sc_hd__decap_6
XFILLER_248_1410 VPWR VGND VPWR VGND sky130_ef_sc_hd__decap_12
XFILLER_206_722 VPWR VGND VPWR VGND sky130_ef_sc_hd__decap_12
XFILLER_218_593 VPWR VGND VPWR VGND sky130_ef_sc_hd__decap_12
XFILLER_166_1121 VPWR VGND VPWR VGND sky130_ef_sc_hd__decap_12
XFILLER_248_1465 VPWR VGND VPWR VGND sky130_ef_sc_hd__decap_12
XFILLER_233_541 VPWR VGND VPWR VGND sky130_ef_sc_hd__decap_12
XTAP_TAPCELL_ROW_155_2_5900 VGND VPWR sky130_fd_sc_hd__tapvpwrvgnd_1
XFILLER_206_777 VPWR VGND VPWR VGND sky130_ef_sc_hd__decap_12
X_528_ net666 VGND VGND VPWR VPWR _010_ sky130_fd_sc_hd__inv_2
XFILLER_166_1176 VGND VGND VPWR VPWR sky130_fd_sc_hd__decap_6
XFILLER_221_725 VGND VGND VPWR VPWR sky130_fd_sc_hd__decap_6
XFILLER_18_1411 VPWR VGND VPWR VGND sky130_ef_sc_hd__decap_12
XFILLER_233_596 VGND VGND VPWR VPWR sky130_fd_sc_hd__decap_6
XFILLER_199_990 VPWR VGND VPWR VGND sky130_ef_sc_hd__decap_12
XTAP_TAPCELL_ROW_233_3907 VGND VPWR sky130_fd_sc_hd__tapvpwrvgnd_1
X_459_ net608 net7 net42 VGND VGND VPWR VPWR addr0\[5\] sky130_fd_sc_hd__mux2_1
XFILLER_53_1335 VPWR VGND VPWR VGND sky130_ef_sc_hd__decap_12
XFILLER_202_961 VGND VGND VPWR VPWR sky130_fd_sc_hd__decap_6
XFILLER_207_1162 VPWR VGND VPWR VGND sky130_ef_sc_hd__decap_12
XTAP_TAPCELL_ROW_233_3918 VGND VPWR sky130_fd_sc_hd__tapvpwrvgnd_1
XFILLER_18_1466 VPWR VGND VPWR VGND sky130_ef_sc_hd__decap_12
XFILLER_105_1414 VGND VGND VPWR VPWR sky130_fd_sc_hd__decap_6
XFILLER_203_1026 VGND VGND VPWR VPWR sky130_fd_sc_hd__decap_6
XFILLER_144_1485 VPWR VGND VPWR VGND sky130_ef_sc_hd__decap_12
XFILLER_242_1097 VPWR VGND VPWR VGND sky130_ef_sc_hd__decap_12
XFILLER_140_1349 VGND VGND VPWR VPWR sky130_fd_sc_hd__decap_6
XTAP_TAPCELL_ROW_105_2_5499 VGND VPWR sky130_fd_sc_hd__tapvpwrvgnd_1
XTAP_TAPCELL_ROW_73_2_5244 VGND VPWR sky130_fd_sc_hd__tapvpwrvgnd_1
XFILLER_63_3 VPWR VGND VPWR VGND sky130_ef_sc_hd__decap_12
XFILLER_173_345 VPWR VGND VPWR VGND sky130_ef_sc_hd__decap_12
XPHY_EDGE_ROW_21_1_Left_276 VGND VGND VPWR VPWR sky130_fd_sc_hd__decap_3
XTAP_TAPCELL_ROW_157_1_1465 VGND VPWR sky130_fd_sc_hd__tapvpwrvgnd_1
XFILLER_177_1272 VPWR VGND VPWR VGND sky130_ef_sc_hd__decap_12
XFILLER_217_56 VPWR VGND VPWR VGND sky130_ef_sc_hd__decap_12
XFILLER_86_1177 VGND VGND VPWR VPWR sky130_fd_sc_hd__decap_6
XTAP_TAPCELL_ROW_40_2_4985 VGND VPWR sky130_fd_sc_hd__tapvpwrvgnd_1
XFILLER_64_1442 VPWR VGND VPWR VGND sky130_ef_sc_hd__decap_12
XFILLER_60_1306 VGND VGND VPWR VPWR sky130_fd_sc_hd__decap_6
XFILLER_214_1133 VGND VGND VPWR VPWR sky130_fd_sc_hd__decap_6
XFILLER_64_1497 VPWR VGND VPWR VGND sky130_ef_sc_hd__decap_12
XTAP_TAPCELL_ROW_19_2_4811 VGND VPWR sky130_fd_sc_hd__tapvpwrvgnd_1
XFILLER_151_1445 VPWR VGND VPWR VGND sky130_ef_sc_hd__decap_12
XFILLER_233_44 VPWR VGND VPWR VGND sky130_ef_sc_hd__decap_12
XFILLER_228_335 VPWR VGND VPWR VGND sky130_ef_sc_hd__decap_12
XFILLER_186_1508 VGND VGND VPWR VPWR sky130_fd_sc_hd__decap_6
XFILLER_216_519 VPWR VGND VPWR VGND sky130_ef_sc_hd__decap_12
XFILLER_233_99 VPWR VGND VPWR VGND sky130_ef_sc_hd__decap_12
XFILLER_249_1229 VPWR VGND VPWR VGND sky130_ef_sc_hd__decap_12
XFILLER_244_839 VPWR VGND VPWR VGND sky130_ef_sc_hd__decap_12
XTAP_TAPCELL_ROW_165_1479 VGND VPWR sky130_fd_sc_hd__tapvpwrvgnd_1
XFILLER_209_560 VPWR VGND VPWR VGND sky130_ef_sc_hd__decap_12
XFILLER_243_338 VGND VGND VPWR VPWR sky130_fd_sc_hd__decap_6
XFILLER_102_15 VGND VGND VPWR VPWR sky130_fd_sc_hd__decap_6
XFILLER_236_390 VPWR VGND VPWR VGND sky130_ef_sc_hd__decap_12
XFILLER_97_1273 VPWR VGND VPWR VGND sky130_ef_sc_hd__decap_12
XFILLER_212_703 VGND VGND VPWR VPWR sky130_fd_sc_hd__decap_6
XFILLER_197_916 VPWR VGND VPWR VGND sky130_ef_sc_hd__decap_12
XFILLER_224_574 VGND VGND VPWR VPWR sky130_fd_sc_hd__decap_6
XFILLER_252_894 VPWR VGND VPWR VGND sky130_ef_sc_hd__decap_12
XPHY_EDGE_ROW_72_1_Right_728 VGND VGND VPWR VPWR sky130_fd_sc_hd__decap_3
XFILLER_71_1402 VPWR VGND VPWR VGND sky130_ef_sc_hd__decap_12
XFILLER_145_1249 VPWR VGND VPWR VGND sky130_ef_sc_hd__decap_12
XFILLER_71_1457 VGND VGND VPWR VPWR sky130_fd_sc_hd__decap_6
XFILLER_225_1284 VGND VGND VPWR VPWR sky130_fd_sc_hd__decap_6
XFILLER_176_194 VPWR VGND VPWR VGND sky130_ef_sc_hd__decap_12
XFILLER_178_1047 VGND VGND VPWR VPWR sky130_fd_sc_hd__decap_6
XFILLER_191_142 VPWR VGND VPWR VGND sky130_ef_sc_hd__decap_12
XFILLER_30_1165 VPWR VGND VPWR VGND sky130_ef_sc_hd__decap_12
XFILLER_11_56 VPWR VGND VPWR VGND sky130_ef_sc_hd__decap_12
XFILLER_65_1206 VPWR VGND VPWR VGND sky130_ef_sc_hd__decap_12
XFILLER_191_197 VPWR VGND VPWR VGND sky130_ef_sc_hd__decap_12
XFILLER_219_1033 VPWR VGND VPWR VGND sky130_ef_sc_hd__decap_12
XFILLER_127_56 VPWR VGND VPWR VGND sky130_ef_sc_hd__decap_12
XFILLER_2_7 VPWR VGND VPWR VGND sky130_ef_sc_hd__decap_12
XFILLER_87_27 VPWR VGND VPWR VGND sky130_ef_sc_hd__decap_12
XFILLER_156_1356 VPWR VGND VPWR VGND sky130_ef_sc_hd__decap_12
XTAP_TAPCELL_ROW_247_4394 VGND VPWR sky130_fd_sc_hd__tapvpwrvgnd_1
XFILLER_219_1088 VPWR VGND VPWR VGND sky130_ef_sc_hd__decap_12
XTAP_TAPCELL_ROW_243_4247 VGND VPWR sky130_fd_sc_hd__tapvpwrvgnd_1
XTAP_TAPCELL_ROW_243_4258 VGND VPWR sky130_fd_sc_hd__tapvpwrvgnd_1
XFILLER_236_1391 VGND VGND VPWR VPWR sky130_fd_sc_hd__decap_6
XTAP_TAPCELL_ROW_243_4269 VGND VPWR sky130_fd_sc_hd__tapvpwrvgnd_1
XFILLER_8_1133 VGND VGND VPWR VPWR sky130_fd_sc_hd__decap_6
XFILLER_219_302 VPWR VGND VPWR VGND sky130_ef_sc_hd__decap_12
XFILLER_143_44 VPWR VGND VPWR VGND sky130_ef_sc_hd__decap_12
XFILLER_246_132 VPWR VGND VPWR VGND sky130_ef_sc_hd__decap_12
XFILLER_219_357 VPWR VGND VPWR VGND sky130_ef_sc_hd__decap_12
XTAP_TAPCELL_ROW_129_2_5695 VGND VPWR sky130_fd_sc_hd__tapvpwrvgnd_1
XFILLER_189_1143 VPWR VGND VPWR VGND sky130_ef_sc_hd__decap_12
XTAP_TAPCELL_ROW_9_1183 VGND VPWR sky130_fd_sc_hd__tapvpwrvgnd_1
XFILLER_41_1261 VPWR VGND VPWR VGND sky130_ef_sc_hd__decap_12
XTAP_TAPCELL_ROW_9_1194 VGND VPWR sky130_fd_sc_hd__tapvpwrvgnd_1
XTAP_TAPCELL_ROW_97_2_5440 VGND VPWR sky130_fd_sc_hd__tapvpwrvgnd_1
XTAP_TAPCELL_ROW_5_1036 VGND VPWR sky130_fd_sc_hd__tapvpwrvgnd_1
XFILLER_234_316 VGND VGND VPWR VPWR sky130_fd_sc_hd__decap_6
XFILLER_246_187 VGND VGND VPWR VPWR sky130_fd_sc_hd__decap_6
XTAP_TAPCELL_ROW_5_1047 VGND VPWR sky130_fd_sc_hd__tapvpwrvgnd_1
XTAP_TAPCELL_ROW_5_1058 VGND VPWR sky130_fd_sc_hd__tapvpwrvgnd_1
XFILLER_189_1198 VGND VGND VPWR VPWR sky130_fd_sc_hd__decap_6
XFILLER_76_1313 VPWR VGND VPWR VGND sky130_ef_sc_hd__decap_12
XFILLER_215_541 VPWR VGND VPWR VGND sky130_ef_sc_hd__decap_12
XTAP_TAPCELL_ROW_196_2608 VGND VPWR sky130_fd_sc_hd__tapvpwrvgnd_1
XFILLER_243_861 VPWR VGND VPWR VGND sky130_ef_sc_hd__decap_12
XTAP_TAPCELL_ROW_196_2619 VGND VPWR sky130_fd_sc_hd__tapvpwrvgnd_1
XFILLER_167_1463 VPWR VGND VPWR VGND sky130_ef_sc_hd__decap_12
XFILLER_226_1004 VGND VGND VPWR VPWR sky130_fd_sc_hd__decap_6
XFILLER_76_1368 VPWR VGND VPWR VGND sky130_ef_sc_hd__decap_12
XFILLER_163_1316 VPWR VGND VPWR VGND sky130_ef_sc_hd__decap_12
XFILLER_203_725 VGND VGND VPWR VPWR sky130_fd_sc_hd__decap_6
XFILLER_215_596 VGND VGND VPWR VPWR sky130_fd_sc_hd__decap_6
XFILLER_188_949 VPWR VGND VPWR VGND sky130_ef_sc_hd__decap_12
X_313_ _100_ net508 VGND VGND VPWR VPWR _102_ sky130_fd_sc_hd__nor2_1
XTAP_TAPCELL_ROW_122_2_5638 VGND VPWR sky130_fd_sc_hd__tapvpwrvgnd_1
XFILLER_204_1324 VPWR VGND VPWR VGND sky130_ef_sc_hd__decap_12
XTAP_TAPCELL_ROW_58_2_5124 VGND VPWR sky130_fd_sc_hd__tapvpwrvgnd_1
Xinput17 wr_data[16] VGND VGND VPWR VPWR net17 sky130_fd_sc_hd__clkbuf_1
Xinput28 wr_data[26] VGND VGND VPWR VPWR net28 sky130_fd_sc_hd__clkbuf_1
XFILLER_204_1379 VPWR VGND VPWR VGND sky130_ef_sc_hd__decap_12
Xinput39 wr_data[7] VGND VGND VPWR VPWR net39 sky130_fd_sc_hd__clkbuf_1
XFILLER_182_120 VPWR VGND VPWR VGND sky130_ef_sc_hd__decap_12
Xmax_cap509 _100_ VGND VGND VPWR VPWR net509 sky130_fd_sc_hd__clkbuf_1
XFILLER_6_366 VGND VGND VPWR VPWR sky130_fd_sc_hd__fill_1
XFILLER_170_304 VPWR VGND VPWR VGND sky130_ef_sc_hd__decap_12
XFILLER_237_1100 VPWR VGND VPWR VGND sky130_ef_sc_hd__decap_12
XFILLER_182_175 VPWR VGND VPWR VGND sky130_ef_sc_hd__decap_12
XTAP_TAPCELL_ROW_25_2_4865 VGND VPWR sky130_fd_sc_hd__tapvpwrvgnd_1
XFILLER_87_1464 VPWR VGND VPWR VGND sky130_ef_sc_hd__decap_12
XFILLER_170_359 VGND VGND VPWR VPWR sky130_fd_sc_hd__decap_6
XFILLER_174_1434 VGND VGND VPWR VPWR sky130_fd_sc_hd__decap_6
XFILLER_83_1328 VGND VGND VPWR VPWR sky130_fd_sc_hd__decap_6
XFILLER_237_1155 VGND VGND VPWR VPWR sky130_fd_sc_hd__decap_6
XFILLER_100_1399 VPWR VGND VPWR VGND sky130_ef_sc_hd__decap_12
XFILLER_215_1420 VPWR VGND VPWR VGND sky130_ef_sc_hd__decap_12
XFILLER_250_1355 VPWR VGND VPWR VGND sky130_ef_sc_hd__decap_12
XFILLER_215_1475 VPWR VGND VPWR VGND sky130_ef_sc_hd__decap_12
XFILLER_253_603 VPWR VGND VPWR VGND sky130_ef_sc_hd__decap_12
XFILLER_237_154 VPWR VGND VPWR VGND sky130_ef_sc_hd__decap_12
XFILLER_226_839 VPWR VGND VPWR VGND sky130_ef_sc_hd__decap_12
XFILLER_59_1500 VGND VGND VPWR VPWR sky130_fd_sc_hd__decap_6
XFILLER_168_1238 VPWR VGND VPWR VGND sky130_ef_sc_hd__decap_12
XFILLER_225_338 VGND VGND VPWR VPWR sky130_fd_sc_hd__decap_6
XFILLER_253_658 VPWR VGND VPWR VGND sky130_ef_sc_hd__decap_12
XFILLER_20_1356 VPWR VGND VPWR VGND sky130_ef_sc_hd__decap_12
XFILLER_218_390 VPWR VGND VPWR VGND sky130_ef_sc_hd__decap_12
XFILLER_248_1262 VGND VGND VPWR VPWR sky130_fd_sc_hd__decap_6
XFILLER_94_1435 VGND VGND VPWR VPWR sky130_fd_sc_hd__decap_6
XFILLER_206_574 VGND VGND VPWR VPWR sky130_fd_sc_hd__decap_6
XFILLER_179_916 VPWR VGND VPWR VGND sky130_ef_sc_hd__decap_12
XFILLER_234_894 VPWR VGND VPWR VGND sky130_ef_sc_hd__decap_12
XFILLER_18_1263 VGND VGND VPWR VPWR sky130_fd_sc_hd__decap_6
XFILLER_187_971 VPWR VGND VPWR VGND sky130_ef_sc_hd__decap_12
XFILLER_53_1165 VPWR VGND VPWR VGND sky130_ef_sc_hd__decap_12
XFILLER_144_1282 VPWR VGND VPWR VGND sky130_ef_sc_hd__decap_12
XFILLER_179_1334 VPWR VGND VPWR VGND sky130_ef_sc_hd__decap_12
XFILLER_228_22 VPWR VGND VPWR VGND sky130_ef_sc_hd__decap_12
XFILLER_173_142 VPWR VGND VPWR VGND sky130_ef_sc_hd__decap_12
XFILLER_88_1239 VPWR VGND VPWR VGND sky130_ef_sc_hd__decap_12
XFILLER_179_1389 VPWR VGND VPWR VGND sky130_ef_sc_hd__decap_12
XFILLER_228_77 VPWR VGND VPWR VGND sky130_ef_sc_hd__decap_12
XFILLER_173_197 VPWR VGND VPWR VGND sky130_ef_sc_hd__decap_12
XFILLER_153_1507 VGND VGND VPWR VPWR sky130_fd_sc_hd__decap_8
XFILLER_251_1119 VPWR VGND VPWR VGND sky130_ef_sc_hd__decap_12
XFILLER_170_882 VPWR VGND VPWR VGND sky130_ef_sc_hd__decap_12
XFILLER_9_1420 VGND VGND VPWR VPWR sky130_fd_sc_hd__decap_8
XFILLER_25_1201 VGND VGND VPWR VPWR sky130_fd_sc_hd__decap_4
XFILLER_244_65 VPWR VGND VPWR VGND sky130_ef_sc_hd__decap_12
XTAP_TAPCELL_ROW_115_2_5581 VGND VPWR sky130_fd_sc_hd__tapvpwrvgnd_1
XFILLER_64_1294 VPWR VGND VPWR VGND sky130_ef_sc_hd__decap_12
XFILLER_151_1242 VGND VGND VPWR VPWR sky130_fd_sc_hd__decap_6
XFILLER_228_132 VPWR VGND VPWR VGND sky130_ef_sc_hd__decap_12
XFILLER_99_1335 VPWR VGND VPWR VGND sky130_ef_sc_hd__decap_12
XFILLER_186_1305 VGND VGND VPWR VPWR sky130_fd_sc_hd__decap_6
XFILLER_249_1026 VGND VGND VPWR VPWR sky130_fd_sc_hd__decap_6
XFILLER_216_316 VGND VGND VPWR VPWR sky130_fd_sc_hd__decap_6
XFILLER_244_636 VPWR VGND VPWR VGND sky130_ef_sc_hd__decap_12
XFILLER_228_187 VGND VGND VPWR VPWR sky130_fd_sc_hd__decap_6
XTAP_TAPCELL_ROW_203_2851 VGND VPWR sky130_fd_sc_hd__tapvpwrvgnd_1
XFILLER_225_861 VPWR VGND VPWR VGND sky130_ef_sc_hd__decap_12
XTAP_TAPCELL_ROW_203_2862 VGND VPWR sky130_fd_sc_hd__tapvpwrvgnd_1
XTAP_TAPCELL_ROW_203_2873 VGND VPWR sky130_fd_sc_hd__tapvpwrvgnd_1
XTAP_TAPCELL_ROW_107_2_5518 VGND VPWR sky130_fd_sc_hd__tapvpwrvgnd_1
XFILLER_240_820 VPWR VGND VPWR VGND sky130_ef_sc_hd__decap_12
XFILLER_197_713 VPWR VGND VPWR VGND sky130_ef_sc_hd__decap_12
Xwire85 _252_ VGND VGND VPWR VPWR net85 sky130_fd_sc_hd__clkbuf_1
XFILLER_227_1346 VPWR VGND VPWR VGND sky130_ef_sc_hd__decap_12
XFILLER_252_691 VPWR VGND VPWR VGND sky130_ef_sc_hd__decap_12
XTAP_TAPCELL_ROW_255_4674 VGND VPWR sky130_fd_sc_hd__tapvpwrvgnd_1
XTAP_TAPCELL_ROW_44_2_5010 VGND VPWR sky130_fd_sc_hd__tapvpwrvgnd_1
XTAP_TAPCELL_ROW_255_4685 VGND VPWR sky130_fd_sc_hd__tapvpwrvgnd_1
XTAP_TAPCELL_ROW_255_4696 VGND VPWR sky130_fd_sc_hd__tapvpwrvgnd_1
XTAP_TAPCELL_ROW_251_4527 VGND VPWR sky130_fd_sc_hd__tapvpwrvgnd_1
XTAP_TAPCELL_ROW_251_4538 VGND VPWR sky130_fd_sc_hd__tapvpwrvgnd_1
XFILLER_240_875 VGND VGND VPWR VPWR sky130_fd_sc_hd__decap_6
XTAP_TAPCELL_ROW_251_4549 VGND VPWR sky130_fd_sc_hd__tapvpwrvgnd_1
XPHY_EDGE_ROW_73_1_Right_729 VGND VGND VPWR VPWR sky130_fd_sc_hd__decap_3
XFILLER_75_1390 VPWR VGND VPWR VGND sky130_ef_sc_hd__decap_12
XFILLER_197_768 VGND VGND VPWR VPWR sky130_fd_sc_hd__decap_6
XFILLER_165_610 VPWR VGND VPWR VGND sky130_ef_sc_hd__decap_12
XFILLER_32_1227 VPWR VGND VPWR VGND sky130_ef_sc_hd__decap_12
XFILLER_22_22 VPWR VGND VPWR VGND sky130_ef_sc_hd__decap_12
XFILLER_197_1401 VPWR VGND VPWR VGND sky130_ef_sc_hd__decap_12
XTAP_TAPCELL_ROW_11_2_4751 VGND VPWR sky130_fd_sc_hd__tapvpwrvgnd_1
XFILLER_138_22 VPWR VGND VPWR VGND sky130_ef_sc_hd__decap_12
XFILLER_165_643 VGND VGND VPWR VPWR sky130_fd_sc_hd__decap_8
XFILLER_197_1456 VGND VGND VPWR VPWR sky130_fd_sc_hd__decap_6
XFILLER_98_15 VGND VGND VPWR VPWR sky130_fd_sc_hd__decap_6
XTAP_TAPCELL_ROW_249_4456 VGND VPWR sky130_fd_sc_hd__tapvpwrvgnd_1
XFILLER_180_624 VPWR VGND VPWR VGND sky130_ef_sc_hd__decap_12
XTAP_TAPCELL_ROW_249_4467 VGND VPWR sky130_fd_sc_hd__tapvpwrvgnd_1
XFILLER_4_837 VGND VGND VPWR VPWR sky130_fd_sc_hd__fill_1
XFILLER_192_495 VPWR VGND VPWR VGND sky130_ef_sc_hd__decap_12
XFILLER_3_314 VGND VGND VPWR VPWR sky130_fd_sc_hd__decap_4
XTAP_TAPCELL_ROW_249_4478 VGND VPWR sky130_fd_sc_hd__tapvpwrvgnd_1
XFILLER_238_1453 VPWR VGND VPWR VGND sky130_ef_sc_hd__decap_12
XFILLER_180_679 VPWR VGND VPWR VGND sky130_ef_sc_hd__decap_12
XFILLER_191_1033 VPWR VGND VPWR VGND sky130_ef_sc_hd__decap_12
XFILLER_154_65 VGND VGND VPWR VPWR sky130_fd_sc_hd__decap_6
XFILLER_191_1088 VPWR VGND VPWR VGND sky130_ef_sc_hd__decap_12
XTAP_TAPCELL_ROW_7_1109 VGND VPWR sky130_fd_sc_hd__tapvpwrvgnd_1
XFILLER_43_1378 VPWR VGND VPWR VGND sky130_ef_sc_hd__decap_12
XFILLER_219_154 VPWR VGND VPWR VGND sky130_ef_sc_hd__decap_12
XFILLER_235_603 VPWR VGND VPWR VGND sky130_ef_sc_hd__decap_12
XFILLER_247_474 VPWR VGND VPWR VGND sky130_ef_sc_hd__decap_12
XFILLER_130_1337 VPWR VGND VPWR VGND sky130_ef_sc_hd__decap_12
XFILLER_169_1514 VGND VGND VPWR VPWR sky130_fd_sc_hd__fill_1
XFILLER_208_839 VPWR VGND VPWR VGND sky130_ef_sc_hd__decap_12
XFILLER_207_338 VGND VGND VPWR VPWR sky130_fd_sc_hd__decap_6
XFILLER_235_658 VPWR VGND VPWR VGND sky130_ef_sc_hd__decap_12
XFILLER_250_617 VGND VGND VPWR VPWR sky130_fd_sc_hd__decap_6
XFILLER_245_1413 VGND VGND VPWR VPWR sky130_fd_sc_hd__decap_6
XFILLER_167_1260 VPWR VGND VPWR VGND sky130_ef_sc_hd__decap_12
XFILLER_216_894 VPWR VGND VPWR VGND sky130_ef_sc_hd__decap_12
XFILLER_76_1165 VPWR VGND VPWR VGND sky130_ef_sc_hd__decap_12
XFILLER_231_842 VPWR VGND VPWR VGND sky130_ef_sc_hd__decap_12
XFILLER_188_746 VGND VGND VPWR VPWR sky130_fd_sc_hd__decap_6
XFILLER_231_897 VGND VGND VPWR VPWR sky130_fd_sc_hd__decap_6
XFILLER_15_1414 VGND VGND VPWR VPWR sky130_fd_sc_hd__decap_6
XFILLER_169_971 VPWR VGND VPWR VGND sky130_ef_sc_hd__decap_12
XFILLER_204_1121 VPWR VGND VPWR VGND sky130_ef_sc_hd__decap_12
XFILLER_8_46 VPWR VGND VPWR VGND sky130_ef_sc_hd__decap_12
XFILLER_54_1485 VPWR VGND VPWR VGND sky130_ef_sc_hd__decap_12
XFILLER_141_1433 VPWR VGND VPWR VGND sky130_ef_sc_hd__decap_12
XFILLER_50_1349 VGND VGND VPWR VPWR sky130_fd_sc_hd__decap_6
XFILLER_204_1176 VGND VGND VPWR VPWR sky130_fd_sc_hd__decap_6
Xwire540 net50 VGND VGND VPWR VPWR net540 sky130_fd_sc_hd__clkbuf_1
XPHY_EDGE_ROW_100_2_Left_602 VGND VGND VPWR VPWR sky130_fd_sc_hd__decap_3
Xwire562 net68 VGND VGND VPWR VPWR net562 sky130_fd_sc_hd__buf_1
XFILLER_141_1488 VPWR VGND VPWR VGND sky130_ef_sc_hd__decap_12
XTAP_TAPCELL_ROW_152_2_5877 VGND VPWR sky130_fd_sc_hd__tapvpwrvgnd_1
XFILLER_239_1217 VPWR VGND VPWR VGND sky130_ef_sc_hd__decap_12
Xwire573 dout0_q\[14\] VGND VGND VPWR VPWR net573 sky130_fd_sc_hd__clkbuf_1
Xwire584 dout0_q\[5\] VGND VGND VPWR VPWR net584 sky130_fd_sc_hd__clkbuf_1
XFILLER_6_163 VGND VGND VPWR VPWR sky130_fd_sc_hd__decap_4
XFILLER_170_101 VGND VGND VPWR VPWR sky130_fd_sc_hd__decap_6
Xmax_cap339 _134_ VGND VGND VPWR VPWR net339 sky130_fd_sc_hd__clkbuf_1
XTAP_TAPCELL_ROW_88_2_5363 VGND VPWR sky130_fd_sc_hd__tapvpwrvgnd_1
XTAP_TAPCELL_ROW_172_1770 VGND VPWR sky130_fd_sc_hd__tapvpwrvgnd_1
XFILLER_6_185 VGND VGND VPWR VPWR sky130_fd_sc_hd__decap_8
XFILLER_171_646 VPWR VGND VPWR VGND sky130_ef_sc_hd__decap_12
XTAP_TAPCELL_ROW_172_1781 VGND VPWR sky130_fd_sc_hd__tapvpwrvgnd_1
XFILLER_87_1261 VPWR VGND VPWR VGND sky130_ef_sc_hd__decap_12
XTAP_TAPCELL_ROW_172_1792 VGND VPWR sky130_fd_sc_hd__tapvpwrvgnd_1
XTAP_TAPCELL_ROW_132_2_5720 VGND VPWR sky130_fd_sc_hd__tapvpwrvgnd_1
XFILLER_100_1196 VPWR VGND VPWR VGND sky130_ef_sc_hd__decap_12
XFILLER_26_3 VPWR VGND VPWR VGND sky130_ef_sc_hd__decap_12
XFILLER_250_1152 VPWR VGND VPWR VGND sky130_ef_sc_hd__decap_12
XFILLER_61_1445 VPWR VGND VPWR VGND sky130_ef_sc_hd__decap_12
XFILLER_215_1272 VPWR VGND VPWR VGND sky130_ef_sc_hd__decap_12
XFILLER_214_46 VPWR VGND VPWR VGND sky130_ef_sc_hd__decap_12
XTAP_TAPCELL_ROW_81_2_5306 VGND VPWR sky130_fd_sc_hd__tapvpwrvgnd_1
XTAP_TAPCELL_ROW_166_1552 VGND VPWR sky130_fd_sc_hd__tapvpwrvgnd_1
XFILLER_238_452 VPWR VGND VPWR VGND sky130_ef_sc_hd__decap_12
XTAP_TAPCELL_ROW_166_1563 VGND VPWR sky130_fd_sc_hd__tapvpwrvgnd_1
XFILLER_253_400 VPWR VGND VPWR VGND sky130_ef_sc_hd__decap_12
XTAP_TAPCELL_ROW_50_2_5064 VGND VPWR sky130_fd_sc_hd__tapvpwrvgnd_1
XTAP_TAPCELL_ROW_166_1574 VGND VPWR sky130_fd_sc_hd__tapvpwrvgnd_1
XFILLER_226_636 VPWR VGND VPWR VGND sky130_ef_sc_hd__decap_12
XFILLER_168_1035 VPWR VGND VPWR VGND sky130_ef_sc_hd__decap_12
XFILLER_253_455 VPWR VGND VPWR VGND sky130_ef_sc_hd__decap_12
XFILLER_207_861 VPWR VGND VPWR VGND sky130_ef_sc_hd__decap_12
XPHY_EDGE_ROW_166_Right_11 VGND VGND VPWR VPWR sky130_fd_sc_hd__decap_3
XFILLER_230_34 VPWR VGND VPWR VGND sky130_ef_sc_hd__decap_12
XFILLER_111_1292 VPWR VGND VPWR VGND sky130_ef_sc_hd__decap_12
XFILLER_241_639 VGND VGND VPWR VPWR sky130_fd_sc_hd__decap_6
XFILLER_179_713 VPWR VGND VPWR VGND sky130_ef_sc_hd__decap_12
XFILLER_222_820 VPWR VGND VPWR VGND sky130_ef_sc_hd__decap_12
XFILLER_234_691 VPWR VGND VPWR VGND sky130_ef_sc_hd__decap_12
XTAP_TAPCELL_ROW_16_2_4788 VGND VPWR sky130_fd_sc_hd__tapvpwrvgnd_1
XFILLER_224_1508 VGND VGND VPWR VPWR sky130_fd_sc_hd__decap_6
XFILLER_230_89 VPWR VGND VPWR VGND sky130_ef_sc_hd__decap_12
XTAP_TAPCELL_ROW_145_1_1447 VGND VPWR sky130_fd_sc_hd__tapvpwrvgnd_1
XFILLER_55_1249 VPWR VGND VPWR VGND sky130_ef_sc_hd__decap_12
XFILLER_209_1076 VPWR VGND VPWR VGND sky130_ef_sc_hd__decap_12
XFILLER_179_768 VGND VGND VPWR VPWR sky130_fd_sc_hd__decap_6
XFILLER_222_875 VGND VGND VPWR VPWR sky130_fd_sc_hd__decap_6
XFILLER_107_1328 VGND VGND VPWR VPWR sky130_fd_sc_hd__decap_6
XFILLER_142_1208 VPWR VGND VPWR VGND sky130_ef_sc_hd__decap_12
XFILLER_146_1399 VPWR VGND VPWR VGND sky130_ef_sc_hd__decap_12
XPHY_EDGE_ROW_32_2_Left_534 VGND VGND VPWR VPWR sky130_fd_sc_hd__decap_3
XFILLER_193_259 VPWR VGND VPWR VGND sky130_ef_sc_hd__decap_12
XFILLER_239_87 VPWR VGND VPWR VGND sky130_ef_sc_hd__decap_12
XFILLER_179_1131 VPWR VGND VPWR VGND sky130_ef_sc_hd__decap_12
XFILLER_174_495 VPWR VGND VPWR VGND sky130_ef_sc_hd__decap_12
XPHY_EDGE_ROW_175_Right_20 VGND VGND VPWR VPWR sky130_fd_sc_hd__decap_3
XFILLER_179_1186 VPWR VGND VPWR VGND sky130_ef_sc_hd__decap_12
XFILLER_255_1030 VPWR VGND VPWR VGND sky130_ef_sc_hd__decap_12
XFILLER_108_58 VGND VGND VPWR VPWR sky130_fd_sc_hd__decap_6
XFILLER_255_64 VPWR VGND VPWR VGND sky130_ef_sc_hd__decap_12
XFILLER_255_1063 VGND VGND VPWR VPWR sky130_fd_sc_hd__decap_8
XFILLER_66_1356 VPWR VGND VPWR VGND sky130_ef_sc_hd__decap_12
XFILLER_153_1304 VPWR VGND VPWR VGND sky130_ef_sc_hd__decap_12
XFILLER_255_97 VGND VGND VPWR VPWR sky130_fd_sc_hd__decap_8
XFILLER_118_1435 VGND VGND VPWR VPWR sky130_fd_sc_hd__decap_6
XFILLER_216_1047 VGND VGND VPWR VPWR sky130_fd_sc_hd__decap_6
XFILLER_153_1359 VPWR VGND VPWR VGND sky130_ef_sc_hd__decap_12
XFILLER_248_249 VPWR VGND VPWR VGND sky130_ef_sc_hd__decap_12
XFILLER_9_1261 VPWR VGND VPWR VGND sky130_ef_sc_hd__decap_12
XPHY_EDGE_ROW_109_1_Left_364 VGND VGND VPWR VPWR sky130_fd_sc_hd__decap_3
XFILLER_124_46 VPWR VGND VPWR VGND sky130_ef_sc_hd__decap_12
XFILLER_9_1294 VGND VGND VPWR VPWR sky130_fd_sc_hd__decap_8
XFILLER_217_603 VPWR VGND VPWR VGND sky130_ef_sc_hd__decap_12
XTAP_TAPCELL_ROW_205_2924 VGND VPWR sky130_fd_sc_hd__tapvpwrvgnd_1
XFILLER_229_474 VPWR VGND VPWR VGND sky130_ef_sc_hd__decap_12
XTAP_TAPCELL_ROW_205_2935 VGND VPWR sky130_fd_sc_hd__tapvpwrvgnd_1
XFILLER_244_433 VPWR VGND VPWR VGND sky130_ef_sc_hd__decap_12
XFILLER_99_1165 VPWR VGND VPWR VGND sky130_ef_sc_hd__decap_12
XTAP_TAPCELL_ROW_205_2946 VGND VPWR sky130_fd_sc_hd__tapvpwrvgnd_1
XFILLER_217_658 VPWR VGND VPWR VGND sky130_ef_sc_hd__decap_12
XTAP_TAPCELL_ROW_238_4102 VGND VPWR sky130_fd_sc_hd__tapvpwrvgnd_1
XFILLER_17_44 VPWR VGND VPWR VGND sky130_ef_sc_hd__decap_12
XPHY_EDGE_ROW_46_1_Left_301 VGND VGND VPWR VPWR sky130_fd_sc_hd__decap_3
XTAP_TAPCELL_ROW_0_840 VGND VPWR sky130_fd_sc_hd__tapvpwrvgnd_1
XFILLER_140_34 VPWR VGND VPWR VGND sky130_ef_sc_hd__decap_12
XFILLER_232_617 VGND VGND VPWR VPWR sky130_fd_sc_hd__decap_6
XFILLER_244_488 VGND VGND VPWR VPWR sky130_fd_sc_hd__decap_6
XTAP_TAPCELL_ROW_0_851 VGND VPWR sky130_fd_sc_hd__tapvpwrvgnd_1
XTAP_TAPCELL_ROW_0_862 VGND VPWR sky130_fd_sc_hd__tapvpwrvgnd_1
XTAP_TAPCELL_ROW_0_873 VGND VPWR sky130_fd_sc_hd__tapvpwrvgnd_1
XFILLER_164_1411 VPWR VGND VPWR VGND sky130_ef_sc_hd__decap_12
XTAP_TAPCELL_ROW_0_884 VGND VPWR sky130_fd_sc_hd__tapvpwrvgnd_1
XFILLER_197_510 VGND VGND VPWR VPWR sky130_fd_sc_hd__decap_6
XFILLER_227_1143 VPWR VGND VPWR VGND sky130_ef_sc_hd__decap_12
XFILLER_73_1316 VPWR VGND VPWR VGND sky130_ef_sc_hd__decap_12
XFILLER_213_842 VPWR VGND VPWR VGND sky130_ef_sc_hd__decap_12
XFILLER_164_1466 VPWR VGND VPWR VGND sky130_ef_sc_hd__decap_12
XFILLER_213_897 VGND VGND VPWR VPWR sky130_fd_sc_hd__decap_6
XFILLER_227_1198 VGND VGND VPWR VPWR sky130_fd_sc_hd__decap_6
XFILLER_130_3 VPWR VGND VPWR VGND sky130_ef_sc_hd__decap_12
XTAP_TAPCELL_ROW_137_2_5757 VGND VPWR sky130_fd_sc_hd__tapvpwrvgnd_1
XFILLER_205_1463 VPWR VGND VPWR VGND sky130_ef_sc_hd__decap_12
XFILLER_184_237 VPWR VGND VPWR VGND sky130_ef_sc_hd__decap_12
XFILLER_228_3 VPWR VGND VPWR VGND sky130_ef_sc_hd__decap_12
XPHY_EDGE_ROW_89_2_Left_591 VGND VGND VPWR VPWR sky130_fd_sc_hd__decap_3
XFILLER_201_1327 VGND VGND VPWR VPWR sky130_fd_sc_hd__decap_6
XFILLER_240_1398 VPWR VGND VPWR VGND sky130_ef_sc_hd__decap_12
XTAP_TAPCELL_ROW_117_2_5600 VGND VPWR sky130_fd_sc_hd__tapvpwrvgnd_1
XFILLER_165_484 VPWR VGND VPWR VGND sky130_ef_sc_hd__decap_12
XFILLER_180_421 VPWR VGND VPWR VGND sky130_ef_sc_hd__decap_12
XFILLER_3_111 VPWR VGND VPWR VGND sky130_ef_sc_hd__decap_12
XFILLER_192_292 VPWR VGND VPWR VGND sky130_ef_sc_hd__decap_12
XFILLER_4_645 VGND VGND VPWR VPWR sky130_fd_sc_hd__fill_1
XFILLER_4_667 VGND VGND VPWR VPWR sky130_fd_sc_hd__fill_1
XFILLER_84_1423 VPWR VGND VPWR VGND sky130_ef_sc_hd__decap_12
XFILLER_238_1250 VPWR VGND VPWR VGND sky130_ef_sc_hd__decap_12
XFILLER_165_64 VPWR VGND VPWR VGND sky130_ef_sc_hd__decap_12
XTAP_TAPCELL_ROW_41_2_4990 VGND VPWR sky130_fd_sc_hd__tapvpwrvgnd_1
XFILLER_4_678 VGND VGND VPWR VPWR sky130_fd_sc_hd__fill_1
XFILLER_180_476 VPWR VGND VPWR VGND sky130_ef_sc_hd__decap_12
XFILLER_10_1399 VPWR VGND VPWR VGND sky130_ef_sc_hd__decap_12
XFILLER_165_97 VGND VGND VPWR VPWR sky130_fd_sc_hd__decap_8
XFILLER_84_1478 VGND VGND VPWR VPWR sky130_fd_sc_hd__decap_6
XFILLER_239_216 VPWR VGND VPWR VGND sky130_ef_sc_hd__decap_12
XFILLER_0_862 VGND VGND VPWR VPWR sky130_fd_sc_hd__fill_2
XFILLER_212_1434 VGND VGND VPWR VPWR sky130_fd_sc_hd__decap_6
XFILLER_134_1270 VPWR VGND VPWR VGND sky130_ef_sc_hd__decap_12
XFILLER_235_400 VPWR VGND VPWR VGND sky130_ef_sc_hd__decap_12
XFILLER_247_271 VPWR VGND VPWR VGND sky130_ef_sc_hd__decap_12
XFILLER_208_636 VPWR VGND VPWR VGND sky130_ef_sc_hd__decap_12
XTAP_TAPCELL_ROW_33_2_4927 VGND VPWR sky130_fd_sc_hd__tapvpwrvgnd_1
XFILLER_78_1227 VPWR VGND VPWR VGND sky130_ef_sc_hd__decap_12
XFILLER_251_904 VPWR VGND VPWR VGND sky130_ef_sc_hd__decap_12
XFILLER_235_455 VPWR VGND VPWR VGND sky130_ef_sc_hd__decap_12
XTAP_TAPCELL_ROW_221_3482 VGND VPWR sky130_fd_sc_hd__tapvpwrvgnd_1
XPHY_EDGE_ROW_30_1_Left_285 VGND VGND VPWR VPWR sky130_fd_sc_hd__decap_3
XFILLER_169_1377 VPWR VGND VPWR VGND sky130_ef_sc_hd__decap_12
XFILLER_165_1219 VPWR VGND VPWR VGND sky130_ef_sc_hd__decap_12
XTAP_TAPCELL_ROW_221_3493 VGND VPWR sky130_fd_sc_hd__tapvpwrvgnd_1
XFILLER_204_820 VPWR VGND VPWR VGND sky130_ef_sc_hd__decap_12
XFILLER_223_639 VGND VGND VPWR VPWR sky130_fd_sc_hd__decap_6
XFILLER_251_959 VPWR VGND VPWR VGND sky130_ef_sc_hd__decap_12
XFILLER_216_691 VPWR VGND VPWR VGND sky130_ef_sc_hd__decap_12
XFILLER_200_15 VGND VGND VPWR VPWR sky130_fd_sc_hd__decap_6
XFILLER_204_875 VGND VGND VPWR VPWR sky130_fd_sc_hd__decap_6
XFILLER_206_1238 VPWR VGND VPWR VGND sky130_ef_sc_hd__decap_12
XFILLER_54_1282 VPWR VGND VPWR VGND sky130_ef_sc_hd__decap_12
XFILLER_141_1230 VPWR VGND VPWR VGND sky130_ef_sc_hd__decap_12
XTAP_TAPCELL_ROW_178_1990 VGND VPWR sky130_fd_sc_hd__tapvpwrvgnd_1
XTAP_TAPCELL_ROW_174_1832 VGND VPWR sky130_fd_sc_hd__tapvpwrvgnd_1
XTAP_TAPCELL_ROW_174_1843 VGND VPWR sky130_fd_sc_hd__tapvpwrvgnd_1
XFILLER_175_259 VPWR VGND VPWR VGND sky130_ef_sc_hd__decap_12
XTAP_TAPCELL_ROW_215_3264 VGND VPWR sky130_fd_sc_hd__tapvpwrvgnd_1
XTAP_TAPCELL_ROW_174_1854 VGND VPWR sky130_fd_sc_hd__tapvpwrvgnd_1
XTAP_TAPCELL_ROW_215_3275 VGND VPWR sky130_fd_sc_hd__tapvpwrvgnd_1
XTAP_TAPCELL_ROW_215_3286 VGND VPWR sky130_fd_sc_hd__tapvpwrvgnd_1
XFILLER_141_1285 VGND VGND VPWR VPWR sky130_fd_sc_hd__decap_6
XTAP_TAPCELL_ROW_170_1707 VGND VPWR sky130_fd_sc_hd__tapvpwrvgnd_1
XTAP_TAPCELL_ROW_211_3128 VGND VPWR sky130_fd_sc_hd__tapvpwrvgnd_1
XTAP_TAPCELL_ROW_215_3297 VGND VPWR sky130_fd_sc_hd__tapvpwrvgnd_1
XFILLER_190_218 VPWR VGND VPWR VGND sky130_ef_sc_hd__decap_12
XTAP_TAPCELL_ROW_211_3139 VGND VPWR sky130_fd_sc_hd__tapvpwrvgnd_1
XFILLER_239_1014 VPWR VGND VPWR VGND sky130_ef_sc_hd__decap_12
Xwire370 net371 VGND VGND VPWR VPWR net370 sky130_fd_sc_hd__clkbuf_1
XTAP_TAPCELL_ROW_170_1718 VGND VPWR sky130_fd_sc_hd__tapvpwrvgnd_1
Xwire381 net382 VGND VGND VPWR VPWR net381 sky130_fd_sc_hd__clkbuf_1
Xwire392 net393 VGND VGND VPWR VPWR net392 sky130_fd_sc_hd__clkbuf_1
XFILLER_89_1378 VPWR VGND VPWR VGND sky130_ef_sc_hd__decap_12
XFILLER_209_68 VPWR VGND VPWR VGND sky130_ef_sc_hd__decap_12
Xmax_cap125 net126 VGND VGND VPWR VPWR net125 sky130_fd_sc_hd__clkbuf_1
Xmax_cap136 _145_ VGND VGND VPWR VPWR net136 sky130_fd_sc_hd__clkbuf_1
XFILLER_171_443 VPWR VGND VPWR VGND sky130_ef_sc_hd__decap_12
Xmax_cap147 _195_ VGND VGND VPWR VPWR net147 sky130_fd_sc_hd__clkbuf_1
XFILLER_176_1348 VGND VGND VPWR VPWR sky130_fd_sc_hd__decap_6
XFILLER_239_1069 VGND VGND VPWR VPWR sky130_fd_sc_hd__decap_6
Xmax_cap158 net159 VGND VGND VPWR VPWR net158 sky130_fd_sc_hd__clkbuf_1
Xmax_cap169 _135_ VGND VGND VPWR VPWR net169 sky130_fd_sc_hd__clkbuf_1
XFILLER_171_498 VPWR VGND VPWR VGND sky130_ef_sc_hd__decap_12
XFILLER_217_1334 VPWR VGND VPWR VGND sky130_ef_sc_hd__decap_12
XFILLER_63_1507 VGND VGND VPWR VPWR sky130_fd_sc_hd__decap_8
XTAP_TAPCELL_ROW_168_1625 VGND VPWR sky130_fd_sc_hd__tapvpwrvgnd_1
XFILLER_225_56 VPWR VGND VPWR VGND sky130_ef_sc_hd__decap_12
XFILLER_252_1269 VPWR VGND VPWR VGND sky130_ef_sc_hd__decap_12
XTAP_TAPCELL_ROW_168_1636 VGND VPWR sky130_fd_sc_hd__tapvpwrvgnd_1
XTAP_TAPCELL_ROW_209_3057 VGND VPWR sky130_fd_sc_hd__tapvpwrvgnd_1
XFILLER_217_1389 VPWR VGND VPWR VGND sky130_ef_sc_hd__decap_12
XTAP_TAPCELL_ROW_168_1647 VGND VPWR sky130_fd_sc_hd__tapvpwrvgnd_1
XTAP_TAPCELL_ROW_209_3068 VGND VPWR sky130_fd_sc_hd__tapvpwrvgnd_1
XTAP_TAPCELL_ROW_209_3079 VGND VPWR sky130_fd_sc_hd__tapvpwrvgnd_1
XFILLER_61_1242 VGND VGND VPWR VPWR sky130_fd_sc_hd__decap_6
XFILLER_6_1434 VGND VGND VPWR VPWR sky130_fd_sc_hd__decap_6
XFILLER_152_1392 VGND VGND VPWR VPWR sky130_fd_sc_hd__decap_6
XFILLER_241_44 VPWR VGND VPWR VGND sky130_ef_sc_hd__decap_12
XFILLER_226_433 VPWR VGND VPWR VGND sky130_ef_sc_hd__decap_12
XFILLER_254_753 VPWR VGND VPWR VGND sky130_ef_sc_hd__decap_12
XFILLER_187_1444 VPWR VGND VPWR VGND sky130_ef_sc_hd__decap_12
XFILLER_0_1000 VGND VGND VPWR VPWR sky130_fd_sc_hd__decap_8
XFILLER_253_252 VGND VGND VPWR VPWR sky130_fd_sc_hd__decap_6
XFILLER_96_1349 VGND VGND VPWR VPWR sky130_fd_sc_hd__decap_6
XFILLER_214_617 VGND VGND VPWR VPWR sky130_fd_sc_hd__decap_6
XFILLER_242_937 VPWR VGND VPWR VGND sky130_ef_sc_hd__decap_12
XFILLER_241_99 VPWR VGND VPWR VGND sky130_ef_sc_hd__decap_12
XFILLER_226_488 VGND VGND VPWR VPWR sky130_fd_sc_hd__decap_6
XFILLER_187_1499 VGND VGND VPWR VPWR sky130_fd_sc_hd__decap_6
XFILLER_228_1441 VPWR VGND VPWR VGND sky130_ef_sc_hd__decap_12
XFILLER_179_510 VGND VGND VPWR VPWR sky130_fd_sc_hd__decap_6
XFILLER_110_15 VGND VGND VPWR VPWR sky130_fd_sc_hd__decap_6
XTAP_TAPCELL_ROW_79_2_5297 VGND VPWR sky130_fd_sc_hd__tapvpwrvgnd_1
XFILLER_224_1305 VGND VGND VPWR VPWR sky130_fd_sc_hd__decap_6
XTAP_TAPCELL_ROW_123_2_5643 VGND VPWR sky130_fd_sc_hd__tapvpwrvgnd_1
XFILLER_228_1496 VPWR VGND VPWR VGND sky130_ef_sc_hd__decap_12
XFILLER_250_992 VPWR VGND VPWR VGND sky130_ef_sc_hd__decap_12
XPHY_EDGE_ROW_3_Right_3 VGND VGND VPWR VPWR sky130_fd_sc_hd__decap_3
XFILLER_146_1196 VPWR VGND VPWR VGND sky130_ef_sc_hd__decap_12
XFILLER_181_1076 VPWR VGND VPWR VGND sky130_ef_sc_hd__decap_12
XFILLER_166_237 VPWR VGND VPWR VGND sky130_ef_sc_hd__decap_12
XFILLER_120_1325 VPWR VGND VPWR VGND sky130_ef_sc_hd__decap_12
XFILLER_119_68 VGND VGND VPWR VPWR sky130_fd_sc_hd__decap_3
XTAP_TAPCELL_ROW_190_2390 VGND VPWR sky130_fd_sc_hd__tapvpwrvgnd_1
XTAP_TAPCELL_ROW_26_2_4870 VGND VPWR sky130_fd_sc_hd__tapvpwrvgnd_1
XFILLER_174_292 VPWR VGND VPWR VGND sky130_ef_sc_hd__decap_12
XFILLER_79_39 VGND VGND VPWR VPWR sky130_fd_sc_hd__decap_4
XFILLER_218_1109 VPWR VGND VPWR VGND sky130_ef_sc_hd__decap_12
XFILLER_235_1401 VPWR VGND VPWR VGND sky130_ef_sc_hd__decap_12
XFILLER_190_796 VPWR VGND VPWR VGND sky130_ef_sc_hd__decap_12
XFILLER_157_1292 VPWR VGND VPWR VGND sky130_ef_sc_hd__decap_12
XFILLER_235_1456 VGND VGND VPWR VPWR sky130_fd_sc_hd__decap_6
XFILLER_135_56 VPWR VGND VPWR VGND sky130_ef_sc_hd__decap_12
XFILLER_192_1183 VPWR VGND VPWR VGND sky130_ef_sc_hd__decap_12
XFILLER_95_27 VPWR VGND VPWR VGND sky130_ef_sc_hd__decap_12
XFILLER_0_169 VPWR VGND VPWR VGND sky130_ef_sc_hd__decap_12
XFILLER_153_1189 VPWR VGND VPWR VGND sky130_ef_sc_hd__decap_12
XTAP_TAPCELL_ROW_18_2_4807 VGND VPWR sky130_fd_sc_hd__tapvpwrvgnd_1
XFILLER_131_1421 VPWR VGND VPWR VGND sky130_ef_sc_hd__decap_12
XTAP_TAPCELL_ROW_184_2183 VGND VPWR sky130_fd_sc_hd__tapvpwrvgnd_1
XTAP_TAPCELL_ROW_184_2194 VGND VPWR sky130_fd_sc_hd__tapvpwrvgnd_1
XFILLER_188_1219 VGND VGND VPWR VPWR sky130_fd_sc_hd__decap_6
XFILLER_217_400 VPWR VGND VPWR VGND sky130_ef_sc_hd__decap_12
X_630_ clknet_3_5__leaf_clk dout0\[28\] _038_ VGND VGND VPWR VPWR dout0_q\[28\] sky130_fd_sc_hd__dfrtp_1
XFILLER_229_271 VPWR VGND VPWR VGND sky130_ef_sc_hd__decap_12
XFILLER_40_1337 VPWR VGND VPWR VGND sky130_ef_sc_hd__decap_12
XTAP_TAPCELL_ROW_180_2047 VGND VPWR sky130_fd_sc_hd__tapvpwrvgnd_1
XTAP_TAPCELL_ROW_180_2058 VGND VPWR sky130_fd_sc_hd__tapvpwrvgnd_1
XFILLER_131_1476 VPWR VGND VPWR VGND sky130_ef_sc_hd__decap_12
XFILLER_151_44 VPWR VGND VPWR VGND sky130_ef_sc_hd__decap_12
XTAP_TAPCELL_ROW_180_2069 VGND VPWR sky130_fd_sc_hd__tapvpwrvgnd_1
XFILLER_244_230 VGND VGND VPWR VPWR sky130_fd_sc_hd__decap_6
XFILLER_178_3 VPWR VGND VPWR VGND sky130_ef_sc_hd__decap_12
XFILLER_217_455 VPWR VGND VPWR VGND sky130_ef_sc_hd__decap_12
XFILLER_229_1205 VPWR VGND VPWR VGND sky130_ef_sc_hd__decap_12
XFILLER_233_904 VPWR VGND VPWR VGND sky130_ef_sc_hd__decap_12
XFILLER_245_775 VPWR VGND VPWR VGND sky130_ef_sc_hd__decap_12
X_561_ net664 VGND VGND VPWR VPWR _043_ sky130_fd_sc_hd__inv_2
XFILLER_205_639 VGND VGND VPWR VPWR sky130_fd_sc_hd__decap_6
XFILLER_233_959 VPWR VGND VPWR VGND sky130_ef_sc_hd__decap_12
X_492_ net170 net103 VGND VGND VPWR VPWR acc_core.adder.cla_blocks\[4\].block.sum\[0\]
+ sky130_fd_sc_hd__xnor2_1
XFILLER_207_1514 VGND VGND VPWR VPWR sky130_fd_sc_hd__fill_1
XFILLER_198_863 VPWR VGND VPWR VGND sky130_ef_sc_hd__decap_12
XFILLER_164_1263 VGND VGND VPWR VPWR sky130_fd_sc_hd__decap_6
XFILLER_9_715 VPWR VGND VPWR VGND sky130_ef_sc_hd__decap_12
XFILLER_199_1315 VPWR VGND VPWR VGND sky130_ef_sc_hd__decap_12
XFILLER_9_748 VGND VGND VPWR VPWR sky130_fd_sc_hd__decap_8
XFILLER_240_1140 VPWR VGND VPWR VGND sky130_ef_sc_hd__decap_12
XFILLER_51_1433 VPWR VGND VPWR VGND sky130_ef_sc_hd__decap_12
XFILLER_205_1260 VPWR VGND VPWR VGND sky130_ef_sc_hd__decap_12
XFILLER_200_366 VPWR VGND VPWR VGND sky130_ef_sc_hd__decap_12
XFILLER_240_1195 VPWR VGND VPWR VGND sky130_ef_sc_hd__decap_12
XFILLER_51_1488 VPWR VGND VPWR VGND sky130_ef_sc_hd__decap_12
XFILLER_172_218 VPWR VGND VPWR VGND sky130_ef_sc_hd__decap_12
XFILLER_84_1220 VGND VGND VPWR VPWR sky130_fd_sc_hd__decap_6
XFILLER_180_273 VGND VGND VPWR VPWR sky130_fd_sc_hd__decap_6
XFILLER_45_1204 VGND VGND VPWR VPWR sky130_fd_sc_hd__fill_1
XFILLER_10_1196 VPWR VGND VPWR VGND sky130_ef_sc_hd__decap_12
XFILLER_175_1370 VGND VGND VPWR VPWR sky130_fd_sc_hd__decap_6
XFILLER_255_517 VGND VGND VPWR VPWR sky130_fd_sc_hd__decap_8
XTAP_TAPCELL_ROW_227_3691 VGND VPWR sky130_fd_sc_hd__tapvpwrvgnd_1
XFILLER_251_1291 VPWR VGND VPWR VGND sky130_ef_sc_hd__decap_12
XTAP_TAPCELL_ROW_160_2_5939 VGND VPWR sky130_fd_sc_hd__tapvpwrvgnd_1
XTAP_TAPCELL_ROW_223_3544 VGND VPWR sky130_fd_sc_hd__tapvpwrvgnd_1
XFILLER_10_6 VPWR VGND VPWR VGND sky130_ef_sc_hd__decap_12
XTAP_TAPCELL_ROW_223_3555 VGND VPWR sky130_fd_sc_hd__tapvpwrvgnd_1
XTAP_TAPCELL_ROW_223_3566 VGND VPWR sky130_fd_sc_hd__tapvpwrvgnd_1
XFILLER_208_433 VPWR VGND VPWR VGND sky130_ef_sc_hd__decap_12
XTAP_TAPCELL_ROW_223_3577 VGND VPWR sky130_fd_sc_hd__tapvpwrvgnd_1
XFILLER_236_753 VPWR VGND VPWR VGND sky130_ef_sc_hd__decap_12
XFILLER_251_701 VPWR VGND VPWR VGND sky130_ef_sc_hd__decap_12
XFILLER_235_252 VGND VGND VPWR VPWR sky130_fd_sc_hd__decap_6
XFILLER_247_1327 VGND VGND VPWR VPWR sky130_fd_sc_hd__decap_6
XTAP_TAPCELL_ROW_65_2_5183 VGND VPWR sky130_fd_sc_hd__tapvpwrvgnd_1
XFILLER_169_1174 VPWR VGND VPWR VGND sky130_ef_sc_hd__decap_12
XFILLER_208_488 VGND VGND VPWR VPWR sky130_fd_sc_hd__decap_6
XFILLER_224_937 VPWR VGND VPWR VGND sky130_ef_sc_hd__decap_12
XFILLER_21_1292 VPWR VGND VPWR VGND sky130_ef_sc_hd__decap_12
XTAP_TAPCELL_ROW_108_2_5523 VGND VPWR sky130_fd_sc_hd__tapvpwrvgnd_1
XFILLER_251_756 VPWR VGND VPWR VGND sky130_ef_sc_hd__decap_12
XFILLER_189_830 VPWR VGND VPWR VGND sky130_ef_sc_hd__decap_12
XFILLER_95_1371 VGND VGND VPWR VPWR sky130_fd_sc_hd__decap_6
XFILLER_108_1423 VPWR VGND VPWR VGND sky130_ef_sc_hd__decap_12
XFILLER_210_108 VPWR VGND VPWR VGND sky130_ef_sc_hd__decap_12
XFILLER_93_3 VPWR VGND VPWR VGND sky130_ef_sc_hd__decap_12
XTAP_TAPCELL_ROW_176_1905 VGND VPWR sky130_fd_sc_hd__tapvpwrvgnd_1
XFILLER_232_992 VPWR VGND VPWR VGND sky130_ef_sc_hd__decap_12
XFILLER_52_1208 VPWR VGND VPWR VGND sky130_ef_sc_hd__decap_12
XFILLER_17_1328 VGND VGND VPWR VPWR sky130_fd_sc_hd__decap_6
XTAP_TAPCELL_ROW_176_1916 VGND VPWR sky130_fd_sc_hd__tapvpwrvgnd_1
XFILLER_189_885 VPWR VGND VPWR VGND sky130_ef_sc_hd__decap_12
XFILLER_206_1035 VPWR VGND VPWR VGND sky130_ef_sc_hd__decap_12
XTAP_TAPCELL_ROW_217_3337 VGND VPWR sky130_fd_sc_hd__tapvpwrvgnd_1
XTAP_TAPCELL_ROW_176_1927 VGND VPWR sky130_fd_sc_hd__tapvpwrvgnd_1
XTAP_TAPCELL_ROW_217_3348 VGND VPWR sky130_fd_sc_hd__tapvpwrvgnd_1
XFILLER_56_1399 VPWR VGND VPWR VGND sky130_ef_sc_hd__decap_12
XFILLER_143_1347 VPWR VGND VPWR VGND sky130_ef_sc_hd__decap_12
XTAP_TAPCELL_ROW_217_3359 VGND VPWR sky130_fd_sc_hd__tapvpwrvgnd_1
XFILLER_108_1478 VGND VGND VPWR VPWR sky130_fd_sc_hd__decap_6
XFILLER_236_22 VPWR VGND VPWR VGND sky130_ef_sc_hd__decap_12
XFILLER_171_240 VPWR VGND VPWR VGND sky130_ef_sc_hd__decap_12
XFILLER_172_796 VPWR VGND VPWR VGND sky130_ef_sc_hd__decap_12
XFILLER_236_77 VPWR VGND VPWR VGND sky130_ef_sc_hd__decap_12
XFILLER_252_1011 VPWR VGND VPWR VGND sky130_ef_sc_hd__decap_12
XFILLER_63_1304 VPWR VGND VPWR VGND sky130_ef_sc_hd__decap_12
XTAP_TAPCELL_ROW_45_1_1297 VGND VPWR sky130_fd_sc_hd__tapvpwrvgnd_1
XFILLER_171_295 VGND VGND VPWR VPWR sky130_fd_sc_hd__decap_6
XFILLER_217_1131 VPWR VGND VPWR VGND sky130_ef_sc_hd__decap_12
XFILLER_28_1435 VGND VGND VPWR VPWR sky130_fd_sc_hd__decap_6
XFILLER_154_1454 VPWR VGND VPWR VGND sky130_ef_sc_hd__decap_12
XFILLER_252_1066 VPWR VGND VPWR VGND sky130_ef_sc_hd__decap_12
XFILLER_63_1359 VPWR VGND VPWR VGND sky130_ef_sc_hd__decap_12
XFILLER_105_15 VPWR VGND VPWR VGND sky130_ef_sc_hd__decap_12
XFILLER_217_1186 VPWR VGND VPWR VGND sky130_ef_sc_hd__decap_12
XFILLER_189_1506 VGND VGND VPWR VPWR sky130_fd_sc_hd__decap_8
XFILLER_252_65 VPWR VGND VPWR VGND sky130_ef_sc_hd__decap_12
XFILLER_65_19 VPWR VGND VPWR VGND sky130_ef_sc_hd__decap_12
XTAP_TAPCELL_ROW_133_1_1429 VGND VPWR sky130_fd_sc_hd__tapvpwrvgnd_1
XTAP_TAPCELL_ROW_2_935 VGND VPWR sky130_fd_sc_hd__tapvpwrvgnd_1
XTAP_TAPCELL_ROW_2_946 VGND VPWR sky130_fd_sc_hd__tapvpwrvgnd_1
XFILLER_215_904 VPWR VGND VPWR VGND sky130_ef_sc_hd__decap_12
XFILLER_226_230 VGND VGND VPWR VPWR sky130_fd_sc_hd__decap_6
XFILLER_254_550 VPWR VGND VPWR VGND sky130_ef_sc_hd__decap_12
XTAP_TAPCELL_ROW_2_957 VGND VPWR sky130_fd_sc_hd__tapvpwrvgnd_1
XFILLER_187_1241 VGND VGND VPWR VPWR sky130_fd_sc_hd__decap_6
XFILLER_227_775 VPWR VGND VPWR VGND sky130_ef_sc_hd__decap_12
XFILLER_242_734 VPWR VGND VPWR VGND sky130_ef_sc_hd__decap_12
XFILLER_199_627 VPWR VGND VPWR VGND sky130_ef_sc_hd__decap_12
XFILLER_215_959 VPWR VGND VPWR VGND sky130_ef_sc_hd__decap_12
XFILLER_74_1411 VPWR VGND VPWR VGND sky130_ef_sc_hd__decap_12
XFILLER_230_918 VGND VGND VPWR VPWR sky130_fd_sc_hd__decap_6
XFILLER_242_789 VGND VGND VPWR VPWR sky130_fd_sc_hd__decap_6
XFILLER_74_1466 VPWR VGND VPWR VGND sky130_ef_sc_hd__decap_12
XFILLER_161_1414 VGND VGND VPWR VPWR sky130_fd_sc_hd__decap_6
XFILLER_195_811 VGND VGND VPWR VPWR sky130_fd_sc_hd__decap_6
XFILLER_201_80 VGND VGND VPWR VPWR sky130_fd_sc_hd__decap_6
XFILLER_228_1293 VPWR VGND VPWR VGND sky130_ef_sc_hd__decap_12
XFILLER_14_34 VPWR VGND VPWR VGND sky130_ef_sc_hd__decap_12
XTAP_TAPCELL_ROW_192_2463 VGND VPWR sky130_fd_sc_hd__tapvpwrvgnd_1
XTAP_TAPCELL_ROW_192_2474 VGND VPWR sky130_fd_sc_hd__tapvpwrvgnd_1
XFILLER_202_1422 VPWR VGND VPWR VGND sky130_ef_sc_hd__decap_12
XTAP_TAPCELL_ROW_192_2485 VGND VPWR sky130_fd_sc_hd__tapvpwrvgnd_1
XTAP_TAPCELL_ROW_153_2_5882 VGND VPWR sky130_fd_sc_hd__tapvpwrvgnd_1
XFILLER_182_538 VPWR VGND VPWR VGND sky130_ef_sc_hd__decap_12
XFILLER_30_22 VPWR VGND VPWR VGND sky130_ef_sc_hd__decap_12
XFILLER_202_1477 VGND VGND VPWR VPWR sky130_fd_sc_hd__decap_6
XFILLER_146_22 VPWR VGND VPWR VGND sky130_ef_sc_hd__decap_12
XFILLER_120_1177 VGND VGND VPWR VPWR sky130_fd_sc_hd__decap_6
XFILLER_155_1218 VPWR VGND VPWR VGND sky130_ef_sc_hd__decap_12
XFILLER_190_593 VPWR VGND VPWR VGND sky130_ef_sc_hd__decap_12
XFILLER_190_1109 VPWR VGND VPWR VGND sky130_ef_sc_hd__decap_12
XFILLER_2_968 VPWR VGND VPWR VGND sky130_ef_sc_hd__decap_12
XTAP_TAPCELL_ROW_186_2256 VGND VPWR sky130_fd_sc_hd__tapvpwrvgnd_1
XTAP_TAPCELL_ROW_186_2267 VGND VPWR sky130_fd_sc_hd__tapvpwrvgnd_1
XTAP_TAPCELL_ROW_145_2_5819 VGND VPWR sky130_fd_sc_hd__tapvpwrvgnd_1
XTAP_TAPCELL_ROW_182_2109 VGND VPWR sky130_fd_sc_hd__tapvpwrvgnd_1
XTAP_TAPCELL_ROW_186_2278 VGND VPWR sky130_fd_sc_hd__tapvpwrvgnd_1
XTAP_TAPCELL_ROW_114_2_5577 VGND VPWR sky130_fd_sc_hd__tapvpwrvgnd_1
XFILLER_237_517 VPWR VGND VPWR VGND sky130_ef_sc_hd__decap_12
XFILLER_249_388 VPWR VGND VPWR VGND sky130_ef_sc_hd__decap_12
XFILLER_44_1270 VPWR VGND VPWR VGND sky130_ef_sc_hd__decap_12
XFILLER_162_65 VGND VGND VPWR VPWR sky130_fd_sc_hd__decap_6
XFILLER_218_753 VPWR VGND VPWR VGND sky130_ef_sc_hd__decap_12
X_613_ clknet_3_6__leaf_clk dout0\[11\] _021_ VGND VGND VPWR VPWR dout0_q\[11\] sky130_fd_sc_hd__dfrtp_1
XFILLER_131_1273 VPWR VGND VPWR VGND sky130_ef_sc_hd__decap_12
XFILLER_217_252 VGND VGND VPWR VPWR sky130_fd_sc_hd__decap_6
XFILLER_229_1002 VPWR VGND VPWR VGND sky130_ef_sc_hd__decap_12
XFILLER_233_701 VPWR VGND VPWR VGND sky130_ef_sc_hd__decap_12
XFILLER_245_572 VPWR VGND VPWR VGND sky130_ef_sc_hd__decap_12
XFILLER_206_937 VPWR VGND VPWR VGND sky130_ef_sc_hd__decap_12
X_544_ net669 VGND VGND VPWR VPWR _026_ sky130_fd_sc_hd__inv_2
XFILLER_166_1336 VPWR VGND VPWR VGND sky130_ef_sc_hd__decap_12
XFILLER_229_1057 VPWR VGND VPWR VGND sky130_ef_sc_hd__decap_12
XFILLER_233_756 VPWR VGND VPWR VGND sky130_ef_sc_hd__decap_12
X_475_ net158 net110 VGND VGND VPWR VPWR acc_core.adder.cla_blocks\[2\].block.sum\[1\]
+ sky130_fd_sc_hd__xnor2_1
XFILLER_198_660 VGND VGND VPWR VPWR sky130_fd_sc_hd__decap_6
XFILLER_214_992 VPWR VGND VPWR VGND sky130_ef_sc_hd__decap_12
XTAP_TAPCELL_ROW_43_2_5006 VGND VPWR sky130_fd_sc_hd__tapvpwrvgnd_1
XFILLER_9_501 VGND VGND VPWR VPWR sky130_fd_sc_hd__decap_3
XFILLER_207_1377 VPWR VGND VPWR VGND sky130_ef_sc_hd__decap_12
XFILLER_140_1509 VGND VGND VPWR VPWR sky130_fd_sc_hd__decap_6
XFILLER_199_1112 VGND VGND VPWR VPWR sky130_fd_sc_hd__decap_6
XFILLER_51_1230 VPWR VGND VPWR VGND sky130_ef_sc_hd__decap_12
XTAP_TAPCELL_ROW_235_3971 VGND VPWR sky130_fd_sc_hd__tapvpwrvgnd_1
XTAP_TAPCELL_ROW_235_3982 VGND VPWR sky130_fd_sc_hd__tapvpwrvgnd_1
XFILLER_200_163 VPWR VGND VPWR VGND sky130_ef_sc_hd__decap_12
XTAP_TAPCELL_ROW_231_3824 VGND VPWR sky130_fd_sc_hd__tapvpwrvgnd_1
XTAP_TAPCELL_ROW_235_3993 VGND VPWR sky130_fd_sc_hd__tapvpwrvgnd_1
XTAP_TAPCELL_ROW_231_3835 VGND VPWR sky130_fd_sc_hd__tapvpwrvgnd_1
XFILLER_142_1380 VPWR VGND VPWR VGND sky130_ef_sc_hd__decap_12
XTAP_TAPCELL_ROW_231_3846 VGND VPWR sky130_fd_sc_hd__tapvpwrvgnd_1
XTAP_TAPCELL_ROW_231_3857 VGND VPWR sky130_fd_sc_hd__tapvpwrvgnd_1
XFILLER_65_7 VPWR VGND VPWR VGND sky130_ef_sc_hd__decap_12
XFILLER_51_1285 VGND VGND VPWR VPWR sky130_fd_sc_hd__decap_6
XFILLER_177_1432 VPWR VGND VPWR VGND sky130_ef_sc_hd__decap_12
XFILLER_86_1337 VPWR VGND VPWR VGND sky130_ef_sc_hd__decap_12
XFILLER_181_560 VPWR VGND VPWR VGND sky130_ef_sc_hd__decap_12
XFILLER_5_784 VGND VGND VPWR VPWR sky130_fd_sc_hd__fill_1
XFILLER_177_1487 VPWR VGND VPWR VGND sky130_ef_sc_hd__decap_12
XTAP_TAPCELL_ROW_229_3764 VGND VPWR sky130_fd_sc_hd__tapvpwrvgnd_1
XPHY_EDGE_ROW_164_1_Right_820 VGND VGND VPWR VPWR sky130_fd_sc_hd__decap_3
XFILLER_218_1484 VPWR VGND VPWR VGND sky130_ef_sc_hd__decap_12
XTAP_TAPCELL_ROW_229_3775 VGND VPWR sky130_fd_sc_hd__tapvpwrvgnd_1
XFILLER_206_58 VGND VGND VPWR VPWR sky130_fd_sc_hd__decap_6
XTAP_TAPCELL_ROW_225_3617 VGND VPWR sky130_fd_sc_hd__tapvpwrvgnd_1
XTAP_TAPCELL_ROW_229_3786 VGND VPWR sky130_fd_sc_hd__tapvpwrvgnd_1
XTAP_TAPCELL_ROW_225_3628 VGND VPWR sky130_fd_sc_hd__tapvpwrvgnd_1
XTAP_TAPCELL_ROW_225_3639 VGND VPWR sky130_fd_sc_hd__tapvpwrvgnd_1
XFILLER_136_1184 VPWR VGND VPWR VGND sky130_ef_sc_hd__decap_12
XFILLER_214_1348 VGND VGND VPWR VPWR sky130_fd_sc_hd__decap_6
XFILLER_1_990 VPWR VGND VPWR VGND sky130_ef_sc_hd__decap_12
XFILLER_62_1392 VGND VGND VPWR VPWR sky130_fd_sc_hd__decap_6
XPHY_EDGE_ROW_41_2_Left_543 VGND VGND VPWR VPWR sky130_fd_sc_hd__decap_3
XFILLER_255_358 VPWR VGND VPWR VGND sky130_ef_sc_hd__decap_12
XFILLER_110_1313 VPWR VGND VPWR VGND sky130_ef_sc_hd__decap_12
XFILLER_208_230 VGND VGND VPWR VPWR sky130_fd_sc_hd__decap_6
XFILLER_236_550 VPWR VGND VPWR VGND sky130_ef_sc_hd__decap_12
XFILLER_97_1433 VPWR VGND VPWR VGND sky130_ef_sc_hd__decap_12
XFILLER_209_775 VPWR VGND VPWR VGND sky130_ef_sc_hd__decap_12
XFILLER_222_46 VPWR VGND VPWR VGND sky130_ef_sc_hd__decap_12
XFILLER_110_1368 VPWR VGND VPWR VGND sky130_ef_sc_hd__decap_12
XFILLER_224_734 VPWR VGND VPWR VGND sky130_ef_sc_hd__decap_12
XFILLER_97_1488 VPWR VGND VPWR VGND sky130_ef_sc_hd__decap_12
XFILLER_251_553 VGND VGND VPWR VPWR sky130_fd_sc_hd__decap_6
XFILLER_212_918 VGND VGND VPWR VPWR sky130_fd_sc_hd__decap_6
XFILLER_224_789 VGND VGND VPWR VPWR sky130_fd_sc_hd__decap_6
XFILLER_108_1220 VGND VGND VPWR VPWR sky130_fd_sc_hd__decap_6
XFILLER_177_811 VGND VGND VPWR VPWR sky130_fd_sc_hd__decap_6
XFILLER_225_1444 VPWR VGND VPWR VGND sky130_ef_sc_hd__decap_12
XFILLER_189_682 VGND VGND VPWR VPWR sky130_fd_sc_hd__decap_6
XFILLER_56_1196 VPWR VGND VPWR VGND sky130_ef_sc_hd__decap_12
XTAP_TAPCELL_ROW_138_2_5762 VGND VPWR sky130_fd_sc_hd__tapvpwrvgnd_1
XFILLER_225_1499 VGND VGND VPWR VPWR sky130_fd_sc_hd__decap_6
XFILLER_143_1177 VPWR VGND VPWR VGND sky130_ef_sc_hd__decap_12
XPHY_EDGE_ROW_118_1_Left_373 VGND VGND VPWR VPWR sky130_fd_sc_hd__decap_3
XFILLER_178_1207 VPWR VGND VPWR VGND sky130_ef_sc_hd__decap_12
XFILLER_191_302 VPWR VGND VPWR VGND sky130_ef_sc_hd__decap_12
XFILLER_30_1325 VPWR VGND VPWR VGND sky130_ef_sc_hd__decap_12
XFILLER_121_1464 VPWR VGND VPWR VGND sky130_ef_sc_hd__decap_12
XFILLER_191_357 VPWR VGND VPWR VGND sky130_ef_sc_hd__decap_12
XFILLER_247_87 VPWR VGND VPWR VGND sky130_ef_sc_hd__decap_12
XTAP_TAPCELL_ROW_87_2_5359 VGND VPWR sky130_fd_sc_hd__tapvpwrvgnd_1
XPHY_EDGE_ROW_55_1_Left_310 VGND VGND VPWR VPWR sky130_fd_sc_hd__decap_3
XFILLER_219_1248 VPWR VGND VPWR VGND sky130_ef_sc_hd__decap_12
XFILLER_172_593 VPWR VGND VPWR VGND sky130_ef_sc_hd__decap_12
XTAP_TAPCELL_ROW_100_2_5463 VGND VPWR sky130_fd_sc_hd__tapvpwrvgnd_1
XFILLER_67_1292 VPWR VGND VPWR VGND sky130_ef_sc_hd__decap_12
XFILLER_116_58 VGND VGND VPWR VPWR sky130_fd_sc_hd__decap_6
XFILLER_154_1251 VPWR VGND VPWR VGND sky130_ef_sc_hd__decap_12
XFILLER_119_1371 VGND VGND VPWR VPWR sky130_fd_sc_hd__decap_6
XFILLER_8_1348 VGND VGND VPWR VPWR sky130_fd_sc_hd__decap_6
XFILLER_219_517 VPWR VGND VPWR VGND sky130_ef_sc_hd__decap_12
XFILLER_63_1189 VPWR VGND VPWR VGND sky130_ef_sc_hd__decap_12
XFILLER_189_1303 VPWR VGND VPWR VGND sky130_ef_sc_hd__decap_12
XFILLER_41_1421 VPWR VGND VPWR VGND sky130_ef_sc_hd__decap_12
XTAP_TAPCELL_ROW_241_4175 VGND VPWR sky130_fd_sc_hd__tapvpwrvgnd_1
XFILLER_98_1208 VPWR VGND VPWR VGND sky130_ef_sc_hd__decap_12
XTAP_TAPCELL_ROW_241_4186 VGND VPWR sky130_fd_sc_hd__tapvpwrvgnd_1
XFILLER_246_347 VPWR VGND VPWR VGND sky130_ef_sc_hd__decap_12
XTAP_TAPCELL_ROW_241_4197 VGND VPWR sky130_fd_sc_hd__tapvpwrvgnd_1
XTAP_TAPCELL_ROW_34_2_4932 VGND VPWR sky130_fd_sc_hd__tapvpwrvgnd_1
XFILLER_189_1358 VPWR VGND VPWR VGND sky130_ef_sc_hd__decap_12
XFILLER_41_1476 VPWR VGND VPWR VGND sky130_ef_sc_hd__decap_12
XFILLER_132_46 VPWR VGND VPWR VGND sky130_ef_sc_hd__decap_12
XFILLER_230_1183 VPWR VGND VPWR VGND sky130_ef_sc_hd__decap_12
XFILLER_215_701 VPWR VGND VPWR VGND sky130_ef_sc_hd__decap_12
XFILLER_227_572 VPWR VGND VPWR VGND sky130_ef_sc_hd__decap_12
XFILLER_242_531 VGND VGND VPWR VPWR sky130_fd_sc_hd__decap_6
XFILLER_199_424 VGND VGND VPWR VPWR sky130_fd_sc_hd__decap_6
XFILLER_215_756 VPWR VGND VPWR VGND sky130_ef_sc_hd__decap_12
XFILLER_25_33 VGND VGND VPWR VPWR sky130_fd_sc_hd__fill_1
XFILLER_226_1219 VGND VGND VPWR VPWR sky130_fd_sc_hd__decap_6
XFILLER_25_44 VGND VGND VPWR VPWR sky130_fd_sc_hd__decap_4
XTAP_TAPCELL_ROW_198_2672 VGND VPWR sky130_fd_sc_hd__tapvpwrvgnd_1
XTAP_TAPCELL_ROW_198_2683 VGND VPWR sky130_fd_sc_hd__tapvpwrvgnd_1
XFILLER_25_66 VGND VGND VPWR VPWR sky130_fd_sc_hd__fill_2
XTAP_TAPCELL_ROW_198_2694 VGND VPWR sky130_fd_sc_hd__tapvpwrvgnd_1
XTAP_TAPCELL_ROW_194_2536 VGND VPWR sky130_fd_sc_hd__tapvpwrvgnd_1
XFILLER_74_1263 VGND VGND VPWR VPWR sky130_fd_sc_hd__decap_6
XTAP_TAPCELL_ROW_194_2547 VGND VPWR sky130_fd_sc_hd__tapvpwrvgnd_1
XFILLER_228_1090 VGND VGND VPWR VPWR sky130_fd_sc_hd__decap_6
XFILLER_211_940 VGND VGND VPWR VPWR sky130_fd_sc_hd__decap_6
XTAP_TAPCELL_ROW_194_2558 VGND VPWR sky130_fd_sc_hd__tapvpwrvgnd_1
XFILLER_194_151 VPWR VGND VPWR VGND sky130_ef_sc_hd__decap_12
XFILLER_122_1239 VPWR VGND VPWR VGND sky130_ef_sc_hd__decap_12
XFILLER_182_335 VPWR VGND VPWR VGND sky130_ef_sc_hd__decap_12
XFILLER_210_3 VPWR VGND VPWR VGND sky130_ef_sc_hd__decap_12
XFILLER_170_519 VPWR VGND VPWR VGND sky130_ef_sc_hd__decap_12
XFILLER_237_1315 VPWR VGND VPWR VGND sky130_ef_sc_hd__decap_12
XTAP_TAPCELL_ROW_188_2329 VGND VPWR sky130_fd_sc_hd__tapvpwrvgnd_1
XFILLER_190_390 VPWR VGND VPWR VGND sky130_ef_sc_hd__decap_12
XFILLER_1_220 VGND VGND VPWR VPWR sky130_fd_sc_hd__fill_1
XFILLER_2_743 VGND VGND VPWR VPWR sky130_fd_sc_hd__decap_8
XFILLER_81_1201 VGND VGND VPWR VPWR sky130_fd_sc_hd__decap_4
XFILLER_194_1097 VPWR VGND VPWR VGND sky130_ef_sc_hd__decap_12
XFILLER_1_253 VGND VGND VPWR VPWR sky130_fd_sc_hd__decap_4
XFILLER_249_130 VPWR VGND VPWR VGND sky130_ef_sc_hd__decap_12
XPHY_EDGE_ROW_8_Left_264 VGND VGND VPWR VPWR sky130_fd_sc_hd__decap_3
XFILLER_133_1335 VPWR VGND VPWR VGND sky130_ef_sc_hd__decap_12
XFILLER_237_314 VPWR VGND VPWR VGND sky130_ef_sc_hd__decap_12
XFILLER_249_185 VPWR VGND VPWR VGND sky130_ef_sc_hd__decap_12
XTAP_TAPCELL_ROW_103_1_1384 VGND VPWR sky130_fd_sc_hd__tapvpwrvgnd_1
XFILLER_213_1370 VGND VGND VPWR VPWR sky130_fd_sc_hd__decap_6
XFILLER_253_818 VPWR VGND VPWR VGND sky130_ef_sc_hd__decap_12
XFILLER_237_369 VPWR VGND VPWR VGND sky130_ef_sc_hd__decap_12
XFILLER_218_550 VPWR VGND VPWR VGND sky130_ef_sc_hd__decap_12
XFILLER_248_1422 VPWR VGND VPWR VGND sky130_ef_sc_hd__decap_12
XFILLER_206_734 VPWR VGND VPWR VGND sky130_ef_sc_hd__decap_12
XFILLER_166_1133 VGND VGND VPWR VPWR sky130_fd_sc_hd__decap_6
XFILLER_248_1477 VGND VGND VPWR VPWR sky130_fd_sc_hd__decap_6
XTAP_TAPCELL_ROW_155_2_5901 VGND VPWR sky130_fd_sc_hd__tapvpwrvgnd_1
XFILLER_233_553 VGND VGND VPWR VPWR sky130_fd_sc_hd__decap_6
X_527_ net664 VGND VGND VPWR VPWR _009_ sky130_fd_sc_hd__inv_2
XFILLER_206_789 VGND VGND VPWR VPWR sky130_fd_sc_hd__decap_6
XFILLER_18_1423 VPWR VGND VPWR VGND sky130_ef_sc_hd__decap_12
X_458_ net610 net6 net625 VGND VGND VPWR VPWR addr0\[4\] sky130_fd_sc_hd__mux2_1
XFILLER_144_1442 VPWR VGND VPWR VGND sky130_ef_sc_hd__decap_12
XTAP_TAPCELL_ROW_233_3908 VGND VPWR sky130_fd_sc_hd__tapvpwrvgnd_1
XFILLER_242_1054 VPWR VGND VPWR VGND sky130_ef_sc_hd__decap_12
XFILLER_207_1174 VPWR VGND VPWR VGND sky130_ef_sc_hd__decap_12
XTAP_TAPCELL_ROW_233_3919 VGND VPWR sky130_fd_sc_hd__tapvpwrvgnd_1
XFILLER_53_1347 VPWR VGND VPWR VGND sky130_ef_sc_hd__decap_12
XFILLER_18_1478 VGND VGND VPWR VPWR sky130_fd_sc_hd__decap_6
XFILLER_9_331 VGND VGND VPWR VPWR sky130_fd_sc_hd__decap_4
XFILLER_140_1306 VGND VGND VPWR VPWR sky130_fd_sc_hd__decap_6
X_389_ _169_ net213 _177_ _167_ VGND VGND VPWR VPWR _178_ sky130_fd_sc_hd__a211oi_1
XFILLER_144_1497 VPWR VGND VPWR VGND sky130_ef_sc_hd__decap_12
XFILLER_173_302 VPWR VGND VPWR VGND sky130_ef_sc_hd__decap_12
XFILLER_185_173 VPWR VGND VPWR VGND sky130_ef_sc_hd__decap_12
XTAP_TAPCELL_ROW_73_2_5245 VGND VPWR sky130_fd_sc_hd__tapvpwrvgnd_1
XFILLER_173_357 VPWR VGND VPWR VGND sky130_ef_sc_hd__decap_12
XFILLER_56_3 VPWR VGND VPWR VGND sky130_ef_sc_hd__decap_12
XFILLER_177_1284 VGND VGND VPWR VPWR sky130_fd_sc_hd__decap_6
XFILLER_217_68 VPWR VGND VPWR VGND sky130_ef_sc_hd__decap_12
XFILLER_64_1454 VPWR VGND VPWR VGND sky130_ef_sc_hd__decap_12
XFILLER_151_1402 VPWR VGND VPWR VGND sky130_ef_sc_hd__decap_12
XFILLER_218_1281 VPWR VGND VPWR VGND sky130_ef_sc_hd__decap_12
XTAP_TAPCELL_ROW_19_2_4812 VGND VPWR sky130_fd_sc_hd__tapvpwrvgnd_1
XFILLER_190_1484 VPWR VGND VPWR VGND sky130_ef_sc_hd__decap_12
XFILLER_151_1457 VGND VGND VPWR VPWR sky130_fd_sc_hd__decap_6
XFILLER_233_56 VPWR VGND VPWR VGND sky130_ef_sc_hd__decap_12
XFILLER_228_347 VPWR VGND VPWR VGND sky130_ef_sc_hd__decap_12
XFILLER_7_1370 VGND VGND VPWR VPWR sky130_fd_sc_hd__decap_6
XFILLER_97_1230 VPWR VGND VPWR VGND sky130_ef_sc_hd__decap_12
XFILLER_209_572 VPWR VGND VPWR VGND sky130_ef_sc_hd__decap_12
XFILLER_110_1165 VPWR VGND VPWR VGND sky130_ef_sc_hd__decap_12
XFILLER_224_531 VGND VGND VPWR VPWR sky130_fd_sc_hd__decap_6
XFILLER_227_1506 VGND VGND VPWR VPWR sky130_fd_sc_hd__decap_8
XFILLER_252_851 VPWR VGND VPWR VGND sky130_ef_sc_hd__decap_12
XFILLER_188_1391 VGND VGND VPWR VPWR sky130_fd_sc_hd__decap_6
XFILLER_97_1285 VGND VGND VPWR VPWR sky130_fd_sc_hd__decap_6
XFILLER_145_1206 VPWR VGND VPWR VGND sky130_ef_sc_hd__decap_12
XFILLER_197_928 VPWR VGND VPWR VGND sky130_ef_sc_hd__decap_12
XFILLER_71_1414 VGND VGND VPWR VPWR sky130_fd_sc_hd__decap_6
XTAP_TAPCELL_ROW_201_2790 VGND VPWR sky130_fd_sc_hd__tapvpwrvgnd_1
XFILLER_225_1241 VGND VGND VPWR VPWR sky130_fd_sc_hd__decap_6
XFILLER_176_151 VPWR VGND VPWR VGND sky130_ef_sc_hd__decap_12
XTAP_TAPCELL_ROW_33_1_1279 VGND VPWR sky130_fd_sc_hd__tapvpwrvgnd_1
XFILLER_178_1004 VGND VGND VPWR VPWR sky130_fd_sc_hd__decap_6
XFILLER_121_1261 VPWR VGND VPWR VGND sky130_ef_sc_hd__decap_12
XFILLER_191_154 VPWR VGND VPWR VGND sky130_ef_sc_hd__decap_12
XFILLER_180_839 VPWR VGND VPWR VGND sky130_ef_sc_hd__decap_12
XFILLER_30_1177 VGND VGND VPWR VPWR sky130_fd_sc_hd__decap_6
XFILLER_156_1313 VPWR VGND VPWR VGND sky130_ef_sc_hd__decap_12
XFILLER_65_1218 VPWR VGND VPWR VGND sky130_ef_sc_hd__decap_12
XFILLER_172_390 VPWR VGND VPWR VGND sky130_ef_sc_hd__decap_12
XFILLER_219_1045 VPWR VGND VPWR VGND sky130_ef_sc_hd__decap_12
XFILLER_127_68 VGND VGND VPWR VPWR sky130_fd_sc_hd__decap_3
XTAP_TAPCELL_ROW_247_4384 VGND VPWR sky130_fd_sc_hd__tapvpwrvgnd_1
XFILLER_87_39 VGND VGND VPWR VPWR sky130_fd_sc_hd__decap_4
XFILLER_191_1248 VPWR VGND VPWR VGND sky130_ef_sc_hd__decap_12
XTAP_TAPCELL_ROW_247_4395 VGND VPWR sky130_fd_sc_hd__tapvpwrvgnd_1
XFILLER_156_1368 VPWR VGND VPWR VGND sky130_ef_sc_hd__decap_12
XTAP_TAPCELL_ROW_243_4248 VGND VPWR sky130_fd_sc_hd__tapvpwrvgnd_1
XTAP_TAPCELL_ROW_243_4259 VGND VPWR sky130_fd_sc_hd__tapvpwrvgnd_1
XFILLER_219_314 VPWR VGND VPWR VGND sky130_ef_sc_hd__decap_12
XFILLER_189_1100 VPWR VGND VPWR VGND sky130_ef_sc_hd__decap_12
XFILLER_143_56 VPWR VGND VPWR VGND sky130_ef_sc_hd__decap_12
XFILLER_246_144 VGND VGND VPWR VPWR sky130_fd_sc_hd__decap_6
XTAP_TAPCELL_ROW_9_1184 VGND VPWR sky130_fd_sc_hd__tapvpwrvgnd_1
XTAP_TAPCELL_ROW_129_2_5696 VGND VPWR sky130_fd_sc_hd__tapvpwrvgnd_1
XFILLER_219_369 VPWR VGND VPWR VGND sky130_ef_sc_hd__decap_12
XFILLER_235_818 VPWR VGND VPWR VGND sky130_ef_sc_hd__decap_12
XFILLER_247_689 VPWR VGND VPWR VGND sky130_ef_sc_hd__decap_12
XTAP_TAPCELL_ROW_9_1195 VGND VPWR sky130_fd_sc_hd__tapvpwrvgnd_1
XTAP_TAPCELL_ROW_97_2_5441 VGND VPWR sky130_fd_sc_hd__tapvpwrvgnd_1
XFILLER_189_1155 VGND VGND VPWR VPWR sky130_fd_sc_hd__decap_6
XTAP_TAPCELL_ROW_5_1037 VGND VPWR sky130_fd_sc_hd__tapvpwrvgnd_1
XFILLER_41_1273 VPWR VGND VPWR VGND sky130_ef_sc_hd__decap_12
XTAP_TAPCELL_ROW_5_1048 VGND VPWR sky130_fd_sc_hd__tapvpwrvgnd_1
XTAP_TAPCELL_ROW_5_1059 VGND VPWR sky130_fd_sc_hd__tapvpwrvgnd_1
XFILLER_167_1420 VPWR VGND VPWR VGND sky130_ef_sc_hd__decap_12
XFILLER_36_54 VGND VGND VPWR VPWR sky130_fd_sc_hd__decap_8
XFILLER_36_65 VGND VGND VPWR VPWR sky130_fd_sc_hd__decap_3
XFILLER_76_1325 VPWR VGND VPWR VGND sky130_ef_sc_hd__decap_12
XFILLER_160_3 VPWR VGND VPWR VGND sky130_ef_sc_hd__decap_12
XTAP_TAPCELL_ROW_196_2609 VGND VPWR sky130_fd_sc_hd__tapvpwrvgnd_1
XFILLER_215_553 VGND VGND VPWR VPWR sky130_fd_sc_hd__decap_6
XFILLER_243_873 VPWR VGND VPWR VGND sky130_ef_sc_hd__decap_12
XFILLER_188_906 VPWR VGND VPWR VGND sky130_ef_sc_hd__decap_12
XFILLER_167_1475 VPWR VGND VPWR VGND sky130_ef_sc_hd__decap_12
XFILLER_163_1328 VGND VGND VPWR VPWR sky130_fd_sc_hd__decap_6
X_312_ net597 dout0_q\[27\] net529 VGND VGND VPWR VPWR _101_ sky130_fd_sc_hd__a21oi_1
XFILLER_39_1180 VPWR VGND VPWR VGND sky130_ef_sc_hd__decap_12
XTAP_TAPCELL_ROW_122_2_5639 VGND VPWR sky130_fd_sc_hd__tapvpwrvgnd_1
XFILLER_196_961 VGND VGND VPWR VPWR sky130_fd_sc_hd__decap_6
XFILLER_50_1509 VGND VGND VPWR VPWR sky130_fd_sc_hd__decap_6
XFILLER_204_1336 VPWR VGND VPWR VGND sky130_ef_sc_hd__decap_12
XTAP_TAPCELL_ROW_58_2_5125 VGND VPWR sky130_fd_sc_hd__tapvpwrvgnd_1
Xinput18 wr_data[17] VGND VGND VPWR VPWR net18 sky130_fd_sc_hd__clkbuf_1
XFILLER_210_280 VPWR VGND VPWR VGND sky130_ef_sc_hd__decap_12
XFILLER_167_173 VPWR VGND VPWR VGND sky130_ef_sc_hd__decap_12
Xinput29 wr_data[27] VGND VGND VPWR VPWR net29 sky130_fd_sc_hd__clkbuf_1
XPHY_EDGE_ROW_244_Right_89 VGND VGND VPWR VPWR sky130_fd_sc_hd__decap_3
XFILLER_52_1380 VPWR VGND VPWR VGND sky130_ef_sc_hd__decap_12
XFILLER_6_323 VGND VGND VPWR VPWR sky130_fd_sc_hd__fill_1
XFILLER_6_334 VGND VGND VPWR VPWR sky130_fd_sc_hd__fill_1
XFILLER_182_132 VPWR VGND VPWR VGND sky130_ef_sc_hd__decap_12
XFILLER_87_1421 VPWR VGND VPWR VGND sky130_ef_sc_hd__decap_12
XFILLER_139_1500 VGND VGND VPWR VPWR sky130_fd_sc_hd__decap_6
XFILLER_170_316 VGND VGND VPWR VPWR sky130_fd_sc_hd__decap_6
XFILLER_182_187 VGND VGND VPWR VPWR sky130_fd_sc_hd__decap_6
XFILLER_237_1112 VGND VGND VPWR VPWR sky130_fd_sc_hd__decap_6
XFILLER_100_1356 VPWR VGND VPWR VGND sky130_ef_sc_hd__decap_12
XFILLER_87_1476 VPWR VGND VPWR VGND sky130_ef_sc_hd__decap_12
Xsram0_680 VGND VGND VPWR VPWR sram0_680/HI net680 sky130_fd_sc_hd__conb_1
XFILLER_250_1312 VPWR VGND VPWR VGND sky130_ef_sc_hd__decap_12
XFILLER_215_1432 VPWR VGND VPWR VGND sky130_ef_sc_hd__decap_12
XFILLER_46_1184 VPWR VGND VPWR VGND sky130_ef_sc_hd__decap_12
XFILLER_250_1367 VPWR VGND VPWR VGND sky130_ef_sc_hd__decap_12
XFILLER_237_111 VPWR VGND VPWR VGND sky130_ef_sc_hd__decap_12
XFILLER_215_1487 VPWR VGND VPWR VGND sky130_ef_sc_hd__decap_12
XFILLER_133_1165 VPWR VGND VPWR VGND sky130_ef_sc_hd__decap_12
XPHY_EDGE_ROW_253_Right_98 VGND VGND VPWR VPWR sky130_fd_sc_hd__decap_3
XFILLER_238_667 VPWR VGND VPWR VGND sky130_ef_sc_hd__decap_12
XFILLER_203_15 VPWR VGND VPWR VGND sky130_ef_sc_hd__decap_12
XFILLER_253_615 VPWR VGND VPWR VGND sky130_ef_sc_hd__decap_12
XFILLER_237_166 VGND VGND VPWR VPWR sky130_fd_sc_hd__decap_6
XFILLER_20_1313 VPWR VGND VPWR VGND sky130_ef_sc_hd__decap_12
XFILLER_206_531 VGND VGND VPWR VPWR sky130_fd_sc_hd__decap_6
XFILLER_0_1429 VPWR VGND VPWR VGND sky130_ef_sc_hd__decap_12
XFILLER_234_851 VPWR VGND VPWR VGND sky130_ef_sc_hd__decap_12
XFILLER_20_1368 VPWR VGND VPWR VGND sky130_ef_sc_hd__decap_12
XFILLER_179_928 VPWR VGND VPWR VGND sky130_ef_sc_hd__decap_12
XFILLER_18_1220 VGND VGND VPWR VPWR sky130_fd_sc_hd__decap_6
XFILLER_105_1201 VGND VGND VPWR VPWR sky130_fd_sc_hd__decap_4
XFILLER_187_983 VGND VGND VPWR VPWR sky130_fd_sc_hd__decap_6
XFILLER_53_1177 VPWR VGND VPWR VGND sky130_ef_sc_hd__decap_12
XFILLER_144_1294 VPWR VGND VPWR VGND sky130_ef_sc_hd__decap_12
XFILLER_179_1346 VPWR VGND VPWR VGND sky130_ef_sc_hd__decap_12
XFILLER_228_34 VPWR VGND VPWR VGND sky130_ef_sc_hd__decap_12
XFILLER_31_1464 VPWR VGND VPWR VGND sky130_ef_sc_hd__decap_12
XFILLER_173_154 VPWR VGND VPWR VGND sky130_ef_sc_hd__decap_12
XFILLER_228_89 VPWR VGND VPWR VGND sky130_ef_sc_hd__decap_12
XFILLER_216_1207 VPWR VGND VPWR VGND sky130_ef_sc_hd__decap_12
XFILLER_244_22 VPWR VGND VPWR VGND sky130_ef_sc_hd__decap_12
XFILLER_248_409 VPWR VGND VPWR VGND sky130_ef_sc_hd__decap_12
XFILLER_170_894 VPWR VGND VPWR VGND sky130_ef_sc_hd__decap_12
XFILLER_64_1251 VPWR VGND VPWR VGND sky130_ef_sc_hd__decap_12
XFILLER_29_1371 VGND VGND VPWR VPWR sky130_fd_sc_hd__decap_6
XFILLER_244_77 VPWR VGND VPWR VGND sky130_ef_sc_hd__decap_12
XTAP_TAPCELL_ROW_115_2_5582 VGND VPWR sky130_fd_sc_hd__tapvpwrvgnd_1
XFILLER_155_1390 VPWR VGND VPWR VGND sky130_ef_sc_hd__decap_12
XFILLER_190_1281 VPWR VGND VPWR VGND sky130_ef_sc_hd__decap_12
XFILLER_3_80 VGND VGND VPWR VPWR sky130_fd_sc_hd__decap_6
XFILLER_112_1227 VPWR VGND VPWR VGND sky130_ef_sc_hd__decap_12
XFILLER_217_818 VPWR VGND VPWR VGND sky130_ef_sc_hd__decap_12
XFILLER_228_144 VGND VGND VPWR VPWR sky130_fd_sc_hd__decap_6
XFILLER_113_15 VPWR VGND VPWR VGND sky130_ef_sc_hd__decap_12
XFILLER_99_1347 VPWR VGND VPWR VGND sky130_ef_sc_hd__decap_12
XFILLER_229_689 VPWR VGND VPWR VGND sky130_ef_sc_hd__decap_12
XFILLER_244_648 VPWR VGND VPWR VGND sky130_ef_sc_hd__decap_12
XTAP_TAPCELL_ROW_203_2852 VGND VPWR sky130_fd_sc_hd__tapvpwrvgnd_1
XFILLER_227_1303 VPWR VGND VPWR VGND sky130_ef_sc_hd__decap_12
XTAP_TAPCELL_ROW_203_2863 VGND VPWR sky130_fd_sc_hd__tapvpwrvgnd_1
XFILLER_225_873 VPWR VGND VPWR VGND sky130_ef_sc_hd__decap_12
XTAP_TAPCELL_ROW_203_2874 VGND VPWR sky130_fd_sc_hd__tapvpwrvgnd_1
Xwire75 _267_ VGND VGND VPWR VPWR net75 sky130_fd_sc_hd__clkbuf_1
XTAP_TAPCELL_ROW_107_2_5519 VGND VPWR sky130_fd_sc_hd__tapvpwrvgnd_1
Xwire86 _249_ VGND VGND VPWR VPWR net86 sky130_fd_sc_hd__clkbuf_1
XTAP_TAPCELL_ROW_236_4030 VGND VPWR sky130_fd_sc_hd__tapvpwrvgnd_1
XTAP_TAPCELL_ROW_255_4664 VGND VPWR sky130_fd_sc_hd__tapvpwrvgnd_1
XFILLER_240_832 VGND VGND VPWR VPWR sky130_fd_sc_hd__decap_6
XFILLER_197_725 VGND VGND VPWR VPWR sky130_fd_sc_hd__decap_6
XTAP_TAPCELL_ROW_255_4675 VGND VPWR sky130_fd_sc_hd__tapvpwrvgnd_1
Xwire97 _212_ VGND VGND VPWR VPWR net97 sky130_fd_sc_hd__clkbuf_1
XFILLER_227_1358 VPWR VGND VPWR VGND sky130_ef_sc_hd__decap_12
XTAP_TAPCELL_ROW_255_4686 VGND VPWR sky130_fd_sc_hd__tapvpwrvgnd_1
XTAP_TAPCELL_ROW_44_2_5011 VGND VPWR sky130_fd_sc_hd__tapvpwrvgnd_1
XTAP_TAPCELL_ROW_251_4528 VGND VPWR sky130_fd_sc_hd__tapvpwrvgnd_1
XTAP_TAPCELL_ROW_255_4697 VGND VPWR sky130_fd_sc_hd__tapvpwrvgnd_1
XTAP_TAPCELL_ROW_251_4539 VGND VPWR sky130_fd_sc_hd__tapvpwrvgnd_1
XPHY_EDGE_ROW_129_2_Left_631 VGND VGND VPWR VPWR sky130_fd_sc_hd__decap_3
XFILLER_240_1514 VGND VGND VPWR VPWR sky130_fd_sc_hd__fill_1
XFILLER_178_961 VGND VGND VPWR VPWR sky130_fd_sc_hd__decap_6
XFILLER_22_34 VPWR VGND VPWR VGND sky130_ef_sc_hd__decap_12
XFILLER_165_622 VGND VGND VPWR VPWR sky130_fd_sc_hd__decap_8
XFILLER_32_1239 VPWR VGND VPWR VGND sky130_ef_sc_hd__decap_12
XFILLER_197_1413 VGND VGND VPWR VPWR sky130_fd_sc_hd__decap_6
XTAP_TAPCELL_ROW_11_2_4752 VGND VPWR sky130_fd_sc_hd__tapvpwrvgnd_1
XFILLER_123_1378 VPWR VGND VPWR VGND sky130_ef_sc_hd__decap_12
XFILLER_138_34 VPWR VGND VPWR VGND sky130_ef_sc_hd__decap_12
XFILLER_192_452 VPWR VGND VPWR VGND sky130_ef_sc_hd__decap_12
XFILLER_4_816 VGND VGND VPWR VPWR sky130_fd_sc_hd__decap_6
XFILLER_238_1410 VPWR VGND VPWR VGND sky130_ef_sc_hd__decap_12
XTAP_TAPCELL_ROW_249_4457 VGND VPWR sky130_fd_sc_hd__tapvpwrvgnd_1
XTAP_TAPCELL_ROW_249_4468 VGND VPWR sky130_fd_sc_hd__tapvpwrvgnd_1
XTAP_TAPCELL_ROW_139_1_1438 VGND VPWR sky130_fd_sc_hd__tapvpwrvgnd_1
XFILLER_180_636 VPWR VGND VPWR VGND sky130_ef_sc_hd__decap_12
XTAP_TAPCELL_ROW_249_4479 VGND VPWR sky130_fd_sc_hd__tapvpwrvgnd_1
XFILLER_238_1465 VPWR VGND VPWR VGND sky130_ef_sc_hd__decap_12
XFILLER_154_22 VPWR VGND VPWR VGND sky130_ef_sc_hd__decap_12
XFILLER_156_1165 VPWR VGND VPWR VGND sky130_ef_sc_hd__decap_12
XFILLER_191_1045 VPWR VGND VPWR VGND sky130_ef_sc_hd__decap_12
XFILLER_43_1335 VPWR VGND VPWR VGND sky130_ef_sc_hd__decap_12
XFILLER_219_111 VPWR VGND VPWR VGND sky130_ef_sc_hd__decap_12
XFILLER_247_431 VPWR VGND VPWR VGND sky130_ef_sc_hd__decap_12
XFILLER_134_1485 VPWR VGND VPWR VGND sky130_ef_sc_hd__decap_12
XFILLER_232_1097 VPWR VGND VPWR VGND sky130_ef_sc_hd__decap_12
XFILLER_235_615 VPWR VGND VPWR VGND sky130_ef_sc_hd__decap_12
XFILLER_130_1349 VGND VGND VPWR VPWR sky130_fd_sc_hd__decap_6
XFILLER_219_166 VGND VGND VPWR VPWR sky130_fd_sc_hd__decap_6
XFILLER_247_486 VPWR VGND VPWR VGND sky130_ef_sc_hd__decap_12
XFILLER_170_65 VPWR VGND VPWR VGND sky130_ef_sc_hd__decap_12
XFILLER_216_851 VPWR VGND VPWR VGND sky130_ef_sc_hd__decap_12
XFILLER_243_670 VPWR VGND VPWR VGND sky130_ef_sc_hd__decap_12
XFILLER_188_703 VGND VGND VPWR VPWR sky130_fd_sc_hd__decap_6
XFILLER_167_1272 VPWR VGND VPWR VGND sky130_ef_sc_hd__decap_12
XFILLER_76_1177 VGND VGND VPWR VPWR sky130_fd_sc_hd__decap_6
XFILLER_231_854 VGND VGND VPWR VPWR sky130_fd_sc_hd__decap_6
XFILLER_54_1442 VPWR VGND VPWR VGND sky130_ef_sc_hd__decap_12
XFILLER_50_1306 VGND VGND VPWR VPWR sky130_fd_sc_hd__decap_6
XFILLER_169_983 VGND VGND VPWR VPWR sky130_fd_sc_hd__decap_6
XFILLER_204_1133 VGND VGND VPWR VPWR sky130_fd_sc_hd__decap_6
XFILLER_8_58 VGND VGND VPWR VPWR sky130_fd_sc_hd__decap_6
XFILLER_54_1497 VPWR VGND VPWR VGND sky130_ef_sc_hd__decap_12
XFILLER_141_1445 VPWR VGND VPWR VGND sky130_ef_sc_hd__decap_12
XFILLER_6_120 VPWR VGND VPWR VGND sky130_ef_sc_hd__decap_12
XTAP_TAPCELL_ROW_152_2_5878 VGND VPWR sky130_fd_sc_hd__tapvpwrvgnd_1
XPHY_EDGE_ROW_50_2_Left_552 VGND VGND VPWR VPWR sky130_fd_sc_hd__decap_3
Xwire574 dout0_q\[13\] VGND VGND VPWR VPWR net574 sky130_fd_sc_hd__clkbuf_1
XFILLER_171_603 VPWR VGND VPWR VGND sky130_ef_sc_hd__decap_12
XFILLER_176_1508 VGND VGND VPWR VPWR sky130_fd_sc_hd__decap_6
XFILLER_239_1229 VPWR VGND VPWR VGND sky130_ef_sc_hd__decap_12
Xwire585 dout0_q\[4\] VGND VGND VPWR VPWR net585 sky130_fd_sc_hd__clkbuf_1
XFILLER_183_474 VPWR VGND VPWR VGND sky130_ef_sc_hd__decap_12
XTAP_TAPCELL_ROW_172_1760 VGND VPWR sky130_fd_sc_hd__tapvpwrvgnd_1
XTAP_TAPCELL_ROW_172_1771 VGND VPWR sky130_fd_sc_hd__tapvpwrvgnd_1
XTAP_TAPCELL_ROW_88_2_5364 VGND VPWR sky130_fd_sc_hd__tapvpwrvgnd_1
XTAP_TAPCELL_ROW_172_1782 VGND VPWR sky130_fd_sc_hd__tapvpwrvgnd_1
XFILLER_171_658 VPWR VGND VPWR VGND sky130_ef_sc_hd__decap_12
XTAP_TAPCELL_ROW_172_1793 VGND VPWR sky130_fd_sc_hd__tapvpwrvgnd_1
XFILLER_87_1273 VPWR VGND VPWR VGND sky130_ef_sc_hd__decap_12
XTAP_TAPCELL_ROW_132_2_5721 VGND VPWR sky130_fd_sc_hd__tapvpwrvgnd_1
XFILLER_3_893 VGND VGND VPWR VPWR sky130_fd_sc_hd__decap_8
XFILLER_61_1402 VPWR VGND VPWR VGND sky130_ef_sc_hd__decap_12
XFILLER_135_1249 VPWR VGND VPWR VGND sky130_ef_sc_hd__decap_12
XFILLER_2_392 VGND VGND VPWR VPWR sky130_fd_sc_hd__fill_2
XFILLER_250_1164 VPWR VGND VPWR VGND sky130_ef_sc_hd__decap_12
XFILLER_61_1457 VGND VGND VPWR VPWR sky130_fd_sc_hd__decap_6
XFILLER_215_1284 VGND VGND VPWR VPWR sky130_fd_sc_hd__decap_6
XTAP_TAPCELL_ROW_81_2_5307 VGND VPWR sky130_fd_sc_hd__tapvpwrvgnd_1
XFILLER_214_58 VGND VGND VPWR VPWR sky130_fd_sc_hd__decap_6
XTAP_TAPCELL_ROW_166_1553 VGND VPWR sky130_fd_sc_hd__tapvpwrvgnd_1
XFILLER_19_3 VPWR VGND VPWR VGND sky130_ef_sc_hd__decap_12
XTAP_TAPCELL_ROW_166_1564 VGND VPWR sky130_fd_sc_hd__tapvpwrvgnd_1
XFILLER_238_464 VPWR VGND VPWR VGND sky130_ef_sc_hd__decap_12
XTAP_TAPCELL_ROW_166_1575 VGND VPWR sky130_fd_sc_hd__tapvpwrvgnd_1
XFILLER_253_412 VPWR VGND VPWR VGND sky130_ef_sc_hd__decap_12
XTAP_TAPCELL_ROW_50_2_5065 VGND VPWR sky130_fd_sc_hd__tapvpwrvgnd_1
XFILLER_96_1509 VGND VGND VPWR VPWR sky130_fd_sc_hd__decap_6
XPHY_EDGE_ROW_127_1_Left_382 VGND VGND VPWR VPWR sky130_fd_sc_hd__decap_3
XFILLER_226_648 VPWR VGND VPWR VGND sky130_ef_sc_hd__decap_12
XFILLER_254_968 VPWR VGND VPWR VGND sky130_ef_sc_hd__decap_12
XFILLER_168_1047 VGND VGND VPWR VPWR sky130_fd_sc_hd__decap_6
XFILLER_253_467 VGND VGND VPWR VPWR sky130_fd_sc_hd__decap_6
XFILLER_20_1165 VPWR VGND VPWR VGND sky130_ef_sc_hd__decap_12
XFILLER_98_1380 VPWR VGND VPWR VGND sky130_ef_sc_hd__decap_12
XFILLER_207_873 VPWR VGND VPWR VGND sky130_ef_sc_hd__decap_12
XFILLER_230_46 VPWR VGND VPWR VGND sky130_ef_sc_hd__decap_12
XFILLER_55_1206 VPWR VGND VPWR VGND sky130_ef_sc_hd__decap_12
XFILLER_209_1033 VPWR VGND VPWR VGND sky130_ef_sc_hd__decap_12
XFILLER_179_725 VGND VGND VPWR VPWR sky130_fd_sc_hd__decap_6
XFILLER_222_832 VGND VGND VPWR VPWR sky130_fd_sc_hd__decap_6
XTAP_TAPCELL_ROW_16_2_4789 VGND VPWR sky130_fd_sc_hd__tapvpwrvgnd_1
XFILLER_146_1356 VPWR VGND VPWR VGND sky130_ef_sc_hd__decap_12
XFILLER_209_1088 VPWR VGND VPWR VGND sky130_ef_sc_hd__decap_12
XFILLER_226_1391 VGND VGND VPWR VPWR sky130_fd_sc_hd__decap_6
XFILLER_193_216 VPWR VGND VPWR VGND sky130_ef_sc_hd__decap_12
XFILLER_239_44 VPWR VGND VPWR VGND sky130_ef_sc_hd__decap_12
XFILLER_174_452 VPWR VGND VPWR VGND sky130_ef_sc_hd__decap_12
XFILLER_239_99 VPWR VGND VPWR VGND sky130_ef_sc_hd__decap_12
XFILLER_179_1143 VPWR VGND VPWR VGND sky130_ef_sc_hd__decap_12
XFILLER_31_1261 VPWR VGND VPWR VGND sky130_ef_sc_hd__decap_12
XFILLER_108_15 VGND VGND VPWR VPWR sky130_fd_sc_hd__decap_6
XFILLER_179_1198 VGND VGND VPWR VPWR sky130_fd_sc_hd__decap_6
XFILLER_255_43 VPWR VGND VPWR VGND sky130_ef_sc_hd__decap_12
XFILLER_66_1313 VPWR VGND VPWR VGND sky130_ef_sc_hd__decap_12
XFILLER_255_1042 VGND VGND VPWR VPWR sky130_fd_sc_hd__decap_8
XTAP_TAPCELL_ROW_244_4310 VGND VPWR sky130_fd_sc_hd__tapvpwrvgnd_1
XFILLER_255_76 VGND VGND VPWR VPWR sky130_fd_sc_hd__decap_8
XFILLER_216_1004 VGND VGND VPWR VPWR sky130_fd_sc_hd__decap_6
XFILLER_0_307 VGND VGND VPWR VPWR sky130_fd_sc_hd__fill_2
XFILLER_66_1368 VPWR VGND VPWR VGND sky130_ef_sc_hd__decap_12
XFILLER_153_1316 VPWR VGND VPWR VGND sky130_ef_sc_hd__decap_12
XFILLER_170_691 VPWR VGND VPWR VGND sky130_ef_sc_hd__decap_12
XFILLER_248_206 VPWR VGND VPWR VGND sky130_ef_sc_hd__decap_12
XFILLER_192_1398 VPWR VGND VPWR VGND sky130_ef_sc_hd__decap_12
XFILLER_9_1240 VPWR VGND VPWR VGND sky130_ef_sc_hd__decap_12
XFILLER_9_1273 VGND VGND VPWR VPWR sky130_fd_sc_hd__decap_8
XFILLER_229_431 VPWR VGND VPWR VGND sky130_ef_sc_hd__decap_12
XFILLER_124_58 VGND VGND VPWR VPWR sky130_fd_sc_hd__decap_6
XTAP_TAPCELL_ROW_205_2914 VGND VPWR sky130_fd_sc_hd__tapvpwrvgnd_1
XFILLER_217_615 VPWR VGND VPWR VGND sky130_ef_sc_hd__decap_12
XTAP_TAPCELL_ROW_205_2925 VGND VPWR sky130_fd_sc_hd__tapvpwrvgnd_1
XFILLER_229_486 VPWR VGND VPWR VGND sky130_ef_sc_hd__decap_12
XTAP_TAPCELL_ROW_205_2936 VGND VPWR sky130_fd_sc_hd__tapvpwrvgnd_1
XTAP_TAPCELL_ROW_205_2947 VGND VPWR sky130_fd_sc_hd__tapvpwrvgnd_1
XFILLER_244_445 VGND VGND VPWR VPWR sky130_fd_sc_hd__decap_6
XFILLER_99_1177 VPWR VGND VPWR VGND sky130_ef_sc_hd__decap_12
XTAP_TAPCELL_ROW_238_4103 VGND VPWR sky130_fd_sc_hd__tapvpwrvgnd_1
XTAP_TAPCELL_ROW_0_830 VGND VPWR sky130_fd_sc_hd__tapvpwrvgnd_1
XFILLER_17_56 VGND VGND VPWR VPWR sky130_fd_sc_hd__decap_6
XTAP_TAPCELL_ROW_0_841 VGND VPWR sky130_fd_sc_hd__tapvpwrvgnd_1
XFILLER_227_1100 VPWR VGND VPWR VGND sky130_ef_sc_hd__decap_12
XTAP_TAPCELL_ROW_0_852 VGND VPWR sky130_fd_sc_hd__tapvpwrvgnd_1
XFILLER_140_46 VPWR VGND VPWR VGND sky130_ef_sc_hd__decap_12
XTAP_TAPCELL_ROW_0_863 VGND VPWR sky130_fd_sc_hd__tapvpwrvgnd_1
XFILLER_225_670 VPWR VGND VPWR VGND sky130_ef_sc_hd__decap_12
XFILLER_253_990 VPWR VGND VPWR VGND sky130_ef_sc_hd__decap_12
XTAP_TAPCELL_ROW_0_874 VGND VPWR sky130_fd_sc_hd__tapvpwrvgnd_1
XFILLER_77_1464 VPWR VGND VPWR VGND sky130_ef_sc_hd__decap_12
XTAP_TAPCELL_ROW_0_885 VGND VPWR sky130_fd_sc_hd__tapvpwrvgnd_1
XFILLER_164_1423 VPWR VGND VPWR VGND sky130_ef_sc_hd__decap_12
XFILLER_73_1328 VGND VGND VPWR VPWR sky130_fd_sc_hd__decap_6
XFILLER_213_854 VGND VGND VPWR VPWR sky130_fd_sc_hd__decap_6
XFILLER_227_1155 VGND VGND VPWR VPWR sky130_fd_sc_hd__decap_6
XFILLER_164_1478 VGND VGND VPWR VPWR sky130_fd_sc_hd__decap_6
XFILLER_205_1420 VPWR VGND VPWR VGND sky130_ef_sc_hd__decap_12
XFILLER_33_44 VGND VGND VPWR VPWR sky130_fd_sc_hd__fill_1
XFILLER_149_44 VPWR VGND VPWR VGND sky130_ef_sc_hd__decap_12
XTAP_TAPCELL_ROW_137_2_5758 VGND VPWR sky130_fd_sc_hd__tapvpwrvgnd_1
XFILLER_240_1355 VPWR VGND VPWR VGND sky130_ef_sc_hd__decap_12
XFILLER_205_1475 VPWR VGND VPWR VGND sky130_ef_sc_hd__decap_12
XFILLER_184_249 VPWR VGND VPWR VGND sky130_ef_sc_hd__decap_12
XTAP_TAPCELL_ROW_74_2_5250 VGND VPWR sky130_fd_sc_hd__tapvpwrvgnd_1
XFILLER_123_3 VPWR VGND VPWR VGND sky130_ef_sc_hd__decap_12
XFILLER_165_463 VPWR VGND VPWR VGND sky130_ef_sc_hd__decap_12
XTAP_TAPCELL_ROW_117_2_5601 VGND VPWR sky130_fd_sc_hd__tapvpwrvgnd_1
XFILLER_49_1500 VGND VGND VPWR VPWR sky130_fd_sc_hd__decap_6
XFILLER_158_1227 VPWR VGND VPWR VGND sky130_ef_sc_hd__decap_12
XFILLER_165_496 VGND VGND VPWR VPWR sky130_fd_sc_hd__decap_8
XFILLER_180_433 VPWR VGND VPWR VGND sky130_ef_sc_hd__decap_12
XFILLER_10_1356 VPWR VGND VPWR VGND sky130_ef_sc_hd__decap_12
XFILLER_3_123 VGND VGND VPWR VPWR sky130_fd_sc_hd__decap_6
XFILLER_165_43 VPWR VGND VPWR VGND sky130_ef_sc_hd__decap_12
XFILLER_84_1435 VGND VGND VPWR VPWR sky130_fd_sc_hd__decap_6
XFILLER_238_1262 VGND VGND VPWR VPWR sky130_fd_sc_hd__decap_6
XTAP_TAPCELL_ROW_41_2_4991 VGND VPWR sky130_fd_sc_hd__tapvpwrvgnd_1
XFILLER_165_76 VGND VGND VPWR VPWR sky130_fd_sc_hd__decap_8
XFILLER_180_488 VGND VGND VPWR VPWR sky130_fd_sc_hd__decap_6
XFILLER_0_841 VPWR VGND VPWR VGND sky130_ef_sc_hd__decap_12
XFILLER_239_228 VPWR VGND VPWR VGND sky130_ef_sc_hd__decap_12
XFILLER_0_896 VGND VGND VPWR VPWR sky130_fd_sc_hd__decap_6
XFILLER_43_1165 VPWR VGND VPWR VGND sky130_ef_sc_hd__decap_12
XFILLER_134_1282 VPWR VGND VPWR VGND sky130_ef_sc_hd__decap_12
XFILLER_235_412 VPWR VGND VPWR VGND sky130_ef_sc_hd__decap_12
XFILLER_247_283 VPWR VGND VPWR VGND sky130_ef_sc_hd__decap_12
XFILLER_208_648 VPWR VGND VPWR VGND sky130_ef_sc_hd__decap_12
XTAP_TAPCELL_ROW_33_2_4928 VGND VPWR sky130_fd_sc_hd__tapvpwrvgnd_1
XFILLER_169_1334 VPWR VGND VPWR VGND sky130_ef_sc_hd__decap_12
XFILLER_236_968 VPWR VGND VPWR VGND sky130_ef_sc_hd__decap_12
XFILLER_78_1239 VPWR VGND VPWR VGND sky130_ef_sc_hd__decap_12
XFILLER_251_916 VPWR VGND VPWR VGND sky130_ef_sc_hd__decap_12
XFILLER_235_467 VGND VGND VPWR VPWR sky130_fd_sc_hd__decap_6
XTAP_TAPCELL_ROW_221_3483 VGND VPWR sky130_fd_sc_hd__tapvpwrvgnd_1
XTAP_TAPCELL_ROW_221_3494 VGND VPWR sky130_fd_sc_hd__tapvpwrvgnd_1
XFILLER_169_1389 VPWR VGND VPWR VGND sky130_ef_sc_hd__decap_12
XFILLER_204_832 VGND VGND VPWR VPWR sky130_fd_sc_hd__decap_6
XFILLER_143_1507 VGND VGND VPWR VPWR sky130_fd_sc_hd__decap_8
XFILLER_241_1119 VPWR VGND VPWR VGND sky130_ef_sc_hd__decap_12
XFILLER_15_1201 VGND VGND VPWR VPWR sky130_fd_sc_hd__decap_4
XFILLER_175_216 VPWR VGND VPWR VGND sky130_ef_sc_hd__decap_12
XTAP_TAPCELL_ROW_178_1980 VGND VPWR sky130_fd_sc_hd__tapvpwrvgnd_1
XFILLER_230_194 VPWR VGND VPWR VGND sky130_ef_sc_hd__decap_12
XTAP_TAPCELL_ROW_178_1991 VGND VPWR sky130_fd_sc_hd__tapvpwrvgnd_1
XFILLER_54_1294 VPWR VGND VPWR VGND sky130_ef_sc_hd__decap_12
XFILLER_141_1242 VGND VGND VPWR VPWR sky130_fd_sc_hd__decap_6
XTAP_TAPCELL_ROW_174_1833 VGND VPWR sky130_fd_sc_hd__tapvpwrvgnd_1
XTAP_TAPCELL_ROW_174_1844 VGND VPWR sky130_fd_sc_hd__tapvpwrvgnd_1
XTAP_TAPCELL_ROW_215_3265 VGND VPWR sky130_fd_sc_hd__tapvpwrvgnd_1
XTAP_TAPCELL_ROW_174_1855 VGND VPWR sky130_fd_sc_hd__tapvpwrvgnd_1
XTAP_TAPCELL_ROW_215_3276 VGND VPWR sky130_fd_sc_hd__tapvpwrvgnd_1
XFILLER_89_1335 VPWR VGND VPWR VGND sky130_ef_sc_hd__decap_12
XTAP_TAPCELL_ROW_215_3287 VGND VPWR sky130_fd_sc_hd__tapvpwrvgnd_1
Xwire360 net361 VGND VGND VPWR VPWR net360 sky130_fd_sc_hd__clkbuf_1
XTAP_TAPCELL_ROW_170_1708 VGND VPWR sky130_fd_sc_hd__tapvpwrvgnd_1
XTAP_TAPCELL_ROW_211_3129 VGND VPWR sky130_fd_sc_hd__tapvpwrvgnd_1
XTAP_TAPCELL_ROW_215_3298 VGND VPWR sky130_fd_sc_hd__tapvpwrvgnd_1
XFILLER_7_462 VGND VGND VPWR VPWR sky130_fd_sc_hd__fill_2
XTAP_TAPCELL_ROW_170_1719 VGND VPWR sky130_fd_sc_hd__tapvpwrvgnd_1
XFILLER_171_400 VPWR VGND VPWR VGND sky130_ef_sc_hd__decap_12
XFILLER_239_1026 VGND VGND VPWR VPWR sky130_fd_sc_hd__decap_6
Xwire371 net372 VGND VGND VPWR VPWR net371 sky130_fd_sc_hd__clkbuf_1
Xmax_cap104 _240_ VGND VGND VPWR VPWR net104 sky130_fd_sc_hd__clkbuf_1
XFILLER_176_1305 VGND VGND VPWR VPWR sky130_fd_sc_hd__decap_6
Xwire382 net383 VGND VGND VPWR VPWR net382 sky130_fd_sc_hd__clkbuf_1
Xmax_cap115 _202_ VGND VGND VPWR VPWR net115 sky130_fd_sc_hd__clkbuf_1
XFILLER_183_271 VPWR VGND VPWR VGND sky130_ef_sc_hd__decap_12
Xwire393 net394 VGND VGND VPWR VPWR net393 sky130_fd_sc_hd__clkbuf_1
XTAP_TAPCELL_ROW_109_1_1393 VGND VPWR sky130_fd_sc_hd__tapvpwrvgnd_1
Xmax_cap137 _125_ VGND VGND VPWR VPWR net137 sky130_fd_sc_hd__clkbuf_1
XFILLER_171_455 VPWR VGND VPWR VGND sky130_ef_sc_hd__decap_12
Xmax_cap159 _162_ VGND VGND VPWR VPWR net159 sky130_fd_sc_hd__clkbuf_1
XFILLER_252_1226 VPWR VGND VPWR VGND sky130_ef_sc_hd__decap_12
XFILLER_217_1346 VPWR VGND VPWR VGND sky130_ef_sc_hd__decap_12
XTAP_TAPCELL_ROW_168_1626 VGND VPWR sky130_fd_sc_hd__tapvpwrvgnd_1
XTAP_TAPCELL_ROW_168_1637 VGND VPWR sky130_fd_sc_hd__tapvpwrvgnd_1
XTAP_TAPCELL_ROW_209_3058 VGND VPWR sky130_fd_sc_hd__tapvpwrvgnd_1
XTAP_TAPCELL_ROW_168_1648 VGND VPWR sky130_fd_sc_hd__tapvpwrvgnd_1
XTAP_TAPCELL_ROW_209_3069 VGND VPWR sky130_fd_sc_hd__tapvpwrvgnd_1
XFILLER_225_68 VPWR VGND VPWR VGND sky130_ef_sc_hd__decap_12
XFILLER_65_1390 VPWR VGND VPWR VGND sky130_ef_sc_hd__decap_12
XTAP_TAPCELL_ROW_162_2_5960 VGND VPWR sky130_fd_sc_hd__tapvpwrvgnd_1
XPHY_EDGE_ROW_249_Left_504 VGND VGND VPWR VPWR sky130_fd_sc_hd__decap_3
XFILLER_245_209 VGND VGND VPWR VPWR sky130_fd_sc_hd__decap_6
XFILLER_254_710 VPWR VGND VPWR VGND sky130_ef_sc_hd__decap_12
XFILLER_22_1227 VPWR VGND VPWR VGND sky130_ef_sc_hd__decap_12
XFILLER_238_261 VPWR VGND VPWR VGND sky130_ef_sc_hd__decap_12
XFILLER_187_1401 VPWR VGND VPWR VGND sky130_ef_sc_hd__decap_12
XFILLER_96_1306 VGND VGND VPWR VPWR sky130_fd_sc_hd__decap_6
XFILLER_241_56 VPWR VGND VPWR VGND sky130_ef_sc_hd__decap_12
XFILLER_226_445 VGND VGND VPWR VPWR sky130_fd_sc_hd__decap_6
XFILLER_254_765 VPWR VGND VPWR VGND sky130_ef_sc_hd__decap_12
XFILLER_187_1456 VGND VGND VPWR VPWR sky130_fd_sc_hd__decap_6
XFILLER_207_670 VPWR VGND VPWR VGND sky130_ef_sc_hd__decap_12
XFILLER_242_949 VPWR VGND VPWR VGND sky130_ef_sc_hd__decap_12
XFILLER_0_81 VGND VGND VPWR VPWR sky130_fd_sc_hd__decap_3
XFILLER_235_990 VPWR VGND VPWR VGND sky130_ef_sc_hd__decap_12
XFILLER_228_1453 VPWR VGND VPWR VGND sky130_ef_sc_hd__decap_12
XTAP_TAPCELL_ROW_123_2_5644 VGND VPWR sky130_fd_sc_hd__tapvpwrvgnd_1
XFILLER_181_1033 VPWR VGND VPWR VGND sky130_ef_sc_hd__decap_12
XTAP_TAPCELL_ROW_59_2_5130 VGND VPWR sky130_fd_sc_hd__tapvpwrvgnd_1
XFILLER_181_1088 VPWR VGND VPWR VGND sky130_ef_sc_hd__decap_12
XFILLER_166_249 VPWR VGND VPWR VGND sky130_ef_sc_hd__decap_12
XFILLER_33_1378 VPWR VGND VPWR VGND sky130_ef_sc_hd__decap_12
XFILLER_120_1337 VPWR VGND VPWR VGND sky130_ef_sc_hd__decap_12
XTAP_TAPCELL_ROW_190_2391 VGND VPWR sky130_fd_sc_hd__tapvpwrvgnd_1
XTAP_TAPCELL_ROW_26_2_4871 VGND VPWR sky130_fd_sc_hd__tapvpwrvgnd_1
XFILLER_190_753 VPWR VGND VPWR VGND sky130_ef_sc_hd__decap_12
XFILLER_235_1413 VGND VGND VPWR VPWR sky130_fd_sc_hd__decap_6
XFILLER_192_1140 VPWR VGND VPWR VGND sky130_ef_sc_hd__decap_12
XFILLER_66_1165 VPWR VGND VPWR VGND sky130_ef_sc_hd__decap_12
XFILLER_0_148 VPWR VGND VPWR VGND sky130_ef_sc_hd__decap_12
XFILLER_135_68 VGND VGND VPWR VPWR sky130_fd_sc_hd__decap_3
XFILLER_192_1195 VPWR VGND VPWR VGND sky130_ef_sc_hd__decap_12
XFILLER_95_39 VGND VGND VPWR VPWR sky130_fd_sc_hd__decap_4
XFILLER_28_22 VPWR VGND VPWR VGND sky130_ef_sc_hd__decap_12
XTAP_TAPCELL_ROW_18_2_4808 VGND VPWR sky130_fd_sc_hd__tapvpwrvgnd_1
XTAP_TAPCELL_ROW_184_2184 VGND VPWR sky130_fd_sc_hd__tapvpwrvgnd_1
XFILLER_44_1485 VPWR VGND VPWR VGND sky130_ef_sc_hd__decap_12
XFILLER_131_1433 VPWR VGND VPWR VGND sky130_ef_sc_hd__decap_12
XTAP_TAPCELL_ROW_184_2195 VGND VPWR sky130_fd_sc_hd__tapvpwrvgnd_1
XTAP_TAPCELL_ROW_180_2048 VGND VPWR sky130_fd_sc_hd__tapvpwrvgnd_1
XFILLER_217_412 VPWR VGND VPWR VGND sky130_ef_sc_hd__decap_12
XFILLER_245_732 VPWR VGND VPWR VGND sky130_ef_sc_hd__decap_12
XFILLER_229_283 VPWR VGND VPWR VGND sky130_ef_sc_hd__decap_12
XFILLER_40_1349 VGND VGND VPWR VPWR sky130_fd_sc_hd__decap_6
XTAP_TAPCELL_ROW_180_2059 VGND VPWR sky130_fd_sc_hd__tapvpwrvgnd_1
XFILLER_151_56 VPWR VGND VPWR VGND sky130_ef_sc_hd__decap_12
XFILLER_218_968 VPWR VGND VPWR VGND sky130_ef_sc_hd__decap_12
X_560_ net664 VGND VGND VPWR VPWR _042_ sky130_fd_sc_hd__inv_2
XFILLER_131_1488 VPWR VGND VPWR VGND sky130_ef_sc_hd__decap_12
XFILLER_229_1217 VPWR VGND VPWR VGND sky130_ef_sc_hd__decap_12
XFILLER_233_916 VPWR VGND VPWR VGND sky130_ef_sc_hd__decap_12
XTAP_TAPCELL_ROW_39_1_1288 VGND VPWR sky130_fd_sc_hd__tapvpwrvgnd_1
XFILLER_217_467 VGND VGND VPWR VPWR sky130_fd_sc_hd__decap_6
XFILLER_245_787 VPWR VGND VPWR VGND sky130_ef_sc_hd__decap_12
X_491_ net92 _251_ VGND VGND VPWR VPWR acc_core.adder.cla_blocks\[4\].block.sum\[1\]
+ sky130_fd_sc_hd__nor2_1
XFILLER_77_1261 VPWR VGND VPWR VGND sky130_ef_sc_hd__decap_12
XFILLER_198_820 VPWR VGND VPWR VGND sky130_ef_sc_hd__decap_12
XFILLER_164_1220 VGND VGND VPWR VPWR sky130_fd_sc_hd__decap_6
XFILLER_44_65 VGND VGND VPWR VPWR sky130_fd_sc_hd__decap_3
XFILLER_241_971 VPWR VGND VPWR VGND sky130_ef_sc_hd__decap_12
XFILLER_240_3 VPWR VGND VPWR VGND sky130_ef_sc_hd__decap_12
XFILLER_198_875 VGND VGND VPWR VPWR sky130_fd_sc_hd__decap_6
XFILLER_9_727 VGND VGND VPWR VPWR sky130_fd_sc_hd__decap_8
XFILLER_200_323 VPWR VGND VPWR VGND sky130_ef_sc_hd__decap_12
XFILLER_212_194 VPWR VGND VPWR VGND sky130_ef_sc_hd__decap_12
XFILLER_8_226 VGND VGND VPWR VPWR sky130_fd_sc_hd__decap_6
XFILLER_199_1327 VGND VGND VPWR VPWR sky130_fd_sc_hd__decap_6
XFILLER_240_1152 VPWR VGND VPWR VGND sky130_ef_sc_hd__decap_12
XFILLER_8_237 VGND VGND VPWR VPWR sky130_fd_sc_hd__decap_4
XFILLER_51_1445 VPWR VGND VPWR VGND sky130_ef_sc_hd__decap_12
XFILLER_205_1272 VPWR VGND VPWR VGND sky130_ef_sc_hd__decap_12
XFILLER_200_378 VPWR VGND VPWR VGND sky130_ef_sc_hd__decap_12
XFILLER_180_230 VGND VGND VPWR VPWR sky130_fd_sc_hd__decap_6
XFILLER_181_775 VPWR VGND VPWR VGND sky130_ef_sc_hd__decap_12
XFILLER_101_1292 VPWR VGND VPWR VGND sky130_ef_sc_hd__decap_12
XTAP_TAPCELL_ROW_147_2_5840 VGND VPWR sky130_fd_sc_hd__tapvpwrvgnd_1
XFILLER_214_1508 VGND VGND VPWR VPWR sky130_fd_sc_hd__decap_6
XFILLER_45_1249 VPWR VGND VPWR VGND sky130_ef_sc_hd__decap_12
XPHY_EDGE_ROW_194_Right_39 VGND VGND VPWR VPWR sky130_fd_sc_hd__decap_3
XFILLER_132_1208 VPWR VGND VPWR VGND sky130_ef_sc_hd__decap_12
XFILLER_0_660 VGND VGND VPWR VPWR sky130_fd_sc_hd__fill_1
XFILLER_136_1399 VPWR VGND VPWR VGND sky130_ef_sc_hd__decap_12
XFILLER_227_209 VGND VGND VPWR VPWR sky130_fd_sc_hd__decap_6
XTAP_TAPCELL_ROW_227_3692 VGND VPWR sky130_fd_sc_hd__tapvpwrvgnd_1
XTAP_TAPCELL_ROW_223_3545 VGND VPWR sky130_fd_sc_hd__tapvpwrvgnd_1
XFILLER_236_710 VPWR VGND VPWR VGND sky130_ef_sc_hd__decap_12
XFILLER_248_581 VPWR VGND VPWR VGND sky130_ef_sc_hd__decap_12
XTAP_TAPCELL_ROW_223_3556 VGND VPWR sky130_fd_sc_hd__tapvpwrvgnd_1
XTAP_TAPCELL_ROW_223_3567 VGND VPWR sky130_fd_sc_hd__tapvpwrvgnd_1
XTAP_TAPCELL_ROW_96_2_5426 VGND VPWR sky130_fd_sc_hd__tapvpwrvgnd_1
XFILLER_208_445 VGND VGND VPWR VPWR sky130_fd_sc_hd__decap_6
XTAP_TAPCELL_ROW_223_3578 VGND VPWR sky130_fd_sc_hd__tapvpwrvgnd_1
XFILLER_169_1131 VPWR VGND VPWR VGND sky130_ef_sc_hd__decap_12
XFILLER_236_765 VPWR VGND VPWR VGND sky130_ef_sc_hd__decap_12
XFILLER_251_713 VPWR VGND VPWR VGND sky130_ef_sc_hd__decap_12
XTAP_TAPCELL_ROW_65_2_5184 VGND VPWR sky130_fd_sc_hd__tapvpwrvgnd_1
XFILLER_211_15 VPWR VGND VPWR VGND sky130_ef_sc_hd__decap_12
XFILLER_224_949 VPWR VGND VPWR VGND sky130_ef_sc_hd__decap_12
XTAP_TAPCELL_ROW_108_2_5524 VGND VPWR sky130_fd_sc_hd__tapvpwrvgnd_1
XFILLER_169_1186 VPWR VGND VPWR VGND sky130_ef_sc_hd__decap_12
XFILLER_217_990 VPWR VGND VPWR VGND sky130_ef_sc_hd__decap_12
XFILLER_251_768 VGND VGND VPWR VPWR sky130_fd_sc_hd__decap_6
XFILLER_189_842 VPWR VGND VPWR VGND sky130_ef_sc_hd__decap_12
XFILLER_56_1356 VPWR VGND VPWR VGND sky130_ef_sc_hd__decap_12
XFILLER_143_1304 VPWR VGND VPWR VGND sky130_ef_sc_hd__decap_12
XFILLER_108_1435 VGND VGND VPWR VPWR sky130_fd_sc_hd__decap_6
XTAP_TAPCELL_ROW_176_1906 VGND VPWR sky130_fd_sc_hd__tapvpwrvgnd_1
XTAP_TAPCELL_ROW_176_1917 VGND VPWR sky130_fd_sc_hd__tapvpwrvgnd_1
XFILLER_189_897 VGND VGND VPWR VPWR sky130_fd_sc_hd__decap_6
XTAP_TAPCELL_ROW_217_3338 VGND VPWR sky130_fd_sc_hd__tapvpwrvgnd_1
XTAP_TAPCELL_ROW_176_1928 VGND VPWR sky130_fd_sc_hd__tapvpwrvgnd_1
XFILLER_206_1047 VGND VGND VPWR VPWR sky130_fd_sc_hd__decap_6
XTAP_TAPCELL_ROW_217_3349 VGND VPWR sky130_fd_sc_hd__tapvpwrvgnd_1
XFILLER_86_3 VPWR VGND VPWR VGND sky130_ef_sc_hd__decap_12
XFILLER_143_1359 VPWR VGND VPWR VGND sky130_ef_sc_hd__decap_12
XPHY_EDGE_ROW_130_1_Right_786 VGND VGND VPWR VPWR sky130_fd_sc_hd__decap_3
XFILLER_191_517 VPWR VGND VPWR VGND sky130_ef_sc_hd__decap_12
XFILLER_89_1165 VPWR VGND VPWR VGND sky130_ef_sc_hd__decap_12
XFILLER_172_753 VPWR VGND VPWR VGND sky130_ef_sc_hd__decap_12
XFILLER_236_34 VPWR VGND VPWR VGND sky130_ef_sc_hd__decap_12
XFILLER_171_252 VGND VGND VPWR VPWR sky130_fd_sc_hd__decap_6
XFILLER_154_1411 VPWR VGND VPWR VGND sky130_ef_sc_hd__decap_12
XPHY_EDGE_ROW_13_2_Left_515 VGND VGND VPWR VPWR sky130_fd_sc_hd__decap_3
XFILLER_236_89 VPWR VGND VPWR VGND sky130_ef_sc_hd__decap_12
XFILLER_252_1023 VPWR VGND VPWR VGND sky130_ef_sc_hd__decap_12
XFILLER_63_1316 VPWR VGND VPWR VGND sky130_ef_sc_hd__decap_12
XFILLER_8_1508 VGND VGND VPWR VPWR sky130_fd_sc_hd__decap_6
XFILLER_217_1143 VPWR VGND VPWR VGND sky130_ef_sc_hd__decap_12
XFILLER_154_1466 VPWR VGND VPWR VGND sky130_ef_sc_hd__decap_12
XFILLER_252_1078 VPWR VGND VPWR VGND sky130_ef_sc_hd__decap_12
XFILLER_252_22 VPWR VGND VPWR VGND sky130_ef_sc_hd__decap_12
XFILLER_105_27 VPWR VGND VPWR VGND sky130_ef_sc_hd__decap_12
XFILLER_217_1198 VGND VGND VPWR VPWR sky130_fd_sc_hd__decap_6
XFILLER_246_507 VPWR VGND VPWR VGND sky130_ef_sc_hd__decap_12
XPHY_EDGE_ROW_138_2_Left_640 VGND VGND VPWR VPWR sky130_fd_sc_hd__decap_3
XFILLER_252_77 VPWR VGND VPWR VGND sky130_ef_sc_hd__decap_12
XFILLER_227_732 VPWR VGND VPWR VGND sky130_ef_sc_hd__decap_12
XTAP_TAPCELL_ROW_2_936 VGND VPWR sky130_fd_sc_hd__tapvpwrvgnd_1
XTAP_TAPCELL_ROW_2_947 VGND VPWR sky130_fd_sc_hd__tapvpwrvgnd_1
XTAP_TAPCELL_ROW_2_958 VGND VPWR sky130_fd_sc_hd__tapvpwrvgnd_1
XFILLER_230_1398 VPWR VGND VPWR VGND sky130_ef_sc_hd__decap_12
XFILLER_215_916 VPWR VGND VPWR VGND sky130_ef_sc_hd__decap_12
XFILLER_254_562 VPWR VGND VPWR VGND sky130_ef_sc_hd__decap_12
XFILLER_227_787 VPWR VGND VPWR VGND sky130_ef_sc_hd__decap_12
XFILLER_121_15 VPWR VGND VPWR VGND sky130_ef_sc_hd__decap_12
XFILLER_242_746 VGND VGND VPWR VPWR sky130_fd_sc_hd__decap_6
XFILLER_199_639 VGND VGND VPWR VPWR sky130_fd_sc_hd__decap_6
XFILLER_74_1423 VPWR VGND VPWR VGND sky130_ef_sc_hd__decap_12
XFILLER_228_1250 VPWR VGND VPWR VGND sky130_ef_sc_hd__decap_12
XFILLER_223_971 VPWR VGND VPWR VGND sky130_ef_sc_hd__decap_12
XFILLER_74_1478 VGND VGND VPWR VPWR sky130_fd_sc_hd__decap_6
XFILLER_14_46 VGND VGND VPWR VPWR sky130_fd_sc_hd__decap_8
XFILLER_14_57 VGND VGND VPWR VPWR sky130_fd_sc_hd__decap_6
XTAP_TAPCELL_ROW_192_2464 VGND VPWR sky130_fd_sc_hd__tapvpwrvgnd_1
XFILLER_6_708 VGND VGND VPWR VPWR sky130_fd_sc_hd__fill_1
XTAP_TAPCELL_ROW_192_2475 VGND VPWR sky130_fd_sc_hd__tapvpwrvgnd_1
XFILLER_124_1270 VPWR VGND VPWR VGND sky130_ef_sc_hd__decap_12
XTAP_TAPCELL_ROW_192_2486 VGND VPWR sky130_fd_sc_hd__tapvpwrvgnd_1
XFILLER_194_366 VPWR VGND VPWR VGND sky130_ef_sc_hd__decap_12
XFILLER_202_1434 VGND VGND VPWR VPWR sky130_fd_sc_hd__decap_6
XTAP_TAPCELL_ROW_153_2_5883 VGND VPWR sky130_fd_sc_hd__tapvpwrvgnd_1
XFILLER_30_34 VPWR VGND VPWR VGND sky130_ef_sc_hd__decap_12
XFILLER_68_1227 VPWR VGND VPWR VGND sky130_ef_sc_hd__decap_12
XFILLER_146_34 VPWR VGND VPWR VGND sky130_ef_sc_hd__decap_12
XFILLER_190_550 VPWR VGND VPWR VGND sky130_ef_sc_hd__decap_12
XFILLER_2_925 VPWR VGND VPWR VGND sky130_ef_sc_hd__decap_12
XTAP_TAPCELL_ROW_186_2257 VGND VPWR sky130_fd_sc_hd__tapvpwrvgnd_1
XTAP_TAPCELL_ROW_186_2268 VGND VPWR sky130_fd_sc_hd__tapvpwrvgnd_1
XFILLER_249_345 VPWR VGND VPWR VGND sky130_ef_sc_hd__decap_12
XTAP_TAPCELL_ROW_186_2279 VGND VPWR sky130_fd_sc_hd__tapvpwrvgnd_1
XFILLER_162_22 VPWR VGND VPWR VGND sky130_ef_sc_hd__decap_12
XFILLER_209_209 VGND VGND VPWR VPWR sky130_fd_sc_hd__decap_6
XFILLER_190_3 VPWR VGND VPWR VGND sky130_ef_sc_hd__decap_12
XFILLER_218_710 VPWR VGND VPWR VGND sky130_ef_sc_hd__decap_12
XFILLER_237_529 VPWR VGND VPWR VGND sky130_ef_sc_hd__decap_12
XTAP_TAPCELL_ROW_51_2_5070 VGND VPWR sky130_fd_sc_hd__tapvpwrvgnd_1
XFILLER_44_1282 VPWR VGND VPWR VGND sky130_ef_sc_hd__decap_12
XFILLER_131_1230 VPWR VGND VPWR VGND sky130_ef_sc_hd__decap_12
X_612_ clknet_3_6__leaf_clk dout0\[10\] _020_ VGND VGND VPWR VPWR dout0_q\[10\] sky130_fd_sc_hd__dfrtp_1
XFILLER_218_765 VPWR VGND VPWR VGND sky130_ef_sc_hd__decap_12
XFILLER_131_1285 VGND VGND VPWR VPWR sky130_fd_sc_hd__decap_6
XFILLER_229_1014 VPWR VGND VPWR VGND sky130_ef_sc_hd__decap_12
XFILLER_233_713 VPWR VGND VPWR VGND sky130_ef_sc_hd__decap_12
XFILLER_245_584 VPWR VGND VPWR VGND sky130_ef_sc_hd__decap_12
X_543_ net668 VGND VGND VPWR VPWR _025_ sky130_fd_sc_hd__inv_2
XFILLER_206_949 VPWR VGND VPWR VGND sky130_ef_sc_hd__decap_12
XFILLER_79_1378 VPWR VGND VPWR VGND sky130_ef_sc_hd__decap_12
XFILLER_166_1348 VGND VGND VPWR VPWR sky130_fd_sc_hd__decap_6
XTAP_TAPCELL_ROW_17_2_4794 VGND VPWR sky130_fd_sc_hd__tapvpwrvgnd_1
XFILLER_229_1069 VGND VGND VPWR VPWR sky130_fd_sc_hd__decap_6
XFILLER_233_768 VGND VGND VPWR VPWR sky130_fd_sc_hd__decap_6
X_474_ net160 net99 VGND VGND VPWR VPWR acc_core.adder.cla_blocks\[2\].block.sum\[2\]
+ sky130_fd_sc_hd__xnor2_1
XFILLER_53_1507 VGND VGND VPWR VPWR sky130_fd_sc_hd__decap_8
XFILLER_207_1334 VPWR VGND VPWR VGND sky130_ef_sc_hd__decap_12
XTAP_TAPCELL_ROW_43_2_5007 VGND VPWR sky130_fd_sc_hd__tapvpwrvgnd_1
XFILLER_200_120 VPWR VGND VPWR VGND sky130_ef_sc_hd__decap_12
XFILLER_242_1269 VPWR VGND VPWR VGND sky130_ef_sc_hd__decap_12
XFILLER_207_1389 VPWR VGND VPWR VGND sky130_ef_sc_hd__decap_12
XTAP_TAPCELL_ROW_235_3972 VGND VPWR sky130_fd_sc_hd__tapvpwrvgnd_1
XFILLER_51_1242 VGND VGND VPWR VPWR sky130_fd_sc_hd__decap_6
XTAP_TAPCELL_ROW_235_3983 VGND VPWR sky130_fd_sc_hd__tapvpwrvgnd_1
XFILLER_9_568 VGND VGND VPWR VPWR sky130_fd_sc_hd__fill_1
XTAP_TAPCELL_ROW_231_3825 VGND VPWR sky130_fd_sc_hd__tapvpwrvgnd_1
XTAP_TAPCELL_ROW_235_3994 VGND VPWR sky130_fd_sc_hd__tapvpwrvgnd_1
XPHY_EDGE_ROW_11_1_Left_266 VGND VGND VPWR VPWR sky130_fd_sc_hd__decap_3
XFILLER_173_517 VPWR VGND VPWR VGND sky130_ef_sc_hd__decap_12
XFILLER_200_175 VPWR VGND VPWR VGND sky130_ef_sc_hd__decap_12
XTAP_TAPCELL_ROW_231_3836 VGND VPWR sky130_fd_sc_hd__tapvpwrvgnd_1
XFILLER_185_388 VPWR VGND VPWR VGND sky130_ef_sc_hd__decap_12
XTAP_TAPCELL_ROW_231_3847 VGND VPWR sky130_fd_sc_hd__tapvpwrvgnd_1
XFILLER_142_1392 VGND VGND VPWR VPWR sky130_fd_sc_hd__decap_6
XTAP_TAPCELL_ROW_231_3858 VGND VPWR sky130_fd_sc_hd__tapvpwrvgnd_1
XFILLER_177_1444 VPWR VGND VPWR VGND sky130_ef_sc_hd__decap_12
XPHY_EDGE_ROW_136_1_Left_391 VGND VGND VPWR VPWR sky130_fd_sc_hd__decap_3
XFILLER_86_1349 VGND VGND VPWR VPWR sky130_fd_sc_hd__decap_6
XFILLER_181_572 VPWR VGND VPWR VGND sky130_ef_sc_hd__decap_12
XFILLER_177_1499 VGND VGND VPWR VPWR sky130_fd_sc_hd__decap_6
XFILLER_218_1441 VPWR VGND VPWR VGND sky130_ef_sc_hd__decap_12
XFILLER_206_15 VGND VGND VPWR VPWR sky130_fd_sc_hd__decap_6
XTAP_TAPCELL_ROW_229_3754 VGND VPWR sky130_fd_sc_hd__tapvpwrvgnd_1
XTAP_TAPCELL_ROW_229_3765 VGND VPWR sky130_fd_sc_hd__tapvpwrvgnd_1
XFILLER_214_1305 VGND VGND VPWR VPWR sky130_fd_sc_hd__decap_6
XTAP_TAPCELL_ROW_229_3776 VGND VPWR sky130_fd_sc_hd__tapvpwrvgnd_1
XTAP_TAPCELL_ROW_225_3618 VGND VPWR sky130_fd_sc_hd__tapvpwrvgnd_1
XTAP_TAPCELL_ROW_229_3787 VGND VPWR sky130_fd_sc_hd__tapvpwrvgnd_1
XFILLER_218_1496 VPWR VGND VPWR VGND sky130_ef_sc_hd__decap_12
XTAP_TAPCELL_ROW_225_3629 VGND VPWR sky130_fd_sc_hd__tapvpwrvgnd_1
XFILLER_228_507 VPWR VGND VPWR VGND sky130_ef_sc_hd__decap_12
XFILLER_136_1196 VPWR VGND VPWR VGND sky130_ef_sc_hd__decap_12
XFILLER_171_1076 VPWR VGND VPWR VGND sky130_ef_sc_hd__decap_12
XFILLER_255_337 VPWR VGND VPWR VGND sky130_ef_sc_hd__decap_12
XFILLER_209_732 VPWR VGND VPWR VGND sky130_ef_sc_hd__decap_12
XFILLER_110_1325 VPWR VGND VPWR VGND sky130_ef_sc_hd__decap_12
XFILLER_236_562 VPWR VGND VPWR VGND sky130_ef_sc_hd__decap_12
XFILLER_97_1445 VPWR VGND VPWR VGND sky130_ef_sc_hd__decap_12
XFILLER_209_787 VPWR VGND VPWR VGND sky130_ef_sc_hd__decap_12
XFILLER_222_58 VGND VGND VPWR VPWR sky130_fd_sc_hd__decap_6
XFILLER_251_510 VGND VGND VPWR VPWR sky130_fd_sc_hd__decap_6
XFILLER_224_746 VGND VGND VPWR VPWR sky130_fd_sc_hd__decap_6
XFILLER_1_1162 VPWR VGND VPWR VGND sky130_ef_sc_hd__decap_12
XFILLER_208_1109 VPWR VGND VPWR VGND sky130_ef_sc_hd__decap_12
XFILLER_225_1401 VPWR VGND VPWR VGND sky130_ef_sc_hd__decap_12
XFILLER_205_971 VPWR VGND VPWR VGND sky130_ef_sc_hd__decap_12
XFILLER_147_1292 VPWR VGND VPWR VGND sky130_ef_sc_hd__decap_12
XFILLER_225_1456 VGND VGND VPWR VPWR sky130_fd_sc_hd__decap_6
XFILLER_182_1183 VPWR VGND VPWR VGND sky130_ef_sc_hd__decap_12
XTAP_TAPCELL_ROW_138_2_5763 VGND VPWR sky130_fd_sc_hd__tapvpwrvgnd_1
XPHY_EDGE_ROW_131_1_Right_787 VGND VGND VPWR VPWR sky130_fd_sc_hd__decap_3
XFILLER_143_1189 VPWR VGND VPWR VGND sky130_ef_sc_hd__decap_12
XFILLER_176_366 VPWR VGND VPWR VGND sky130_ef_sc_hd__decap_12
XFILLER_121_1421 VPWR VGND VPWR VGND sky130_ef_sc_hd__decap_12
XFILLER_178_1219 VGND VGND VPWR VPWR sky130_fd_sc_hd__decap_6
XFILLER_191_314 VPWR VGND VPWR VGND sky130_ef_sc_hd__decap_12
XFILLER_247_44 VPWR VGND VPWR VGND sky130_ef_sc_hd__decap_12
XFILLER_30_1337 VPWR VGND VPWR VGND sky130_ef_sc_hd__decap_12
XFILLER_121_1476 VPWR VGND VPWR VGND sky130_ef_sc_hd__decap_12
XFILLER_172_550 VPWR VGND VPWR VGND sky130_ef_sc_hd__decap_12
XFILLER_191_369 VPWR VGND VPWR VGND sky130_ef_sc_hd__decap_12
XFILLER_219_1205 VPWR VGND VPWR VGND sky130_ef_sc_hd__decap_12
XFILLER_247_99 VPWR VGND VPWR VGND sky130_ef_sc_hd__decap_12
XTAP_TAPCELL_ROW_131_2_5706 VGND VPWR sky130_fd_sc_hd__tapvpwrvgnd_1
XFILLER_116_15 VGND VGND VPWR VPWR sky130_fd_sc_hd__decap_6
XTAP_TAPCELL_ROW_100_2_5464 VGND VPWR sky130_fd_sc_hd__tapvpwrvgnd_1
XFILLER_8_1305 VGND VGND VPWR VPWR sky130_fd_sc_hd__decap_6
XFILLER_154_1263 VGND VGND VPWR VPWR sky130_fd_sc_hd__decap_6
XFILLER_246_304 VPWR VGND VPWR VGND sky130_ef_sc_hd__decap_12
XFILLER_219_529 VPWR VGND VPWR VGND sky130_ef_sc_hd__decap_12
XFILLER_189_1315 VPWR VGND VPWR VGND sky130_ef_sc_hd__decap_12
XTAP_TAPCELL_ROW_241_4176 VGND VPWR sky130_fd_sc_hd__tapvpwrvgnd_1
XFILLER_41_1433 VPWR VGND VPWR VGND sky130_ef_sc_hd__decap_12
XFILLER_230_1140 VPWR VGND VPWR VGND sky130_ef_sc_hd__decap_12
XTAP_TAPCELL_ROW_241_4187 VGND VPWR sky130_fd_sc_hd__tapvpwrvgnd_1
XFILLER_246_359 VGND VGND VPWR VPWR sky130_fd_sc_hd__decap_6
XTAP_TAPCELL_ROW_241_4198 VGND VPWR sky130_fd_sc_hd__tapvpwrvgnd_1
XTAP_TAPCELL_ROW_34_2_4933 VGND VPWR sky130_fd_sc_hd__tapvpwrvgnd_1
XFILLER_41_1488 VPWR VGND VPWR VGND sky130_ef_sc_hd__decap_12
XFILLER_132_58 VGND VGND VPWR VPWR sky130_fd_sc_hd__decap_6
XFILLER_230_1195 VPWR VGND VPWR VGND sky130_ef_sc_hd__decap_12
XFILLER_215_713 VPWR VGND VPWR VGND sky130_ef_sc_hd__decap_12
XFILLER_227_584 VPWR VGND VPWR VGND sky130_ef_sc_hd__decap_12
XFILLER_215_768 VGND VGND VPWR VPWR sky130_fd_sc_hd__decap_6
XFILLER_74_1220 VGND VGND VPWR VPWR sky130_fd_sc_hd__decap_6
XTAP_TAPCELL_ROW_198_2673 VGND VPWR sky130_fd_sc_hd__tapvpwrvgnd_1
XFILLER_25_56 VGND VGND VPWR VPWR sky130_fd_sc_hd__fill_2
XTAP_TAPCELL_ROW_198_2684 VGND VPWR sky130_fd_sc_hd__tapvpwrvgnd_1
XFILLER_186_108 VPWR VGND VPWR VGND sky130_ef_sc_hd__decap_12
XTAP_TAPCELL_ROW_198_2695 VGND VPWR sky130_fd_sc_hd__tapvpwrvgnd_1
XFILLER_161_1201 VGND VGND VPWR VPWR sky130_fd_sc_hd__decap_4
XTAP_TAPCELL_ROW_194_2537 VGND VPWR sky130_fd_sc_hd__tapvpwrvgnd_1
XTAP_TAPCELL_ROW_194_2548 VGND VPWR sky130_fd_sc_hd__tapvpwrvgnd_1
XTAP_TAPCELL_ROW_194_2559 VGND VPWR sky130_fd_sc_hd__tapvpwrvgnd_1
XFILLER_41_44 VPWR VGND VPWR VGND sky130_ef_sc_hd__decap_12
XFILLER_194_163 VPWR VGND VPWR VGND sky130_ef_sc_hd__decap_12
XFILLER_241_1291 VPWR VGND VPWR VGND sky130_ef_sc_hd__decap_12
XFILLER_167_388 VPWR VGND VPWR VGND sky130_ef_sc_hd__decap_12
XFILLER_210_495 VPWR VGND VPWR VGND sky130_ef_sc_hd__decap_12
XFILLER_157_44 VPWR VGND VPWR VGND sky130_ef_sc_hd__decap_12
XFILLER_182_347 VPWR VGND VPWR VGND sky130_ef_sc_hd__decap_12
XFILLER_203_3 VPWR VGND VPWR VGND sky130_ef_sc_hd__decap_12
XTAP_TAPCELL_ROW_188_2319 VGND VPWR sky130_fd_sc_hd__tapvpwrvgnd_1
XFILLER_237_1327 VGND VGND VPWR VPWR sky130_fd_sc_hd__decap_6
XFILLER_194_1054 VPWR VGND VPWR VGND sky130_ef_sc_hd__decap_12
XFILLER_11_1292 VPWR VGND VPWR VGND sky130_ef_sc_hd__decap_12
XFILLER_1_210 VGND VGND VPWR VPWR sky130_fd_sc_hd__decap_4
XFILLER_85_1371 VGND VGND VPWR VPWR sky130_fd_sc_hd__decap_6
XFILLER_2_777 VGND VGND VPWR VPWR sky130_fd_sc_hd__fill_1
XFILLER_249_142 VPWR VGND VPWR VGND sky130_ef_sc_hd__decap_12
XFILLER_42_1208 VPWR VGND VPWR VGND sky130_ef_sc_hd__decap_12
XFILLER_173_87 VPWR VGND VPWR VGND sky130_ef_sc_hd__decap_12
XFILLER_46_1399 VPWR VGND VPWR VGND sky130_ef_sc_hd__decap_12
XFILLER_133_1347 VPWR VGND VPWR VGND sky130_ef_sc_hd__decap_12
XFILLER_237_326 VPWR VGND VPWR VGND sky130_ef_sc_hd__decap_12
XFILLER_249_197 VPWR VGND VPWR VGND sky130_ef_sc_hd__decap_12
XFILLER_218_562 VPWR VGND VPWR VGND sky130_ef_sc_hd__decap_12
XFILLER_246_882 VPWR VGND VPWR VGND sky130_ef_sc_hd__decap_12
XPHY_EDGE_ROW_204_Left_459 VGND VGND VPWR VPWR sky130_fd_sc_hd__decap_3
XFILLER_233_510 VGND VGND VPWR VPWR sky130_fd_sc_hd__decap_6
XFILLER_248_1434 VGND VGND VPWR VPWR sky130_fd_sc_hd__decap_6
XFILLER_245_381 VGND VGND VPWR VPWR sky130_fd_sc_hd__decap_6
XFILLER_206_746 VGND VGND VPWR VPWR sky130_fd_sc_hd__decap_6
XTAP_TAPCELL_ROW_155_2_5902 VGND VPWR sky130_fd_sc_hd__tapvpwrvgnd_1
X_526_ net664 VGND VGND VPWR VPWR _008_ sky130_fd_sc_hd__inv_2
XTAP_TAPCELL_ROW_218_3400 VGND VPWR sky130_fd_sc_hd__tapvpwrvgnd_1
XFILLER_242_1011 VPWR VGND VPWR VGND sky130_ef_sc_hd__decap_12
XFILLER_53_1304 VPWR VGND VPWR VGND sky130_ef_sc_hd__decap_12
XFILLER_207_1131 VPWR VGND VPWR VGND sky130_ef_sc_hd__decap_12
X_457_ rd_addr\[3\] net622 net625 VGND VGND VPWR VPWR addr0\[3\] sky130_fd_sc_hd__mux2_1
XFILLER_18_1435 VGND VGND VPWR VPWR sky130_fd_sc_hd__decap_6
XFILLER_220_237 VPWR VGND VPWR VGND sky130_ef_sc_hd__decap_12
XTAP_TAPCELL_ROW_233_3909 VGND VPWR sky130_fd_sc_hd__tapvpwrvgnd_1
XFILLER_144_1454 VPWR VGND VPWR VGND sky130_ef_sc_hd__decap_12
XFILLER_242_1066 VPWR VGND VPWR VGND sky130_ef_sc_hd__decap_12
XFILLER_53_1359 VPWR VGND VPWR VGND sky130_ef_sc_hd__decap_12
XFILLER_207_1186 VPWR VGND VPWR VGND sky130_ef_sc_hd__decap_12
X_388_ net153 net209 VGND VGND VPWR VPWR _177_ sky130_fd_sc_hd__and2b_1
XFILLER_185_130 VPWR VGND VPWR VGND sky130_ef_sc_hd__decap_12
XFILLER_179_1506 VGND VGND VPWR VPWR sky130_fd_sc_hd__decap_8
XFILLER_173_314 VPWR VGND VPWR VGND sky130_ef_sc_hd__decap_12
XFILLER_185_185 VPWR VGND VPWR VGND sky130_ef_sc_hd__decap_12
XTAP_TAPCELL_ROW_73_2_5246 VGND VPWR sky130_fd_sc_hd__tapvpwrvgnd_1
XPHY_EDGE_ROW_213_Left_468 VGND VGND VPWR VPWR sky130_fd_sc_hd__decap_3
XFILLER_173_369 VPWR VGND VPWR VGND sky130_ef_sc_hd__decap_12
XFILLER_177_1241 VGND VGND VPWR VPWR sky130_fd_sc_hd__decap_6
XFILLER_5_560 VGND VGND VPWR VPWR sky130_fd_sc_hd__fill_1
XFILLER_49_3 VPWR VGND VPWR VGND sky130_ef_sc_hd__decap_12
XFILLER_64_1411 VPWR VGND VPWR VGND sky130_ef_sc_hd__decap_12
XFILLER_253_1162 VPWR VGND VPWR VGND sky130_ef_sc_hd__decap_12
XFILLER_190_1441 VPWR VGND VPWR VGND sky130_ef_sc_hd__decap_12
XFILLER_64_1466 VPWR VGND VPWR VGND sky130_ef_sc_hd__decap_12
XFILLER_151_1414 VGND VGND VPWR VPWR sky130_fd_sc_hd__decap_6
XFILLER_218_1293 VPWR VGND VPWR VGND sky130_ef_sc_hd__decap_12
XFILLER_228_304 VPWR VGND VPWR VGND sky130_ef_sc_hd__decap_12
XTAP_TAPCELL_ROW_19_2_4813 VGND VPWR sky130_fd_sc_hd__tapvpwrvgnd_1
XFILLER_99_1507 VGND VGND VPWR VPWR sky130_fd_sc_hd__decap_8
XFILLER_190_1496 VPWR VGND VPWR VGND sky130_ef_sc_hd__decap_12
XFILLER_233_68 VPWR VGND VPWR VGND sky130_ef_sc_hd__decap_12
XFILLER_244_808 VPWR VGND VPWR VGND sky130_ef_sc_hd__decap_12
XPHY_EDGE_ROW_222_Left_477 VGND VGND VPWR VPWR sky130_fd_sc_hd__decap_3
XFILLER_228_359 VGND VGND VPWR VPWR sky130_fd_sc_hd__decap_6
XFILLER_97_1242 VGND VGND VPWR VPWR sky130_fd_sc_hd__decap_6
XFILLER_209_584 VPWR VGND VPWR VGND sky130_ef_sc_hd__decap_12
XFILLER_110_1177 VGND VGND VPWR VPWR sky130_fd_sc_hd__decap_6
XFILLER_252_863 VPWR VGND VPWR VGND sky130_ef_sc_hd__decap_12
XFILLER_145_1218 VPWR VGND VPWR VGND sky130_ef_sc_hd__decap_12
XFILLER_180_1109 VPWR VGND VPWR VGND sky130_ef_sc_hd__decap_12
XFILLER_168_108 VPWR VGND VPWR VGND sky130_ef_sc_hd__decap_12
XTAP_TAPCELL_ROW_201_2780 VGND VPWR sky130_fd_sc_hd__tapvpwrvgnd_1
XTAP_TAPCELL_ROW_201_2791 VGND VPWR sky130_fd_sc_hd__tapvpwrvgnd_1
XFILLER_211_259 VPWR VGND VPWR VGND sky130_ef_sc_hd__decap_12
XPHY_EDGE_ROW_231_Left_486 VGND VGND VPWR VPWR sky130_fd_sc_hd__decap_3
XFILLER_176_163 VPWR VGND VPWR VGND sky130_ef_sc_hd__decap_12
XFILLER_34_1270 VPWR VGND VPWR VGND sky130_ef_sc_hd__decap_12
XFILLER_191_111 VPWR VGND VPWR VGND sky130_ef_sc_hd__decap_12
XPHY_EDGE_ROW_132_1_Right_788 VGND VGND VPWR VPWR sky130_fd_sc_hd__decap_3
XFILLER_192_667 VPWR VGND VPWR VGND sky130_ef_sc_hd__decap_12
XFILLER_121_1273 VPWR VGND VPWR VGND sky130_ef_sc_hd__decap_12
XFILLER_191_166 VGND VGND VPWR VPWR sky130_fd_sc_hd__decap_6
XFILLER_219_1002 VPWR VGND VPWR VGND sky130_ef_sc_hd__decap_12
XFILLER_156_1325 VPWR VGND VPWR VGND sky130_ef_sc_hd__decap_12
XFILLER_191_1205 VPWR VGND VPWR VGND sky130_ef_sc_hd__decap_12
XFILLER_219_1057 VPWR VGND VPWR VGND sky130_ef_sc_hd__decap_12
XTAP_TAPCELL_ROW_247_4385 VGND VPWR sky130_fd_sc_hd__tapvpwrvgnd_1
XTAP_TAPCELL_ROW_247_4396 VGND VPWR sky130_fd_sc_hd__tapvpwrvgnd_1
XTAP_TAPCELL_ROW_243_4249 VGND VPWR sky130_fd_sc_hd__tapvpwrvgnd_1
XFILLER_207_80 VGND VGND VPWR VPWR sky130_fd_sc_hd__decap_6
XPHY_EDGE_ROW_240_Left_495 VGND VGND VPWR VPWR sky130_fd_sc_hd__decap_3
XFILLER_246_101 VGND VGND VPWR VPWR sky130_fd_sc_hd__decap_6
XFILLER_219_326 VPWR VGND VPWR VGND sky130_ef_sc_hd__decap_12
XFILLER_247_646 VPWR VGND VPWR VGND sky130_ef_sc_hd__decap_12
XFILLER_130_1509 VGND VGND VPWR VPWR sky130_fd_sc_hd__decap_6
XFILLER_189_1112 VGND VGND VPWR VPWR sky130_fd_sc_hd__decap_6
XFILLER_143_68 VGND VGND VPWR VPWR sky130_fd_sc_hd__decap_3
XFILLER_41_1230 VPWR VGND VPWR VGND sky130_ef_sc_hd__decap_12
XTAP_TAPCELL_ROW_9_1174 VGND VPWR sky130_fd_sc_hd__tapvpwrvgnd_1
XTAP_TAPCELL_ROW_9_1185 VGND VPWR sky130_fd_sc_hd__tapvpwrvgnd_1
XTAP_TAPCELL_ROW_129_2_5697 VGND VPWR sky130_fd_sc_hd__tapvpwrvgnd_1
XTAP_TAPCELL_ROW_9_1196 VGND VPWR sky130_fd_sc_hd__tapvpwrvgnd_1
XTAP_TAPCELL_ROW_5_1038 VGND VPWR sky130_fd_sc_hd__tapvpwrvgnd_1
XFILLER_132_1380 VPWR VGND VPWR VGND sky130_ef_sc_hd__decap_12
XFILLER_36_22 VPWR VGND VPWR VGND sky130_ef_sc_hd__decap_12
XTAP_TAPCELL_ROW_5_1049 VGND VPWR sky130_fd_sc_hd__tapvpwrvgnd_1
XFILLER_228_882 VPWR VGND VPWR VGND sky130_ef_sc_hd__decap_12
XFILLER_41_1285 VGND VGND VPWR VPWR sky130_fd_sc_hd__decap_6
XFILLER_215_510 VGND VGND VPWR VPWR sky130_fd_sc_hd__decap_6
XFILLER_243_830 VPWR VGND VPWR VGND sky130_ef_sc_hd__decap_12
XFILLER_227_381 VGND VGND VPWR VPWR sky130_fd_sc_hd__decap_6
XFILLER_167_1432 VPWR VGND VPWR VGND sky130_ef_sc_hd__decap_12
XFILLER_76_1337 VPWR VGND VPWR VGND sky130_ef_sc_hd__decap_12
XFILLER_243_885 VPWR VGND VPWR VGND sky130_ef_sc_hd__decap_12
XFILLER_188_918 VGND VGND VPWR VPWR sky130_fd_sc_hd__decap_6
XFILLER_153_3 VPWR VGND VPWR VGND sky130_ef_sc_hd__decap_12
XFILLER_167_1487 VPWR VGND VPWR VGND sky130_ef_sc_hd__decap_12
X_311_ net597 dout0_q\[27\] net529 VGND VGND VPWR VPWR _100_ sky130_fd_sc_hd__and3_1
XFILLER_202_237 VPWR VGND VPWR VGND sky130_ef_sc_hd__decap_12
XPHY_EDGE_ROW_94_1_Right_750 VGND VGND VPWR VPWR sky130_fd_sc_hd__decap_3
XFILLER_39_1192 VPWR VGND VPWR VGND sky130_ef_sc_hd__decap_12
XFILLER_208_1484 VPWR VGND VPWR VGND sky130_ef_sc_hd__decap_12
XFILLER_52_65 VGND VGND VPWR VPWR sky130_fd_sc_hd__decap_6
XFILLER_167_130 VPWR VGND VPWR VGND sky130_ef_sc_hd__decap_12
XTAP_TAPCELL_ROW_58_2_5126 VGND VPWR sky130_fd_sc_hd__tapvpwrvgnd_1
XFILLER_204_1348 VGND VGND VPWR VPWR sky130_fd_sc_hd__decap_6
XFILLER_126_1184 VPWR VGND VPWR VGND sky130_ef_sc_hd__decap_12
XFILLER_168_65 VPWR VGND VPWR VGND sky130_ef_sc_hd__decap_12
Xinput19 wr_data[18] VGND VGND VPWR VPWR net19 sky130_fd_sc_hd__clkbuf_1
XFILLER_167_185 VPWR VGND VPWR VGND sky130_ef_sc_hd__decap_12
XFILLER_210_292 VPWR VGND VPWR VGND sky130_ef_sc_hd__decap_12
XFILLER_52_1392 VGND VGND VPWR VPWR sky130_fd_sc_hd__decap_6
XFILLER_182_144 VGND VGND VPWR VPWR sky130_fd_sc_hd__decap_6
XFILLER_100_1313 VPWR VGND VPWR VGND sky130_ef_sc_hd__decap_12
XFILLER_171_818 VPWR VGND VPWR VGND sky130_ef_sc_hd__decap_12
XFILLER_87_1433 VPWR VGND VPWR VGND sky130_ef_sc_hd__decap_12
XFILLER_183_689 VPWR VGND VPWR VGND sky130_ef_sc_hd__decap_12
XFILLER_100_1368 VPWR VGND VPWR VGND sky130_ef_sc_hd__decap_12
XFILLER_87_1488 VPWR VGND VPWR VGND sky130_ef_sc_hd__decap_12
Xsram0_681 VGND VGND VPWR VPWR sram0_681/HI net681 sky130_fd_sc_hd__conb_1
XFILLER_250_1324 VPWR VGND VPWR VGND sky130_ef_sc_hd__decap_12
XFILLER_215_1444 VPWR VGND VPWR VGND sky130_ef_sc_hd__decap_12
XFILLER_238_624 VPWR VGND VPWR VGND sky130_ef_sc_hd__decap_12
XFILLER_46_1196 VPWR VGND VPWR VGND sky130_ef_sc_hd__decap_12
XFILLER_250_1379 VPWR VGND VPWR VGND sky130_ef_sc_hd__decap_12
XFILLER_215_1499 VGND VGND VPWR VPWR sky130_fd_sc_hd__decap_6
XFILLER_237_123 VGND VGND VPWR VPWR sky130_fd_sc_hd__decap_6
XFILLER_133_1177 VPWR VGND VPWR VGND sky130_ef_sc_hd__decap_12
XFILLER_226_808 VPWR VGND VPWR VGND sky130_ef_sc_hd__decap_12
XFILLER_238_679 VPWR VGND VPWR VGND sky130_ef_sc_hd__decap_12
XFILLER_203_27 VPWR VGND VPWR VGND sky130_ef_sc_hd__decap_12
XFILLER_168_1207 VPWR VGND VPWR VGND sky130_ef_sc_hd__decap_12
XFILLER_253_627 VPWR VGND VPWR VGND sky130_ef_sc_hd__decap_12
XFILLER_20_1325 VPWR VGND VPWR VGND sky130_ef_sc_hd__decap_12
XFILLER_0_1408 VPWR VGND VPWR VGND sky130_ef_sc_hd__decap_12
XFILLER_111_1464 VPWR VGND VPWR VGND sky130_ef_sc_hd__decap_12
XFILLER_234_863 VPWR VGND VPWR VGND sky130_ef_sc_hd__decap_12
XFILLER_209_1248 VPWR VGND VPWR VGND sky130_ef_sc_hd__decap_12
XPHY_EDGE_ROW_30_2_Right_121 VGND VGND VPWR VPWR sky130_fd_sc_hd__decap_3
X_509_ net525 net188 VGND VGND VPWR VPWR _260_ sky130_fd_sc_hd__xor2_1
XPHY_EDGE_ROW_22_2_Left_524 VGND VGND VPWR VPWR sky130_fd_sc_hd__decap_3
XFILLER_187_940 VGND VGND VPWR VPWR sky130_fd_sc_hd__decap_6
XFILLER_57_1292 VPWR VGND VPWR VGND sky130_ef_sc_hd__decap_12
XFILLER_109_1371 VGND VGND VPWR VPWR sky130_fd_sc_hd__decap_6
XFILLER_144_1251 VPWR VGND VPWR VGND sky130_ef_sc_hd__decap_12
XFILLER_179_1303 VPWR VGND VPWR VGND sky130_ef_sc_hd__decap_12
XFILLER_53_1189 VPWR VGND VPWR VGND sky130_ef_sc_hd__decap_12
XFILLER_31_1421 VPWR VGND VPWR VGND sky130_ef_sc_hd__decap_12
XFILLER_88_1208 VPWR VGND VPWR VGND sky130_ef_sc_hd__decap_12
XFILLER_173_111 VPWR VGND VPWR VGND sky130_ef_sc_hd__decap_12
XFILLER_174_667 VPWR VGND VPWR VGND sky130_ef_sc_hd__decap_12
XFILLER_179_1358 VPWR VGND VPWR VGND sky130_ef_sc_hd__decap_12
XFILLER_228_46 VPWR VGND VPWR VGND sky130_ef_sc_hd__decap_12
XFILLER_220_1183 VPWR VGND VPWR VGND sky130_ef_sc_hd__decap_12
XFILLER_31_1476 VPWR VGND VPWR VGND sky130_ef_sc_hd__decap_12
XFILLER_173_166 VGND VGND VPWR VPWR sky130_fd_sc_hd__decap_6
XFILLER_192_1514 VGND VGND VPWR VPWR sky130_fd_sc_hd__fill_1
XFILLER_170_851 VPWR VGND VPWR VGND sky130_ef_sc_hd__decap_12
XFILLER_216_1219 VGND VGND VPWR VPWR sky130_fd_sc_hd__decap_6
XFILLER_244_34 VPWR VGND VPWR VGND sky130_ef_sc_hd__decap_12
XFILLER_64_1263 VGND VGND VPWR VPWR sky130_fd_sc_hd__decap_6
XFILLER_218_1090 VGND VGND VPWR VPWR sky130_fd_sc_hd__decap_6
XTAP_TAPCELL_ROW_115_2_5583 VGND VPWR sky130_fd_sc_hd__tapvpwrvgnd_1
XFILLER_244_89 VPWR VGND VPWR VGND sky130_ef_sc_hd__decap_12
XFILLER_228_101 VGND VGND VPWR VPWR sky130_fd_sc_hd__decap_6
XFILLER_99_1304 VPWR VGND VPWR VGND sky130_ef_sc_hd__decap_12
XFILLER_190_1293 VPWR VGND VPWR VGND sky130_ef_sc_hd__decap_12
XFILLER_229_646 VPWR VGND VPWR VGND sky130_ef_sc_hd__decap_12
XFILLER_244_605 VPWR VGND VPWR VGND sky130_ef_sc_hd__decap_12
XFILLER_112_1239 VPWR VGND VPWR VGND sky130_ef_sc_hd__decap_12
XFILLER_99_1359 VPWR VGND VPWR VGND sky130_ef_sc_hd__decap_12
XFILLER_113_27 VPWR VGND VPWR VGND sky130_ef_sc_hd__decap_12
XFILLER_209_381 VGND VGND VPWR VPWR sky130_fd_sc_hd__decap_6
XFILLER_225_830 VPWR VGND VPWR VGND sky130_ef_sc_hd__decap_12
XFILLER_3_1076 VPWR VGND VPWR VGND sky130_ef_sc_hd__decap_12
XTAP_TAPCELL_ROW_203_2853 VGND VPWR sky130_fd_sc_hd__tapvpwrvgnd_1
XTAP_TAPCELL_ROW_203_2864 VGND VPWR sky130_fd_sc_hd__tapvpwrvgnd_1
XFILLER_252_660 VGND VGND VPWR VPWR sky130_fd_sc_hd__decap_6
XFILLER_227_1315 VPWR VGND VPWR VGND sky130_ef_sc_hd__decap_12
XTAP_TAPCELL_ROW_203_2875 VGND VPWR sky130_fd_sc_hd__tapvpwrvgnd_1
XFILLER_225_885 VPWR VGND VPWR VGND sky130_ef_sc_hd__decap_12
XTAP_TAPCELL_ROW_236_4020 VGND VPWR sky130_fd_sc_hd__tapvpwrvgnd_1
XTAP_TAPCELL_ROW_236_4031 VGND VPWR sky130_fd_sc_hd__tapvpwrvgnd_1
XTAP_TAPCELL_ROW_255_4665 VGND VPWR sky130_fd_sc_hd__tapvpwrvgnd_1
XTAP_TAPCELL_ROW_255_4676 VGND VPWR sky130_fd_sc_hd__tapvpwrvgnd_1
XTAP_TAPCELL_ROW_44_2_5012 VGND VPWR sky130_fd_sc_hd__tapvpwrvgnd_1
XTAP_TAPCELL_ROW_255_4687 VGND VPWR sky130_fd_sc_hd__tapvpwrvgnd_1
XTAP_TAPCELL_ROW_255_4698 VGND VPWR sky130_fd_sc_hd__tapvpwrvgnd_1
XTAP_TAPCELL_ROW_251_4529 VGND VPWR sky130_fd_sc_hd__tapvpwrvgnd_1
XFILLER_71_1201 VGND VGND VPWR VPWR sky130_fd_sc_hd__decap_4
XFILLER_184_1097 VPWR VGND VPWR VGND sky130_ef_sc_hd__decap_12
XFILLER_184_409 VPWR VGND VPWR VGND sky130_ef_sc_hd__decap_12
XPHY_EDGE_ROW_79_2_Left_581 VGND VGND VPWR VPWR sky130_fd_sc_hd__decap_3
XFILLER_165_601 VGND VGND VPWR VPWR sky130_fd_sc_hd__decap_8
XFILLER_123_1335 VPWR VGND VPWR VGND sky130_ef_sc_hd__decap_12
XFILLER_22_46 VPWR VGND VPWR VGND sky130_ef_sc_hd__decap_12
XTAP_TAPCELL_ROW_11_2_4753 VGND VPWR sky130_fd_sc_hd__tapvpwrvgnd_1
XFILLER_203_1370 VGND VGND VPWR VPWR sky130_fd_sc_hd__decap_6
XFILLER_138_46 VPWR VGND VPWR VGND sky130_ef_sc_hd__decap_12
XFILLER_192_464 VPWR VGND VPWR VGND sky130_ef_sc_hd__decap_12
XPHY_EDGE_ROW_133_1_Right_789 VGND VGND VPWR VPWR sky130_fd_sc_hd__decap_3
XTAP_TAPCELL_ROW_249_4458 VGND VPWR sky130_fd_sc_hd__tapvpwrvgnd_1
XFILLER_238_1422 VPWR VGND VPWR VGND sky130_ef_sc_hd__decap_12
XTAP_TAPCELL_ROW_249_4469 VGND VPWR sky130_fd_sc_hd__tapvpwrvgnd_1
XFILLER_180_648 VPWR VGND VPWR VGND sky130_ef_sc_hd__decap_12
XFILLER_191_1002 VPWR VGND VPWR VGND sky130_ef_sc_hd__decap_12
XFILLER_238_1477 VGND VGND VPWR VPWR sky130_fd_sc_hd__decap_6
XFILLER_154_34 VPWR VGND VPWR VGND sky130_ef_sc_hd__decap_12
XFILLER_156_1177 VGND VGND VPWR VPWR sky130_fd_sc_hd__decap_6
XFILLER_191_1057 VPWR VGND VPWR VGND sky130_ef_sc_hd__decap_12
XFILLER_134_1442 VPWR VGND VPWR VGND sky130_ef_sc_hd__decap_12
XFILLER_43_1347 VPWR VGND VPWR VGND sky130_ef_sc_hd__decap_12
XFILLER_219_123 VGND VGND VPWR VPWR sky130_fd_sc_hd__decap_6
XFILLER_232_1054 VPWR VGND VPWR VGND sky130_ef_sc_hd__decap_12
XFILLER_130_1306 VGND VGND VPWR VPWR sky130_fd_sc_hd__decap_6
XFILLER_247_443 VPWR VGND VPWR VGND sky130_ef_sc_hd__decap_12
XFILLER_208_808 VPWR VGND VPWR VGND sky130_ef_sc_hd__decap_12
XFILLER_134_1497 VPWR VGND VPWR VGND sky130_ef_sc_hd__decap_12
XFILLER_170_22 VPWR VGND VPWR VGND sky130_ef_sc_hd__decap_12
XFILLER_235_627 VPWR VGND VPWR VGND sky130_ef_sc_hd__decap_12
XFILLER_247_498 VPWR VGND VPWR VGND sky130_ef_sc_hd__decap_12
XPHY_EDGE_ROW_20_1_Left_275 VGND VGND VPWR VPWR sky130_fd_sc_hd__decap_3
XFILLER_170_77 VPWR VGND VPWR VGND sky130_ef_sc_hd__decap_12
XFILLER_216_863 VPWR VGND VPWR VGND sky130_ef_sc_hd__decap_12
XFILLER_231_811 VGND VGND VPWR VPWR sky130_fd_sc_hd__decap_6
XFILLER_243_682 VGND VGND VPWR VPWR sky130_fd_sc_hd__decap_6
XFILLER_167_1284 VGND VGND VPWR VPWR sky130_fd_sc_hd__decap_6
XFILLER_169_940 VGND VGND VPWR VPWR sky130_fd_sc_hd__decap_6
XFILLER_54_1454 VPWR VGND VPWR VGND sky130_ef_sc_hd__decap_12
XFILLER_8_15 VGND VGND VPWR VPWR sky130_fd_sc_hd__decap_6
XFILLER_141_1402 VPWR VGND VPWR VGND sky130_ef_sc_hd__decap_12
XFILLER_208_1281 VPWR VGND VPWR VGND sky130_ef_sc_hd__decap_12
XPHY_EDGE_ROW_95_1_Right_751 VGND VGND VPWR VPWR sky130_fd_sc_hd__decap_3
XFILLER_7_600 VGND VGND VPWR VPWR sky130_fd_sc_hd__fill_2
XFILLER_180_1484 VPWR VGND VPWR VGND sky130_ef_sc_hd__decap_12
XFILLER_141_1457 VGND VGND VPWR VPWR sky130_fd_sc_hd__decap_6
XFILLER_183_431 VPWR VGND VPWR VGND sky130_ef_sc_hd__decap_12
XFILLER_7_644 VGND VGND VPWR VPWR sky130_fd_sc_hd__fill_1
Xwire553 net72 VGND VGND VPWR VPWR net553 sky130_fd_sc_hd__buf_1
Xwire564 net566 VGND VGND VPWR VPWR net564 sky130_fd_sc_hd__clkbuf_1
XTAP_TAPCELL_ROW_152_2_5879 VGND VPWR sky130_fd_sc_hd__tapvpwrvgnd_1
XFILLER_6_132 VPWR VGND VPWR VGND sky130_ef_sc_hd__decap_12
Xwire575 dout0_q\[12\] VGND VGND VPWR VPWR net575 sky130_fd_sc_hd__clkbuf_1
XFILLER_171_615 VPWR VGND VPWR VGND sky130_ef_sc_hd__decap_12
Xwire586 dout0_q\[3\] VGND VGND VPWR VPWR net586 sky130_fd_sc_hd__clkbuf_1
XFILLER_87_1230 VPWR VGND VPWR VGND sky130_ef_sc_hd__decap_12
XPHY_EDGE_ROW_164_1_Left_419 VGND VGND VPWR VPWR sky130_fd_sc_hd__decap_3
XTAP_TAPCELL_ROW_172_1761 VGND VPWR sky130_fd_sc_hd__tapvpwrvgnd_1
XFILLER_183_486 VPWR VGND VPWR VGND sky130_ef_sc_hd__decap_12
XFILLER_6_176 VGND VGND VPWR VPWR sky130_fd_sc_hd__decap_3
XTAP_TAPCELL_ROW_88_2_5365 VGND VPWR sky130_fd_sc_hd__tapvpwrvgnd_1
XTAP_TAPCELL_ROW_172_1772 VGND VPWR sky130_fd_sc_hd__tapvpwrvgnd_1
XTAP_TAPCELL_ROW_172_1783 VGND VPWR sky130_fd_sc_hd__tapvpwrvgnd_1
XFILLER_6_198 VGND VGND VPWR VPWR sky130_fd_sc_hd__fill_2
XFILLER_100_1165 VPWR VGND VPWR VGND sky130_ef_sc_hd__decap_12
XFILLER_217_1506 VGND VGND VPWR VPWR sky130_fd_sc_hd__decap_8
XFILLER_178_1391 VGND VGND VPWR VPWR sky130_fd_sc_hd__decap_6
XFILLER_87_1285 VGND VGND VPWR VPWR sky130_fd_sc_hd__decap_6
XFILLER_135_1206 VPWR VGND VPWR VGND sky130_ef_sc_hd__decap_12
XFILLER_3_872 VGND VGND VPWR VPWR sky130_fd_sc_hd__decap_6
XFILLER_2_382 VGND VGND VPWR VPWR sky130_fd_sc_hd__fill_1
XFILLER_250_1121 VPWR VGND VPWR VGND sky130_ef_sc_hd__decap_12
XFILLER_61_1414 VGND VGND VPWR VPWR sky130_fd_sc_hd__decap_6
XFILLER_215_1241 VGND VGND VPWR VPWR sky130_fd_sc_hd__decap_6
XFILLER_214_15 VGND VGND VPWR VPWR sky130_fd_sc_hd__decap_6
XFILLER_238_421 VPWR VGND VPWR VGND sky130_ef_sc_hd__decap_12
XTAP_TAPCELL_ROW_81_2_5308 VGND VPWR sky130_fd_sc_hd__tapvpwrvgnd_1
XFILLER_250_1176 VGND VGND VPWR VPWR sky130_fd_sc_hd__decap_6
XTAP_TAPCELL_ROW_166_1554 VGND VPWR sky130_fd_sc_hd__tapvpwrvgnd_1
XFILLER_226_605 VPWR VGND VPWR VGND sky130_ef_sc_hd__decap_12
XFILLER_254_925 VPWR VGND VPWR VGND sky130_ef_sc_hd__decap_12
XTAP_TAPCELL_ROW_166_1565 VGND VPWR sky130_fd_sc_hd__tapvpwrvgnd_1
XFILLER_238_476 VPWR VGND VPWR VGND sky130_ef_sc_hd__decap_12
XTAP_TAPCELL_ROW_166_1576 VGND VPWR sky130_fd_sc_hd__tapvpwrvgnd_1
XFILLER_168_1004 VGND VGND VPWR VPWR sky130_fd_sc_hd__decap_6
XFILLER_253_424 VGND VGND VPWR VPWR sky130_fd_sc_hd__decap_6
XFILLER_207_830 VPWR VGND VPWR VGND sky130_ef_sc_hd__decap_12
XFILLER_111_1261 VPWR VGND VPWR VGND sky130_ef_sc_hd__decap_12
XFILLER_98_1392 VGND VGND VPWR VPWR sky130_fd_sc_hd__decap_6
XFILLER_20_1177 VGND VGND VPWR VPWR sky130_fd_sc_hd__decap_6
XFILLER_234_660 VGND VGND VPWR VPWR sky130_fd_sc_hd__decap_6
XFILLER_207_885 VPWR VGND VPWR VGND sky130_ef_sc_hd__decap_12
XFILLER_146_1313 VPWR VGND VPWR VGND sky130_ef_sc_hd__decap_12
XFILLER_230_58 VGND VGND VPWR VPWR sky130_fd_sc_hd__decap_6
XFILLER_55_1218 VPWR VGND VPWR VGND sky130_ef_sc_hd__decap_12
XFILLER_209_1045 VPWR VGND VPWR VGND sky130_ef_sc_hd__decap_12
XFILLER_146_1368 VPWR VGND VPWR VGND sky130_ef_sc_hd__decap_12
XFILLER_181_1248 VPWR VGND VPWR VGND sky130_ef_sc_hd__decap_12
XPHY_EDGE_ROW_31_2_Right_122 VGND VGND VPWR VPWR sky130_fd_sc_hd__decap_3
XFILLER_166_409 VPWR VGND VPWR VGND sky130_ef_sc_hd__decap_12
XFILLER_193_228 VPWR VGND VPWR VGND sky130_ef_sc_hd__decap_12
XFILLER_179_1100 VPWR VGND VPWR VGND sky130_ef_sc_hd__decap_12
XFILLER_239_56 VPWR VGND VPWR VGND sky130_ef_sc_hd__decap_12
XFILLER_186_280 VPWR VGND VPWR VGND sky130_ef_sc_hd__decap_12
XFILLER_174_464 VPWR VGND VPWR VGND sky130_ef_sc_hd__decap_12
XFILLER_179_1155 VGND VGND VPWR VPWR sky130_fd_sc_hd__decap_6
XFILLER_31_1273 VPWR VGND VPWR VGND sky130_ef_sc_hd__decap_12
XFILLER_255_22 VPWR VGND VPWR VGND sky130_ef_sc_hd__decap_12
XFILLER_255_1021 VGND VGND VPWR VPWR sky130_fd_sc_hd__decap_8
XFILLER_190_968 VPWR VGND VPWR VGND sky130_ef_sc_hd__decap_12
XFILLER_66_1325 VPWR VGND VPWR VGND sky130_ef_sc_hd__decap_12
XFILLER_255_55 VGND VGND VPWR VPWR sky130_fd_sc_hd__decap_8
XTAP_TAPCELL_ROW_244_4300 VGND VPWR sky130_fd_sc_hd__tapvpwrvgnd_1
XFILLER_1_809 VGND VGND VPWR VPWR sky130_fd_sc_hd__fill_1
XTAP_TAPCELL_ROW_244_4311 VGND VPWR sky130_fd_sc_hd__tapvpwrvgnd_1
XFILLER_157_1464 VPWR VGND VPWR VGND sky130_ef_sc_hd__decap_12
XFILLER_192_1355 VPWR VGND VPWR VGND sky130_ef_sc_hd__decap_12
XFILLER_153_1328 VGND VGND VPWR VPWR sky130_fd_sc_hd__decap_6
XFILLER_248_218 VPWR VGND VPWR VGND sky130_ef_sc_hd__decap_12
XFILLER_124_15 VGND VGND VPWR VPWR sky130_fd_sc_hd__decap_6
XFILLER_9_1252 VGND VGND VPWR VPWR sky130_fd_sc_hd__decap_8
XFILLER_190_1090 VGND VGND VPWR VPWR sky130_fd_sc_hd__decap_6
XFILLER_229_443 VPWR VGND VPWR VGND sky130_ef_sc_hd__decap_12
XFILLER_40_1509 VGND VGND VPWR VPWR sky130_fd_sc_hd__decap_6
XTAP_TAPCELL_ROW_6_1100 VGND VPWR sky130_fd_sc_hd__tapvpwrvgnd_1
XTAP_TAPCELL_ROW_205_2915 VGND VPWR sky130_fd_sc_hd__tapvpwrvgnd_1
XFILLER_244_402 VGND VGND VPWR VPWR sky130_fd_sc_hd__decap_6
XTAP_TAPCELL_ROW_205_2926 VGND VPWR sky130_fd_sc_hd__tapvpwrvgnd_1
XFILLER_217_627 VPWR VGND VPWR VGND sky130_ef_sc_hd__decap_12
XFILLER_245_947 VPWR VGND VPWR VGND sky130_ef_sc_hd__decap_12
XTAP_TAPCELL_ROW_205_2937 VGND VPWR sky130_fd_sc_hd__tapvpwrvgnd_1
XFILLER_229_498 VPWR VGND VPWR VGND sky130_ef_sc_hd__decap_12
XFILLER_42_1380 VPWR VGND VPWR VGND sky130_ef_sc_hd__decap_12
XTAP_TAPCELL_ROW_205_2948 VGND VPWR sky130_fd_sc_hd__tapvpwrvgnd_1
XFILLER_99_1189 VPWR VGND VPWR VGND sky130_ef_sc_hd__decap_12
XTAP_TAPCELL_ROW_0_831 VGND VPWR sky130_fd_sc_hd__tapvpwrvgnd_1
XFILLER_77_1421 VPWR VGND VPWR VGND sky130_ef_sc_hd__decap_12
XTAP_TAPCELL_ROW_0_842 VGND VPWR sky130_fd_sc_hd__tapvpwrvgnd_1
XFILLER_129_1500 VGND VGND VPWR VPWR sky130_fd_sc_hd__decap_6
XTAP_TAPCELL_ROW_0_853 VGND VPWR sky130_fd_sc_hd__tapvpwrvgnd_1
XFILLER_213_811 VGND VGND VPWR VPWR sky130_fd_sc_hd__decap_6
XFILLER_227_1112 VGND VGND VPWR VPWR sky130_fd_sc_hd__decap_6
XTAP_TAPCELL_ROW_0_864 VGND VPWR sky130_fd_sc_hd__tapvpwrvgnd_1
XFILLER_140_58 VGND VGND VPWR VPWR sky130_fd_sc_hd__decap_6
XTAP_TAPCELL_ROW_0_875 VGND VPWR sky130_fd_sc_hd__tapvpwrvgnd_1
XFILLER_225_682 VGND VGND VPWR VPWR sky130_fd_sc_hd__decap_6
XTAP_TAPCELL_ROW_0_886 VGND VPWR sky130_fd_sc_hd__tapvpwrvgnd_1
XFILLER_77_1476 VPWR VGND VPWR VGND sky130_ef_sc_hd__decap_12
XFILLER_164_1435 VGND VGND VPWR VPWR sky130_fd_sc_hd__decap_6
XFILLER_240_1312 VPWR VGND VPWR VGND sky130_ef_sc_hd__decap_12
XFILLER_205_1432 VPWR VGND VPWR VGND sky130_ef_sc_hd__decap_12
XFILLER_184_206 VPWR VGND VPWR VGND sky130_ef_sc_hd__decap_12
XFILLER_200_538 VPWR VGND VPWR VGND sky130_ef_sc_hd__decap_12
XTAP_TAPCELL_ROW_137_2_5759 VGND VPWR sky130_fd_sc_hd__tapvpwrvgnd_1
XFILLER_36_1184 VPWR VGND VPWR VGND sky130_ef_sc_hd__decap_12
XFILLER_149_56 VPWR VGND VPWR VGND sky130_ef_sc_hd__decap_12
XFILLER_240_1367 VPWR VGND VPWR VGND sky130_ef_sc_hd__decap_12
XFILLER_205_1487 VPWR VGND VPWR VGND sky130_ef_sc_hd__decap_12
XTAP_TAPCELL_ROW_74_2_5251 VGND VPWR sky130_fd_sc_hd__tapvpwrvgnd_1
XFILLER_123_1165 VPWR VGND VPWR VGND sky130_ef_sc_hd__decap_12
XFILLER_165_442 VPWR VGND VPWR VGND sky130_ef_sc_hd__decap_12
XFILLER_4_603 VGND VGND VPWR VPWR sky130_fd_sc_hd__fill_1
XFILLER_165_475 VGND VGND VPWR VPWR sky130_fd_sc_hd__decap_8
XFILLER_10_1313 VPWR VGND VPWR VGND sky130_ef_sc_hd__decap_12
XFILLER_116_3 VPWR VGND VPWR VGND sky130_ef_sc_hd__decap_12
XFILLER_192_261 VPWR VGND VPWR VGND sky130_ef_sc_hd__decap_12
XFILLER_165_22 VPWR VGND VPWR VGND sky130_ef_sc_hd__decap_12
XFILLER_158_1239 VPWR VGND VPWR VGND sky130_ef_sc_hd__decap_12
XFILLER_193_1119 VPWR VGND VPWR VGND sky130_ef_sc_hd__decap_12
XFILLER_180_445 VGND VGND VPWR VPWR sky130_fd_sc_hd__decap_6
XFILLER_10_1368 VPWR VGND VPWR VGND sky130_ef_sc_hd__decap_12
XFILLER_165_55 VGND VGND VPWR VPWR sky130_fd_sc_hd__decap_8
XTAP_TAPCELL_ROW_41_2_4992 VGND VPWR sky130_fd_sc_hd__tapvpwrvgnd_1
XFILLER_0_820 VGND VGND VPWR VPWR sky130_fd_sc_hd__fill_2
XFILLER_0_853 VGND VGND VPWR VPWR sky130_fd_sc_hd__fill_1
XFILLER_251_1463 VPWR VGND VPWR VGND sky130_ef_sc_hd__decap_12
XFILLER_0_875 VGND VGND VPWR VPWR sky130_fd_sc_hd__decap_6
XFILLER_247_240 VPWR VGND VPWR VGND sky130_ef_sc_hd__decap_12
XFILLER_208_605 VPWR VGND VPWR VGND sky130_ef_sc_hd__decap_12
XFILLER_43_1177 VPWR VGND VPWR VGND sky130_ef_sc_hd__decap_12
XFILLER_134_1294 VPWR VGND VPWR VGND sky130_ef_sc_hd__decap_12
XFILLER_181_87 VPWR VGND VPWR VGND sky130_ef_sc_hd__decap_12
XFILLER_236_925 VPWR VGND VPWR VGND sky130_ef_sc_hd__decap_12
XFILLER_248_796 VPWR VGND VPWR VGND sky130_ef_sc_hd__decap_12
XTAP_TAPCELL_ROW_54_1_1310 VGND VPWR sky130_fd_sc_hd__tapvpwrvgnd_1
XFILLER_235_424 VGND VGND VPWR VPWR sky130_fd_sc_hd__decap_6
XFILLER_247_295 VGND VGND VPWR VPWR sky130_fd_sc_hd__decap_6
XTAP_TAPCELL_ROW_33_2_4929 VGND VPWR sky130_fd_sc_hd__tapvpwrvgnd_1
XFILLER_1_1514 VGND VGND VPWR VPWR sky130_fd_sc_hd__fill_1
XFILLER_169_1346 VPWR VGND VPWR VGND sky130_ef_sc_hd__decap_12
XFILLER_21_1464 VPWR VGND VPWR VGND sky130_ef_sc_hd__decap_12
XFILLER_251_928 VPWR VGND VPWR VGND sky130_ef_sc_hd__decap_12
XFILLER_216_660 VGND VGND VPWR VPWR sky130_fd_sc_hd__decap_6
XTAP_TAPCELL_ROW_221_3484 VGND VPWR sky130_fd_sc_hd__tapvpwrvgnd_1
XFILLER_249_1370 VGND VGND VPWR VPWR sky130_fd_sc_hd__decap_6
XTAP_TAPCELL_ROW_221_3495 VGND VPWR sky130_fd_sc_hd__tapvpwrvgnd_1
XFILLER_244_980 VPWR VGND VPWR VGND sky130_ef_sc_hd__decap_12
XFILLER_206_1207 VPWR VGND VPWR VGND sky130_ef_sc_hd__decap_12
XFILLER_230_151 VPWR VGND VPWR VGND sky130_ef_sc_hd__decap_12
XFILLER_54_1251 VPWR VGND VPWR VGND sky130_ef_sc_hd__decap_12
XFILLER_19_1371 VGND VGND VPWR VPWR sky130_fd_sc_hd__decap_6
XTAP_TAPCELL_ROW_178_1970 VGND VPWR sky130_fd_sc_hd__tapvpwrvgnd_1
XFILLER_145_1390 VPWR VGND VPWR VGND sky130_ef_sc_hd__decap_12
XFILLER_175_228 VPWR VGND VPWR VGND sky130_ef_sc_hd__decap_12
XTAP_TAPCELL_ROW_178_1981 VGND VPWR sky130_fd_sc_hd__tapvpwrvgnd_1
XPHY_EDGE_ROW_96_1_Right_752 VGND VGND VPWR VPWR sky130_fd_sc_hd__decap_3
XTAP_TAPCELL_ROW_178_1992 VGND VPWR sky130_fd_sc_hd__tapvpwrvgnd_1
XFILLER_180_1281 VPWR VGND VPWR VGND sky130_ef_sc_hd__decap_12
XFILLER_168_280 VPWR VGND VPWR VGND sky130_ef_sc_hd__decap_12
XTAP_TAPCELL_ROW_174_1834 VGND VPWR sky130_fd_sc_hd__tapvpwrvgnd_1
XTAP_TAPCELL_ROW_174_1845 VGND VPWR sky130_fd_sc_hd__tapvpwrvgnd_1
XTAP_TAPCELL_ROW_215_3266 VGND VPWR sky130_fd_sc_hd__tapvpwrvgnd_1
XTAP_TAPCELL_ROW_174_1856 VGND VPWR sky130_fd_sc_hd__tapvpwrvgnd_1
XFILLER_209_15 VPWR VGND VPWR VGND sky130_ef_sc_hd__decap_12
XTAP_TAPCELL_ROW_215_3277 VGND VPWR sky130_fd_sc_hd__tapvpwrvgnd_1
XFILLER_102_1227 VPWR VGND VPWR VGND sky130_ef_sc_hd__decap_12
XTAP_TAPCELL_ROW_215_3288 VGND VPWR sky130_fd_sc_hd__tapvpwrvgnd_1
Xwire350 net351 VGND VGND VPWR VPWR net350 sky130_fd_sc_hd__clkbuf_1
Xwire361 net362 VGND VGND VPWR VPWR net361 sky130_fd_sc_hd__clkbuf_1
XFILLER_89_1347 VPWR VGND VPWR VGND sky130_ef_sc_hd__decap_12
XTAP_TAPCELL_ROW_170_1709 VGND VPWR sky130_fd_sc_hd__tapvpwrvgnd_1
Xmax_cap105 net106 VGND VGND VPWR VPWR net105 sky130_fd_sc_hd__clkbuf_1
Xwire372 net373 VGND VGND VPWR VPWR net372 sky130_fd_sc_hd__clkbuf_1
Xwire383 net384 VGND VGND VPWR VPWR net383 sky130_fd_sc_hd__clkbuf_1
XFILLER_171_412 VPWR VGND VPWR VGND sky130_ef_sc_hd__decap_12
Xmax_cap116 _199_ VGND VGND VPWR VPWR net116 sky130_fd_sc_hd__clkbuf_1
XFILLER_183_283 VPWR VGND VPWR VGND sky130_ef_sc_hd__decap_12
Xwire394 net395 VGND VGND VPWR VPWR net394 sky130_fd_sc_hd__clkbuf_1
Xmax_cap138 net139 VGND VGND VPWR VPWR net138 sky130_fd_sc_hd__clkbuf_1
XFILLER_172_968 VPWR VGND VPWR VGND sky130_ef_sc_hd__decap_12
Xmax_cap149 _185_ VGND VGND VPWR VPWR net149 sky130_fd_sc_hd__clkbuf_1
XFILLER_171_467 VGND VGND VPWR VPWR sky130_fd_sc_hd__decap_6
XFILLER_217_1303 VPWR VGND VPWR VGND sky130_ef_sc_hd__decap_12
XFILLER_252_1238 VPWR VGND VPWR VGND sky130_ef_sc_hd__decap_12
XFILLER_217_1358 VPWR VGND VPWR VGND sky130_ef_sc_hd__decap_12
XFILLER_31_3 VPWR VGND VPWR VGND sky130_ef_sc_hd__decap_12
XTAP_TAPCELL_ROW_168_1627 VGND VPWR sky130_fd_sc_hd__tapvpwrvgnd_1
XTAP_TAPCELL_ROW_168_1638 VGND VPWR sky130_fd_sc_hd__tapvpwrvgnd_1
XTAP_TAPCELL_ROW_209_3059 VGND VPWR sky130_fd_sc_hd__tapvpwrvgnd_1
XTAP_TAPCELL_ROW_168_1649 VGND VPWR sky130_fd_sc_hd__tapvpwrvgnd_1
XTAP_TAPCELL_ROW_162_2_5961 VGND VPWR sky130_fd_sc_hd__tapvpwrvgnd_1
XFILLER_230_1514 VGND VGND VPWR VPWR sky130_fd_sc_hd__fill_1
XFILLER_226_402 VGND VGND VPWR VPWR sky130_fd_sc_hd__decap_6
XFILLER_254_722 VPWR VGND VPWR VGND sky130_ef_sc_hd__decap_12
XFILLER_22_1239 VPWR VGND VPWR VGND sky130_ef_sc_hd__decap_12
XFILLER_238_273 VGND VGND VPWR VPWR sky130_fd_sc_hd__decap_6
XFILLER_187_1413 VGND VGND VPWR VPWR sky130_fd_sc_hd__decap_6
XFILLER_227_947 VPWR VGND VPWR VGND sky130_ef_sc_hd__decap_12
XFILLER_113_1378 VPWR VGND VPWR VGND sky130_ef_sc_hd__decap_12
XFILLER_242_906 VPWR VGND VPWR VGND sky130_ef_sc_hd__decap_12
XFILLER_241_68 VPWR VGND VPWR VGND sky130_ef_sc_hd__decap_12
XFILLER_254_777 VPWR VGND VPWR VGND sky130_ef_sc_hd__decap_12
XFILLER_228_1410 VPWR VGND VPWR VGND sky130_ef_sc_hd__decap_12
XFILLER_207_682 VGND VGND VPWR VPWR sky130_fd_sc_hd__decap_6
XFILLER_228_1465 VPWR VGND VPWR VGND sky130_ef_sc_hd__decap_12
XFILLER_250_961 VGND VGND VPWR VPWR sky130_fd_sc_hd__decap_6
XTAP_TAPCELL_ROW_123_2_5645 VGND VPWR sky130_fd_sc_hd__tapvpwrvgnd_1
XFILLER_146_1165 VPWR VGND VPWR VGND sky130_ef_sc_hd__decap_12
XFILLER_181_1045 VPWR VGND VPWR VGND sky130_ef_sc_hd__decap_12
XPHY_EDGE_ROW_172_Left_427 VGND VGND VPWR VPWR sky130_fd_sc_hd__decap_3
XFILLER_221_173 VPWR VGND VPWR VGND sky130_ef_sc_hd__decap_12
XTAP_TAPCELL_ROW_59_2_5131 VGND VPWR sky130_fd_sc_hd__tapvpwrvgnd_1
XFILLER_166_206 VPWR VGND VPWR VGND sky130_ef_sc_hd__decap_12
XPHY_EDGE_ROW_32_2_Right_123 VGND VGND VPWR VPWR sky130_fd_sc_hd__decap_3
XFILLER_33_1335 VPWR VGND VPWR VGND sky130_ef_sc_hd__decap_12
XFILLER_119_15 VPWR VGND VPWR VGND sky130_ef_sc_hd__decap_12
XFILLER_124_1485 VPWR VGND VPWR VGND sky130_ef_sc_hd__decap_12
XFILLER_181_209 VGND VGND VPWR VPWR sky130_fd_sc_hd__decap_6
XFILLER_222_1097 VPWR VGND VPWR VGND sky130_ef_sc_hd__decap_12
XFILLER_174_261 VPWR VGND VPWR VGND sky130_ef_sc_hd__decap_12
XFILLER_190_710 VPWR VGND VPWR VGND sky130_ef_sc_hd__decap_12
XFILLER_120_1349 VGND VGND VPWR VPWR sky130_fd_sc_hd__decap_6
XTAP_TAPCELL_ROW_190_2392 VGND VPWR sky130_fd_sc_hd__tapvpwrvgnd_1
XTAP_TAPCELL_ROW_26_2_4872 VGND VPWR sky130_fd_sc_hd__tapvpwrvgnd_1
XFILLER_190_765 VPWR VGND VPWR VGND sky130_ef_sc_hd__decap_12
XTAP_TAPCELL_ROW_60_1_1320 VGND VPWR sky130_fd_sc_hd__tapvpwrvgnd_1
XFILLER_157_1261 VPWR VGND VPWR VGND sky130_ef_sc_hd__decap_12
XFILLER_171_990 VPWR VGND VPWR VGND sky130_ef_sc_hd__decap_12
XFILLER_192_1152 VPWR VGND VPWR VGND sky130_ef_sc_hd__decap_12
XPHY_EDGE_ROW_181_Left_436 VGND VGND VPWR VPWR sky130_fd_sc_hd__decap_3
XFILLER_66_1177 VGND VGND VPWR VPWR sky130_fd_sc_hd__decap_6
XFILLER_0_127 VPWR VGND VPWR VGND sky130_ef_sc_hd__decap_12
XFILLER_44_1442 VPWR VGND VPWR VGND sky130_ef_sc_hd__decap_12
XFILLER_40_1306 VGND VGND VPWR VPWR sky130_fd_sc_hd__decap_6
XTAP_TAPCELL_ROW_18_2_4809 VGND VPWR sky130_fd_sc_hd__tapvpwrvgnd_1
XFILLER_215_80 VGND VGND VPWR VPWR sky130_fd_sc_hd__decap_6
XFILLER_229_240 VPWR VGND VPWR VGND sky130_ef_sc_hd__decap_12
XFILLER_28_34 VGND VGND VPWR VPWR sky130_fd_sc_hd__decap_8
XFILLER_9_1093 VPWR VGND VPWR VGND sky130_ef_sc_hd__decap_12
XTAP_TAPCELL_ROW_184_2185 VGND VPWR sky130_fd_sc_hd__tapvpwrvgnd_1
XTAP_TAPCELL_ROW_184_2196 VGND VPWR sky130_fd_sc_hd__tapvpwrvgnd_1
XFILLER_218_925 VPWR VGND VPWR VGND sky130_ef_sc_hd__decap_12
XFILLER_44_1497 VPWR VGND VPWR VGND sky130_ef_sc_hd__decap_12
XFILLER_131_1445 VPWR VGND VPWR VGND sky130_ef_sc_hd__decap_12
XTAP_TAPCELL_ROW_180_2049 VGND VPWR sky130_fd_sc_hd__tapvpwrvgnd_1
XFILLER_217_424 VGND VGND VPWR VPWR sky130_fd_sc_hd__decap_6
XFILLER_245_744 VPWR VGND VPWR VGND sky130_ef_sc_hd__decap_12
XFILLER_229_295 VGND VGND VPWR VPWR sky130_fd_sc_hd__decap_6
XFILLER_151_68 VGND VGND VPWR VPWR sky130_fd_sc_hd__decap_3
XFILLER_166_1508 VGND VGND VPWR VPWR sky130_fd_sc_hd__decap_6
XFILLER_229_1229 VPWR VGND VPWR VGND sky130_ef_sc_hd__decap_12
XFILLER_233_928 VPWR VGND VPWR VGND sky130_ef_sc_hd__decap_12
XFILLER_245_799 VPWR VGND VPWR VGND sky130_ef_sc_hd__decap_12
XFILLER_226_980 VPWR VGND VPWR VGND sky130_ef_sc_hd__decap_12
X_490_ net174 net495 net102 VGND VGND VPWR VPWR _251_ sky130_fd_sc_hd__and3_1
XFILLER_44_22 VPWR VGND VPWR VGND sky130_ef_sc_hd__decap_12
XFILLER_77_1273 VPWR VGND VPWR VGND sky130_ef_sc_hd__decap_12
XFILLER_198_832 VGND VGND VPWR VPWR sky130_fd_sc_hd__decap_6
XPHY_EDGE_ROW_190_Left_445 VGND VGND VPWR VPWR sky130_fd_sc_hd__decap_3
XFILLER_241_983 VGND VGND VPWR VPWR sky130_fd_sc_hd__decap_6
XFILLER_212_151 VPWR VGND VPWR VGND sky130_ef_sc_hd__decap_12
XFILLER_9_706 VGND VGND VPWR VPWR sky130_fd_sc_hd__decap_8
XFILLER_51_1402 VPWR VGND VPWR VGND sky130_ef_sc_hd__decap_12
XFILLER_125_1249 VPWR VGND VPWR VGND sky130_ef_sc_hd__decap_12
XFILLER_233_3 VPWR VGND VPWR VGND sky130_ef_sc_hd__decap_12
XFILLER_200_335 VPWR VGND VPWR VGND sky130_ef_sc_hd__decap_12
XFILLER_240_1164 VPWR VGND VPWR VGND sky130_ef_sc_hd__decap_12
XFILLER_205_1284 VGND VGND VPWR VPWR sky130_fd_sc_hd__decap_6
XFILLER_51_1457 VGND VGND VPWR VPWR sky130_fd_sc_hd__decap_6
XFILLER_60_65 VGND VGND VPWR VPWR sky130_fd_sc_hd__decap_6
XFILLER_86_1509 VGND VGND VPWR VPWR sky130_fd_sc_hd__decap_6
XFILLER_176_65 VPWR VGND VPWR VGND sky130_ef_sc_hd__decap_12
XFILLER_181_732 VPWR VGND VPWR VGND sky130_ef_sc_hd__decap_12
XFILLER_88_1380 VPWR VGND VPWR VGND sky130_ef_sc_hd__decap_12
XFILLER_10_1165 VPWR VGND VPWR VGND sky130_ef_sc_hd__decap_12
XFILLER_181_787 VPWR VGND VPWR VGND sky130_ef_sc_hd__decap_12
XFILLER_253_1514 VGND VGND VPWR VPWR sky130_fd_sc_hd__fill_1
XFILLER_45_1206 VPWR VGND VPWR VGND sky130_ef_sc_hd__decap_12
XTAP_TAPCELL_ROW_147_2_5841 VGND VPWR sky130_fd_sc_hd__tapvpwrvgnd_1
XFILLER_136_1356 VPWR VGND VPWR VGND sky130_ef_sc_hd__decap_12
XFILLER_0_650 VGND VGND VPWR VPWR sky130_fd_sc_hd__fill_1
XFILLER_251_1260 VPWR VGND VPWR VGND sky130_ef_sc_hd__decap_12
XPHY_EDGE_ROW_31_2_Left_533 VGND VGND VPWR VPWR sky130_fd_sc_hd__decap_3
XFILLER_216_1391 VGND VGND VPWR VPWR sky130_fd_sc_hd__decap_6
XTAP_TAPCELL_ROW_227_3693 VGND VPWR sky130_fd_sc_hd__tapvpwrvgnd_1
XFILLER_208_402 VGND VGND VPWR VPWR sky130_fd_sc_hd__decap_6
XTAP_TAPCELL_ROW_223_3546 VGND VPWR sky130_fd_sc_hd__tapvpwrvgnd_1
XFILLER_236_722 VPWR VGND VPWR VGND sky130_ef_sc_hd__decap_12
XFILLER_209_947 VPWR VGND VPWR VGND sky130_ef_sc_hd__decap_12
XTAP_TAPCELL_ROW_223_3557 VGND VPWR sky130_fd_sc_hd__tapvpwrvgnd_1
XFILLER_248_593 VPWR VGND VPWR VGND sky130_ef_sc_hd__decap_12
XTAP_TAPCELL_ROW_223_3568 VGND VPWR sky130_fd_sc_hd__tapvpwrvgnd_1
XTAP_TAPCELL_ROW_96_2_5427 VGND VPWR sky130_fd_sc_hd__tapvpwrvgnd_1
XFILLER_224_906 VPWR VGND VPWR VGND sky130_ef_sc_hd__decap_12
XFILLER_169_1143 VPWR VGND VPWR VGND sky130_ef_sc_hd__decap_12
XFILLER_236_777 VPWR VGND VPWR VGND sky130_ef_sc_hd__decap_12
XTAP_TAPCELL_ROW_65_2_5185 VGND VPWR sky130_fd_sc_hd__tapvpwrvgnd_1
XFILLER_21_1261 VPWR VGND VPWR VGND sky130_ef_sc_hd__decap_12
XFILLER_251_725 VGND VGND VPWR VPWR sky130_fd_sc_hd__decap_6
XFILLER_211_27 VPWR VGND VPWR VGND sky130_ef_sc_hd__decap_12
XTAP_TAPCELL_ROW_108_2_5525 VGND VPWR sky130_fd_sc_hd__tapvpwrvgnd_1
XFILLER_169_1198 VGND VGND VPWR VPWR sky130_fd_sc_hd__decap_6
XFILLER_56_1313 VPWR VGND VPWR VGND sky130_ef_sc_hd__decap_12
XFILLER_1_1377 VPWR VGND VPWR VGND sky130_ef_sc_hd__decap_12
XFILLER_189_854 VGND VGND VPWR VPWR sky130_fd_sc_hd__decap_6
XFILLER_206_1004 VGND VGND VPWR VPWR sky130_fd_sc_hd__decap_6
XFILLER_232_961 VGND VGND VPWR VPWR sky130_fd_sc_hd__decap_6
XFILLER_56_1368 VPWR VGND VPWR VGND sky130_ef_sc_hd__decap_12
XFILLER_143_1316 VPWR VGND VPWR VGND sky130_ef_sc_hd__decap_12
XTAP_TAPCELL_ROW_176_1907 VGND VPWR sky130_fd_sc_hd__tapvpwrvgnd_1
XTAP_TAPCELL_ROW_176_1918 VGND VPWR sky130_fd_sc_hd__tapvpwrvgnd_1
XTAP_TAPCELL_ROW_217_3339 VGND VPWR sky130_fd_sc_hd__tapvpwrvgnd_1
XFILLER_203_173 VPWR VGND VPWR VGND sky130_ef_sc_hd__decap_12
XTAP_TAPCELL_ROW_176_1929 VGND VPWR sky130_fd_sc_hd__tapvpwrvgnd_1
XFILLER_182_1398 VPWR VGND VPWR VGND sky130_ef_sc_hd__decap_12
XPHY_EDGE_ROW_108_1_Left_363 VGND VGND VPWR VPWR sky130_fd_sc_hd__decap_3
XFILLER_79_3 VPWR VGND VPWR VGND sky130_ef_sc_hd__decap_12
XPHY_EDGE_ROW_97_1_Right_753 VGND VGND VPWR VPWR sky130_fd_sc_hd__decap_3
XFILLER_191_529 VPWR VGND VPWR VGND sky130_ef_sc_hd__decap_12
XFILLER_172_710 VPWR VGND VPWR VGND sky130_ef_sc_hd__decap_12
XFILLER_184_581 VPWR VGND VPWR VGND sky130_ef_sc_hd__decap_12
XPHY_EDGE_ROW_45_1_Left_300 VGND VGND VPWR VPWR sky130_fd_sc_hd__decap_3
XFILLER_89_1177 VPWR VGND VPWR VGND sky130_ef_sc_hd__decap_12
XFILLER_172_765 VPWR VGND VPWR VGND sky130_ef_sc_hd__decap_12
XFILLER_236_46 VPWR VGND VPWR VGND sky130_ef_sc_hd__decap_12
XFILLER_217_1100 VPWR VGND VPWR VGND sky130_ef_sc_hd__decap_12
XFILLER_67_1464 VPWR VGND VPWR VGND sky130_ef_sc_hd__decap_12
XFILLER_154_1423 VPWR VGND VPWR VGND sky130_ef_sc_hd__decap_12
XFILLER_252_1035 VPWR VGND VPWR VGND sky130_ef_sc_hd__decap_12
XFILLER_63_1328 VGND VGND VPWR VPWR sky130_fd_sc_hd__decap_6
XFILLER_217_1155 VGND VGND VPWR VPWR sky130_fd_sc_hd__decap_6
XFILLER_154_1478 VGND VGND VPWR VPWR sky130_fd_sc_hd__decap_6
XFILLER_252_34 VPWR VGND VPWR VGND sky130_ef_sc_hd__decap_12
XFILLER_105_39 VGND VGND VPWR VPWR sky130_fd_sc_hd__decap_4
XFILLER_246_519 VPWR VGND VPWR VGND sky130_ef_sc_hd__decap_12
XFILLER_239_560 VPWR VGND VPWR VGND sky130_ef_sc_hd__decap_12
XPHY_EDGE_ROW_88_2_Left_590 VGND VGND VPWR VPWR sky130_fd_sc_hd__decap_3
XFILLER_230_1355 VPWR VGND VPWR VGND sky130_ef_sc_hd__decap_12
XFILLER_252_89 VPWR VGND VPWR VGND sky130_ef_sc_hd__decap_12
XTAP_TAPCELL_ROW_2_937 VGND VPWR sky130_fd_sc_hd__tapvpwrvgnd_1
XFILLER_227_744 VPWR VGND VPWR VGND sky130_ef_sc_hd__decap_12
XTAP_TAPCELL_ROW_2_948 VGND VPWR sky130_fd_sc_hd__tapvpwrvgnd_1
XTAP_TAPCELL_ROW_2_959 VGND VPWR sky130_fd_sc_hd__tapvpwrvgnd_1
XFILLER_242_703 VGND VGND VPWR VPWR sky130_fd_sc_hd__decap_6
XFILLER_254_574 VGND VGND VPWR VPWR sky130_fd_sc_hd__decap_6
XFILLER_215_928 VPWR VGND VPWR VGND sky130_ef_sc_hd__decap_12
XFILLER_227_799 VPWR VGND VPWR VGND sky130_ef_sc_hd__decap_12
XFILLER_39_1500 VGND VGND VPWR VPWR sky130_fd_sc_hd__decap_6
XFILLER_121_27 VPWR VGND VPWR VGND sky130_ef_sc_hd__decap_12
XFILLER_148_1227 VPWR VGND VPWR VGND sky130_ef_sc_hd__decap_12
XFILLER_208_980 VPWR VGND VPWR VGND sky130_ef_sc_hd__decap_12
XFILLER_74_1435 VGND VGND VPWR VPWR sky130_fd_sc_hd__decap_6
XFILLER_228_1262 VGND VGND VPWR VPWR sky130_fd_sc_hd__decap_6
XFILLER_223_983 VGND VGND VPWR VPWR sky130_fd_sc_hd__decap_6
XFILLER_194_323 VPWR VGND VPWR VGND sky130_ef_sc_hd__decap_12
XTAP_TAPCELL_ROW_192_2465 VGND VPWR sky130_fd_sc_hd__tapvpwrvgnd_1
XPHY_EDGE_ROW_33_2_Right_124 VGND VGND VPWR VPWR sky130_fd_sc_hd__decap_3
XTAP_TAPCELL_ROW_192_2476 VGND VPWR sky130_fd_sc_hd__tapvpwrvgnd_1
XFILLER_182_507 VPWR VGND VPWR VGND sky130_ef_sc_hd__decap_12
XTAP_TAPCELL_ROW_192_2487 VGND VPWR sky130_fd_sc_hd__tapvpwrvgnd_1
XFILLER_194_378 VPWR VGND VPWR VGND sky130_ef_sc_hd__decap_12
XFILLER_33_1165 VPWR VGND VPWR VGND sky130_ef_sc_hd__decap_12
XFILLER_124_1282 VPWR VGND VPWR VGND sky130_ef_sc_hd__decap_12
XTAP_TAPCELL_ROW_153_2_5884 VGND VPWR sky130_fd_sc_hd__tapvpwrvgnd_1
XFILLER_30_46 VGND VGND VPWR VPWR sky130_fd_sc_hd__decap_8
XTAP_TAPCELL_ROW_89_2_5370 VGND VPWR sky130_fd_sc_hd__tapvpwrvgnd_1
XFILLER_68_1239 VPWR VGND VPWR VGND sky130_ef_sc_hd__decap_12
XFILLER_146_46 VPWR VGND VPWR VGND sky130_ef_sc_hd__decap_12
XFILLER_190_562 VPWR VGND VPWR VGND sky130_ef_sc_hd__decap_12
XFILLER_159_1378 VPWR VGND VPWR VGND sky130_ef_sc_hd__decap_12
XFILLER_194_1269 VPWR VGND VPWR VGND sky130_ef_sc_hd__decap_12
XFILLER_2_937 VPWR VGND VPWR VGND sky130_ef_sc_hd__decap_12
XFILLER_249_302 VPWR VGND VPWR VGND sky130_ef_sc_hd__decap_12
XTAP_TAPCELL_ROW_186_2258 VGND VPWR sky130_fd_sc_hd__tapvpwrvgnd_1
XFILLER_133_1507 VGND VGND VPWR VPWR sky130_fd_sc_hd__decap_8
XTAP_TAPCELL_ROW_186_2269 VGND VPWR sky130_fd_sc_hd__tapvpwrvgnd_1
XFILLER_39_44 VGND VGND VPWR VPWR sky130_fd_sc_hd__decap_4
XFILLER_231_1119 VPWR VGND VPWR VGND sky130_ef_sc_hd__decap_12
XFILLER_249_357 VPWR VGND VPWR VGND sky130_ef_sc_hd__decap_12
XFILLER_162_34 VPWR VGND VPWR VGND sky130_ef_sc_hd__decap_12
XFILLER_218_722 VPWR VGND VPWR VGND sky130_ef_sc_hd__decap_12
XTAP_TAPCELL_ROW_51_2_5071 VGND VPWR sky130_fd_sc_hd__tapvpwrvgnd_1
XFILLER_44_1294 VPWR VGND VPWR VGND sky130_ef_sc_hd__decap_12
XFILLER_131_1242 VGND VGND VPWR VPWR sky130_fd_sc_hd__decap_6
XFILLER_183_3 VPWR VGND VPWR VGND sky130_ef_sc_hd__decap_12
X_611_ clknet_3_6__leaf_clk dout0\[9\] _019_ VGND VGND VPWR VPWR dout0_q\[9\] sky130_fd_sc_hd__dfrtp_1
XFILLER_245_541 VPWR VGND VPWR VGND sky130_ef_sc_hd__decap_12
XFILLER_79_1335 VPWR VGND VPWR VGND sky130_ef_sc_hd__decap_12
XFILLER_206_906 VPWR VGND VPWR VGND sky130_ef_sc_hd__decap_12
XFILLER_218_777 VPWR VGND VPWR VGND sky130_ef_sc_hd__decap_12
XFILLER_166_1305 VGND VGND VPWR VPWR sky130_fd_sc_hd__decap_6
X_542_ net668 VGND VGND VPWR VPWR _024_ sky130_fd_sc_hd__inv_2
XFILLER_229_1026 VGND VGND VPWR VPWR sky130_fd_sc_hd__decap_6
XFILLER_233_725 VGND VGND VPWR VPWR sky130_fd_sc_hd__decap_6
XFILLER_245_596 VGND VGND VPWR VPWR sky130_fd_sc_hd__decap_6
XTAP_TAPCELL_ROW_17_2_4795 VGND VPWR sky130_fd_sc_hd__tapvpwrvgnd_1
X_473_ net161 _243_ VGND VGND VPWR VPWR acc_core.adder.cla_blocks\[2\].block.sum\[3\]
+ sky130_fd_sc_hd__xor2_1
XFILLER_214_961 VGND VGND VPWR VPWR sky130_fd_sc_hd__decap_6
XFILLER_242_1226 VPWR VGND VPWR VGND sky130_ef_sc_hd__decap_12
XTAP_TAPCELL_ROW_43_2_5008 VGND VPWR sky130_fd_sc_hd__tapvpwrvgnd_1
XFILLER_207_1346 VPWR VGND VPWR VGND sky130_ef_sc_hd__decap_12
XFILLER_200_132 VPWR VGND VPWR VGND sky130_ef_sc_hd__decap_12
XFILLER_55_1390 VPWR VGND VPWR VGND sky130_ef_sc_hd__decap_12
XFILLER_9_547 VGND VGND VPWR VPWR sky130_fd_sc_hd__fill_2
XFILLER_90_1270 VPWR VGND VPWR VGND sky130_ef_sc_hd__decap_12
XFILLER_185_345 VPWR VGND VPWR VGND sky130_ef_sc_hd__decap_12
XTAP_TAPCELL_ROW_235_3973 VGND VPWR sky130_fd_sc_hd__tapvpwrvgnd_1
XTAP_TAPCELL_ROW_235_3984 VGND VPWR sky130_fd_sc_hd__tapvpwrvgnd_1
XTAP_TAPCELL_ROW_231_3826 VGND VPWR sky130_fd_sc_hd__tapvpwrvgnd_1
XTAP_TAPCELL_ROW_235_3995 VGND VPWR sky130_fd_sc_hd__tapvpwrvgnd_1
XTAP_TAPCELL_ROW_231_3837 VGND VPWR sky130_fd_sc_hd__tapvpwrvgnd_1
XFILLER_173_529 VPWR VGND VPWR VGND sky130_ef_sc_hd__decap_12
XFILLER_200_187 VGND VGND VPWR VPWR sky130_fd_sc_hd__decap_6
XTAP_TAPCELL_ROW_231_3848 VGND VPWR sky130_fd_sc_hd__tapvpwrvgnd_1
XFILLER_12_1227 VPWR VGND VPWR VGND sky130_ef_sc_hd__decap_12
XTAP_TAPCELL_ROW_10_2_4738 VGND VPWR sky130_fd_sc_hd__tapvpwrvgnd_1
XFILLER_177_1401 VPWR VGND VPWR VGND sky130_ef_sc_hd__decap_12
XFILLER_166_581 VPWR VGND VPWR VGND sky130_ef_sc_hd__decap_12
XFILLER_86_1306 VGND VGND VPWR VPWR sky130_fd_sc_hd__decap_6
XFILLER_5_742 VGND VGND VPWR VPWR sky130_fd_sc_hd__decap_4
XFILLER_177_1456 VGND VGND VPWR VPWR sky130_fd_sc_hd__decap_6
XFILLER_5_775 VGND VGND VPWR VPWR sky130_fd_sc_hd__fill_1
XFILLER_181_584 VPWR VGND VPWR VGND sky130_ef_sc_hd__decap_12
XFILLER_218_1453 VPWR VGND VPWR VGND sky130_ef_sc_hd__decap_12
XTAP_TAPCELL_ROW_229_3755 VGND VPWR sky130_fd_sc_hd__tapvpwrvgnd_1
XTAP_TAPCELL_ROW_229_3766 VGND VPWR sky130_fd_sc_hd__tapvpwrvgnd_1
XTAP_TAPCELL_ROW_229_3777 VGND VPWR sky130_fd_sc_hd__tapvpwrvgnd_1
XFILLER_171_1033 VPWR VGND VPWR VGND sky130_ef_sc_hd__decap_12
XTAP_TAPCELL_ROW_225_3619 VGND VPWR sky130_fd_sc_hd__tapvpwrvgnd_1
XTAP_TAPCELL_ROW_229_3788 VGND VPWR sky130_fd_sc_hd__tapvpwrvgnd_1
XFILLER_253_1377 VPWR VGND VPWR VGND sky130_ef_sc_hd__decap_12
XFILLER_228_519 VPWR VGND VPWR VGND sky130_ef_sc_hd__decap_12
XFILLER_255_316 VPWR VGND VPWR VGND sky130_ef_sc_hd__decap_12
XFILLER_171_1088 VPWR VGND VPWR VGND sky130_ef_sc_hd__decap_12
XFILLER_222_15 VGND VGND VPWR VPWR sky130_fd_sc_hd__decap_6
XFILLER_255_349 VGND VGND VPWR VPWR sky130_fd_sc_hd__decap_8
XFILLER_248_390 VPWR VGND VPWR VGND sky130_ef_sc_hd__decap_12
XFILLER_97_1402 VPWR VGND VPWR VGND sky130_ef_sc_hd__decap_12
XFILLER_209_744 VPWR VGND VPWR VGND sky130_ef_sc_hd__decap_12
XFILLER_23_1378 VPWR VGND VPWR VGND sky130_ef_sc_hd__decap_12
XFILLER_110_1337 VPWR VGND VPWR VGND sky130_ef_sc_hd__decap_12
XFILLER_224_703 VGND VGND VPWR VPWR sky130_fd_sc_hd__decap_6
XFILLER_236_574 VGND VGND VPWR VPWR sky130_fd_sc_hd__decap_6
XFILLER_97_1457 VGND VGND VPWR VPWR sky130_fd_sc_hd__decap_6
XFILLER_209_799 VPWR VGND VPWR VGND sky130_ef_sc_hd__decap_12
XFILLER_1_1174 VPWR VGND VPWR VGND sky130_ef_sc_hd__decap_12
XFILLER_225_1413 VGND VGND VPWR VPWR sky130_fd_sc_hd__decap_6
XFILLER_182_1140 VPWR VGND VPWR VGND sky130_ef_sc_hd__decap_12
XFILLER_205_983 VGND VGND VPWR VPWR sky130_fd_sc_hd__decap_6
XFILLER_56_1165 VPWR VGND VPWR VGND sky130_ef_sc_hd__decap_12
XFILLER_176_323 VPWR VGND VPWR VGND sky130_ef_sc_hd__decap_12
XFILLER_182_1195 VPWR VGND VPWR VGND sky130_ef_sc_hd__decap_12
XTAP_TAPCELL_ROW_138_2_5764 VGND VPWR sky130_fd_sc_hd__tapvpwrvgnd_1
XPHY_EDGE_ROW_160_2_Right_251 VGND VGND VPWR VPWR sky130_fd_sc_hd__decap_3
XFILLER_188_194 VPWR VGND VPWR VGND sky130_ef_sc_hd__decap_12
XFILLER_176_378 VPWR VGND VPWR VGND sky130_ef_sc_hd__decap_12
XFILLER_34_1485 VPWR VGND VPWR VGND sky130_ef_sc_hd__decap_12
XFILLER_121_1433 VPWR VGND VPWR VGND sky130_ef_sc_hd__decap_12
XFILLER_191_326 VPWR VGND VPWR VGND sky130_ef_sc_hd__decap_12
XFILLER_247_56 VPWR VGND VPWR VGND sky130_ef_sc_hd__decap_12
XFILLER_30_1349 VGND VGND VPWR VPWR sky130_fd_sc_hd__decap_6
XPHY_EDGE_ROW_98_1_Right_754 VGND VGND VPWR VPWR sky130_fd_sc_hd__decap_3
XFILLER_121_1488 VPWR VGND VPWR VGND sky130_ef_sc_hd__decap_12
XFILLER_172_562 VPWR VGND VPWR VGND sky130_ef_sc_hd__decap_12
XFILLER_219_1217 VPWR VGND VPWR VGND sky130_ef_sc_hd__decap_12
XTAP_TAPCELL_ROW_131_2_5707 VGND VPWR sky130_fd_sc_hd__tapvpwrvgnd_1
XFILLER_67_1261 VPWR VGND VPWR VGND sky130_ef_sc_hd__decap_12
XTAP_TAPCELL_ROW_100_2_5465 VGND VPWR sky130_fd_sc_hd__tapvpwrvgnd_1
XFILLER_154_1220 VGND VGND VPWR VPWR sky130_fd_sc_hd__decap_6
XFILLER_193_1291 VPWR VGND VPWR VGND sky130_ef_sc_hd__decap_12
XTAP_TAPCELL_ROW_181_2100 VGND VPWR sky130_fd_sc_hd__tapvpwrvgnd_1
XFILLER_246_316 VGND VGND VPWR VPWR sky130_fd_sc_hd__decap_6
XTAP_TAPCELL_ROW_241_4177 VGND VPWR sky130_fd_sc_hd__tapvpwrvgnd_1
XFILLER_189_1327 VGND VGND VPWR VPWR sky130_fd_sc_hd__decap_6
XTAP_TAPCELL_ROW_241_4188 VGND VPWR sky130_fd_sc_hd__tapvpwrvgnd_1
XTAP_TAPCELL_ROW_241_4199 VGND VPWR sky130_fd_sc_hd__tapvpwrvgnd_1
XFILLER_41_1445 VPWR VGND VPWR VGND sky130_ef_sc_hd__decap_12
XFILLER_132_15 VGND VGND VPWR VPWR sky130_fd_sc_hd__decap_6
XFILLER_230_1152 VPWR VGND VPWR VGND sky130_ef_sc_hd__decap_12
XTAP_TAPCELL_ROW_34_2_4934 VGND VPWR sky130_fd_sc_hd__tapvpwrvgnd_1
XFILLER_227_541 VPWR VGND VPWR VGND sky130_ef_sc_hd__decap_12
XFILLER_255_883 VPWR VGND VPWR VGND sky130_ef_sc_hd__decap_12
XFILLER_215_725 VGND VGND VPWR VPWR sky130_fd_sc_hd__decap_6
XFILLER_227_596 VGND VGND VPWR VPWR sky130_fd_sc_hd__decap_6
XTAP_TAPCELL_ROW_198_2674 VGND VPWR sky130_fd_sc_hd__tapvpwrvgnd_1
XTAP_TAPCELL_ROW_198_2685 VGND VPWR sky130_fd_sc_hd__tapvpwrvgnd_1
XTAP_TAPCELL_ROW_198_2696 VGND VPWR sky130_fd_sc_hd__tapvpwrvgnd_1
XTAP_TAPCELL_ROW_194_2538 VGND VPWR sky130_fd_sc_hd__tapvpwrvgnd_1
XTAP_TAPCELL_ROW_194_2549 VGND VPWR sky130_fd_sc_hd__tapvpwrvgnd_1
XFILLER_204_1508 VGND VGND VPWR VPWR sky130_fd_sc_hd__decap_6
XFILLER_35_1249 VPWR VGND VPWR VGND sky130_ef_sc_hd__decap_12
XFILLER_122_1208 VPWR VGND VPWR VGND sky130_ef_sc_hd__decap_12
XFILLER_194_120 VPWR VGND VPWR VGND sky130_ef_sc_hd__decap_12
XFILLER_210_452 VPWR VGND VPWR VGND sky130_ef_sc_hd__decap_12
XFILLER_167_345 VPWR VGND VPWR VGND sky130_ef_sc_hd__decap_12
XFILLER_126_1399 VPWR VGND VPWR VGND sky130_ef_sc_hd__decap_12
XFILLER_182_304 VPWR VGND VPWR VGND sky130_ef_sc_hd__decap_12
XFILLER_41_56 VPWR VGND VPWR VGND sky130_ef_sc_hd__decap_12
XFILLER_194_175 VPWR VGND VPWR VGND sky130_ef_sc_hd__decap_12
XPHY_EDGE_ROW_34_2_Right_125 VGND VGND VPWR VPWR sky130_fd_sc_hd__decap_3
XFILLER_157_56 VPWR VGND VPWR VGND sky130_ef_sc_hd__decap_12
XFILLER_182_359 VGND VGND VPWR VPWR sky130_fd_sc_hd__decap_6
XFILLER_194_1011 VPWR VGND VPWR VGND sky130_ef_sc_hd__decap_12
XFILLER_194_1066 VPWR VGND VPWR VGND sky130_ef_sc_hd__decap_12
XFILLER_173_44 VPWR VGND VPWR VGND sky130_ef_sc_hd__decap_12
XFILLER_46_1356 VPWR VGND VPWR VGND sky130_ef_sc_hd__decap_12
XFILLER_133_1304 VPWR VGND VPWR VGND sky130_ef_sc_hd__decap_12
XFILLER_249_154 VPWR VGND VPWR VGND sky130_ef_sc_hd__decap_12
XFILLER_173_99 VPWR VGND VPWR VGND sky130_ef_sc_hd__decap_12
XFILLER_238_839 VPWR VGND VPWR VGND sky130_ef_sc_hd__decap_12
XFILLER_133_1359 VPWR VGND VPWR VGND sky130_ef_sc_hd__decap_12
XFILLER_237_338 VGND VGND VPWR VPWR sky130_fd_sc_hd__decap_6
XFILLER_206_703 VGND VGND VPWR VPWR sky130_fd_sc_hd__decap_6
XFILLER_218_574 VGND VGND VPWR VPWR sky130_fd_sc_hd__decap_6
XFILLER_246_894 VPWR VGND VPWR VGND sky130_ef_sc_hd__decap_12
XFILLER_79_1165 VPWR VGND VPWR VGND sky130_ef_sc_hd__decap_12
X_525_ net665 VGND VGND VPWR VPWR _007_ sky130_fd_sc_hd__inv_2
XTAP_TAPCELL_ROW_155_2_5903 VGND VPWR sky130_fd_sc_hd__tapvpwrvgnd_1
XTAP_TAPCELL_ROW_124_2_5650 VGND VPWR sky130_fd_sc_hd__tapvpwrvgnd_1
XTAP_TAPCELL_ROW_218_3401 VGND VPWR sky130_fd_sc_hd__tapvpwrvgnd_1
XFILLER_199_971 VPWR VGND VPWR VGND sky130_ef_sc_hd__decap_12
XFILLER_144_1411 VPWR VGND VPWR VGND sky130_ef_sc_hd__decap_12
X_456_ rd_addr\[2\] net628 net625 VGND VGND VPWR VPWR addr0\[2\] sky130_fd_sc_hd__mux2_1
XFILLER_242_1023 VPWR VGND VPWR VGND sky130_ef_sc_hd__decap_12
XFILLER_53_1316 VPWR VGND VPWR VGND sky130_ef_sc_hd__decap_12
XFILLER_207_1143 VPWR VGND VPWR VGND sky130_ef_sc_hd__decap_12
XFILLER_220_249 VPWR VGND VPWR VGND sky130_ef_sc_hd__decap_12
XFILLER_144_1466 VPWR VGND VPWR VGND sky130_ef_sc_hd__decap_12
X_387_ net591 net584 net70 VGND VGND VPWR VPWR _176_ sky130_fd_sc_hd__and3_1
XFILLER_242_1078 VPWR VGND VPWR VGND sky130_ef_sc_hd__decap_12
XFILLER_207_1198 VGND VGND VPWR VPWR sky130_fd_sc_hd__decap_6
XFILLER_185_142 VPWR VGND VPWR VGND sky130_ef_sc_hd__decap_12
XFILLER_201_474 VPWR VGND VPWR VGND sky130_ef_sc_hd__decap_12
XFILLER_173_326 VPWR VGND VPWR VGND sky130_ef_sc_hd__decap_12
XTAP_TAPCELL_ROW_73_2_5247 VGND VPWR sky130_fd_sc_hd__tapvpwrvgnd_1
XFILLER_185_197 VPWR VGND VPWR VGND sky130_ef_sc_hd__decap_12
XFILLER_220_1398 VPWR VGND VPWR VGND sky130_ef_sc_hd__decap_12
XFILLER_217_15 VPWR VGND VPWR VGND sky130_ef_sc_hd__decap_12
XFILLER_182_882 VPWR VGND VPWR VGND sky130_ef_sc_hd__decap_12
XFILLER_181_381 VGND VGND VPWR VPWR sky130_fd_sc_hd__decap_6
XFILLER_64_1423 VPWR VGND VPWR VGND sky130_ef_sc_hd__decap_12
XFILLER_218_1250 VPWR VGND VPWR VGND sky130_ef_sc_hd__decap_12
XFILLER_190_1453 VPWR VGND VPWR VGND sky130_ef_sc_hd__decap_12
XFILLER_253_1174 VPWR VGND VPWR VGND sky130_ef_sc_hd__decap_12
XFILLER_64_1478 VGND VGND VPWR VPWR sky130_fd_sc_hd__decap_6
XTAP_TAPCELL_ROW_20_2_4820 VGND VPWR sky130_fd_sc_hd__tapvpwrvgnd_1
XTAP_TAPCELL_ROW_19_2_4814 VGND VPWR sky130_fd_sc_hd__tapvpwrvgnd_1
XFILLER_228_316 VGND VGND VPWR VPWR sky130_fd_sc_hd__decap_6
XFILLER_209_541 VPWR VGND VPWR VGND sky130_ef_sc_hd__decap_12
XFILLER_114_1270 VPWR VGND VPWR VGND sky130_ef_sc_hd__decap_12
XFILLER_237_861 VPWR VGND VPWR VGND sky130_ef_sc_hd__decap_12
XFILLER_252_820 VPWR VGND VPWR VGND sky130_ef_sc_hd__decap_12
XFILLER_209_596 VGND VGND VPWR VPWR sky130_fd_sc_hd__decap_6
XFILLER_58_1227 VPWR VGND VPWR VGND sky130_ef_sc_hd__decap_12
XFILLER_252_875 VGND VGND VPWR VPWR sky130_fd_sc_hd__decap_6
XPHY_EDGE_ROW_119_2_Left_621 VGND VGND VPWR VPWR sky130_fd_sc_hd__decap_3
XFILLER_211_216 VPWR VGND VPWR VGND sky130_ef_sc_hd__decap_12
XTAP_TAPCELL_ROW_201_2781 VGND VPWR sky130_fd_sc_hd__tapvpwrvgnd_1
XTAP_TAPCELL_ROW_201_2792 VGND VPWR sky130_fd_sc_hd__tapvpwrvgnd_1
XFILLER_176_120 VPWR VGND VPWR VGND sky130_ef_sc_hd__decap_12
XPHY_EDGE_ROW_161_2_Right_252 VGND VGND VPWR VPWR sky130_fd_sc_hd__decap_3
XFILLER_192_624 VPWR VGND VPWR VGND sky130_ef_sc_hd__decap_12
XFILLER_176_175 VPWR VGND VPWR VGND sky130_ef_sc_hd__decap_12
XFILLER_34_1282 VPWR VGND VPWR VGND sky130_ef_sc_hd__decap_12
XFILLER_121_1230 VPWR VGND VPWR VGND sky130_ef_sc_hd__decap_12
XFILLER_191_123 VGND VGND VPWR VPWR sky130_fd_sc_hd__decap_6
XFILLER_11_15 VPWR VGND VPWR VGND sky130_ef_sc_hd__decap_12
XFILLER_180_808 VPWR VGND VPWR VGND sky130_ef_sc_hd__decap_12
XFILLER_192_679 VPWR VGND VPWR VGND sky130_ef_sc_hd__decap_12
XFILLER_121_1285 VGND VGND VPWR VPWR sky130_fd_sc_hd__decap_6
XFILLER_127_15 VPWR VGND VPWR VGND sky130_ef_sc_hd__decap_12
XPHY_EDGE_ROW_99_1_Right_755 VGND VGND VPWR VPWR sky130_fd_sc_hd__decap_3
XFILLER_219_1014 VPWR VGND VPWR VGND sky130_ef_sc_hd__decap_12
XFILLER_69_1378 VPWR VGND VPWR VGND sky130_ef_sc_hd__decap_12
XFILLER_156_1337 VPWR VGND VPWR VGND sky130_ef_sc_hd__decap_12
XFILLER_191_1217 VPWR VGND VPWR VGND sky130_ef_sc_hd__decap_12
XFILLER_219_1069 VGND VGND VPWR VPWR sky130_fd_sc_hd__decap_6
XTAP_TAPCELL_ROW_247_4386 VGND VPWR sky130_fd_sc_hd__tapvpwrvgnd_1
XTAP_TAPCELL_ROW_247_4397 VGND VPWR sky130_fd_sc_hd__tapvpwrvgnd_1
XFILLER_43_1507 VGND VGND VPWR VPWR sky130_fd_sc_hd__decap_8
XFILLER_247_603 VPWR VGND VPWR VGND sky130_ef_sc_hd__decap_12
XTAP_TAPCELL_ROW_161_2_5946 VGND VPWR sky130_fd_sc_hd__tapvpwrvgnd_1
XFILLER_232_1269 VPWR VGND VPWR VGND sky130_ef_sc_hd__decap_12
XFILLER_219_338 VGND VGND VPWR VPWR sky130_fd_sc_hd__decap_6
XFILLER_247_658 VPWR VGND VPWR VGND sky130_ef_sc_hd__decap_12
XTAP_TAPCELL_ROW_9_1175 VGND VPWR sky130_fd_sc_hd__tapvpwrvgnd_1
XFILLER_41_1242 VGND VGND VPWR VPWR sky130_fd_sc_hd__decap_6
XTAP_TAPCELL_ROW_9_1186 VGND VPWR sky130_fd_sc_hd__tapvpwrvgnd_1
XTAP_TAPCELL_ROW_9_1197 VGND VPWR sky130_fd_sc_hd__tapvpwrvgnd_1
XTAP_TAPCELL_ROW_5_1039 VGND VPWR sky130_fd_sc_hd__tapvpwrvgnd_1
XFILLER_132_1392 VGND VGND VPWR VPWR sky130_fd_sc_hd__decap_6
XTAP_TAPCELL_ROW_66_2_5190 VGND VPWR sky130_fd_sc_hd__tapvpwrvgnd_1
XFILLER_36_34 VPWR VGND VPWR VGND sky130_ef_sc_hd__decap_12
XFILLER_223_80 VGND VGND VPWR VPWR sky130_fd_sc_hd__decap_6
XFILLER_228_894 VPWR VGND VPWR VGND sky130_ef_sc_hd__decap_12
XFILLER_243_842 VPWR VGND VPWR VGND sky130_ef_sc_hd__decap_12
XTAP_TAPCELL_ROW_109_2_5530 VGND VPWR sky130_fd_sc_hd__tapvpwrvgnd_1
XFILLER_167_1444 VPWR VGND VPWR VGND sky130_ef_sc_hd__decap_12
XFILLER_76_1349 VGND VGND VPWR VPWR sky130_fd_sc_hd__decap_6
XFILLER_243_897 VGND VGND VPWR VPWR sky130_fd_sc_hd__decap_6
X_310_ _096_ _098_ VGND VGND VPWR VPWR _099_ sky130_fd_sc_hd__or2_1
XFILLER_167_1499 VGND VGND VPWR VPWR sky130_fd_sc_hd__decap_6
XFILLER_208_1441 VPWR VGND VPWR VGND sky130_ef_sc_hd__decap_12
XFILLER_52_22 VPWR VGND VPWR VGND sky130_ef_sc_hd__decap_12
XFILLER_202_249 VPWR VGND VPWR VGND sky130_ef_sc_hd__decap_12
XFILLER_146_3 VPWR VGND VPWR VGND sky130_ef_sc_hd__decap_12
XFILLER_204_1305 VGND VGND VPWR VPWR sky130_fd_sc_hd__decap_6
XFILLER_168_22 VPWR VGND VPWR VGND sky130_ef_sc_hd__decap_12
XFILLER_208_1496 VPWR VGND VPWR VGND sky130_ef_sc_hd__decap_12
XTAP_TAPCELL_ROW_58_2_5127 VGND VPWR sky130_fd_sc_hd__tapvpwrvgnd_1
XFILLER_167_142 VPWR VGND VPWR VGND sky130_ef_sc_hd__decap_12
XFILLER_7_815 VGND VGND VPWR VPWR sky130_fd_sc_hd__fill_2
XFILLER_126_1196 VPWR VGND VPWR VGND sky130_ef_sc_hd__decap_12
XPHY_EDGE_ROW_40_2_Left_542 VGND VGND VPWR VPWR sky130_fd_sc_hd__decap_3
XFILLER_168_77 VPWR VGND VPWR VGND sky130_ef_sc_hd__decap_12
XFILLER_182_101 VGND VGND VPWR VPWR sky130_fd_sc_hd__decap_6
XFILLER_7_848 VPWR VGND VPWR VGND sky130_ef_sc_hd__decap_12
XFILLER_167_197 VPWR VGND VPWR VGND sky130_ef_sc_hd__decap_12
XFILLER_183_646 VPWR VGND VPWR VGND sky130_ef_sc_hd__decap_12
XPHY_EDGE_ROW_35_2_Right_126 VGND VGND VPWR VPWR sky130_fd_sc_hd__decap_3
XFILLER_100_1325 VPWR VGND VPWR VGND sky130_ef_sc_hd__decap_12
XFILLER_87_1445 VPWR VGND VPWR VGND sky130_ef_sc_hd__decap_12
XPHY_EDGE_ROW_10_1_Right_821 VGND VGND VPWR VPWR sky130_fd_sc_hd__decap_3
XFILLER_184_65 VPWR VGND VPWR VGND sky130_ef_sc_hd__decap_12
Xsram0_682 VGND VGND VPWR VPWR sram0_682/HI net682 sky130_fd_sc_hd__conb_1
XFILLER_215_1401 VPWR VGND VPWR VGND sky130_ef_sc_hd__decap_12
XFILLER_250_1336 VPWR VGND VPWR VGND sky130_ef_sc_hd__decap_12
XFILLER_215_1456 VGND VGND VPWR VPWR sky130_fd_sc_hd__decap_6
XFILLER_137_1292 VPWR VGND VPWR VGND sky130_ef_sc_hd__decap_12
XFILLER_172_1183 VPWR VGND VPWR VGND sky130_ef_sc_hd__decap_12
XFILLER_238_636 VPWR VGND VPWR VGND sky130_ef_sc_hd__decap_12
XPHY_EDGE_ROW_117_1_Left_372 VGND VGND VPWR VPWR sky130_fd_sc_hd__decap_3
XFILLER_133_1189 VPWR VGND VPWR VGND sky130_ef_sc_hd__decap_12
XFILLER_219_861 VPWR VGND VPWR VGND sky130_ef_sc_hd__decap_12
XFILLER_111_1421 VPWR VGND VPWR VGND sky130_ef_sc_hd__decap_12
XFILLER_168_1219 VGND VGND VPWR VPWR sky130_fd_sc_hd__decap_6
XFILLER_203_39 VGND VGND VPWR VPWR sky130_fd_sc_hd__decap_4
XFILLER_253_639 VGND VGND VPWR VPWR sky130_fd_sc_hd__decap_6
XFILLER_20_1337 VPWR VGND VPWR VGND sky130_ef_sc_hd__decap_12
XFILLER_234_820 VPWR VGND VPWR VGND sky130_ef_sc_hd__decap_12
XFILLER_246_691 VPWR VGND VPWR VGND sky130_ef_sc_hd__decap_12
XFILLER_111_1476 VPWR VGND VPWR VGND sky130_ef_sc_hd__decap_12
XFILLER_209_1205 VPWR VGND VPWR VGND sky130_ef_sc_hd__decap_12
XFILLER_234_875 VGND VGND VPWR VPWR sky130_fd_sc_hd__decap_6
X_508_ net597 dout0_q\[31\] VGND VGND VPWR VPWR _259_ sky130_fd_sc_hd__nand2_1
X_439_ net118 _227_ VGND VGND VPWR VPWR _228_ sky130_fd_sc_hd__nand2_1
XFILLER_92_1184 VPWR VGND VPWR VGND sky130_ef_sc_hd__decap_12
XFILLER_144_1263 VGND VGND VPWR VPWR sky130_fd_sc_hd__decap_6
XFILLER_201_271 VPWR VGND VPWR VGND sky130_ef_sc_hd__decap_12
XFILLER_174_624 VPWR VGND VPWR VGND sky130_ef_sc_hd__decap_12
XFILLER_179_1315 VPWR VGND VPWR VGND sky130_ef_sc_hd__decap_12
XFILLER_186_495 VPWR VGND VPWR VGND sky130_ef_sc_hd__decap_12
XFILLER_220_1140 VPWR VGND VPWR VGND sky130_ef_sc_hd__decap_12
XFILLER_31_1433 VPWR VGND VPWR VGND sky130_ef_sc_hd__decap_12
XFILLER_173_123 VGND VGND VPWR VPWR sky130_fd_sc_hd__decap_6
XFILLER_61_3 VPWR VGND VPWR VGND sky130_ef_sc_hd__decap_12
XFILLER_174_679 VPWR VGND VPWR VGND sky130_ef_sc_hd__decap_12
XFILLER_228_58 VGND VGND VPWR VPWR sky130_fd_sc_hd__decap_6
XFILLER_220_1195 VPWR VGND VPWR VGND sky130_ef_sc_hd__decap_12
XFILLER_31_1488 VPWR VGND VPWR VGND sky130_ef_sc_hd__decap_12
XFILLER_170_863 VPWR VGND VPWR VGND sky130_ef_sc_hd__decap_12
XFILLER_64_1220 VGND VGND VPWR VPWR sky130_fd_sc_hd__decap_6
XFILLER_244_46 VPWR VGND VPWR VGND sky130_ef_sc_hd__decap_12
XTAP_TAPCELL_ROW_146_2_5826 VGND VPWR sky130_fd_sc_hd__tapvpwrvgnd_1
XFILLER_151_1201 VGND VGND VPWR VPWR sky130_fd_sc_hd__decap_4
XFILLER_190_1250 VPWR VGND VPWR VGND sky130_ef_sc_hd__decap_12
XFILLER_229_603 VPWR VGND VPWR VGND sky130_ef_sc_hd__decap_12
XTAP_TAPCELL_ROW_115_2_5584 VGND VPWR sky130_fd_sc_hd__tapvpwrvgnd_1
XFILLER_99_1316 VPWR VGND VPWR VGND sky130_ef_sc_hd__decap_12
XFILLER_229_658 VPWR VGND VPWR VGND sky130_ef_sc_hd__decap_12
XFILLER_244_617 VGND VGND VPWR VPWR sky130_fd_sc_hd__decap_6
XFILLER_113_39 VGND VGND VPWR VPWR sky130_fd_sc_hd__decap_4
XFILLER_3_1033 VPWR VGND VPWR VGND sky130_ef_sc_hd__decap_12
XFILLER_231_1291 VPWR VGND VPWR VGND sky130_ef_sc_hd__decap_12
XTAP_TAPCELL_ROW_207_2990 VGND VPWR sky130_fd_sc_hd__tapvpwrvgnd_1
XFILLER_225_842 VPWR VGND VPWR VGND sky130_ef_sc_hd__decap_12
XFILLER_3_1088 VPWR VGND VPWR VGND sky130_ef_sc_hd__decap_12
XTAP_TAPCELL_ROW_203_2854 VGND VPWR sky130_fd_sc_hd__tapvpwrvgnd_1
XTAP_TAPCELL_ROW_203_2865 VGND VPWR sky130_fd_sc_hd__tapvpwrvgnd_1
XTAP_TAPCELL_ROW_203_2876 VGND VPWR sky130_fd_sc_hd__tapvpwrvgnd_1
XFILLER_227_1327 VGND VGND VPWR VPWR sky130_fd_sc_hd__decap_6
XTAP_TAPCELL_ROW_236_4010 VGND VPWR sky130_fd_sc_hd__tapvpwrvgnd_1
XTAP_TAPCELL_ROW_236_4021 VGND VPWR sky130_fd_sc_hd__tapvpwrvgnd_1
XFILLER_184_1054 VPWR VGND VPWR VGND sky130_ef_sc_hd__decap_12
XFILLER_225_897 VGND VGND VPWR VPWR sky130_fd_sc_hd__decap_6
XTAP_TAPCELL_ROW_236_4032 VGND VPWR sky130_fd_sc_hd__tapvpwrvgnd_1
XTAP_TAPCELL_ROW_255_4666 VGND VPWR sky130_fd_sc_hd__tapvpwrvgnd_1
Xwire88 net89 VGND VGND VPWR VPWR net88 sky130_fd_sc_hd__clkbuf_1
XTAP_TAPCELL_ROW_255_4677 VGND VPWR sky130_fd_sc_hd__tapvpwrvgnd_1
XTAP_TAPCELL_ROW_44_2_5013 VGND VPWR sky130_fd_sc_hd__tapvpwrvgnd_1
XTAP_TAPCELL_ROW_255_4688 VGND VPWR sky130_fd_sc_hd__tapvpwrvgnd_1
XTAP_TAPCELL_ROW_255_4699 VGND VPWR sky130_fd_sc_hd__tapvpwrvgnd_1
XFILLER_75_1371 VGND VGND VPWR VPWR sky130_fd_sc_hd__decap_6
XFILLER_196_237 VPWR VGND VPWR VGND sky130_ef_sc_hd__decap_12
XFILLER_32_1208 VPWR VGND VPWR VGND sky130_ef_sc_hd__decap_12
XFILLER_36_1399 VPWR VGND VPWR VGND sky130_ef_sc_hd__decap_12
XFILLER_123_1347 VPWR VGND VPWR VGND sky130_ef_sc_hd__decap_12
XFILLER_192_421 VPWR VGND VPWR VGND sky130_ef_sc_hd__decap_12
XFILLER_22_58 VGND VGND VPWR VPWR sky130_fd_sc_hd__decap_6
XPHY_EDGE_ROW_162_2_Right_253 VGND VGND VPWR VPWR sky130_fd_sc_hd__decap_3
XFILLER_180_605 VPWR VGND VPWR VGND sky130_ef_sc_hd__decap_12
XFILLER_138_58 VGND VGND VPWR VPWR sky130_fd_sc_hd__decap_6
XFILLER_192_476 VPWR VGND VPWR VGND sky130_ef_sc_hd__decap_12
XTAP_TAPCELL_ROW_249_4459 VGND VPWR sky130_fd_sc_hd__tapvpwrvgnd_1
XFILLER_238_1434 VGND VGND VPWR VPWR sky130_fd_sc_hd__decap_6
XFILLER_191_1014 VPWR VGND VPWR VGND sky130_ef_sc_hd__decap_12
XFILLER_154_46 VPWR VGND VPWR VGND sky130_ef_sc_hd__decap_12
XFILLER_191_1069 VGND VGND VPWR VPWR sky130_fd_sc_hd__decap_6
XFILLER_232_1011 VPWR VGND VPWR VGND sky130_ef_sc_hd__decap_12
XFILLER_43_1304 VPWR VGND VPWR VGND sky130_ef_sc_hd__decap_12
XFILLER_247_400 VPWR VGND VPWR VGND sky130_ef_sc_hd__decap_12
XFILLER_134_1454 VPWR VGND VPWR VGND sky130_ef_sc_hd__decap_12
XFILLER_232_1066 VPWR VGND VPWR VGND sky130_ef_sc_hd__decap_12
XFILLER_43_1359 VPWR VGND VPWR VGND sky130_ef_sc_hd__decap_12
XFILLER_247_455 VPWR VGND VPWR VGND sky130_ef_sc_hd__decap_12
XFILLER_47_44 VGND VGND VPWR VPWR sky130_fd_sc_hd__decap_4
XFILLER_169_1506 VGND VGND VPWR VPWR sky130_fd_sc_hd__decap_8
XFILLER_170_34 VPWR VGND VPWR VGND sky130_ef_sc_hd__decap_12
XFILLER_235_639 VGND VGND VPWR VPWR sky130_fd_sc_hd__decap_6
XFILLER_216_820 VPWR VGND VPWR VGND sky130_ef_sc_hd__decap_12
XFILLER_228_691 VPWR VGND VPWR VGND sky130_ef_sc_hd__decap_12
XFILLER_170_89 VPWR VGND VPWR VGND sky130_ef_sc_hd__decap_12
XFILLER_167_1241 VGND VGND VPWR VPWR sky130_fd_sc_hd__decap_6
XFILLER_216_875 VGND VGND VPWR VPWR sky130_fd_sc_hd__decap_6
XFILLER_54_1411 VPWR VGND VPWR VGND sky130_ef_sc_hd__decap_12
XFILLER_180_1441 VPWR VGND VPWR VGND sky130_ef_sc_hd__decap_12
XFILLER_187_259 VPWR VGND VPWR VGND sky130_ef_sc_hd__decap_12
XFILLER_230_366 VPWR VGND VPWR VGND sky130_ef_sc_hd__decap_12
XFILLER_243_1162 VPWR VGND VPWR VGND sky130_ef_sc_hd__decap_12
XFILLER_179_87 VPWR VGND VPWR VGND sky130_ef_sc_hd__decap_12
XFILLER_54_1466 VPWR VGND VPWR VGND sky130_ef_sc_hd__decap_12
XFILLER_141_1414 VGND VGND VPWR VPWR sky130_fd_sc_hd__decap_6
XFILLER_208_1293 VPWR VGND VPWR VGND sky130_ef_sc_hd__decap_12
XFILLER_89_1507 VGND VGND VPWR VPWR sky130_fd_sc_hd__decap_8
XFILLER_180_1496 VPWR VGND VPWR VGND sky130_ef_sc_hd__decap_12
XFILLER_168_495 VPWR VGND VPWR VGND sky130_ef_sc_hd__decap_12
Xwire543 net48 VGND VGND VPWR VPWR net543 sky130_fd_sc_hd__clkbuf_1
XFILLER_183_443 VPWR VGND VPWR VGND sky130_ef_sc_hd__decap_12
Xwire565 net65 VGND VGND VPWR VPWR net565 sky130_fd_sc_hd__clkbuf_1
Xwire576 dout0_q\[11\] VGND VGND VPWR VPWR net576 sky130_fd_sc_hd__clkbuf_1
XFILLER_6_144 VGND VGND VPWR VPWR sky130_fd_sc_hd__decap_6
Xwire587 net588 VGND VGND VPWR VPWR net587 sky130_fd_sc_hd__clkbuf_1
XFILLER_171_627 VPWR VGND VPWR VGND sky130_ef_sc_hd__decap_12
XTAP_TAPCELL_ROW_172_1762 VGND VPWR sky130_fd_sc_hd__tapvpwrvgnd_1
XTAP_TAPCELL_ROW_172_1773 VGND VPWR sky130_fd_sc_hd__tapvpwrvgnd_1
XTAP_TAPCELL_ROW_213_3194 VGND VPWR sky130_fd_sc_hd__tapvpwrvgnd_1
XFILLER_87_1242 VGND VGND VPWR VPWR sky130_fd_sc_hd__decap_6
XTAP_TAPCELL_ROW_88_2_5366 VGND VPWR sky130_fd_sc_hd__tapvpwrvgnd_1
XFILLER_183_498 VPWR VGND VPWR VGND sky130_ef_sc_hd__decap_12
XPHY_EDGE_ROW_36_2_Right_127 VGND VGND VPWR VPWR sky130_fd_sc_hd__decap_3
XTAP_TAPCELL_ROW_172_1784 VGND VPWR sky130_fd_sc_hd__tapvpwrvgnd_1
XFILLER_100_1177 VGND VGND VPWR VPWR sky130_fd_sc_hd__decap_6
XTAP_TAPCELL_ROW_101_2_5470 VGND VPWR sky130_fd_sc_hd__tapvpwrvgnd_1
XFILLER_135_1218 VPWR VGND VPWR VGND sky130_ef_sc_hd__decap_12
XFILLER_170_1109 VPWR VGND VPWR VGND sky130_ef_sc_hd__decap_12
XFILLER_250_1133 VGND VGND VPWR VPWR sky130_fd_sc_hd__decap_6
XFILLER_238_433 VPWR VGND VPWR VGND sky130_ef_sc_hd__decap_12
XTAP_TAPCELL_ROW_81_2_5309 VGND VPWR sky130_fd_sc_hd__tapvpwrvgnd_1
XTAP_TAPCELL_ROW_166_1555 VGND VPWR sky130_fd_sc_hd__tapvpwrvgnd_1
XTAP_TAPCELL_ROW_166_1566 VGND VPWR sky130_fd_sc_hd__tapvpwrvgnd_1
XTAP_TAPCELL_ROW_166_1577 VGND VPWR sky130_fd_sc_hd__tapvpwrvgnd_1
XFILLER_226_617 VGND VGND VPWR VPWR sky130_fd_sc_hd__decap_6
XFILLER_254_937 VPWR VGND VPWR VGND sky130_ef_sc_hd__decap_12
XFILLER_24_1270 VPWR VGND VPWR VGND sky130_ef_sc_hd__decap_12
XFILLER_238_488 VGND VGND VPWR VPWR sky130_fd_sc_hd__decap_6
XFILLER_207_842 VPWR VGND VPWR VGND sky130_ef_sc_hd__decap_12
XFILLER_230_15 VGND VGND VPWR VPWR sky130_fd_sc_hd__decap_6
XFILLER_111_1273 VPWR VGND VPWR VGND sky130_ef_sc_hd__decap_12
XFILLER_209_1002 VPWR VGND VPWR VGND sky130_ef_sc_hd__decap_12
XFILLER_240_108 VPWR VGND VPWR VGND sky130_ef_sc_hd__decap_12
XFILLER_207_897 VGND VGND VPWR VPWR sky130_fd_sc_hd__decap_6
XFILLER_181_1205 VPWR VGND VPWR VGND sky130_ef_sc_hd__decap_12
XFILLER_146_1325 VPWR VGND VPWR VGND sky130_ef_sc_hd__decap_12
XFILLER_209_1057 VPWR VGND VPWR VGND sky130_ef_sc_hd__decap_12
XFILLER_178_237 VPWR VGND VPWR VGND sky130_ef_sc_hd__decap_12
XTAP_TAPCELL_ROW_48_1_1301 VGND VPWR sky130_fd_sc_hd__tapvpwrvgnd_1
XFILLER_221_388 VPWR VGND VPWR VGND sky130_ef_sc_hd__decap_12
XFILLER_174_421 VPWR VGND VPWR VGND sky130_ef_sc_hd__decap_12
XFILLER_120_1509 VGND VGND VPWR VPWR sky130_fd_sc_hd__decap_6
XFILLER_179_1112 VGND VGND VPWR VPWR sky130_fd_sc_hd__decap_6
XFILLER_239_68 VPWR VGND VPWR VGND sky130_ef_sc_hd__decap_12
XFILLER_186_292 VPWR VGND VPWR VGND sky130_ef_sc_hd__decap_12
XFILLER_31_1230 VPWR VGND VPWR VGND sky130_ef_sc_hd__decap_12
XFILLER_190_925 VPWR VGND VPWR VGND sky130_ef_sc_hd__decap_12
XFILLER_122_1380 VPWR VGND VPWR VGND sky130_ef_sc_hd__decap_12
XFILLER_174_476 VPWR VGND VPWR VGND sky130_ef_sc_hd__decap_12
XFILLER_255_1000 VGND VGND VPWR VPWR sky130_fd_sc_hd__decap_8
XFILLER_31_1285 VGND VGND VPWR VPWR sky130_fd_sc_hd__decap_6
XFILLER_255_34 VGND VGND VPWR VPWR sky130_fd_sc_hd__decap_8
XFILLER_157_1421 VPWR VGND VPWR VGND sky130_ef_sc_hd__decap_12
XFILLER_192_1312 VPWR VGND VPWR VGND sky130_ef_sc_hd__decap_12
XTAP_TAPCELL_ROW_244_4301 VGND VPWR sky130_fd_sc_hd__tapvpwrvgnd_1
XTAP_TAPCELL_ROW_244_4312 VGND VPWR sky130_fd_sc_hd__tapvpwrvgnd_1
XFILLER_66_1337 VPWR VGND VPWR VGND sky130_ef_sc_hd__decap_12
XFILLER_170_660 VGND VGND VPWR VPWR sky130_fd_sc_hd__decap_6
XFILLER_157_1476 VPWR VGND VPWR VGND sky130_ef_sc_hd__decap_12
XFILLER_192_1367 VPWR VGND VPWR VGND sky130_ef_sc_hd__decap_12
XFILLER_9_1231 VGND VGND VPWR VPWR sky130_fd_sc_hd__decap_8
XFILLER_229_400 VPWR VGND VPWR VGND sky130_ef_sc_hd__decap_12
XFILLER_245_904 VPWR VGND VPWR VGND sky130_ef_sc_hd__decap_12
XTAP_TAPCELL_ROW_6_1101 VGND VPWR sky130_fd_sc_hd__tapvpwrvgnd_1
XFILLER_229_455 VPWR VGND VPWR VGND sky130_ef_sc_hd__decap_12
XFILLER_116_1184 VPWR VGND VPWR VGND sky130_ef_sc_hd__decap_12
XTAP_TAPCELL_ROW_205_2916 VGND VPWR sky130_fd_sc_hd__tapvpwrvgnd_1
XTAP_TAPCELL_ROW_205_2927 VGND VPWR sky130_fd_sc_hd__tapvpwrvgnd_1
XTAP_TAPCELL_ROW_205_2938 VGND VPWR sky130_fd_sc_hd__tapvpwrvgnd_1
XFILLER_217_639 VGND VGND VPWR VPWR sky130_fd_sc_hd__decap_6
XFILLER_245_959 VPWR VGND VPWR VGND sky130_ef_sc_hd__decap_12
XFILLER_42_1392 VGND VGND VPWR VPWR sky130_fd_sc_hd__decap_6
XTAP_TAPCELL_ROW_0_832 VGND VPWR sky130_fd_sc_hd__tapvpwrvgnd_1
XFILLER_140_15 VGND VGND VPWR VPWR sky130_fd_sc_hd__decap_6
XTAP_TAPCELL_ROW_0_843 VGND VPWR sky130_fd_sc_hd__tapvpwrvgnd_1
XFILLER_77_1433 VPWR VGND VPWR VGND sky130_ef_sc_hd__decap_12
XTAP_TAPCELL_ROW_0_854 VGND VPWR sky130_fd_sc_hd__tapvpwrvgnd_1
XTAP_TAPCELL_ROW_0_865 VGND VPWR sky130_fd_sc_hd__tapvpwrvgnd_1
XTAP_TAPCELL_ROW_0_876 VGND VPWR sky130_fd_sc_hd__tapvpwrvgnd_1
XTAP_TAPCELL_ROW_0_887 VGND VPWR sky130_fd_sc_hd__tapvpwrvgnd_1
XFILLER_77_1488 VPWR VGND VPWR VGND sky130_ef_sc_hd__decap_12
XFILLER_169_259 VPWR VGND VPWR VGND sky130_ef_sc_hd__decap_12
XFILLER_212_366 VPWR VGND VPWR VGND sky130_ef_sc_hd__decap_12
XFILLER_240_1324 VPWR VGND VPWR VGND sky130_ef_sc_hd__decap_12
XFILLER_205_1444 VPWR VGND VPWR VGND sky130_ef_sc_hd__decap_12
XFILLER_184_218 VPWR VGND VPWR VGND sky130_ef_sc_hd__decap_12
XPHY_EDGE_ROW_24_1_Right_680 VGND VGND VPWR VPWR sky130_fd_sc_hd__decap_3
XFILLER_36_1196 VPWR VGND VPWR VGND sky130_ef_sc_hd__decap_12
XFILLER_149_68 VGND VGND VPWR VPWR sky130_fd_sc_hd__decap_3
XFILLER_165_421 VPWR VGND VPWR VGND sky130_ef_sc_hd__decap_12
XFILLER_240_1379 VPWR VGND VPWR VGND sky130_ef_sc_hd__decap_12
XTAP_TAPCELL_ROW_74_2_5252 VGND VPWR sky130_fd_sc_hd__tapvpwrvgnd_1
XFILLER_205_1499 VGND VGND VPWR VPWR sky130_fd_sc_hd__decap_6
XFILLER_123_1177 VPWR VGND VPWR VGND sky130_ef_sc_hd__decap_12
XFILLER_165_454 VGND VGND VPWR VPWR sky130_fd_sc_hd__decap_8
XFILLER_180_402 VGND VGND VPWR VPWR sky130_fd_sc_hd__decap_6
XPHY_EDGE_ROW_163_2_Right_254 VGND VGND VPWR VPWR sky130_fd_sc_hd__decap_3
XFILLER_192_273 VGND VGND VPWR VPWR sky130_fd_sc_hd__decap_6
XFILLER_10_1325 VPWR VGND VPWR VGND sky130_ef_sc_hd__decap_12
XFILLER_181_947 VPWR VGND VPWR VGND sky130_ef_sc_hd__decap_12
XFILLER_101_1464 VPWR VGND VPWR VGND sky130_ef_sc_hd__decap_12
XFILLER_165_34 VGND VGND VPWR VPWR sky130_fd_sc_hd__decap_8
XFILLER_109_3 VPWR VGND VPWR VGND sky130_ef_sc_hd__decap_12
XTAP_TAPCELL_ROW_41_2_4993 VGND VPWR sky130_fd_sc_hd__tapvpwrvgnd_1
XFILLER_3_169 VGND VGND VPWR VPWR sky130_fd_sc_hd__decap_3
XFILLER_251_1420 VPWR VGND VPWR VGND sky130_ef_sc_hd__decap_12
XFILLER_58_65 VGND VGND VPWR VPWR sky130_fd_sc_hd__decap_6
XFILLER_47_1292 VPWR VGND VPWR VGND sky130_ef_sc_hd__decap_12
XFILLER_134_1251 VPWR VGND VPWR VGND sky130_ef_sc_hd__decap_12
XFILLER_181_44 VPWR VGND VPWR VGND sky130_ef_sc_hd__decap_12
XFILLER_251_1475 VPWR VGND VPWR VGND sky130_ef_sc_hd__decap_12
XFILLER_248_753 VPWR VGND VPWR VGND sky130_ef_sc_hd__decap_12
XFILLER_247_252 VGND VGND VPWR VPWR sky130_fd_sc_hd__decap_6
XFILLER_169_1303 VPWR VGND VPWR VGND sky130_ef_sc_hd__decap_12
XFILLER_208_617 VGND VGND VPWR VPWR sky130_fd_sc_hd__decap_6
XFILLER_43_1189 VPWR VGND VPWR VGND sky130_ef_sc_hd__decap_12
XFILLER_181_99 VPWR VGND VPWR VGND sky130_ef_sc_hd__decap_12
XFILLER_236_937 VPWR VGND VPWR VGND sky130_ef_sc_hd__decap_12
XTAP_TAPCELL_ROW_54_1_1311 VGND VPWR sky130_fd_sc_hd__tapvpwrvgnd_1
XFILLER_21_1421 VPWR VGND VPWR VGND sky130_ef_sc_hd__decap_12
XFILLER_78_1208 VPWR VGND VPWR VGND sky130_ef_sc_hd__decap_12
XFILLER_95_1500 VGND VGND VPWR VPWR sky130_fd_sc_hd__decap_6
XFILLER_169_1358 VPWR VGND VPWR VGND sky130_ef_sc_hd__decap_12
XTAP_TAPCELL_ROW_221_3474 VGND VPWR sky130_fd_sc_hd__tapvpwrvgnd_1
XFILLER_21_1476 VPWR VGND VPWR VGND sky130_ef_sc_hd__decap_12
XFILLER_210_1183 VPWR VGND VPWR VGND sky130_ef_sc_hd__decap_12
XTAP_TAPCELL_ROW_221_3485 VGND VPWR sky130_fd_sc_hd__tapvpwrvgnd_1
XTAP_TAPCELL_ROW_221_3496 VGND VPWR sky130_fd_sc_hd__tapvpwrvgnd_1
XFILLER_222_108 VPWR VGND VPWR VGND sky130_ef_sc_hd__decap_12
XFILLER_244_992 VPWR VGND VPWR VGND sky130_ef_sc_hd__decap_12
XFILLER_182_1514 VGND VGND VPWR VPWR sky130_fd_sc_hd__fill_1
XFILLER_206_1219 VGND VGND VPWR VPWR sky130_fd_sc_hd__decap_6
XFILLER_203_388 VPWR VGND VPWR VGND sky130_ef_sc_hd__decap_12
XFILLER_230_163 VPWR VGND VPWR VGND sky130_ef_sc_hd__decap_12
XFILLER_54_1263 VGND VGND VPWR VPWR sky130_fd_sc_hd__decap_6
XTAP_TAPCELL_ROW_178_1971 VGND VPWR sky130_fd_sc_hd__tapvpwrvgnd_1
XFILLER_208_1090 VGND VGND VPWR VPWR sky130_fd_sc_hd__decap_6
XTAP_TAPCELL_ROW_178_1982 VGND VPWR sky130_fd_sc_hd__tapvpwrvgnd_1
XTAP_TAPCELL_ROW_178_1993 VGND VPWR sky130_fd_sc_hd__tapvpwrvgnd_1
XFILLER_180_1293 VPWR VGND VPWR VGND sky130_ef_sc_hd__decap_12
XFILLER_89_1304 VPWR VGND VPWR VGND sky130_ef_sc_hd__decap_12
XFILLER_168_292 VPWR VGND VPWR VGND sky130_ef_sc_hd__decap_12
XTAP_TAPCELL_ROW_174_1835 VGND VPWR sky130_fd_sc_hd__tapvpwrvgnd_1
XTAP_TAPCELL_ROW_174_1846 VGND VPWR sky130_fd_sc_hd__tapvpwrvgnd_1
XTAP_TAPCELL_ROW_215_3267 VGND VPWR sky130_fd_sc_hd__tapvpwrvgnd_1
Xwire340 net341 VGND VGND VPWR VPWR net340 sky130_fd_sc_hd__clkbuf_1
XTAP_TAPCELL_ROW_174_1857 VGND VPWR sky130_fd_sc_hd__tapvpwrvgnd_1
XTAP_TAPCELL_ROW_215_3278 VGND VPWR sky130_fd_sc_hd__tapvpwrvgnd_1
Xwire351 net352 VGND VGND VPWR VPWR net351 sky130_fd_sc_hd__clkbuf_1
XFILLER_183_240 VPWR VGND VPWR VGND sky130_ef_sc_hd__decap_12
XFILLER_209_27 VPWR VGND VPWR VGND sky130_ef_sc_hd__decap_12
XTAP_TAPCELL_ROW_215_3289 VGND VPWR sky130_fd_sc_hd__tapvpwrvgnd_1
XFILLER_102_1239 VPWR VGND VPWR VGND sky130_ef_sc_hd__decap_12
Xwire362 net363 VGND VGND VPWR VPWR net362 sky130_fd_sc_hd__clkbuf_1
XFILLER_172_925 VPWR VGND VPWR VGND sky130_ef_sc_hd__decap_12
Xwire373 net374 VGND VGND VPWR VPWR net373 sky130_fd_sc_hd__clkbuf_1
XFILLER_89_1359 VPWR VGND VPWR VGND sky130_ef_sc_hd__decap_12
XFILLER_184_796 VPWR VGND VPWR VGND sky130_ef_sc_hd__decap_12
Xwire384 net385 VGND VGND VPWR VPWR net384 sky130_fd_sc_hd__clkbuf_1
Xmax_cap117 _111_ VGND VGND VPWR VPWR net117 sky130_fd_sc_hd__clkbuf_1
Xwire395 net396 VGND VGND VPWR VPWR net395 sky130_fd_sc_hd__clkbuf_1
XFILLER_171_424 VGND VGND VPWR VPWR sky130_fd_sc_hd__decap_6
Xmax_cap128 _110_ VGND VGND VPWR VPWR net128 sky130_fd_sc_hd__clkbuf_1
XFILLER_183_295 VGND VGND VPWR VPWR sky130_fd_sc_hd__decap_6
Xmax_cap139 _108_ VGND VGND VPWR VPWR net139 sky130_fd_sc_hd__clkbuf_1
XPHY_EDGE_ROW_37_2_Right_128 VGND VGND VPWR VPWR sky130_fd_sc_hd__decap_3
XFILLER_217_1315 VPWR VGND VPWR VGND sky130_ef_sc_hd__decap_12
XFILLER_180_980 VPWR VGND VPWR VGND sky130_ef_sc_hd__decap_12
XFILLER_225_15 VPWR VGND VPWR VGND sky130_ef_sc_hd__decap_12
XPHY_EDGE_ROW_128_2_Left_630 VGND VGND VPWR VPWR sky130_fd_sc_hd__decap_3
XTAP_TAPCELL_ROW_168_1628 VGND VPWR sky130_fd_sc_hd__tapvpwrvgnd_1
XFILLER_61_1201 VGND VGND VPWR VPWR sky130_fd_sc_hd__decap_4
XTAP_TAPCELL_ROW_168_1639 VGND VPWR sky130_fd_sc_hd__tapvpwrvgnd_1
XFILLER_174_1097 VPWR VGND VPWR VGND sky130_ef_sc_hd__decap_12
XFILLER_2_191 VGND VGND VPWR VPWR sky130_fd_sc_hd__fill_2
XFILLER_24_3 VPWR VGND VPWR VGND sky130_ef_sc_hd__decap_12
XFILLER_227_904 VPWR VGND VPWR VGND sky130_ef_sc_hd__decap_12
XFILLER_238_230 VGND VGND VPWR VPWR sky130_fd_sc_hd__decap_6
XFILLER_239_775 VPWR VGND VPWR VGND sky130_ef_sc_hd__decap_12
XFILLER_113_1335 VPWR VGND VPWR VGND sky130_ef_sc_hd__decap_12
XFILLER_254_734 VPWR VGND VPWR VGND sky130_ef_sc_hd__decap_12
XFILLER_227_959 VPWR VGND VPWR VGND sky130_ef_sc_hd__decap_12
XFILLER_242_918 VGND VGND VPWR VPWR sky130_fd_sc_hd__decap_6
XFILLER_4_1183 VPWR VGND VPWR VGND sky130_ef_sc_hd__decap_12
XFILLER_254_789 VGND VGND VPWR VPWR sky130_fd_sc_hd__decap_6
XFILLER_228_1422 VPWR VGND VPWR VGND sky130_ef_sc_hd__decap_12
XFILLER_181_1002 VPWR VGND VPWR VGND sky130_ef_sc_hd__decap_12
XFILLER_228_1477 VGND VGND VPWR VPWR sky130_fd_sc_hd__decap_6
XFILLER_221_130 VPWR VGND VPWR VGND sky130_ef_sc_hd__decap_12
XTAP_TAPCELL_ROW_123_2_5646 VGND VPWR sky130_fd_sc_hd__tapvpwrvgnd_1
XFILLER_146_1177 VGND VGND VPWR VPWR sky130_fd_sc_hd__decap_6
XFILLER_181_1057 VPWR VGND VPWR VGND sky130_ef_sc_hd__decap_12
XTAP_TAPCELL_ROW_59_2_5132 VGND VPWR sky130_fd_sc_hd__tapvpwrvgnd_1
XFILLER_166_218 VPWR VGND VPWR VGND sky130_ef_sc_hd__decap_12
XFILLER_221_185 VPWR VGND VPWR VGND sky130_ef_sc_hd__decap_12
XFILLER_124_1442 VPWR VGND VPWR VGND sky130_ef_sc_hd__decap_12
XFILLER_194_538 VPWR VGND VPWR VGND sky130_ef_sc_hd__decap_12
XFILLER_33_1347 VPWR VGND VPWR VGND sky130_ef_sc_hd__decap_12
XFILLER_222_1054 VPWR VGND VPWR VGND sky130_ef_sc_hd__decap_12
XFILLER_120_1306 VGND VGND VPWR VPWR sky130_fd_sc_hd__decap_6
XFILLER_119_27 VPWR VGND VPWR VGND sky130_ef_sc_hd__decap_12
XFILLER_124_1497 VPWR VGND VPWR VGND sky130_ef_sc_hd__decap_12
XFILLER_174_273 VGND VGND VPWR VPWR sky130_fd_sc_hd__decap_6
XFILLER_190_722 VPWR VGND VPWR VGND sky130_ef_sc_hd__decap_12
XTAP_TAPCELL_ROW_190_2393 VGND VPWR sky130_fd_sc_hd__tapvpwrvgnd_1
XTAP_TAPCELL_ROW_26_2_4873 VGND VPWR sky130_fd_sc_hd__tapvpwrvgnd_1
XFILLER_190_777 VPWR VGND VPWR VGND sky130_ef_sc_hd__decap_12
XFILLER_135_15 VPWR VGND VPWR VGND sky130_ef_sc_hd__decap_12
XFILLER_0_106 VPWR VGND VPWR VGND sky130_ef_sc_hd__decap_12
XFILLER_157_1273 VPWR VGND VPWR VGND sky130_ef_sc_hd__decap_12
XFILLER_249_517 VPWR VGND VPWR VGND sky130_ef_sc_hd__decap_12
XFILLER_192_1164 VPWR VGND VPWR VGND sky130_ef_sc_hd__decap_12
XFILLER_0_139 VGND VGND VPWR VPWR sky130_fd_sc_hd__decap_8
XFILLER_44_1454 VPWR VGND VPWR VGND sky130_ef_sc_hd__decap_12
XFILLER_9_1072 VPWR VGND VPWR VGND sky130_ef_sc_hd__decap_12
XFILLER_131_1402 VPWR VGND VPWR VGND sky130_ef_sc_hd__decap_12
XFILLER_245_701 VPWR VGND VPWR VGND sky130_ef_sc_hd__decap_12
XTAP_TAPCELL_ROW_184_2186 VGND VPWR sky130_fd_sc_hd__tapvpwrvgnd_1
XFILLER_170_1484 VPWR VGND VPWR VGND sky130_ef_sc_hd__decap_12
XFILLER_229_252 VGND VGND VPWR VPWR sky130_fd_sc_hd__decap_6
XTAP_TAPCELL_ROW_184_2197 VGND VPWR sky130_fd_sc_hd__tapvpwrvgnd_1
XFILLER_218_937 VPWR VGND VPWR VGND sky130_ef_sc_hd__decap_12
XTAP_TAPCELL_ROW_180_2039 VGND VPWR sky130_fd_sc_hd__tapvpwrvgnd_1
XFILLER_131_1457 VGND VGND VPWR VPWR sky130_fd_sc_hd__decap_6
XFILLER_245_756 VPWR VGND VPWR VGND sky130_ef_sc_hd__decap_12
XFILLER_77_1230 VPWR VGND VPWR VGND sky130_ef_sc_hd__decap_12
XFILLER_204_108 VPWR VGND VPWR VGND sky130_ef_sc_hd__decap_12
XFILLER_226_992 VPWR VGND VPWR VGND sky130_ef_sc_hd__decap_12
XFILLER_231_80 VGND VGND VPWR VPWR sky130_fd_sc_hd__decap_6
XFILLER_44_34 VPWR VGND VPWR VGND sky130_ef_sc_hd__decap_12
XFILLER_241_940 VGND VGND VPWR VPWR sky130_fd_sc_hd__decap_6
XFILLER_168_1391 VGND VGND VPWR VPWR sky130_fd_sc_hd__decap_6
XFILLER_207_1506 VGND VGND VPWR VPWR sky130_fd_sc_hd__decap_8
XFILLER_77_1285 VGND VGND VPWR VPWR sky130_fd_sc_hd__decap_6
XFILLER_125_1206 VPWR VGND VPWR VGND sky130_ef_sc_hd__decap_12
XFILLER_212_163 VPWR VGND VPWR VGND sky130_ef_sc_hd__decap_12
XFILLER_240_1121 VPWR VGND VPWR VGND sky130_ef_sc_hd__decap_12
XFILLER_51_1414 VGND VGND VPWR VPWR sky130_fd_sc_hd__decap_6
XFILLER_205_1241 VGND VGND VPWR VPWR sky130_fd_sc_hd__decap_6
XFILLER_60_22 VPWR VGND VPWR VGND sky130_ef_sc_hd__decap_12
XFILLER_200_347 VPWR VGND VPWR VGND sky130_ef_sc_hd__decap_12
XFILLER_90_1485 VPWR VGND VPWR VGND sky130_ef_sc_hd__decap_12
XFILLER_226_3 VPWR VGND VPWR VGND sky130_ef_sc_hd__decap_12
XFILLER_240_1176 VGND VGND VPWR VPWR sky130_fd_sc_hd__decap_6
XFILLER_176_22 VPWR VGND VPWR VGND sky130_ef_sc_hd__decap_12
XPHY_EDGE_ROW_25_1_Right_681 VGND VGND VPWR VPWR sky130_fd_sc_hd__decap_3
XFILLER_5_902 VGND VGND VPWR VPWR sky130_fd_sc_hd__fill_1
XFILLER_193_560 VPWR VGND VPWR VGND sky130_ef_sc_hd__decap_12
XPHY_EDGE_ROW_126_1_Left_381 VGND VGND VPWR VPWR sky130_fd_sc_hd__decap_3
XFILLER_166_796 VPWR VGND VPWR VGND sky130_ef_sc_hd__decap_12
XTAP_TAPCELL_ROW_210_3120 VGND VPWR sky130_fd_sc_hd__tapvpwrvgnd_1
XFILLER_176_77 VPWR VGND VPWR VGND sky130_ef_sc_hd__decap_12
XFILLER_165_295 VPWR VGND VPWR VGND sky130_ef_sc_hd__decap_12
XFILLER_181_744 VPWR VGND VPWR VGND sky130_ef_sc_hd__decap_12
XFILLER_101_1261 VPWR VGND VPWR VGND sky130_ef_sc_hd__decap_12
XPHY_EDGE_ROW_164_2_Right_255 VGND VGND VPWR VPWR sky130_fd_sc_hd__decap_3
XFILLER_10_1177 VGND VGND VPWR VPWR sky130_fd_sc_hd__decap_6
XFILLER_88_1392 VGND VGND VPWR VPWR sky130_fd_sc_hd__decap_6
XFILLER_181_799 VPWR VGND VPWR VGND sky130_ef_sc_hd__decap_12
XFILLER_136_1313 VPWR VGND VPWR VGND sky130_ef_sc_hd__decap_12
XFILLER_45_1218 VPWR VGND VPWR VGND sky130_ef_sc_hd__decap_12
XFILLER_192_65 VPWR VGND VPWR VGND sky130_ef_sc_hd__decap_12
XFILLER_136_1368 VPWR VGND VPWR VGND sky130_ef_sc_hd__decap_12
XFILLER_171_1248 VPWR VGND VPWR VGND sky130_ef_sc_hd__decap_12
XFILLER_251_1272 VPWR VGND VPWR VGND sky130_ef_sc_hd__decap_12
XFILLER_0_673 VGND VGND VPWR VPWR sky130_fd_sc_hd__fill_2
XFILLER_209_904 VPWR VGND VPWR VGND sky130_ef_sc_hd__decap_12
XFILLER_248_550 VPWR VGND VPWR VGND sky130_ef_sc_hd__decap_12
XTAP_TAPCELL_ROW_227_3694 VGND VPWR sky130_fd_sc_hd__tapvpwrvgnd_1
XTAP_TAPCELL_ROW_223_3547 VGND VPWR sky130_fd_sc_hd__tapvpwrvgnd_1
XTAP_TAPCELL_ROW_223_3558 VGND VPWR sky130_fd_sc_hd__tapvpwrvgnd_1
XFILLER_169_1100 VPWR VGND VPWR VGND sky130_ef_sc_hd__decap_12
XFILLER_236_734 VPWR VGND VPWR VGND sky130_ef_sc_hd__decap_12
XFILLER_209_959 VPWR VGND VPWR VGND sky130_ef_sc_hd__decap_12
XTAP_TAPCELL_ROW_223_3569 VGND VPWR sky130_fd_sc_hd__tapvpwrvgnd_1
XTAP_TAPCELL_ROW_96_2_5428 VGND VPWR sky130_fd_sc_hd__tapvpwrvgnd_1
XFILLER_224_918 VGND VGND VPWR VPWR sky130_fd_sc_hd__decap_6
XFILLER_169_1155 VGND VGND VPWR VPWR sky130_fd_sc_hd__decap_6
XFILLER_236_789 VGND VGND VPWR VPWR sky130_fd_sc_hd__decap_6
XFILLER_1_1334 VPWR VGND VPWR VGND sky130_ef_sc_hd__decap_12
XFILLER_21_1273 VPWR VGND VPWR VGND sky130_ef_sc_hd__decap_12
XTAP_TAPCELL_ROW_108_2_5526 VGND VPWR sky130_fd_sc_hd__tapvpwrvgnd_1
XFILLER_211_39 VGND VGND VPWR VPWR sky130_fd_sc_hd__decap_4
XFILLER_189_811 VGND VGND VPWR VPWR sky130_fd_sc_hd__decap_6
XFILLER_56_1325 VPWR VGND VPWR VGND sky130_ef_sc_hd__decap_12
XFILLER_1_1389 VPWR VGND VPWR VGND sky130_ef_sc_hd__decap_12
XFILLER_147_1464 VPWR VGND VPWR VGND sky130_ef_sc_hd__decap_12
XFILLER_203_130 VPWR VGND VPWR VGND sky130_ef_sc_hd__decap_12
XFILLER_182_1355 VPWR VGND VPWR VGND sky130_ef_sc_hd__decap_12
XFILLER_245_1076 VPWR VGND VPWR VGND sky130_ef_sc_hd__decap_12
XFILLER_91_1249 VPWR VGND VPWR VGND sky130_ef_sc_hd__decap_12
XTAP_TAPCELL_ROW_176_1908 VGND VPWR sky130_fd_sc_hd__tapvpwrvgnd_1
XFILLER_143_1328 VGND VGND VPWR VPWR sky130_fd_sc_hd__decap_6
XTAP_TAPCELL_ROW_176_1919 VGND VPWR sky130_fd_sc_hd__tapvpwrvgnd_1
XFILLER_203_185 VPWR VGND VPWR VGND sky130_ef_sc_hd__decap_12
XFILLER_176_538 VPWR VGND VPWR VGND sky130_ef_sc_hd__decap_12
XFILLER_180_1090 VGND VGND VPWR VPWR sky130_fd_sc_hd__decap_6
XFILLER_30_1509 VGND VGND VPWR VPWR sky130_fd_sc_hd__decap_6
XFILLER_8_751 VGND VGND VPWR VPWR sky130_fd_sc_hd__fill_1
XFILLER_172_722 VPWR VGND VPWR VGND sky130_ef_sc_hd__decap_12
XFILLER_32_1380 VPWR VGND VPWR VGND sky130_ef_sc_hd__decap_12
XFILLER_184_593 VPWR VGND VPWR VGND sky130_ef_sc_hd__decap_12
XFILLER_7_283 VPWR VGND VPWR VGND sky130_ef_sc_hd__decap_12
XFILLER_89_1189 VPWR VGND VPWR VGND sky130_ef_sc_hd__decap_12
XFILLER_67_1421 VPWR VGND VPWR VGND sky130_ef_sc_hd__decap_12
XFILLER_119_1500 VGND VGND VPWR VPWR sky130_fd_sc_hd__decap_6
XFILLER_172_777 VPWR VGND VPWR VGND sky130_ef_sc_hd__decap_12
XFILLER_217_1112 VGND VGND VPWR VPWR sky130_fd_sc_hd__decap_6
XFILLER_236_58 VGND VGND VPWR VPWR sky130_fd_sc_hd__decap_6
XFILLER_67_1476 VPWR VGND VPWR VGND sky130_ef_sc_hd__decap_12
XPHY_EDGE_ROW_38_2_Right_129 VGND VGND VPWR VPWR sky130_fd_sc_hd__decap_3
XFILLER_154_1435 VGND VGND VPWR VPWR sky130_fd_sc_hd__decap_6
XFILLER_252_1047 VGND VGND VPWR VPWR sky130_fd_sc_hd__decap_6
XPHY_EDGE_ROW_7_Right_7 VGND VGND VPWR VPWR sky130_fd_sc_hd__decap_3
XFILLER_230_1312 VPWR VGND VPWR VGND sky130_ef_sc_hd__decap_12
XFILLER_252_46 VPWR VGND VPWR VGND sky130_ef_sc_hd__decap_12
XFILLER_227_701 VPWR VGND VPWR VGND sky130_ef_sc_hd__decap_12
XFILLER_239_572 VPWR VGND VPWR VGND sky130_ef_sc_hd__decap_12
XFILLER_26_1184 VPWR VGND VPWR VGND sky130_ef_sc_hd__decap_12
XFILLER_230_1367 VPWR VGND VPWR VGND sky130_ef_sc_hd__decap_12
XFILLER_254_531 VGND VGND VPWR VPWR sky130_fd_sc_hd__decap_6
XTAP_TAPCELL_ROW_2_938 VGND VPWR sky130_fd_sc_hd__tapvpwrvgnd_1
XFILLER_2_1109 VPWR VGND VPWR VGND sky130_ef_sc_hd__decap_12
XTAP_TAPCELL_ROW_2_949 VGND VPWR sky130_fd_sc_hd__tapvpwrvgnd_1
XFILLER_113_1165 VPWR VGND VPWR VGND sky130_ef_sc_hd__decap_12
XFILLER_227_756 VPWR VGND VPWR VGND sky130_ef_sc_hd__decap_12
XFILLER_121_39 VGND VGND VPWR VPWR sky130_fd_sc_hd__decap_4
XFILLER_148_1239 VPWR VGND VPWR VGND sky130_ef_sc_hd__decap_12
XFILLER_183_1119 VPWR VGND VPWR VGND sky130_ef_sc_hd__decap_12
XFILLER_208_992 VPWR VGND VPWR VGND sky130_ef_sc_hd__decap_12
XFILLER_223_940 VGND VGND VPWR VPWR sky130_fd_sc_hd__decap_6
XFILLER_14_15 VGND VGND VPWR VPWR sky130_fd_sc_hd__decap_6
XFILLER_194_335 VPWR VGND VPWR VGND sky130_ef_sc_hd__decap_12
XFILLER_241_1463 VPWR VGND VPWR VGND sky130_ef_sc_hd__decap_12
XFILLER_210_667 VPWR VGND VPWR VGND sky130_ef_sc_hd__decap_12
XTAP_TAPCELL_ROW_192_2466 VGND VPWR sky130_fd_sc_hd__tapvpwrvgnd_1
XTAP_TAPCELL_ROW_192_2477 VGND VPWR sky130_fd_sc_hd__tapvpwrvgnd_1
XTAP_TAPCELL_ROW_192_2488 VGND VPWR sky130_fd_sc_hd__tapvpwrvgnd_1
XTAP_TAPCELL_ROW_153_2_5885 VGND VPWR sky130_fd_sc_hd__tapvpwrvgnd_1
XFILLER_182_519 VPWR VGND VPWR VGND sky130_ef_sc_hd__decap_12
XFILLER_33_1177 VPWR VGND VPWR VGND sky130_ef_sc_hd__decap_12
XFILLER_175_560 VPWR VGND VPWR VGND sky130_ef_sc_hd__decap_12
XFILLER_124_1294 VPWR VGND VPWR VGND sky130_ef_sc_hd__decap_12
XTAP_TAPCELL_ROW_89_2_5371 VGND VPWR sky130_fd_sc_hd__tapvpwrvgnd_1
XFILLER_159_1335 VPWR VGND VPWR VGND sky130_ef_sc_hd__decap_12
XFILLER_194_1226 VPWR VGND VPWR VGND sky130_ef_sc_hd__decap_12
XFILLER_11_1464 VPWR VGND VPWR VGND sky130_ef_sc_hd__decap_12
XFILLER_190_574 VGND VGND VPWR VPWR sky130_fd_sc_hd__decap_6
XFILLER_239_1370 VGND VGND VPWR VPWR sky130_fd_sc_hd__decap_6
XFILLER_146_58 VGND VGND VPWR VPWR sky130_fd_sc_hd__decap_6
XFILLER_2_949 VPWR VGND VPWR VGND sky130_ef_sc_hd__decap_12
XFILLER_249_314 VPWR VGND VPWR VGND sky130_ef_sc_hd__decap_12
XTAP_TAPCELL_ROW_186_2259 VGND VPWR sky130_fd_sc_hd__tapvpwrvgnd_1
XFILLER_249_369 VPWR VGND VPWR VGND sky130_ef_sc_hd__decap_12
XFILLER_44_1251 VPWR VGND VPWR VGND sky130_ef_sc_hd__decap_12
XTAP_TAPCELL_ROW_82_2_5314 VGND VPWR sky130_fd_sc_hd__tapvpwrvgnd_1
XFILLER_162_46 VPWR VGND VPWR VGND sky130_ef_sc_hd__decap_12
XFILLER_135_1390 VPWR VGND VPWR VGND sky130_ef_sc_hd__decap_12
XTAP_TAPCELL_ROW_51_2_5072 VGND VPWR sky130_fd_sc_hd__tapvpwrvgnd_1
XFILLER_170_1281 VPWR VGND VPWR VGND sky130_ef_sc_hd__decap_12
X_610_ clknet_3_6__leaf_clk dout0\[8\] _018_ VGND VGND VPWR VPWR dout0_q\[8\] sky130_fd_sc_hd__dfrtp_1
XFILLER_218_734 VPWR VGND VPWR VGND sky130_ef_sc_hd__decap_12
XFILLER_245_553 VGND VGND VPWR VPWR sky130_fd_sc_hd__decap_6
XFILLER_79_1347 VPWR VGND VPWR VGND sky130_ef_sc_hd__decap_12
XFILLER_176_3 VPWR VGND VPWR VGND sky130_ef_sc_hd__decap_12
XFILLER_206_918 VGND VGND VPWR VPWR sky130_fd_sc_hd__decap_6
XFILLER_55_44 VGND VGND VPWR VPWR sky130_fd_sc_hd__decap_3
X_541_ net668 VGND VGND VPWR VPWR _023_ sky130_fd_sc_hd__inv_2
XFILLER_218_789 VGND VGND VPWR VPWR sky130_fd_sc_hd__decap_6
XTAP_TAPCELL_ROW_17_2_4796 VGND VPWR sky130_fd_sc_hd__tapvpwrvgnd_1
X_472_ _155_ _242_ net247 VGND VGND VPWR VPWR _243_ sky130_fd_sc_hd__a21oi_1
XFILLER_207_1303 VPWR VGND VPWR VGND sky130_ef_sc_hd__decap_12
XFILLER_220_409 VPWR VGND VPWR VGND sky130_ef_sc_hd__decap_12
XTAP_TAPCELL_ROW_43_2_5009 VGND VPWR sky130_fd_sc_hd__tapvpwrvgnd_1
XFILLER_242_1238 VPWR VGND VPWR VGND sky130_ef_sc_hd__decap_12
XFILLER_207_1358 VPWR VGND VPWR VGND sky130_ef_sc_hd__decap_12
XFILLER_185_302 VPWR VGND VPWR VGND sky130_ef_sc_hd__decap_12
XFILLER_197_173 VPWR VGND VPWR VGND sky130_ef_sc_hd__decap_12
XFILLER_240_280 VPWR VGND VPWR VGND sky130_ef_sc_hd__decap_12
XFILLER_9_526 VGND VGND VPWR VPWR sky130_fd_sc_hd__decap_8
XFILLER_200_144 VGND VGND VPWR VPWR sky130_fd_sc_hd__decap_6
XFILLER_90_1282 VPWR VGND VPWR VGND sky130_ef_sc_hd__decap_12
XFILLER_220_1514 VGND VGND VPWR VPWR sky130_fd_sc_hd__fill_1
XTAP_TAPCELL_ROW_235_3974 VGND VPWR sky130_fd_sc_hd__tapvpwrvgnd_1
XFILLER_185_357 VPWR VGND VPWR VGND sky130_ef_sc_hd__decap_12
XFILLER_201_689 VPWR VGND VPWR VGND sky130_ef_sc_hd__decap_12
XTAP_TAPCELL_ROW_235_3985 VGND VPWR sky130_fd_sc_hd__tapvpwrvgnd_1
XTAP_TAPCELL_ROW_231_3827 VGND VPWR sky130_fd_sc_hd__tapvpwrvgnd_1
XTAP_TAPCELL_ROW_235_3996 VGND VPWR sky130_fd_sc_hd__tapvpwrvgnd_1
XFILLER_187_87 VPWR VGND VPWR VGND sky130_ef_sc_hd__decap_12
XTAP_TAPCELL_ROW_231_3838 VGND VPWR sky130_fd_sc_hd__tapvpwrvgnd_1
XTAP_TAPCELL_ROW_231_3849 VGND VPWR sky130_fd_sc_hd__tapvpwrvgnd_1
XTAP_TAPCELL_ROW_10_2_4739 VGND VPWR sky130_fd_sc_hd__tapvpwrvgnd_1
XFILLER_12_1239 VPWR VGND VPWR VGND sky130_ef_sc_hd__decap_12
XFILLER_177_1413 VGND VGND VPWR VPWR sky130_fd_sc_hd__decap_6
XPHY_EDGE_ROW_26_1_Right_682 VGND VGND VPWR VPWR sky130_fd_sc_hd__decap_3
XFILLER_166_593 VPWR VGND VPWR VGND sky130_ef_sc_hd__decap_12
XFILLER_5_732 VGND VGND VPWR VPWR sky130_fd_sc_hd__decap_4
XFILLER_103_1378 VPWR VGND VPWR VGND sky130_ef_sc_hd__decap_12
XFILLER_181_541 VPWR VGND VPWR VGND sky130_ef_sc_hd__decap_12
XFILLER_5_765 VGND VGND VPWR VPWR sky130_fd_sc_hd__fill_1
XFILLER_218_1410 VPWR VGND VPWR VGND sky130_ef_sc_hd__decap_12
XFILLER_4_264 VGND VGND VPWR VPWR sky130_fd_sc_hd__decap_3
XFILLER_181_596 VGND VGND VPWR VPWR sky130_fd_sc_hd__decap_6
XFILLER_253_1334 VPWR VGND VPWR VGND sky130_ef_sc_hd__decap_12
XTAP_TAPCELL_ROW_229_3756 VGND VPWR sky130_fd_sc_hd__tapvpwrvgnd_1
XFILLER_218_1465 VPWR VGND VPWR VGND sky130_ef_sc_hd__decap_12
XTAP_TAPCELL_ROW_229_3767 VGND VPWR sky130_fd_sc_hd__tapvpwrvgnd_1
XTAP_TAPCELL_ROW_229_3778 VGND VPWR sky130_fd_sc_hd__tapvpwrvgnd_1
XFILLER_171_1045 VPWR VGND VPWR VGND sky130_ef_sc_hd__decap_12
XFILLER_1_971 VPWR VGND VPWR VGND sky130_ef_sc_hd__decap_12
XFILLER_136_1165 VPWR VGND VPWR VGND sky130_ef_sc_hd__decap_12
XFILLER_253_1389 VPWR VGND VPWR VGND sky130_ef_sc_hd__decap_12
XFILLER_209_701 VPWR VGND VPWR VGND sky130_ef_sc_hd__decap_12
XFILLER_255_328 VGND VGND VPWR VPWR sky130_fd_sc_hd__decap_8
XFILLER_23_1335 VPWR VGND VPWR VGND sky130_ef_sc_hd__decap_12
XFILLER_97_1414 VGND VGND VPWR VPWR sky130_fd_sc_hd__decap_6
XFILLER_236_531 VGND VGND VPWR VPWR sky130_fd_sc_hd__decap_6
XFILLER_114_1485 VPWR VGND VPWR VGND sky130_ef_sc_hd__decap_12
XFILLER_209_756 VPWR VGND VPWR VGND sky130_ef_sc_hd__decap_12
XFILLER_212_1097 VPWR VGND VPWR VGND sky130_ef_sc_hd__decap_12
XFILLER_110_1349 VGND VGND VPWR VPWR sky130_fd_sc_hd__decap_6
XFILLER_1_1131 VPWR VGND VPWR VGND sky130_ef_sc_hd__decap_12
XFILLER_205_940 VGND VGND VPWR VPWR sky130_fd_sc_hd__decap_6
XFILLER_1_1186 VPWR VGND VPWR VGND sky130_ef_sc_hd__decap_12
XFILLER_147_1261 VPWR VGND VPWR VGND sky130_ef_sc_hd__decap_12
XFILLER_182_1152 VPWR VGND VPWR VGND sky130_ef_sc_hd__decap_12
XFILLER_91_3 VPWR VGND VPWR VGND sky130_ef_sc_hd__decap_12
XFILLER_188_151 VPWR VGND VPWR VGND sky130_ef_sc_hd__decap_12
XFILLER_56_1177 VGND VGND VPWR VPWR sky130_fd_sc_hd__decap_6
XTAP_TAPCELL_ROW_138_2_5765 VGND VPWR sky130_fd_sc_hd__tapvpwrvgnd_1
XFILLER_176_335 VPWR VGND VPWR VGND sky130_ef_sc_hd__decap_12
XFILLER_34_1442 VPWR VGND VPWR VGND sky130_ef_sc_hd__decap_12
XFILLER_30_1306 VGND VGND VPWR VPWR sky130_fd_sc_hd__decap_6
XFILLER_192_839 VPWR VGND VPWR VGND sky130_ef_sc_hd__decap_12
XFILLER_34_1497 VPWR VGND VPWR VGND sky130_ef_sc_hd__decap_12
XFILLER_121_1445 VPWR VGND VPWR VGND sky130_ef_sc_hd__decap_12
XFILLER_191_338 VGND VGND VPWR VPWR sky130_fd_sc_hd__decap_6
XFILLER_8_581 VGND VGND VPWR VPWR sky130_fd_sc_hd__fill_2
XFILLER_184_390 VPWR VGND VPWR VGND sky130_ef_sc_hd__decap_12
XFILLER_247_68 VPWR VGND VPWR VGND sky130_ef_sc_hd__decap_12
XFILLER_254_1109 VPWR VGND VPWR VGND sky130_ef_sc_hd__decap_12
XFILLER_219_1229 VPWR VGND VPWR VGND sky130_ef_sc_hd__decap_12
XFILLER_172_574 VGND VGND VPWR VPWR sky130_fd_sc_hd__decap_6
XTAP_TAPCELL_ROW_131_2_5708 VGND VPWR sky130_fd_sc_hd__tapvpwrvgnd_1
XFILLER_67_1273 VPWR VGND VPWR VGND sky130_ef_sc_hd__decap_12
XFILLER_247_818 VPWR VGND VPWR VGND sky130_ef_sc_hd__decap_12
XTAP_TAPCELL_ROW_181_2101 VGND VPWR sky130_fd_sc_hd__tapvpwrvgnd_1
XFILLER_41_1402 VPWR VGND VPWR VGND sky130_ef_sc_hd__decap_12
XFILLER_115_1249 VPWR VGND VPWR VGND sky130_ef_sc_hd__decap_12
XTAP_TAPCELL_ROW_241_4178 VGND VPWR sky130_fd_sc_hd__tapvpwrvgnd_1
XTAP_TAPCELL_ROW_241_4189 VGND VPWR sky130_fd_sc_hd__tapvpwrvgnd_1
XFILLER_41_1457 VGND VGND VPWR VPWR sky130_fd_sc_hd__decap_6
XTAP_TAPCELL_ROW_34_2_4935 VGND VPWR sky130_fd_sc_hd__tapvpwrvgnd_1
XFILLER_230_1164 VPWR VGND VPWR VGND sky130_ef_sc_hd__decap_12
XFILLER_255_862 VPWR VGND VPWR VGND sky130_ef_sc_hd__decap_12
XFILLER_227_553 VGND VGND VPWR VPWR sky130_fd_sc_hd__decap_6
XFILLER_6_1097 VPWR VGND VPWR VGND sky130_ef_sc_hd__decap_12
XFILLER_255_895 VGND VGND VPWR VPWR sky130_fd_sc_hd__decap_8
XFILLER_76_1509 VGND VGND VPWR VPWR sky130_fd_sc_hd__decap_6
XTAP_TAPCELL_ROW_179_2030 VGND VPWR sky130_fd_sc_hd__tapvpwrvgnd_1
XFILLER_78_1380 VPWR VGND VPWR VGND sky130_ef_sc_hd__decap_12
XFILLER_202_409 VPWR VGND VPWR VGND sky130_ef_sc_hd__decap_12
XFILLER_243_1514 VGND VGND VPWR VPWR sky130_fd_sc_hd__fill_1
XTAP_TAPCELL_ROW_198_2675 VGND VPWR sky130_fd_sc_hd__tapvpwrvgnd_1
XTAP_TAPCELL_ROW_198_2686 VGND VPWR sky130_fd_sc_hd__tapvpwrvgnd_1
XTAP_TAPCELL_ROW_198_2697 VGND VPWR sky130_fd_sc_hd__tapvpwrvgnd_1
XFILLER_35_1206 VPWR VGND VPWR VGND sky130_ef_sc_hd__decap_12
XTAP_TAPCELL_ROW_194_2539 VGND VPWR sky130_fd_sc_hd__tapvpwrvgnd_1
XFILLER_167_302 VPWR VGND VPWR VGND sky130_ef_sc_hd__decap_12
XFILLER_179_173 VPWR VGND VPWR VGND sky130_ef_sc_hd__decap_12
XFILLER_222_280 VPWR VGND VPWR VGND sky130_ef_sc_hd__decap_12
XFILLER_126_1356 VPWR VGND VPWR VGND sky130_ef_sc_hd__decap_12
XFILLER_167_357 VPWR VGND VPWR VGND sky130_ef_sc_hd__decap_12
XFILLER_194_132 VPWR VGND VPWR VGND sky130_ef_sc_hd__decap_12
XFILLER_210_464 VPWR VGND VPWR VGND sky130_ef_sc_hd__decap_12
XFILLER_241_1260 VPWR VGND VPWR VGND sky130_ef_sc_hd__decap_12
XFILLER_206_1391 VGND VGND VPWR VPWR sky130_fd_sc_hd__decap_6
XFILLER_182_316 VGND VGND VPWR VPWR sky130_fd_sc_hd__decap_6
XFILLER_41_68 VGND VGND VPWR VPWR sky130_fd_sc_hd__decap_3
XFILLER_194_187 VGND VGND VPWR VPWR sky130_fd_sc_hd__decap_6
XFILLER_157_68 VGND VGND VPWR VPWR sky130_fd_sc_hd__decap_3
XFILLER_191_861 VPWR VGND VPWR VGND sky130_ef_sc_hd__decap_12
XFILLER_194_1023 VPWR VGND VPWR VGND sky130_ef_sc_hd__decap_12
XFILLER_11_1261 VPWR VGND VPWR VGND sky130_ef_sc_hd__decap_12
XFILLER_159_1165 VPWR VGND VPWR VGND sky130_ef_sc_hd__decap_12
XFILLER_2_713 VGND VGND VPWR VPWR sky130_fd_sc_hd__decap_4
XFILLER_194_1078 VPWR VGND VPWR VGND sky130_ef_sc_hd__decap_12
XFILLER_46_1313 VPWR VGND VPWR VGND sky130_ef_sc_hd__decap_12
XFILLER_2_757 VPWR VGND VPWR VGND sky130_ef_sc_hd__decap_12
XFILLER_249_111 VPWR VGND VPWR VGND sky130_ef_sc_hd__decap_12
XFILLER_173_56 VPWR VGND VPWR VGND sky130_ef_sc_hd__decap_12
XFILLER_46_1368 VPWR VGND VPWR VGND sky130_ef_sc_hd__decap_12
XFILLER_133_1316 VPWR VGND VPWR VGND sky130_ef_sc_hd__decap_12
XFILLER_1_289 VPWR VGND VPWR VGND sky130_ef_sc_hd__decap_12
XFILLER_249_166 VGND VGND VPWR VPWR sky130_fd_sc_hd__decap_6
XFILLER_172_1398 VPWR VGND VPWR VGND sky130_ef_sc_hd__decap_12
XFILLER_218_531 VGND VGND VPWR VPWR sky130_fd_sc_hd__decap_6
XFILLER_66_65 VGND VGND VPWR VPWR sky130_fd_sc_hd__decap_6
XFILLER_246_851 VPWR VGND VPWR VGND sky130_ef_sc_hd__decap_12
XFILLER_79_1177 VPWR VGND VPWR VGND sky130_ef_sc_hd__decap_12
X_524_ net665 VGND VGND VPWR VPWR _006_ sky130_fd_sc_hd__inv_2
XFILLER_2_1484 VPWR VGND VPWR VGND sky130_ef_sc_hd__decap_12
XTAP_TAPCELL_ROW_155_2_5904 VGND VPWR sky130_fd_sc_hd__tapvpwrvgnd_1
XFILLER_207_1100 VPWR VGND VPWR VGND sky130_ef_sc_hd__decap_12
XTAP_TAPCELL_ROW_218_3402 VGND VPWR sky130_fd_sc_hd__tapvpwrvgnd_1
XPHY_EDGE_ROW_12_2_Left_514 VGND VGND VPWR VPWR sky130_fd_sc_hd__decap_3
XTAP_TAPCELL_ROW_124_2_5651 VGND VPWR sky130_fd_sc_hd__tapvpwrvgnd_1
XFILLER_220_206 VPWR VGND VPWR VGND sky130_ef_sc_hd__decap_12
X_455_ net615 net640 net624 VGND VGND VPWR VPWR addr0\[1\] sky130_fd_sc_hd__mux2_1
XFILLER_57_1464 VPWR VGND VPWR VGND sky130_ef_sc_hd__decap_12
XFILLER_199_983 VGND VGND VPWR VPWR sky130_fd_sc_hd__decap_6
XFILLER_144_1423 VPWR VGND VPWR VGND sky130_ef_sc_hd__decap_12
XFILLER_242_1035 VPWR VGND VPWR VGND sky130_ef_sc_hd__decap_12
XFILLER_53_1328 VGND VGND VPWR VPWR sky130_fd_sc_hd__decap_6
XFILLER_207_1155 VGND VGND VPWR VPWR sky130_fd_sc_hd__decap_6
XFILLER_201_431 VPWR VGND VPWR VGND sky130_ef_sc_hd__decap_12
X_386_ net217 net216 net213 net212 VGND VGND VPWR VPWR _175_ sky130_fd_sc_hd__or4_1
XFILLER_92_1399 VPWR VGND VPWR VGND sky130_ef_sc_hd__decap_12
XFILLER_144_1478 VGND VGND VPWR VPWR sky130_fd_sc_hd__decap_6
XFILLER_185_154 VPWR VGND VPWR VGND sky130_ef_sc_hd__decap_12
XFILLER_201_486 VPWR VGND VPWR VGND sky130_ef_sc_hd__decap_12
XFILLER_174_839 VPWR VGND VPWR VGND sky130_ef_sc_hd__decap_12
XTAP_TAPCELL_ROW_73_2_5248 VGND VPWR sky130_fd_sc_hd__tapvpwrvgnd_1
XFILLER_173_338 VGND VGND VPWR VPWR sky130_fd_sc_hd__decap_6
XFILLER_220_1355 VPWR VGND VPWR VGND sky130_ef_sc_hd__decap_12
XFILLER_166_390 VPWR VGND VPWR VGND sky130_ef_sc_hd__decap_12
XPHY_EDGE_ROW_27_1_Right_683 VGND VGND VPWR VPWR sky130_fd_sc_hd__decap_3
XFILLER_217_27 VPWR VGND VPWR VGND sky130_ef_sc_hd__decap_12
XFILLER_255_1429 VPWR VGND VPWR VGND sky130_ef_sc_hd__decap_12
XFILLER_182_894 VPWR VGND VPWR VGND sky130_ef_sc_hd__decap_12
XFILLER_29_1500 VGND VGND VPWR VPWR sky130_fd_sc_hd__decap_6
XFILLER_138_1227 VPWR VGND VPWR VGND sky130_ef_sc_hd__decap_12
XTAP_TAPCELL_ROW_40_2_4978 VGND VPWR sky130_fd_sc_hd__tapvpwrvgnd_1
XFILLER_190_1410 VPWR VGND VPWR VGND sky130_ef_sc_hd__decap_12
XFILLER_253_1131 VPWR VGND VPWR VGND sky130_ef_sc_hd__decap_12
XFILLER_64_1435 VGND VGND VPWR VPWR sky130_fd_sc_hd__decap_6
XFILLER_218_1262 VGND VGND VPWR VPWR sky130_fd_sc_hd__decap_6
XFILLER_190_1465 VPWR VGND VPWR VGND sky130_ef_sc_hd__decap_12
XFILLER_253_1186 VPWR VGND VPWR VGND sky130_ef_sc_hd__decap_12
XFILLER_229_818 VPWR VGND VPWR VGND sky130_ef_sc_hd__decap_12
XFILLER_233_15 VPWR VGND VPWR VGND sky130_ef_sc_hd__decap_12
XTAP_TAPCELL_ROW_20_2_4821 VGND VPWR sky130_fd_sc_hd__tapvpwrvgnd_1
XTAP_TAPCELL_ROW_19_2_4815 VGND VPWR sky130_fd_sc_hd__tapvpwrvgnd_1
XFILLER_209_553 VGND VGND VPWR VPWR sky130_fd_sc_hd__decap_6
XFILLER_255_169 VPWR VGND VPWR VGND sky130_ef_sc_hd__decap_12
XFILLER_23_1165 VPWR VGND VPWR VGND sky130_ef_sc_hd__decap_12
XFILLER_114_1282 VPWR VGND VPWR VGND sky130_ef_sc_hd__decap_12
XFILLER_237_873 VPWR VGND VPWR VGND sky130_ef_sc_hd__decap_12
XFILLER_3_1248 VPWR VGND VPWR VGND sky130_ef_sc_hd__decap_12
XFILLER_252_832 VGND VGND VPWR VPWR sky130_fd_sc_hd__decap_6
XFILLER_58_1239 VPWR VGND VPWR VGND sky130_ef_sc_hd__decap_12
XFILLER_149_1378 VPWR VGND VPWR VGND sky130_ef_sc_hd__decap_12
XFILLER_184_1269 VPWR VGND VPWR VGND sky130_ef_sc_hd__decap_12
XTAP_TAPCELL_ROW_201_2782 VGND VPWR sky130_fd_sc_hd__tapvpwrvgnd_1
XFILLER_211_228 VPWR VGND VPWR VGND sky130_ef_sc_hd__decap_12
XPHY_EDGE_ROW_69_2_Left_571 VGND VGND VPWR VPWR sky130_fd_sc_hd__decap_3
XTAP_TAPCELL_ROW_201_2793 VGND VPWR sky130_fd_sc_hd__tapvpwrvgnd_1
XFILLER_204_280 VPWR VGND VPWR VGND sky130_ef_sc_hd__decap_12
XFILLER_123_1507 VGND VGND VPWR VPWR sky130_fd_sc_hd__decap_8
XTAP_TAPCELL_ROW_253_4594 VGND VPWR sky130_fd_sc_hd__tapvpwrvgnd_1
XFILLER_176_132 VPWR VGND VPWR VGND sky130_ef_sc_hd__decap_12
XFILLER_221_1119 VPWR VGND VPWR VGND sky130_ef_sc_hd__decap_12
XPHY_EDGE_ROW_4_Left_260 VGND VGND VPWR VPWR sky130_fd_sc_hd__decap_3
XFILLER_176_187 VGND VGND VPWR VPWR sky130_fd_sc_hd__decap_6
XFILLER_192_636 VPWR VGND VPWR VGND sky130_ef_sc_hd__decap_12
XFILLER_34_1294 VPWR VGND VPWR VGND sky130_ef_sc_hd__decap_12
XFILLER_121_1242 VGND VGND VPWR VPWR sky130_fd_sc_hd__decap_6
XFILLER_11_27 VPWR VGND VPWR VGND sky130_ef_sc_hd__decap_12
XTAP_TAPCELL_ROW_95_1_1372 VGND VPWR sky130_fd_sc_hd__tapvpwrvgnd_1
XFILLER_69_1335 VPWR VGND VPWR VGND sky130_ef_sc_hd__decap_12
XFILLER_173_861 VPWR VGND VPWR VGND sky130_ef_sc_hd__decap_12
XFILLER_127_27 VPWR VGND VPWR VGND sky130_ef_sc_hd__decap_12
XFILLER_219_1026 VGND VGND VPWR VPWR sky130_fd_sc_hd__decap_6
XTAP_TAPCELL_ROW_187_2310 VGND VPWR sky130_fd_sc_hd__tapvpwrvgnd_1
XFILLER_156_1349 VGND VGND VPWR VPWR sky130_fd_sc_hd__decap_6
XFILLER_191_1229 VPWR VGND VPWR VGND sky130_ef_sc_hd__decap_12
XTAP_TAPCELL_ROW_247_4387 VGND VPWR sky130_fd_sc_hd__tapvpwrvgnd_1
XTAP_TAPCELL_ROW_247_4398 VGND VPWR sky130_fd_sc_hd__tapvpwrvgnd_1
XFILLER_143_15 VPWR VGND VPWR VGND sky130_ef_sc_hd__decap_12
XFILLER_232_1226 VPWR VGND VPWR VGND sky130_ef_sc_hd__decap_12
XFILLER_247_615 VPWR VGND VPWR VGND sky130_ef_sc_hd__decap_12
XTAP_TAPCELL_ROW_161_2_5947 VGND VPWR sky130_fd_sc_hd__tapvpwrvgnd_1
XFILLER_45_1390 VPWR VGND VPWR VGND sky130_ef_sc_hd__decap_12
XFILLER_80_1270 VPWR VGND VPWR VGND sky130_ef_sc_hd__decap_12
XTAP_TAPCELL_ROW_9_1176 VGND VPWR sky130_fd_sc_hd__tapvpwrvgnd_1
XFILLER_228_851 VPWR VGND VPWR VGND sky130_ef_sc_hd__decap_12
XTAP_TAPCELL_ROW_9_1187 VGND VPWR sky130_fd_sc_hd__tapvpwrvgnd_1
XTAP_TAPCELL_ROW_9_1198 VGND VPWR sky130_fd_sc_hd__tapvpwrvgnd_1
XFILLER_167_1401 VPWR VGND VPWR VGND sky130_ef_sc_hd__decap_12
XTAP_TAPCELL_ROW_66_2_5191 VGND VPWR sky130_fd_sc_hd__tapvpwrvgnd_1
XFILLER_36_46 VGND VGND VPWR VPWR sky130_fd_sc_hd__decap_4
XFILLER_76_1306 VGND VGND VPWR VPWR sky130_fd_sc_hd__decap_6
XPHY_EDGE_ROW_135_1_Left_390 VGND VGND VPWR VPWR sky130_fd_sc_hd__decap_3
XTAP_TAPCELL_ROW_109_2_5531 VGND VPWR sky130_fd_sc_hd__tapvpwrvgnd_1
XFILLER_243_854 VGND VGND VPWR VPWR sky130_fd_sc_hd__decap_6
XFILLER_167_1456 VGND VGND VPWR VPWR sky130_fd_sc_hd__decap_6
XFILLER_202_206 VPWR VGND VPWR VGND sky130_ef_sc_hd__decap_12
XPHY_EDGE_ROW_204_Right_49 VGND VGND VPWR VPWR sky130_fd_sc_hd__decap_3
XFILLER_208_1453 VPWR VGND VPWR VGND sky130_ef_sc_hd__decap_12
XFILLER_52_34 VPWR VGND VPWR VGND sky130_ef_sc_hd__decap_12
XFILLER_243_1377 VPWR VGND VPWR VGND sky130_ef_sc_hd__decap_12
XFILLER_168_34 VPWR VGND VPWR VGND sky130_ef_sc_hd__decap_12
XTAP_TAPCELL_ROW_58_2_5128 VGND VPWR sky130_fd_sc_hd__tapvpwrvgnd_1
XFILLER_139_3 VPWR VGND VPWR VGND sky130_ef_sc_hd__decap_12
XFILLER_167_154 VPWR VGND VPWR VGND sky130_ef_sc_hd__decap_12
XFILLER_183_603 VPWR VGND VPWR VGND sky130_ef_sc_hd__decap_12
XFILLER_210_261 VPWR VGND VPWR VGND sky130_ef_sc_hd__decap_12
XFILLER_195_474 VPWR VGND VPWR VGND sky130_ef_sc_hd__decap_12
XFILLER_168_89 VPWR VGND VPWR VGND sky130_ef_sc_hd__decap_12
XPHY_EDGE_ROW_154_1_Left_409 VGND VGND VPWR VPWR sky130_fd_sc_hd__decap_3
XFILLER_87_1402 VPWR VGND VPWR VGND sky130_ef_sc_hd__decap_12
XFILLER_183_658 VPWR VGND VPWR VGND sky130_ef_sc_hd__decap_12
XFILLER_13_1378 VPWR VGND VPWR VGND sky130_ef_sc_hd__decap_12
XFILLER_100_1337 VPWR VGND VPWR VGND sky130_ef_sc_hd__decap_12
XFILLER_184_22 VPWR VGND VPWR VGND sky130_ef_sc_hd__decap_12
XTAP_TAPCELL_ROW_25_2_4858 VGND VPWR sky130_fd_sc_hd__tapvpwrvgnd_1
XFILLER_87_1457 VGND VGND VPWR VPWR sky130_fd_sc_hd__decap_6
XFILLER_184_77 VPWR VGND VPWR VGND sky130_ef_sc_hd__decap_12
XPHY_EDGE_ROW_213_Right_58 VGND VGND VPWR VPWR sky130_fd_sc_hd__decap_3
Xsram0_683 VGND VGND VPWR VPWR sram0_683/HI net683 sky130_fd_sc_hd__conb_1
XTAP_TAPCELL_ROW_170_1690 VGND VPWR sky130_fd_sc_hd__tapvpwrvgnd_1
XFILLER_215_1413 VGND VGND VPWR VPWR sky130_fd_sc_hd__decap_6
XFILLER_172_1140 VPWR VGND VPWR VGND sky130_ef_sc_hd__decap_12
XFILLER_254_1484 VPWR VGND VPWR VGND sky130_ef_sc_hd__decap_12
XFILLER_46_1165 VPWR VGND VPWR VGND sky130_ef_sc_hd__decap_12
XFILLER_250_1348 VGND VGND VPWR VPWR sky130_fd_sc_hd__decap_6
XFILLER_172_1195 VPWR VGND VPWR VGND sky130_ef_sc_hd__decap_12
XPHY_EDGE_ROW_90_2_Right_181 VGND VGND VPWR VPWR sky130_fd_sc_hd__decap_3
XFILLER_238_648 VPWR VGND VPWR VGND sky130_ef_sc_hd__decap_12
XFILLER_219_873 VPWR VGND VPWR VGND sky130_ef_sc_hd__decap_12
XFILLER_24_1485 VPWR VGND VPWR VGND sky130_ef_sc_hd__decap_12
XFILLER_111_1433 VPWR VGND VPWR VGND sky130_ef_sc_hd__decap_12
XFILLER_20_1349 VGND VGND VPWR VPWR sky130_fd_sc_hd__decap_6
XFILLER_234_832 VGND VGND VPWR VPWR sky130_fd_sc_hd__decap_6
XFILLER_111_1488 VPWR VGND VPWR VGND sky130_ef_sc_hd__decap_12
XFILLER_209_1217 VPWR VGND VPWR VGND sky130_ef_sc_hd__decap_12
XPHY_EDGE_ROW_222_Right_67 VGND VGND VPWR VPWR sky130_fd_sc_hd__decap_3
XFILLER_2_1281 VPWR VGND VPWR VGND sky130_ef_sc_hd__decap_12
X_507_ net175 net91 VGND VGND VPWR VPWR acc_core.adder.cla_blocks\[6\].block.sum\[0\]
+ sky130_fd_sc_hd__xnor2_1
XFILLER_57_1261 VPWR VGND VPWR VGND sky130_ef_sc_hd__decap_12
XFILLER_144_1220 VGND VGND VPWR VPWR sky130_fd_sc_hd__decap_6
X_438_ _225_ net190 VGND VGND VPWR VPWR _227_ sky130_fd_sc_hd__nor2_1
XFILLER_183_1291 VPWR VGND VPWR VGND sky130_ef_sc_hd__decap_12
XFILLER_92_1196 VPWR VGND VPWR VGND sky130_ef_sc_hd__decap_12
XFILLER_186_452 VPWR VGND VPWR VGND sky130_ef_sc_hd__decap_12
X_369_ net593 net578 net551 VGND VGND VPWR VPWR _158_ sky130_fd_sc_hd__nand3_1
XTAP_TAPCELL_ROW_154_2_5890 VGND VPWR sky130_fd_sc_hd__tapvpwrvgnd_1
XFILLER_201_283 VPWR VGND VPWR VGND sky130_ef_sc_hd__decap_12
XFILLER_174_636 VPWR VGND VPWR VGND sky130_ef_sc_hd__decap_12
XFILLER_228_15 VGND VGND VPWR VPWR sky130_fd_sc_hd__decap_6
XFILLER_179_1327 VGND VGND VPWR VPWR sky130_fd_sc_hd__decap_6
XFILLER_31_1445 VPWR VGND VPWR VGND sky130_ef_sc_hd__decap_12
XFILLER_220_1152 VPWR VGND VPWR VGND sky130_ef_sc_hd__decap_12
XPHY_EDGE_ROW_231_Right_76 VGND VGND VPWR VPWR sky130_fd_sc_hd__decap_3
XFILLER_54_3 VPWR VGND VPWR VGND sky130_ef_sc_hd__decap_12
XFILLER_6_882 VPWR VGND VPWR VGND sky130_ef_sc_hd__decap_12
XFILLER_170_820 VPWR VGND VPWR VGND sky130_ef_sc_hd__decap_12
XFILLER_182_691 VPWR VGND VPWR VGND sky130_ef_sc_hd__decap_12
XPHY_EDGE_ROW_28_1_Right_684 VGND VGND VPWR VPWR sky130_fd_sc_hd__decap_3
XFILLER_170_875 VGND VGND VPWR VPWR sky130_fd_sc_hd__decap_6
XTAP_TAPCELL_ROW_146_2_5827 VGND VPWR sky130_fd_sc_hd__tapvpwrvgnd_1
XFILLER_244_58 VGND VGND VPWR VPWR sky130_fd_sc_hd__decap_6
XFILLER_155_1371 VGND VGND VPWR VPWR sky130_fd_sc_hd__decap_6
XTAP_TAPCELL_ROW_242_4240 VGND VPWR sky130_fd_sc_hd__tapvpwrvgnd_1
XFILLER_190_1262 VGND VGND VPWR VPWR sky130_fd_sc_hd__decap_6
XFILLER_229_615 VPWR VGND VPWR VGND sky130_ef_sc_hd__decap_12
XTAP_TAPCELL_ROW_115_2_5585 VGND VPWR sky130_fd_sc_hd__tapvpwrvgnd_1
XFILLER_25_1249 VPWR VGND VPWR VGND sky130_ef_sc_hd__decap_12
XFILLER_112_1208 VPWR VGND VPWR VGND sky130_ef_sc_hd__decap_12
XFILLER_99_1328 VGND VGND VPWR VPWR sky130_fd_sc_hd__decap_6
XFILLER_116_1399 VPWR VGND VPWR VGND sky130_ef_sc_hd__decap_12
XFILLER_237_670 VPWR VGND VPWR VGND sky130_ef_sc_hd__decap_12
XPHY_EDGE_ROW_240_Right_85 VGND VGND VPWR VPWR sky130_fd_sc_hd__decap_3
XFILLER_3_1045 VPWR VGND VPWR VGND sky130_ef_sc_hd__decap_12
XTAP_TAPCELL_ROW_207_2991 VGND VPWR sky130_fd_sc_hd__tapvpwrvgnd_1
XTAP_TAPCELL_ROW_203_2844 VGND VPWR sky130_fd_sc_hd__tapvpwrvgnd_1
XFILLER_184_1011 VPWR VGND VPWR VGND sky130_ef_sc_hd__decap_12
XTAP_TAPCELL_ROW_203_2855 VGND VPWR sky130_fd_sc_hd__tapvpwrvgnd_1
XFILLER_225_854 VGND VGND VPWR VPWR sky130_fd_sc_hd__decap_6
XTAP_TAPCELL_ROW_236_4000 VGND VPWR sky130_fd_sc_hd__tapvpwrvgnd_1
XTAP_TAPCELL_ROW_203_2866 VGND VPWR sky130_fd_sc_hd__tapvpwrvgnd_1
XTAP_TAPCELL_ROW_236_4011 VGND VPWR sky130_fd_sc_hd__tapvpwrvgnd_1
XTAP_TAPCELL_ROW_203_2877 VGND VPWR sky130_fd_sc_hd__tapvpwrvgnd_1
XTAP_TAPCELL_ROW_236_4022 VGND VPWR sky130_fd_sc_hd__tapvpwrvgnd_1
Xwire78 _253_ VGND VGND VPWR VPWR net78 sky130_fd_sc_hd__clkbuf_1
XTAP_TAPCELL_ROW_236_4033 VGND VPWR sky130_fd_sc_hd__tapvpwrvgnd_1
XTAP_TAPCELL_ROW_255_4667 VGND VPWR sky130_fd_sc_hd__tapvpwrvgnd_1
XFILLER_184_1066 VPWR VGND VPWR VGND sky130_ef_sc_hd__decap_12
XTAP_TAPCELL_ROW_255_4678 VGND VPWR sky130_fd_sc_hd__tapvpwrvgnd_1
XTAP_TAPCELL_ROW_255_4689 VGND VPWR sky130_fd_sc_hd__tapvpwrvgnd_1
XTAP_TAPCELL_ROW_44_2_5014 VGND VPWR sky130_fd_sc_hd__tapvpwrvgnd_1
XFILLER_196_249 VPWR VGND VPWR VGND sky130_ef_sc_hd__decap_12
XFILLER_36_1356 VPWR VGND VPWR VGND sky130_ef_sc_hd__decap_12
XFILLER_123_1304 VPWR VGND VPWR VGND sky130_ef_sc_hd__decap_12
XFILLER_22_15 VGND VGND VPWR VPWR sky130_fd_sc_hd__decap_6
XFILLER_177_474 VPWR VGND VPWR VGND sky130_ef_sc_hd__decap_12
XFILLER_220_581 VPWR VGND VPWR VGND sky130_ef_sc_hd__decap_12
XFILLER_123_1359 VPWR VGND VPWR VGND sky130_ef_sc_hd__decap_12
XFILLER_138_15 VGND VGND VPWR VPWR sky130_fd_sc_hd__decap_6
XFILLER_192_433 VPWR VGND VPWR VGND sky130_ef_sc_hd__decap_12
XFILLER_4_808 VGND VGND VPWR VPWR sky130_fd_sc_hd__fill_1
XFILLER_180_617 VGND VGND VPWR VPWR sky130_fd_sc_hd__decap_6
XFILLER_192_488 VGND VGND VPWR VPWR sky130_fd_sc_hd__decap_6
XFILLER_3_318 VGND VGND VPWR VPWR sky130_fd_sc_hd__fill_1
XFILLER_69_1165 VPWR VGND VPWR VGND sky130_ef_sc_hd__decap_12
XFILLER_195_1162 VPWR VGND VPWR VGND sky130_ef_sc_hd__decap_12
XFILLER_191_1026 VGND VGND VPWR VPWR sky130_fd_sc_hd__decap_6
XFILLER_134_1411 VPWR VGND VPWR VGND sky130_ef_sc_hd__decap_12
XFILLER_154_58 VGND VGND VPWR VPWR sky130_fd_sc_hd__decap_6
XFILLER_43_1316 VPWR VGND VPWR VGND sky130_ef_sc_hd__decap_12
XFILLER_232_1023 VPWR VGND VPWR VGND sky130_ef_sc_hd__decap_12
XFILLER_247_412 VPWR VGND VPWR VGND sky130_ef_sc_hd__decap_12
XFILLER_134_1466 VPWR VGND VPWR VGND sky130_ef_sc_hd__decap_12
XFILLER_248_968 VPWR VGND VPWR VGND sky130_ef_sc_hd__decap_12
XFILLER_232_1078 VPWR VGND VPWR VGND sky130_ef_sc_hd__decap_12
XFILLER_247_467 VGND VGND VPWR VPWR sky130_fd_sc_hd__decap_6
XFILLER_170_46 VPWR VGND VPWR VGND sky130_ef_sc_hd__decap_12
XFILLER_216_832 VGND VGND VPWR VPWR sky130_fd_sc_hd__decap_6
XFILLER_210_1398 VPWR VGND VPWR VGND sky130_ef_sc_hd__decap_12
XFILLER_63_44 VPWR VGND VPWR VGND sky130_ef_sc_hd__decap_12
XPHY_EDGE_ROW_129_2_Right_220 VGND VGND VPWR VPWR sky130_fd_sc_hd__decap_3
XFILLER_187_216 VPWR VGND VPWR VGND sky130_ef_sc_hd__decap_12
XFILLER_230_323 VPWR VGND VPWR VGND sky130_ef_sc_hd__decap_12
XFILLER_242_194 VPWR VGND VPWR VGND sky130_ef_sc_hd__decap_12
XFILLER_179_44 VPWR VGND VPWR VGND sky130_ef_sc_hd__decap_12
XFILLER_54_1423 VPWR VGND VPWR VGND sky130_ef_sc_hd__decap_12
XFILLER_208_1250 VPWR VGND VPWR VGND sky130_ef_sc_hd__decap_12
XTAP_TAPCELL_ROW_139_2_5770 VGND VPWR sky130_fd_sc_hd__tapvpwrvgnd_1
XFILLER_180_1453 VPWR VGND VPWR VGND sky130_ef_sc_hd__decap_12
XFILLER_230_378 VPWR VGND VPWR VGND sky130_ef_sc_hd__decap_12
XFILLER_243_1174 VPWR VGND VPWR VGND sky130_ef_sc_hd__decap_12
XFILLER_168_452 VPWR VGND VPWR VGND sky130_ef_sc_hd__decap_12
XFILLER_179_99 VPWR VGND VPWR VGND sky130_ef_sc_hd__decap_12
XFILLER_54_1478 VGND VGND VPWR VPWR sky130_fd_sc_hd__decap_6
Xwire500 _118_ VGND VGND VPWR VPWR net500 sky130_fd_sc_hd__clkbuf_1
XFILLER_183_400 VPWR VGND VPWR VGND sky130_ef_sc_hd__decap_12
XFILLER_195_271 VPWR VGND VPWR VGND sky130_ef_sc_hd__decap_12
XFILLER_6_101 VGND VGND VPWR VPWR sky130_fd_sc_hd__decap_6
XFILLER_7_646 VGND VGND VPWR VPWR sky130_fd_sc_hd__decap_3
Xwire555 net71 VGND VGND VPWR VPWR net555 sky130_fd_sc_hd__buf_1
XFILLER_183_455 VPWR VGND VPWR VGND sky130_ef_sc_hd__decap_12
XFILLER_104_1270 VPWR VGND VPWR VGND sky130_ef_sc_hd__decap_12
Xwire577 dout0_q\[10\] VGND VGND VPWR VPWR net577 sky130_fd_sc_hd__clkbuf_1
Xwire588 dout0_q\[2\] VGND VGND VPWR VPWR net588 sky130_fd_sc_hd__clkbuf_1
XFILLER_6_167 VGND VGND VPWR VPWR sky130_fd_sc_hd__fill_1
Xwire599 net600 VGND VGND VPWR VPWR net599 sky130_fd_sc_hd__clkbuf_1
XTAP_TAPCELL_ROW_172_1763 VGND VPWR sky130_fd_sc_hd__tapvpwrvgnd_1
XFILLER_171_639 VGND VGND VPWR VPWR sky130_fd_sc_hd__decap_6
XTAP_TAPCELL_ROW_172_1774 VGND VPWR sky130_fd_sc_hd__tapvpwrvgnd_1
XFILLER_195_87 VPWR VGND VPWR VGND sky130_ef_sc_hd__decap_12
XTAP_TAPCELL_ROW_213_3195 VGND VPWR sky130_fd_sc_hd__tapvpwrvgnd_1
XTAP_TAPCELL_ROW_88_2_5367 VGND VPWR sky130_fd_sc_hd__tapvpwrvgnd_1
XTAP_TAPCELL_ROW_172_1785 VGND VPWR sky130_fd_sc_hd__tapvpwrvgnd_1
XFILLER_48_1227 VPWR VGND VPWR VGND sky130_ef_sc_hd__decap_12
XFILLER_3_830 VGND VGND VPWR VPWR sky130_fd_sc_hd__decap_6
XFILLER_3_852 VGND VGND VPWR VPWR sky130_fd_sc_hd__fill_2
XTAP_TAPCELL_ROW_101_2_5471 VGND VPWR sky130_fd_sc_hd__tapvpwrvgnd_1
XFILLER_254_1281 VPWR VGND VPWR VGND sky130_ef_sc_hd__decap_12
XFILLER_238_445 VGND VGND VPWR VPWR sky130_fd_sc_hd__decap_6
XTAP_TAPCELL_ROW_166_1556 VGND VPWR sky130_fd_sc_hd__tapvpwrvgnd_1
XTAP_TAPCELL_ROW_35_2_4940 VGND VPWR sky130_fd_sc_hd__tapvpwrvgnd_1
XPHY_EDGE_ROW_91_2_Right_182 VGND VGND VPWR VPWR sky130_fd_sc_hd__decap_3
XTAP_TAPCELL_ROW_166_1567 VGND VPWR sky130_fd_sc_hd__tapvpwrvgnd_1
XTAP_TAPCELL_ROW_166_1578 VGND VPWR sky130_fd_sc_hd__tapvpwrvgnd_1
XFILLER_254_949 VPWR VGND VPWR VGND sky130_ef_sc_hd__decap_12
XFILLER_24_1282 VPWR VGND VPWR VGND sky130_ef_sc_hd__decap_12
XFILLER_111_1230 VPWR VGND VPWR VGND sky130_ef_sc_hd__decap_12
XFILLER_219_670 VPWR VGND VPWR VGND sky130_ef_sc_hd__decap_12
XFILLER_247_990 VPWR VGND VPWR VGND sky130_ef_sc_hd__decap_12
XFILLER_207_854 VGND VGND VPWR VPWR sky130_fd_sc_hd__decap_6
XFILLER_4_1398 VPWR VGND VPWR VGND sky130_ef_sc_hd__decap_12
XFILLER_111_1285 VGND VGND VPWR VPWR sky130_fd_sc_hd__decap_6
XFILLER_209_1014 VPWR VGND VPWR VGND sky130_ef_sc_hd__decap_12
XFILLER_59_1378 VPWR VGND VPWR VGND sky130_ef_sc_hd__decap_12
XFILLER_146_1337 VPWR VGND VPWR VGND sky130_ef_sc_hd__decap_12
XFILLER_181_1217 VPWR VGND VPWR VGND sky130_ef_sc_hd__decap_12
XFILLER_209_1069 VGND VGND VPWR VPWR sky130_fd_sc_hd__decap_6
XFILLER_221_345 VPWR VGND VPWR VGND sky130_ef_sc_hd__decap_12
XFILLER_178_249 VPWR VGND VPWR VGND sky130_ef_sc_hd__decap_12
XTAP_TAPCELL_ROW_250_4520 VGND VPWR sky130_fd_sc_hd__tapvpwrvgnd_1
XTAP_TAPCELL_ROW_48_1_1302 VGND VPWR sky130_fd_sc_hd__tapvpwrvgnd_1
XFILLER_33_1507 VGND VGND VPWR VPWR sky130_fd_sc_hd__decap_8
XFILLER_202_581 VPWR VGND VPWR VGND sky130_ef_sc_hd__decap_12
XFILLER_222_1269 VPWR VGND VPWR VGND sky130_ef_sc_hd__decap_12
XFILLER_174_433 VPWR VGND VPWR VGND sky130_ef_sc_hd__decap_12
XFILLER_31_1242 VGND VGND VPWR VPWR sky130_fd_sc_hd__decap_6
XFILLER_174_488 VGND VGND VPWR VPWR sky130_fd_sc_hd__decap_6
XFILLER_190_937 VPWR VGND VPWR VGND sky130_ef_sc_hd__decap_12
XFILLER_122_1392 VGND VGND VPWR VPWR sky130_fd_sc_hd__decap_6
XFILLER_157_1433 VPWR VGND VPWR VGND sky130_ef_sc_hd__decap_12
XTAP_TAPCELL_ROW_244_4302 VGND VPWR sky130_fd_sc_hd__tapvpwrvgnd_1
XFILLER_192_1324 VPWR VGND VPWR VGND sky130_ef_sc_hd__decap_12
XTAP_TAPCELL_ROW_244_4313 VGND VPWR sky130_fd_sc_hd__tapvpwrvgnd_1
XFILLER_66_1349 VGND VGND VPWR VPWR sky130_fd_sc_hd__decap_6
XPHY_EDGE_ROW_219_Left_474 VGND VGND VPWR VPWR sky130_fd_sc_hd__decap_3
XPHY_EDGE_ROW_29_1_Right_685 VGND VGND VPWR VPWR sky130_fd_sc_hd__decap_3
XFILLER_9_1210 VGND VGND VPWR VPWR sky130_fd_sc_hd__decap_8
XFILLER_157_1488 VPWR VGND VPWR VGND sky130_ef_sc_hd__decap_12
XFILLER_192_1379 VPWR VGND VPWR VGND sky130_ef_sc_hd__decap_12
XFILLER_229_412 VPWR VGND VPWR VGND sky130_ef_sc_hd__decap_12
XTAP_TAPCELL_ROW_6_1102 VGND VPWR sky130_fd_sc_hd__tapvpwrvgnd_1
XFILLER_245_916 VPWR VGND VPWR VGND sky130_ef_sc_hd__decap_12
XTAP_TAPCELL_ROW_205_2917 VGND VPWR sky130_fd_sc_hd__tapvpwrvgnd_1
XFILLER_229_467 VGND VGND VPWR VPWR sky130_fd_sc_hd__decap_6
XFILLER_116_1196 VPWR VGND VPWR VGND sky130_ef_sc_hd__decap_12
XTAP_TAPCELL_ROW_205_2928 VGND VPWR sky130_fd_sc_hd__tapvpwrvgnd_1
XTAP_TAPCELL_ROW_205_2939 VGND VPWR sky130_fd_sc_hd__tapvpwrvgnd_1
XFILLER_17_15 VPWR VGND VPWR VGND sky130_ef_sc_hd__decap_12
XTAP_TAPCELL_ROW_0_822 VGND VPWR sky130_fd_sc_hd__tapvpwrvgnd_1
XTAP_TAPCELL_ROW_0_833 VGND VPWR sky130_fd_sc_hd__tapvpwrvgnd_1
XTAP_TAPCELL_ROW_0_844 VGND VPWR sky130_fd_sc_hd__tapvpwrvgnd_1
XFILLER_253_971 VPWR VGND VPWR VGND sky130_ef_sc_hd__decap_12
XFILLER_77_1445 VPWR VGND VPWR VGND sky130_ef_sc_hd__decap_12
XTAP_TAPCELL_ROW_0_855 VGND VPWR sky130_fd_sc_hd__tapvpwrvgnd_1
XTAP_TAPCELL_ROW_0_866 VGND VPWR sky130_fd_sc_hd__tapvpwrvgnd_1
XPHY_EDGE_ROW_228_Left_483 VGND VGND VPWR VPWR sky130_fd_sc_hd__decap_3
XTAP_TAPCELL_ROW_0_877 VGND VPWR sky130_fd_sc_hd__tapvpwrvgnd_1
XTAP_TAPCELL_ROW_0_888 VGND VPWR sky130_fd_sc_hd__tapvpwrvgnd_1
XFILLER_212_323 VPWR VGND VPWR VGND sky130_ef_sc_hd__decap_12
XFILLER_169_216 VPWR VGND VPWR VGND sky130_ef_sc_hd__decap_12
XFILLER_224_194 VPWR VGND VPWR VGND sky130_ef_sc_hd__decap_12
XFILLER_205_1401 VPWR VGND VPWR VGND sky130_ef_sc_hd__decap_12
XTAP_TAPCELL_ROW_83_1_1354 VGND VPWR sky130_fd_sc_hd__tapvpwrvgnd_1
XFILLER_200_507 VPWR VGND VPWR VGND sky130_ef_sc_hd__decap_12
XFILLER_212_378 VPWR VGND VPWR VGND sky130_ef_sc_hd__decap_12
XFILLER_240_1336 VPWR VGND VPWR VGND sky130_ef_sc_hd__decap_12
XFILLER_127_1292 VPWR VGND VPWR VGND sky130_ef_sc_hd__decap_12
XFILLER_165_400 VPWR VGND VPWR VGND sky130_ef_sc_hd__decap_12
XFILLER_205_1456 VGND VGND VPWR VPWR sky130_fd_sc_hd__decap_6
XFILLER_177_271 VPWR VGND VPWR VGND sky130_ef_sc_hd__decap_12
XTAP_TAPCELL_ROW_74_2_5253 VGND VPWR sky130_fd_sc_hd__tapvpwrvgnd_1
XFILLER_165_433 VGND VGND VPWR VPWR sky130_fd_sc_hd__decap_8
XFILLER_192_230 VGND VGND VPWR VPWR sky130_fd_sc_hd__decap_6
XFILLER_181_904 VPWR VGND VPWR VGND sky130_ef_sc_hd__decap_12
XFILLER_123_1189 VPWR VGND VPWR VGND sky130_ef_sc_hd__decap_12
XFILLER_193_775 VPWR VGND VPWR VGND sky130_ef_sc_hd__decap_12
XFILLER_101_1421 VPWR VGND VPWR VGND sky130_ef_sc_hd__decap_12
XFILLER_229_80 VGND VGND VPWR VPWR sky130_fd_sc_hd__decap_6
XFILLER_158_1208 VPWR VGND VPWR VGND sky130_ef_sc_hd__decap_12
XFILLER_10_1337 VPWR VGND VPWR VGND sky130_ef_sc_hd__decap_12
XFILLER_181_959 VPWR VGND VPWR VGND sky130_ef_sc_hd__decap_12
XPHY_EDGE_ROW_237_Left_492 VGND VGND VPWR VPWR sky130_fd_sc_hd__decap_3
XFILLER_4_649 VGND VGND VPWR VPWR sky130_fd_sc_hd__fill_2
XFILLER_101_1476 VPWR VGND VPWR VGND sky130_ef_sc_hd__decap_12
XFILLER_58_22 VPWR VGND VPWR VGND sky130_ef_sc_hd__decap_12
XFILLER_239_209 VGND VGND VPWR VPWR sky130_fd_sc_hd__decap_6
XPHY_EDGE_ROW_21_2_Left_523 VGND VGND VPWR VPWR sky130_fd_sc_hd__decap_3
XFILLER_251_1432 VPWR VGND VPWR VGND sky130_ef_sc_hd__decap_12
XFILLER_248_710 VPWR VGND VPWR VGND sky130_ef_sc_hd__decap_12
XFILLER_82_1184 VPWR VGND VPWR VGND sky130_ef_sc_hd__decap_12
XFILLER_134_1263 VGND VGND VPWR VPWR sky130_fd_sc_hd__decap_6
XFILLER_181_56 VPWR VGND VPWR VGND sky130_ef_sc_hd__decap_12
XFILLER_251_1487 VPWR VGND VPWR VGND sky130_ef_sc_hd__decap_12
XFILLER_248_765 VPWR VGND VPWR VGND sky130_ef_sc_hd__decap_12
XFILLER_169_1315 VPWR VGND VPWR VGND sky130_ef_sc_hd__decap_12
XFILLER_229_990 VPWR VGND VPWR VGND sky130_ef_sc_hd__decap_12
XFILLER_236_949 VPWR VGND VPWR VGND sky130_ef_sc_hd__decap_12
XFILLER_21_1433 VPWR VGND VPWR VGND sky130_ef_sc_hd__decap_12
XFILLER_210_1140 VPWR VGND VPWR VGND sky130_ef_sc_hd__decap_12
XTAP_TAPCELL_ROW_221_3475 VGND VPWR sky130_fd_sc_hd__tapvpwrvgnd_1
XFILLER_74_65 VGND VGND VPWR VPWR sky130_fd_sc_hd__decap_6
XTAP_TAPCELL_ROW_221_3486 VGND VPWR sky130_fd_sc_hd__tapvpwrvgnd_1
XFILLER_21_1488 VPWR VGND VPWR VGND sky130_ef_sc_hd__decap_12
XFILLER_210_1195 VPWR VGND VPWR VGND sky130_ef_sc_hd__decap_12
XTAP_TAPCELL_ROW_221_3497 VGND VPWR sky130_fd_sc_hd__tapvpwrvgnd_1
XFILLER_230_120 VPWR VGND VPWR VGND sky130_ef_sc_hd__decap_12
XFILLER_203_345 VPWR VGND VPWR VGND sky130_ef_sc_hd__decap_12
XFILLER_54_1220 VGND VGND VPWR VPWR sky130_fd_sc_hd__decap_6
XFILLER_141_1201 VGND VGND VPWR VPWR sky130_fd_sc_hd__decap_4
XFILLER_180_1250 VPWR VGND VPWR VGND sky130_ef_sc_hd__decap_12
XFILLER_230_175 VPWR VGND VPWR VGND sky130_ef_sc_hd__decap_12
XTAP_TAPCELL_ROW_178_1972 VGND VPWR sky130_fd_sc_hd__tapvpwrvgnd_1
XTAP_TAPCELL_ROW_178_1983 VGND VPWR sky130_fd_sc_hd__tapvpwrvgnd_1
XTAP_TAPCELL_ROW_178_1994 VGND VPWR sky130_fd_sc_hd__tapvpwrvgnd_1
XTAP_TAPCELL_ROW_174_1836 VGND VPWR sky130_fd_sc_hd__tapvpwrvgnd_1
XTAP_TAPCELL_ROW_174_1847 VGND VPWR sky130_fd_sc_hd__tapvpwrvgnd_1
XTAP_TAPCELL_ROW_215_3268 VGND VPWR sky130_fd_sc_hd__tapvpwrvgnd_1
XFILLER_89_1316 VPWR VGND VPWR VGND sky130_ef_sc_hd__decap_12
XFILLER_184_753 VPWR VGND VPWR VGND sky130_ef_sc_hd__decap_12
XTAP_TAPCELL_ROW_215_3279 VGND VPWR sky130_fd_sc_hd__tapvpwrvgnd_1
Xwire341 net342 VGND VGND VPWR VPWR net341 sky130_fd_sc_hd__clkbuf_1
XTAP_TAPCELL_ROW_174_1858 VGND VPWR sky130_fd_sc_hd__tapvpwrvgnd_1
Xwire352 net353 VGND VGND VPWR VPWR net352 sky130_fd_sc_hd__clkbuf_1
Xwire363 net364 VGND VGND VPWR VPWR net363 sky130_fd_sc_hd__clkbuf_1
XFILLER_183_252 VGND VGND VPWR VPWR sky130_fd_sc_hd__decap_6
XFILLER_209_39 VGND VGND VPWR VPWR sky130_fd_sc_hd__decap_4
Xwire374 net375 VGND VGND VPWR VPWR net374 sky130_fd_sc_hd__clkbuf_1
Xmax_cap107 net108 VGND VGND VPWR VPWR net107 sky130_fd_sc_hd__clkbuf_1
XFILLER_172_937 VPWR VGND VPWR VGND sky130_ef_sc_hd__decap_12
XFILLER_221_1291 VPWR VGND VPWR VGND sky130_ef_sc_hd__decap_12
Xwire385 net386 VGND VGND VPWR VPWR net385 sky130_fd_sc_hd__clkbuf_1
Xmax_cap118 _224_ VGND VGND VPWR VPWR net118 sky130_fd_sc_hd__clkbuf_1
Xwire396 net397 VGND VGND VPWR VPWR net396 sky130_fd_sc_hd__clkbuf_1
Xmax_cap129 _219_ VGND VGND VPWR VPWR net129 sky130_fd_sc_hd__clkbuf_1
XFILLER_252_1207 VPWR VGND VPWR VGND sky130_ef_sc_hd__decap_12
XFILLER_217_1327 VGND VGND VPWR VPWR sky130_fd_sc_hd__decap_6
XFILLER_174_1054 VPWR VGND VPWR VGND sky130_ef_sc_hd__decap_12
XFILLER_180_992 VPWR VGND VPWR VGND sky130_ef_sc_hd__decap_12
XFILLER_225_27 VPWR VGND VPWR VGND sky130_ef_sc_hd__decap_12
XTAP_TAPCELL_ROW_168_1629 VGND VPWR sky130_fd_sc_hd__tapvpwrvgnd_1
XFILLER_65_1371 VGND VGND VPWR VPWR sky130_fd_sc_hd__decap_6
XPHY_EDGE_ROW_78_2_Left_580 VGND VGND VPWR VPWR sky130_fd_sc_hd__decap_3
XFILLER_239_732 VPWR VGND VPWR VGND sky130_ef_sc_hd__decap_12
XFILLER_22_1208 VPWR VGND VPWR VGND sky130_ef_sc_hd__decap_12
XFILLER_227_916 VPWR VGND VPWR VGND sky130_ef_sc_hd__decap_12
XFILLER_241_15 VPWR VGND VPWR VGND sky130_ef_sc_hd__decap_12
XFILLER_239_787 VPWR VGND VPWR VGND sky130_ef_sc_hd__decap_12
XFILLER_26_1399 VPWR VGND VPWR VGND sky130_ef_sc_hd__decap_12
XFILLER_17_3 VPWR VGND VPWR VGND sky130_ef_sc_hd__decap_12
XFILLER_113_1347 VPWR VGND VPWR VGND sky130_ef_sc_hd__decap_12
XFILLER_254_746 VGND VGND VPWR VPWR sky130_fd_sc_hd__decap_6
XFILLER_4_1140 VPWR VGND VPWR VGND sky130_ef_sc_hd__decap_12
XPHY_EDGE_ROW_92_2_Right_183 VGND VGND VPWR VPWR sky130_fd_sc_hd__decap_3
XFILLER_4_1195 VPWR VGND VPWR VGND sky130_ef_sc_hd__decap_12
XFILLER_235_971 VPWR VGND VPWR VGND sky130_ef_sc_hd__decap_12
XFILLER_228_1434 VGND VGND VPWR VPWR sky130_fd_sc_hd__decap_6
XFILLER_181_1014 VPWR VGND VPWR VGND sky130_ef_sc_hd__decap_12
XFILLER_206_194 VPWR VGND VPWR VGND sky130_ef_sc_hd__decap_12
XTAP_TAPCELL_ROW_123_2_5647 VGND VPWR sky130_fd_sc_hd__tapvpwrvgnd_1
XFILLER_221_142 VPWR VGND VPWR VGND sky130_ef_sc_hd__decap_12
XFILLER_181_1069 VGND VGND VPWR VPWR sky130_fd_sc_hd__decap_6
XTAP_TAPCELL_ROW_59_2_5133 VGND VPWR sky130_fd_sc_hd__tapvpwrvgnd_1
XFILLER_33_1304 VPWR VGND VPWR VGND sky130_ef_sc_hd__decap_12
XFILLER_222_1011 VPWR VGND VPWR VGND sky130_ef_sc_hd__decap_12
XFILLER_221_197 VPWR VGND VPWR VGND sky130_ef_sc_hd__decap_12
XFILLER_124_1454 VPWR VGND VPWR VGND sky130_ef_sc_hd__decap_12
XFILLER_33_1359 VPWR VGND VPWR VGND sky130_ef_sc_hd__decap_12
XFILLER_222_1066 VPWR VGND VPWR VGND sky130_ef_sc_hd__decap_12
XFILLER_174_230 VGND VGND VPWR VPWR sky130_fd_sc_hd__decap_6
XFILLER_119_39 VGND VGND VPWR VPWR sky130_fd_sc_hd__decap_4
XFILLER_175_775 VPWR VGND VPWR VGND sky130_ef_sc_hd__decap_12
XTAP_TAPCELL_ROW_190_2394 VGND VPWR sky130_fd_sc_hd__tapvpwrvgnd_1
XFILLER_190_734 VPWR VGND VPWR VGND sky130_ef_sc_hd__decap_12
XFILLER_157_1230 VPWR VGND VPWR VGND sky130_ef_sc_hd__decap_12
XFILLER_192_1121 VPWR VGND VPWR VGND sky130_ef_sc_hd__decap_12
XFILLER_190_789 VGND VGND VPWR VPWR sky130_fd_sc_hd__decap_6
XFILLER_135_27 VPWR VGND VPWR VGND sky130_ef_sc_hd__decap_12
XFILLER_0_118 VGND VGND VPWR VPWR sky130_fd_sc_hd__decap_8
XFILLER_157_1285 VGND VGND VPWR VPWR sky130_fd_sc_hd__decap_6
XFILLER_192_1176 VGND VGND VPWR VPWR sky130_fd_sc_hd__decap_6
XFILLER_249_529 VPWR VGND VPWR VGND sky130_ef_sc_hd__decap_12
XFILLER_44_1411 VPWR VGND VPWR VGND sky130_ef_sc_hd__decap_12
XFILLER_9_1051 VPWR VGND VPWR VGND sky130_ef_sc_hd__decap_12
XFILLER_170_1441 VPWR VGND VPWR VGND sky130_ef_sc_hd__decap_12
XFILLER_233_1162 VPWR VGND VPWR VGND sky130_ef_sc_hd__decap_12
XFILLER_44_1466 VPWR VGND VPWR VGND sky130_ef_sc_hd__decap_12
XFILLER_131_1414 VGND VGND VPWR VPWR sky130_fd_sc_hd__decap_6
XFILLER_9_1084 VGND VGND VPWR VPWR sky130_fd_sc_hd__decap_8
XTAP_TAPCELL_ROW_184_2187 VGND VPWR sky130_fd_sc_hd__tapvpwrvgnd_1
XFILLER_245_713 VPWR VGND VPWR VGND sky130_ef_sc_hd__decap_12
XFILLER_151_15 VPWR VGND VPWR VGND sky130_ef_sc_hd__decap_12
XTAP_TAPCELL_ROW_184_2198 VGND VPWR sky130_fd_sc_hd__tapvpwrvgnd_1
XFILLER_79_1507 VGND VGND VPWR VPWR sky130_fd_sc_hd__decap_8
XFILLER_170_1496 VPWR VGND VPWR VGND sky130_ef_sc_hd__decap_12
XFILLER_218_949 VPWR VGND VPWR VGND sky130_ef_sc_hd__decap_12
XFILLER_245_768 VGND VGND VPWR VPWR sky130_fd_sc_hd__decap_6
XPHY_EDGE_ROW_163_1_Left_418 VGND VGND VPWR VPWR sky130_fd_sc_hd__decap_3
XFILLER_77_1242 VGND VGND VPWR VPWR sky130_fd_sc_hd__decap_6
XFILLER_44_46 VGND VGND VPWR VPWR sky130_fd_sc_hd__decap_6
XFILLER_212_120 VPWR VGND VPWR VGND sky130_ef_sc_hd__decap_12
XFILLER_125_1218 VPWR VGND VPWR VGND sky130_ef_sc_hd__decap_12
XFILLER_200_304 VPWR VGND VPWR VGND sky130_ef_sc_hd__decap_12
XFILLER_90_1442 VPWR VGND VPWR VGND sky130_ef_sc_hd__decap_12
XFILLER_185_517 VPWR VGND VPWR VGND sky130_ef_sc_hd__decap_12
XFILLER_212_175 VPWR VGND VPWR VGND sky130_ef_sc_hd__decap_12
XFILLER_197_388 VPWR VGND VPWR VGND sky130_ef_sc_hd__decap_12
XFILLER_240_495 VPWR VGND VPWR VGND sky130_ef_sc_hd__decap_12
XFILLER_240_1133 VGND VGND VPWR VPWR sky130_fd_sc_hd__decap_6
XFILLER_60_34 VPWR VGND VPWR VGND sky130_ef_sc_hd__decap_12
XFILLER_200_359 VGND VGND VPWR VPWR sky130_fd_sc_hd__decap_6
XFILLER_90_1497 VPWR VGND VPWR VGND sky130_ef_sc_hd__decap_12
XFILLER_166_753 VPWR VGND VPWR VGND sky130_ef_sc_hd__decap_12
XFILLER_121_3 VPWR VGND VPWR VGND sky130_ef_sc_hd__decap_12
XPHY_EDGE_ROW_245_Left_500 VGND VGND VPWR VPWR sky130_fd_sc_hd__decap_3
XFILLER_176_34 VPWR VGND VPWR VGND sky130_ef_sc_hd__decap_12
XFILLER_181_701 VPWR VGND VPWR VGND sky130_ef_sc_hd__decap_12
XFILLER_219_3 VPWR VGND VPWR VGND sky130_ef_sc_hd__decap_12
XFILLER_193_572 VPWR VGND VPWR VGND sky130_ef_sc_hd__decap_12
XFILLER_14_1270 VPWR VGND VPWR VGND sky130_ef_sc_hd__decap_12
XFILLER_165_274 VPWR VGND VPWR VGND sky130_ef_sc_hd__decap_12
XTAP_TAPCELL_ROW_210_3110 VGND VPWR sky130_fd_sc_hd__tapvpwrvgnd_1
XTAP_TAPCELL_ROW_210_3121 VGND VPWR sky130_fd_sc_hd__tapvpwrvgnd_1
XFILLER_5_947 VPWR VGND VPWR VGND sky130_ef_sc_hd__decap_12
XFILLER_5_18 VPWR VGND VPWR VGND sky130_ef_sc_hd__decap_12
XFILLER_176_89 VPWR VGND VPWR VGND sky130_ef_sc_hd__decap_12
XFILLER_181_756 VPWR VGND VPWR VGND sky130_ef_sc_hd__decap_12
XFILLER_197_1076 VPWR VGND VPWR VGND sky130_ef_sc_hd__decap_12
XFILLER_101_1273 VPWR VGND VPWR VGND sky130_ef_sc_hd__decap_12
XFILLER_192_22 VPWR VGND VPWR VGND sky130_ef_sc_hd__decap_12
XFILLER_136_1325 VPWR VGND VPWR VGND sky130_ef_sc_hd__decap_12
XFILLER_171_1205 VPWR VGND VPWR VGND sky130_ef_sc_hd__decap_12
XTAP_TAPCELL_ROW_116_2_5590 VGND VPWR sky130_fd_sc_hd__tapvpwrvgnd_1
XFILLER_192_77 VPWR VGND VPWR VGND sky130_ef_sc_hd__decap_12
XFILLER_0_652 VGND VGND VPWR VPWR sky130_fd_sc_hd__decap_8
XTAP_TAPCELL_ROW_208_3050 VGND VPWR sky130_fd_sc_hd__tapvpwrvgnd_1
XTAP_TAPCELL_ROW_227_3684 VGND VPWR sky130_fd_sc_hd__tapvpwrvgnd_1
XFILLER_0_685 VGND VGND VPWR VPWR sky130_fd_sc_hd__fill_1
XFILLER_251_1284 VGND VGND VPWR VPWR sky130_fd_sc_hd__decap_6
XFILLER_248_562 VPWR VGND VPWR VGND sky130_ef_sc_hd__decap_12
XFILLER_209_916 VPWR VGND VPWR VGND sky130_ef_sc_hd__decap_12
XTAP_TAPCELL_ROW_227_3695 VGND VPWR sky130_fd_sc_hd__tapvpwrvgnd_1
XTAP_TAPCELL_ROW_223_3548 VGND VPWR sky130_fd_sc_hd__tapvpwrvgnd_1
XTAP_TAPCELL_ROW_223_3559 VGND VPWR sky130_fd_sc_hd__tapvpwrvgnd_1
XFILLER_110_1509 VGND VGND VPWR VPWR sky130_fd_sc_hd__decap_6
XFILLER_169_1112 VGND VGND VPWR VPWR sky130_fd_sc_hd__decap_6
XFILLER_236_746 VGND VGND VPWR VPWR sky130_fd_sc_hd__decap_6
XFILLER_21_1230 VPWR VGND VPWR VGND sky130_ef_sc_hd__decap_12
XTAP_TAPCELL_ROW_96_2_5429 VGND VPWR sky130_fd_sc_hd__tapvpwrvgnd_1
XFILLER_112_1380 VPWR VGND VPWR VGND sky130_ef_sc_hd__decap_12
XFILLER_217_971 VPWR VGND VPWR VGND sky130_ef_sc_hd__decap_12
XFILLER_21_1285 VGND VGND VPWR VPWR sky130_fd_sc_hd__decap_6
XFILLER_1_1346 VPWR VGND VPWR VGND sky130_ef_sc_hd__decap_12
XFILLER_165_1009 VPWR VGND VPWR VGND sky130_ef_sc_hd__decap_12
XTAP_TAPCELL_ROW_108_2_5527 VGND VPWR sky130_fd_sc_hd__tapvpwrvgnd_1
XFILLER_147_1421 VPWR VGND VPWR VGND sky130_ef_sc_hd__decap_12
XFILLER_250_237 VPWR VGND VPWR VGND sky130_ef_sc_hd__decap_12
XFILLER_182_1312 VPWR VGND VPWR VGND sky130_ef_sc_hd__decap_12
XFILLER_245_1033 VPWR VGND VPWR VGND sky130_ef_sc_hd__decap_12
XFILLER_91_1206 VPWR VGND VPWR VGND sky130_ef_sc_hd__decap_12
XFILLER_56_1337 VPWR VGND VPWR VGND sky130_ef_sc_hd__decap_12
XFILLER_147_1476 VPWR VGND VPWR VGND sky130_ef_sc_hd__decap_12
XFILLER_203_142 VPWR VGND VPWR VGND sky130_ef_sc_hd__decap_12
XTAP_TAPCELL_ROW_176_1909 VGND VPWR sky130_fd_sc_hd__tapvpwrvgnd_1
XFILLER_182_1367 VPWR VGND VPWR VGND sky130_ef_sc_hd__decap_12
XFILLER_245_1088 VPWR VGND VPWR VGND sky130_ef_sc_hd__decap_12
XFILLER_188_366 VPWR VGND VPWR VGND sky130_ef_sc_hd__decap_12
XFILLER_203_197 VPWR VGND VPWR VGND sky130_ef_sc_hd__decap_12
XTAP_TAPCELL_ROW_12_2_4760 VGND VPWR sky130_fd_sc_hd__tapvpwrvgnd_1
XFILLER_106_1184 VPWR VGND VPWR VGND sky130_ef_sc_hd__decap_12
XPHY_EDGE_ROW_172_Right_17 VGND VGND VPWR VPWR sky130_fd_sc_hd__decap_3
XFILLER_184_550 VPWR VGND VPWR VGND sky130_ef_sc_hd__decap_12
XFILLER_200_882 VPWR VGND VPWR VGND sky130_ef_sc_hd__decap_12
XTAP_TAPCELL_ROW_141_1_1441 VGND VPWR sky130_fd_sc_hd__tapvpwrvgnd_1
Xwire171 _132_ VGND VGND VPWR VPWR net171 sky130_fd_sc_hd__clkbuf_1
XFILLER_172_734 VPWR VGND VPWR VGND sky130_ef_sc_hd__decap_12
XFILLER_8_796 VPWR VGND VPWR VGND sky130_ef_sc_hd__decap_12
XFILLER_32_1392 VGND VGND VPWR VPWR sky130_fd_sc_hd__decap_6
XFILLER_236_15 VGND VGND VPWR VPWR sky130_fd_sc_hd__decap_6
XFILLER_7_295 VGND VGND VPWR VPWR sky130_fd_sc_hd__decap_6
XFILLER_67_1433 VPWR VGND VPWR VGND sky130_ef_sc_hd__decap_12
XFILLER_172_789 VGND VGND VPWR VPWR sky130_fd_sc_hd__decap_6
XFILLER_252_1004 VGND VGND VPWR VPWR sky130_fd_sc_hd__decap_6
XFILLER_4_980 VPWR VGND VPWR VGND sky130_ef_sc_hd__decap_12
XFILLER_193_1463 VPWR VGND VPWR VGND sky130_ef_sc_hd__decap_12
XFILLER_67_1488 VPWR VGND VPWR VGND sky130_ef_sc_hd__decap_12
XFILLER_230_1324 VPWR VGND VPWR VGND sky130_ef_sc_hd__decap_12
XFILLER_252_58 VGND VGND VPWR VPWR sky130_fd_sc_hd__decap_6
XPHY_EDGE_ROW_181_Right_26 VGND VGND VPWR VPWR sky130_fd_sc_hd__decap_3
XFILLER_227_713 VPWR VGND VPWR VGND sky130_ef_sc_hd__decap_12
XFILLER_239_584 VPWR VGND VPWR VGND sky130_ef_sc_hd__decap_12
XFILLER_26_1196 VPWR VGND VPWR VGND sky130_ef_sc_hd__decap_12
XTAP_TAPCELL_ROW_2_939 VGND VPWR sky130_fd_sc_hd__tapvpwrvgnd_1
XFILLER_230_1379 VPWR VGND VPWR VGND sky130_ef_sc_hd__decap_12
XFILLER_113_1177 VPWR VGND VPWR VGND sky130_ef_sc_hd__decap_12
XPHY_EDGE_ROW_150_1_Right_806 VGND VGND VPWR VPWR sky130_fd_sc_hd__decap_3
XFILLER_227_768 VGND VGND VPWR VPWR sky130_fd_sc_hd__decap_6
XPHY_EDGE_ROW_93_2_Right_184 VGND VGND VPWR VPWR sky130_fd_sc_hd__decap_3
XFILLER_198_108 VPWR VGND VPWR VGND sky130_ef_sc_hd__decap_12
XFILLER_241_259 VPWR VGND VPWR VGND sky130_ef_sc_hd__decap_12
Xclkbuf_3_5__f_clk clknet_0_clk VGND VGND VPWR VPWR clknet_3_5__leaf_clk sky130_fd_sc_hd__clkbuf_16
XFILLER_210_624 VPWR VGND VPWR VGND sky130_ef_sc_hd__decap_12
XFILLER_241_1420 VPWR VGND VPWR VGND sky130_ef_sc_hd__decap_12
XFILLER_167_517 VPWR VGND VPWR VGND sky130_ef_sc_hd__decap_12
XFILLER_179_388 VPWR VGND VPWR VGND sky130_ef_sc_hd__decap_12
XFILLER_222_495 VPWR VGND VPWR VGND sky130_ef_sc_hd__decap_12
XFILLER_37_1292 VPWR VGND VPWR VGND sky130_ef_sc_hd__decap_12
XPHY_EDGE_ROW_190_Right_35 VGND VGND VPWR VPWR sky130_fd_sc_hd__decap_3
XFILLER_124_1251 VPWR VGND VPWR VGND sky130_ef_sc_hd__decap_12
XTAP_TAPCELL_ROW_192_2467 VGND VPWR sky130_fd_sc_hd__tapvpwrvgnd_1
XFILLER_194_347 VPWR VGND VPWR VGND sky130_ef_sc_hd__decap_12
XFILLER_210_679 VPWR VGND VPWR VGND sky130_ef_sc_hd__decap_12
XFILLER_241_1475 VPWR VGND VPWR VGND sky130_ef_sc_hd__decap_12
XTAP_TAPCELL_ROW_192_2478 VGND VPWR sky130_fd_sc_hd__tapvpwrvgnd_1
XTAP_TAPCELL_ROW_192_2489 VGND VPWR sky130_fd_sc_hd__tapvpwrvgnd_1
XTAP_TAPCELL_ROW_153_2_5886 VGND VPWR sky130_fd_sc_hd__tapvpwrvgnd_1
XFILLER_175_572 VPWR VGND VPWR VGND sky130_ef_sc_hd__decap_12
XFILLER_33_1189 VPWR VGND VPWR VGND sky130_ef_sc_hd__decap_12
XFILLER_30_15 VGND VGND VPWR VPWR sky130_fd_sc_hd__decap_6
XFILLER_11_1421 VPWR VGND VPWR VGND sky130_ef_sc_hd__decap_12
XFILLER_68_1208 VPWR VGND VPWR VGND sky130_ef_sc_hd__decap_12
XTAP_TAPCELL_ROW_89_2_5372 VGND VPWR sky130_fd_sc_hd__tapvpwrvgnd_1
XFILLER_190_531 VGND VGND VPWR VPWR sky130_fd_sc_hd__decap_6
XFILLER_85_1500 VGND VGND VPWR VPWR sky130_fd_sc_hd__decap_6
XFILLER_146_15 VGND VGND VPWR VPWR sky130_fd_sc_hd__decap_6
XFILLER_159_1347 VPWR VGND VPWR VGND sky130_ef_sc_hd__decap_12
XFILLER_194_1238 VPWR VGND VPWR VGND sky130_ef_sc_hd__decap_12
XFILLER_11_1476 VPWR VGND VPWR VGND sky130_ef_sc_hd__decap_12
XFILLER_2_906 VPWR VGND VPWR VGND sky130_ef_sc_hd__decap_12
XFILLER_200_1183 VPWR VGND VPWR VGND sky130_ef_sc_hd__decap_12
XFILLER_172_1514 VGND VGND VPWR VPWR sky130_fd_sc_hd__fill_1
XTAP_TAPCELL_ROW_186_2249 VGND VPWR sky130_fd_sc_hd__tapvpwrvgnd_1
XFILLER_249_326 VPWR VGND VPWR VGND sky130_ef_sc_hd__decap_12
XTAP_TAPCELL_ROW_82_2_5315 VGND VPWR sky130_fd_sc_hd__tapvpwrvgnd_1
XFILLER_44_1263 VGND VGND VPWR VPWR sky130_fd_sc_hd__decap_6
XFILLER_162_58 VGND VGND VPWR VPWR sky130_fd_sc_hd__decap_6
XFILLER_245_510 VGND VGND VPWR VPWR sky130_fd_sc_hd__decap_6
XTAP_TAPCELL_ROW_51_2_5073 VGND VPWR sky130_fd_sc_hd__tapvpwrvgnd_1
XFILLER_79_1304 VPWR VGND VPWR VGND sky130_ef_sc_hd__decap_12
XFILLER_170_1293 VPWR VGND VPWR VGND sky130_ef_sc_hd__decap_12
XTAP_TAPCELL_ROW_71_1_1336 VGND VPWR sky130_fd_sc_hd__tapvpwrvgnd_1
XFILLER_218_746 VGND VGND VPWR VPWR sky130_fd_sc_hd__decap_6
X_540_ net668 VGND VGND VPWR VPWR _022_ sky130_fd_sc_hd__inv_2
XFILLER_79_1359 VPWR VGND VPWR VGND sky130_ef_sc_hd__decap_12
XFILLER_169_3 VPWR VGND VPWR VGND sky130_ef_sc_hd__decap_12
X_471_ _161_ net111 net220 VGND VGND VPWR VPWR _242_ sky130_fd_sc_hd__a21bo_1
XFILLER_232_237 VPWR VGND VPWR VGND sky130_ef_sc_hd__decap_12
XTAP_TAPCELL_ROW_17_2_4797 VGND VPWR sky130_fd_sc_hd__tapvpwrvgnd_1
XFILLER_207_1315 VPWR VGND VPWR VGND sky130_ef_sc_hd__decap_12
XFILLER_197_130 VPWR VGND VPWR VGND sky130_ef_sc_hd__decap_12
XFILLER_71_44 VPWR VGND VPWR VGND sky130_ef_sc_hd__decap_12
XFILLER_9_505 VPWR VGND VPWR VGND sky130_ef_sc_hd__decap_12
XFILLER_200_101 VGND VGND VPWR VPWR sky130_fd_sc_hd__decap_6
XFILLER_51_1201 VGND VGND VPWR VPWR sky130_fd_sc_hd__decap_4
XFILLER_185_314 VPWR VGND VPWR VGND sky130_ef_sc_hd__decap_12
XFILLER_201_646 VPWR VGND VPWR VGND sky130_ef_sc_hd__decap_12
XFILLER_197_185 VPWR VGND VPWR VGND sky130_ef_sc_hd__decap_12
XTAP_TAPCELL_ROW_216_3330 VGND VPWR sky130_fd_sc_hd__tapvpwrvgnd_1
XFILLER_240_292 VPWR VGND VPWR VGND sky130_ef_sc_hd__decap_12
XFILLER_187_44 VPWR VGND VPWR VGND sky130_ef_sc_hd__decap_12
XTAP_TAPCELL_ROW_235_3964 VGND VPWR sky130_fd_sc_hd__tapvpwrvgnd_1
XTAP_TAPCELL_ROW_235_3975 VGND VPWR sky130_fd_sc_hd__tapvpwrvgnd_1
XTAP_TAPCELL_ROW_235_3986 VGND VPWR sky130_fd_sc_hd__tapvpwrvgnd_1
XFILLER_90_1294 VPWR VGND VPWR VGND sky130_ef_sc_hd__decap_12
XTAP_TAPCELL_ROW_231_3828 VGND VPWR sky130_fd_sc_hd__tapvpwrvgnd_1
XFILLER_166_550 VPWR VGND VPWR VGND sky130_ef_sc_hd__decap_12
XFILLER_185_369 VPWR VGND VPWR VGND sky130_ef_sc_hd__decap_12
XTAP_TAPCELL_ROW_235_3997 VGND VPWR sky130_fd_sc_hd__tapvpwrvgnd_1
XTAP_TAPCELL_ROW_231_3839 VGND VPWR sky130_fd_sc_hd__tapvpwrvgnd_1
XFILLER_103_1335 VPWR VGND VPWR VGND sky130_ef_sc_hd__decap_12
XFILLER_187_99 VPWR VGND VPWR VGND sky130_ef_sc_hd__decap_12
XFILLER_5_711 VGND VGND VPWR VPWR sky130_fd_sc_hd__decap_3
XFILLER_181_553 VGND VGND VPWR VPWR sky130_fd_sc_hd__decap_6
XFILLER_218_1422 VPWR VGND VPWR VGND sky130_ef_sc_hd__decap_12
XFILLER_171_1002 VPWR VGND VPWR VGND sky130_ef_sc_hd__decap_12
XFILLER_253_1346 VPWR VGND VPWR VGND sky130_ef_sc_hd__decap_12
XTAP_TAPCELL_ROW_229_3757 VGND VPWR sky130_fd_sc_hd__tapvpwrvgnd_1
XTAP_TAPCELL_ROW_229_3768 VGND VPWR sky130_fd_sc_hd__tapvpwrvgnd_1
XFILLER_218_1477 VGND VGND VPWR VPWR sky130_fd_sc_hd__decap_6
XTAP_TAPCELL_ROW_229_3779 VGND VPWR sky130_fd_sc_hd__tapvpwrvgnd_1
XFILLER_136_1177 VGND VGND VPWR VPWR sky130_fd_sc_hd__decap_6
XFILLER_171_1057 VPWR VGND VPWR VGND sky130_ef_sc_hd__decap_12
XFILLER_1_983 VGND VGND VPWR VPWR sky130_fd_sc_hd__decap_6
XFILLER_255_307 VGND VGND VPWR VPWR sky130_fd_sc_hd__decap_8
XFILLER_209_713 VPWR VGND VPWR VGND sky130_ef_sc_hd__decap_12
XFILLER_114_1442 VPWR VGND VPWR VGND sky130_ef_sc_hd__decap_12
XFILLER_23_1347 VPWR VGND VPWR VGND sky130_ef_sc_hd__decap_12
XFILLER_212_1054 VPWR VGND VPWR VGND sky130_ef_sc_hd__decap_12
XFILLER_110_1306 VGND VGND VPWR VPWR sky130_fd_sc_hd__decap_6
XFILLER_209_768 VGND VGND VPWR VPWR sky130_fd_sc_hd__decap_6
XFILLER_114_1497 VPWR VGND VPWR VGND sky130_ef_sc_hd__decap_12
XFILLER_1_1143 VPWR VGND VPWR VGND sky130_ef_sc_hd__decap_12
XPHY_EDGE_ROW_109_2_Left_611 VGND VGND VPWR VPWR sky130_fd_sc_hd__decap_3
XFILLER_223_259 VPWR VGND VPWR VGND sky130_ef_sc_hd__decap_12
XFILLER_1_1198 VGND VGND VPWR VPWR sky130_fd_sc_hd__decap_6
XFILLER_147_1273 VPWR VGND VPWR VGND sky130_ef_sc_hd__decap_12
XFILLER_182_1164 VPWR VGND VPWR VGND sky130_ef_sc_hd__decap_12
XFILLER_188_163 VPWR VGND VPWR VGND sky130_ef_sc_hd__decap_12
XFILLER_204_495 VPWR VGND VPWR VGND sky130_ef_sc_hd__decap_12
XTAP_TAPCELL_ROW_138_2_5766 VGND VPWR sky130_fd_sc_hd__tapvpwrvgnd_1
XFILLER_84_3 VPWR VGND VPWR VGND sky130_ef_sc_hd__decap_12
XFILLER_176_347 VPWR VGND VPWR VGND sky130_ef_sc_hd__decap_12
XFILLER_34_1454 VPWR VGND VPWR VGND sky130_ef_sc_hd__decap_12
XFILLER_121_1402 VPWR VGND VPWR VGND sky130_ef_sc_hd__decap_12
XFILLER_121_1457 VGND VGND VPWR VPWR sky130_fd_sc_hd__decap_6
XFILLER_195_1514 VGND VGND VPWR VPWR sky130_fd_sc_hd__fill_1
XFILLER_172_531 VGND VGND VPWR VPWR sky130_fd_sc_hd__decap_6
XFILLER_156_1509 VGND VGND VPWR VPWR sky130_fd_sc_hd__decap_6
XFILLER_67_1230 VPWR VGND VPWR VGND sky130_ef_sc_hd__decap_12
XTAP_TAPCELL_ROW_131_2_5709 VGND VPWR sky130_fd_sc_hd__tapvpwrvgnd_1
XFILLER_158_1380 VPWR VGND VPWR VGND sky130_ef_sc_hd__decap_12
XFILLER_193_1260 VPWR VGND VPWR VGND sky130_ef_sc_hd__decap_12
XFILLER_67_1285 VGND VGND VPWR VPWR sky130_fd_sc_hd__decap_6
XFILLER_115_1206 VPWR VGND VPWR VGND sky130_ef_sc_hd__decap_12
XTAP_TAPCELL_ROW_181_2102 VGND VPWR sky130_fd_sc_hd__tapvpwrvgnd_1
XFILLER_230_1121 VPWR VGND VPWR VGND sky130_ef_sc_hd__decap_12
XFILLER_41_1414 VGND VGND VPWR VPWR sky130_fd_sc_hd__decap_6
XTAP_TAPCELL_ROW_241_4179 VGND VPWR sky130_fd_sc_hd__tapvpwrvgnd_1
XFILLER_227_510 VGND VGND VPWR VPWR sky130_fd_sc_hd__decap_6
XFILLER_80_1485 VPWR VGND VPWR VGND sky130_ef_sc_hd__decap_12
XFILLER_6_1054 VPWR VGND VPWR VGND sky130_ef_sc_hd__decap_12
XFILLER_239_381 VGND VGND VPWR VPWR sky130_fd_sc_hd__decap_6
XFILLER_255_841 VPWR VGND VPWR VGND sky130_ef_sc_hd__decap_12
XTAP_TAPCELL_ROW_34_2_4936 VGND VPWR sky130_fd_sc_hd__tapvpwrvgnd_1
XFILLER_230_1176 VGND VGND VPWR VPWR sky130_fd_sc_hd__decap_6
XFILLER_255_874 VGND VGND VPWR VPWR sky130_fd_sc_hd__decap_8
XPHY_EDGE_ROW_169_Left_424 VGND VGND VPWR VPWR sky130_fd_sc_hd__decap_3
XPHY_EDGE_ROW_151_1_Right_807 VGND VGND VPWR VPWR sky130_fd_sc_hd__decap_3
XFILLER_25_15 VPWR VGND VPWR VGND sky130_ef_sc_hd__decap_12
XPHY_EDGE_ROW_94_2_Right_185 VGND VGND VPWR VPWR sky130_fd_sc_hd__decap_3
XTAP_TAPCELL_ROW_179_2020 VGND VPWR sky130_fd_sc_hd__tapvpwrvgnd_1
XFILLER_214_237 VPWR VGND VPWR VGND sky130_ef_sc_hd__decap_12
XTAP_TAPCELL_ROW_179_2031 VGND VPWR sky130_fd_sc_hd__tapvpwrvgnd_1
XFILLER_25_37 VGND VGND VPWR VPWR sky130_fd_sc_hd__decap_6
XFILLER_25_48 VGND VGND VPWR VPWR sky130_fd_sc_hd__fill_1
XFILLER_78_1392 VGND VGND VPWR VPWR sky130_fd_sc_hd__decap_6
XTAP_TAPCELL_ROW_198_2676 VGND VPWR sky130_fd_sc_hd__tapvpwrvgnd_1
XTAP_TAPCELL_ROW_198_2687 VGND VPWR sky130_fd_sc_hd__tapvpwrvgnd_1
XFILLER_126_1313 VPWR VGND VPWR VGND sky130_ef_sc_hd__decap_12
XFILLER_179_130 VPWR VGND VPWR VGND sky130_ef_sc_hd__decap_12
XTAP_TAPCELL_ROW_194_2529 VGND VPWR sky130_fd_sc_hd__tapvpwrvgnd_1
XTAP_TAPCELL_ROW_198_2698 VGND VPWR sky130_fd_sc_hd__tapvpwrvgnd_1
XFILLER_35_1218 VPWR VGND VPWR VGND sky130_ef_sc_hd__decap_12
XFILLER_167_314 VPWR VGND VPWR VGND sky130_ef_sc_hd__decap_12
XFILLER_210_421 VPWR VGND VPWR VGND sky130_ef_sc_hd__decap_12
XFILLER_222_292 VPWR VGND VPWR VGND sky130_ef_sc_hd__decap_12
XFILLER_126_1368 VPWR VGND VPWR VGND sky130_ef_sc_hd__decap_12
XFILLER_179_185 VPWR VGND VPWR VGND sky130_ef_sc_hd__decap_12
XPHY_EDGE_ROW_30_2_Left_532 VGND VGND VPWR VPWR sky130_fd_sc_hd__decap_3
XFILLER_194_144 VGND VGND VPWR VPWR sky130_fd_sc_hd__decap_6
XFILLER_167_369 VPWR VGND VPWR VGND sky130_ef_sc_hd__decap_12
XFILLER_183_818 VPWR VGND VPWR VGND sky130_ef_sc_hd__decap_12
XFILLER_210_476 VPWR VGND VPWR VGND sky130_ef_sc_hd__decap_12
XFILLER_241_1272 VPWR VGND VPWR VGND sky130_ef_sc_hd__decap_12
XFILLER_195_689 VPWR VGND VPWR VGND sky130_ef_sc_hd__decap_12
XPHY_EDGE_ROW_178_Left_433 VGND VGND VPWR VPWR sky130_fd_sc_hd__decap_3
XFILLER_191_873 VPWR VGND VPWR VGND sky130_ef_sc_hd__decap_12
XFILLER_194_1035 VPWR VGND VPWR VGND sky130_ef_sc_hd__decap_12
XFILLER_11_1273 VPWR VGND VPWR VGND sky130_ef_sc_hd__decap_12
XFILLER_159_1177 VPWR VGND VPWR VGND sky130_ef_sc_hd__decap_12
XFILLER_237_80 VGND VGND VPWR VPWR sky130_fd_sc_hd__decap_6
XFILLER_46_1325 VPWR VGND VPWR VGND sky130_ef_sc_hd__decap_12
XFILLER_250_1508 VGND VGND VPWR VPWR sky130_fd_sc_hd__decap_6
XFILLER_2_769 VGND VGND VPWR VPWR sky130_fd_sc_hd__decap_8
XFILLER_249_123 VGND VGND VPWR VPWR sky130_fd_sc_hd__decap_6
XFILLER_1_257 VGND VGND VPWR VPWR sky130_fd_sc_hd__fill_1
XFILLER_137_1464 VPWR VGND VPWR VGND sky130_ef_sc_hd__decap_12
XFILLER_172_1355 VPWR VGND VPWR VGND sky130_ef_sc_hd__decap_12
XFILLER_173_68 VPWR VGND VPWR VGND sky130_ef_sc_hd__decap_12
XFILLER_81_1249 VPWR VGND VPWR VGND sky130_ef_sc_hd__decap_12
XFILLER_235_1076 VPWR VGND VPWR VGND sky130_ef_sc_hd__decap_12
XFILLER_238_808 VPWR VGND VPWR VGND sky130_ef_sc_hd__decap_12
XFILLER_2_19 VGND VGND VPWR VPWR sky130_fd_sc_hd__fill_2
XFILLER_133_1328 VGND VGND VPWR VPWR sky130_fd_sc_hd__decap_6
XTAP_TAPCELL_ROW_224_3610 VGND VPWR sky130_fd_sc_hd__tapvpwrvgnd_1
XPHY_EDGE_ROW_107_1_Left_362 VGND VGND VPWR VPWR sky130_fd_sc_hd__decap_3
XFILLER_66_22 VPWR VGND VPWR VGND sky130_ef_sc_hd__decap_12
XTAP_TAPCELL_ROW_89_1_1363 VGND VPWR sky130_fd_sc_hd__tapvpwrvgnd_1
XPHY_EDGE_ROW_187_Left_442 VGND VGND VPWR VPWR sky130_fd_sc_hd__decap_3
XFILLER_170_1090 VGND VGND VPWR VPWR sky130_fd_sc_hd__decap_6
XFILLER_20_1509 VGND VGND VPWR VPWR sky130_fd_sc_hd__decap_6
XFILLER_246_863 VPWR VGND VPWR VGND sky130_ef_sc_hd__decap_12
XFILLER_22_1380 VPWR VGND VPWR VGND sky130_ef_sc_hd__decap_12
XFILLER_2_1441 VPWR VGND VPWR VGND sky130_ef_sc_hd__decap_12
X_523_ net665 VGND VGND VPWR VPWR _005_ sky130_fd_sc_hd__inv_2
XFILLER_79_1189 VPWR VGND VPWR VGND sky130_ef_sc_hd__decap_12
XFILLER_57_1421 VPWR VGND VPWR VGND sky130_ef_sc_hd__decap_12
XTAP_TAPCELL_ROW_155_2_5905 VGND VPWR sky130_fd_sc_hd__tapvpwrvgnd_1
XFILLER_199_940 VGND VGND VPWR VPWR sky130_fd_sc_hd__decap_6
XFILLER_205_259 VPWR VGND VPWR VGND sky130_ef_sc_hd__decap_12
XFILLER_2_1496 VPWR VGND VPWR VGND sky130_ef_sc_hd__decap_12
XFILLER_109_1500 VGND VGND VPWR VPWR sky130_fd_sc_hd__decap_6
XTAP_TAPCELL_ROW_124_2_5652 VGND VPWR sky130_fd_sc_hd__tapvpwrvgnd_1
XTAP_TAPCELL_ROW_218_3403 VGND VPWR sky130_fd_sc_hd__tapvpwrvgnd_1
X_454_ net624 net652 _082_ VGND VGND VPWR VPWR addr0\[0\] sky130_fd_sc_hd__a21bo_1
XFILLER_82_65 VGND VGND VPWR VPWR sky130_fd_sc_hd__decap_6
XFILLER_207_1112 VGND VGND VPWR VPWR sky130_fd_sc_hd__decap_6
XFILLER_220_218 VPWR VGND VPWR VGND sky130_ef_sc_hd__decap_12
XFILLER_246_1183 VPWR VGND VPWR VGND sky130_ef_sc_hd__decap_12
XFILLER_57_1476 VPWR VGND VPWR VGND sky130_ef_sc_hd__decap_12
XFILLER_92_1356 VPWR VGND VPWR VGND sky130_ef_sc_hd__decap_12
XFILLER_144_1435 VGND VGND VPWR VPWR sky130_fd_sc_hd__decap_6
XFILLER_198_65 VPWR VGND VPWR VGND sky130_ef_sc_hd__decap_12
XFILLER_242_1047 VGND VGND VPWR VPWR sky130_fd_sc_hd__decap_6
X_385_ _171_ _172_ VGND VGND VPWR VPWR _174_ sky130_fd_sc_hd__or2_1
XFILLER_185_111 VPWR VGND VPWR VGND sky130_ef_sc_hd__decap_12
XFILLER_201_443 VPWR VGND VPWR VGND sky130_ef_sc_hd__decap_12
XFILLER_9_335 VGND VGND VPWR VPWR sky130_fd_sc_hd__fill_1
XFILLER_186_667 VPWR VGND VPWR VGND sky130_ef_sc_hd__decap_12
XPHY_EDGE_ROW_196_Left_451 VGND VGND VPWR VPWR sky130_fd_sc_hd__decap_3
XFILLER_220_1312 VPWR VGND VPWR VGND sky130_ef_sc_hd__decap_12
XFILLER_185_166 VGND VGND VPWR VPWR sky130_fd_sc_hd__decap_6
XFILLER_9_379 VPWR VGND VPWR VGND sky130_ef_sc_hd__decap_12
XFILLER_201_498 VPWR VGND VPWR VGND sky130_ef_sc_hd__decap_12
XFILLER_16_1184 VPWR VGND VPWR VGND sky130_ef_sc_hd__decap_12
XTAP_TAPCELL_ROW_73_2_5249 VGND VPWR sky130_fd_sc_hd__tapvpwrvgnd_1
XFILLER_220_1367 VPWR VGND VPWR VGND sky130_ef_sc_hd__decap_12
XFILLER_103_1165 VPWR VGND VPWR VGND sky130_ef_sc_hd__decap_12
XFILLER_182_851 VPWR VGND VPWR VGND sky130_ef_sc_hd__decap_12
XFILLER_255_1408 VPWR VGND VPWR VGND sky130_ef_sc_hd__decap_12
XFILLER_217_39 VGND VGND VPWR VPWR sky130_fd_sc_hd__decap_4
XFILLER_173_1119 VPWR VGND VPWR VGND sky130_ef_sc_hd__decap_12
XFILLER_138_1239 VPWR VGND VPWR VGND sky130_ef_sc_hd__decap_12
XTAP_TAPCELL_ROW_40_2_4979 VGND VPWR sky130_fd_sc_hd__tapvpwrvgnd_1
XFILLER_190_1422 VPWR VGND VPWR VGND sky130_ef_sc_hd__decap_12
XFILLER_253_1143 VPWR VGND VPWR VGND sky130_ef_sc_hd__decap_12
XPHY_EDGE_ROW_39_1_Left_294 VGND VGND VPWR VPWR sky130_fd_sc_hd__decap_3
XFILLER_190_1477 VGND VGND VPWR VPWR sky130_fd_sc_hd__decap_6
XFILLER_253_1198 VGND VGND VPWR VPWR sky130_fd_sc_hd__decap_6
XTAP_TAPCELL_ROW_20_2_4822 VGND VPWR sky130_fd_sc_hd__tapvpwrvgnd_1
XFILLER_233_27 VPWR VGND VPWR VGND sky130_ef_sc_hd__decap_12
XTAP_TAPCELL_ROW_19_2_4816 VGND VPWR sky130_fd_sc_hd__tapvpwrvgnd_1
XFILLER_209_510 VGND VGND VPWR VPWR sky130_fd_sc_hd__decap_6
XFILLER_237_830 VPWR VGND VPWR VGND sky130_ef_sc_hd__decap_12
XFILLER_3_1205 VPWR VGND VPWR VGND sky130_ef_sc_hd__decap_12
XFILLER_231_1463 VPWR VGND VPWR VGND sky130_ef_sc_hd__decap_12
XFILLER_255_148 VPWR VGND VPWR VGND sky130_ef_sc_hd__decap_12
XFILLER_97_1201 VGND VGND VPWR VPWR sky130_fd_sc_hd__decap_4
XTAP_TAPCELL_ROW_41_1_1291 VGND VPWR sky130_fd_sc_hd__tapvpwrvgnd_1
XFILLER_23_1177 VPWR VGND VPWR VGND sky130_ef_sc_hd__decap_12
XFILLER_114_1294 VPWR VGND VPWR VGND sky130_ef_sc_hd__decap_12
XFILLER_237_885 VPWR VGND VPWR VGND sky130_ef_sc_hd__decap_12
XFILLER_149_1335 VPWR VGND VPWR VGND sky130_ef_sc_hd__decap_12
XFILLER_184_1226 VPWR VGND VPWR VGND sky130_ef_sc_hd__decap_12
XFILLER_229_1370 VGND VGND VPWR VPWR sky130_fd_sc_hd__decap_6
XFILLER_196_409 VPWR VGND VPWR VGND sky130_ef_sc_hd__decap_12
XTAP_TAPCELL_ROW_201_2783 VGND VPWR sky130_fd_sc_hd__tapvpwrvgnd_1
XTAP_TAPCELL_ROW_201_2794 VGND VPWR sky130_fd_sc_hd__tapvpwrvgnd_1
XFILLER_204_292 VPWR VGND VPWR VGND sky130_ef_sc_hd__decap_12
XTAP_TAPCELL_ROW_253_4595 VGND VPWR sky130_fd_sc_hd__tapvpwrvgnd_1
XFILLER_176_144 VGND VGND VPWR VPWR sky130_fd_sc_hd__decap_6
XFILLER_34_1251 VPWR VGND VPWR VGND sky130_ef_sc_hd__decap_12
XFILLER_177_689 VPWR VGND VPWR VGND sky130_ef_sc_hd__decap_12
XFILLER_220_796 VPWR VGND VPWR VGND sky130_ef_sc_hd__decap_12
XFILLER_125_1390 VPWR VGND VPWR VGND sky130_ef_sc_hd__decap_12
XFILLER_160_1270 VPWR VGND VPWR VGND sky130_ef_sc_hd__decap_12
XFILLER_192_648 VPWR VGND VPWR VGND sky130_ef_sc_hd__decap_12
XFILLER_11_39 VGND VGND VPWR VPWR sky130_fd_sc_hd__decap_4
XFILLER_173_873 VPWR VGND VPWR VGND sky130_ef_sc_hd__decap_12
XFILLER_69_1347 VPWR VGND VPWR VGND sky130_ef_sc_hd__decap_12
XPHY_EDGE_ROW_200_Left_455 VGND VGND VPWR VPWR sky130_fd_sc_hd__decap_3
XFILLER_127_39 VGND VGND VPWR VPWR sky130_fd_sc_hd__decap_4
XFILLER_156_1306 VGND VGND VPWR VPWR sky130_fd_sc_hd__decap_6
XTAP_TAPCELL_ROW_187_2300 VGND VPWR sky130_fd_sc_hd__tapvpwrvgnd_1
XTAP_TAPCELL_ROW_187_2311 VGND VPWR sky130_fd_sc_hd__tapvpwrvgnd_1
XFILLER_195_1377 VPWR VGND VPWR VGND sky130_ef_sc_hd__decap_12
XTAP_TAPCELL_ROW_247_4388 VGND VPWR sky130_fd_sc_hd__tapvpwrvgnd_1
XTAP_TAPCELL_ROW_247_4399 VGND VPWR sky130_fd_sc_hd__tapvpwrvgnd_1
XFILLER_232_1238 VPWR VGND VPWR VGND sky130_ef_sc_hd__decap_12
XFILLER_143_27 VPWR VGND VPWR VGND sky130_ef_sc_hd__decap_12
XFILLER_247_627 VPWR VGND VPWR VGND sky130_ef_sc_hd__decap_12
XTAP_TAPCELL_ROW_161_2_5948 VGND VPWR sky130_fd_sc_hd__tapvpwrvgnd_1
XFILLER_210_1514 VGND VGND VPWR VPWR sky130_fd_sc_hd__fill_1
XFILLER_80_1282 VPWR VGND VPWR VGND sky130_ef_sc_hd__decap_12
XTAP_TAPCELL_ROW_9_1177 VGND VPWR sky130_fd_sc_hd__tapvpwrvgnd_1
XTAP_TAPCELL_ROW_97_2_5434 VGND VPWR sky130_fd_sc_hd__tapvpwrvgnd_1
XTAP_TAPCELL_ROW_9_1188 VGND VPWR sky130_fd_sc_hd__tapvpwrvgnd_1
XFILLER_228_863 VPWR VGND VPWR VGND sky130_ef_sc_hd__decap_12
XTAP_TAPCELL_ROW_9_1199 VGND VPWR sky130_fd_sc_hd__tapvpwrvgnd_1
XFILLER_243_811 VGND VGND VPWR VPWR sky130_fd_sc_hd__decap_6
XTAP_TAPCELL_ROW_66_2_5192 VGND VPWR sky130_fd_sc_hd__tapvpwrvgnd_1
XFILLER_167_1413 VGND VGND VPWR VPWR sky130_fd_sc_hd__decap_6
XTAP_TAPCELL_ROW_109_2_5532 VGND VPWR sky130_fd_sc_hd__tapvpwrvgnd_1
XPHY_EDGE_ROW_152_1_Right_808 VGND VGND VPWR VPWR sky130_fd_sc_hd__decap_3
XFILLER_208_1410 VPWR VGND VPWR VGND sky130_ef_sc_hd__decap_12
XPHY_EDGE_ROW_95_2_Right_186 VGND VGND VPWR VPWR sky130_fd_sc_hd__decap_3
XFILLER_202_218 VPWR VGND VPWR VGND sky130_ef_sc_hd__decap_12
XFILLER_230_538 VPWR VGND VPWR VGND sky130_ef_sc_hd__decap_12
XFILLER_243_1334 VPWR VGND VPWR VGND sky130_ef_sc_hd__decap_12
XFILLER_208_1465 VPWR VGND VPWR VGND sky130_ef_sc_hd__decap_12
XFILLER_52_46 VGND VGND VPWR VPWR sky130_fd_sc_hd__fill_1
XFILLER_167_111 VPWR VGND VPWR VGND sky130_ef_sc_hd__decap_12
XFILLER_195_431 VPWR VGND VPWR VGND sky130_ef_sc_hd__decap_12
XFILLER_126_1165 VPWR VGND VPWR VGND sky130_ef_sc_hd__decap_12
XFILLER_243_1389 VPWR VGND VPWR VGND sky130_ef_sc_hd__decap_12
XFILLER_168_46 VPWR VGND VPWR VGND sky130_ef_sc_hd__decap_12
XFILLER_168_667 VPWR VGND VPWR VGND sky130_ef_sc_hd__decap_12
XTAP_TAPCELL_ROW_58_2_5129 VGND VPWR sky130_fd_sc_hd__tapvpwrvgnd_1
XFILLER_167_166 VGND VGND VPWR VPWR sky130_fd_sc_hd__decap_6
XFILLER_183_615 VPWR VGND VPWR VGND sky130_ef_sc_hd__decap_12
XFILLER_210_273 VGND VGND VPWR VPWR sky130_fd_sc_hd__decap_6
XFILLER_195_486 VPWR VGND VPWR VGND sky130_ef_sc_hd__decap_12
XFILLER_13_1335 VPWR VGND VPWR VGND sky130_ef_sc_hd__decap_12
XFILLER_87_1414 VGND VGND VPWR VPWR sky130_fd_sc_hd__decap_6
XFILLER_104_1485 VPWR VGND VPWR VGND sky130_ef_sc_hd__decap_12
XTAP_TAPCELL_ROW_25_2_4859 VGND VPWR sky130_fd_sc_hd__tapvpwrvgnd_1
XFILLER_201_3 VPWR VGND VPWR VGND sky130_ef_sc_hd__decap_12
XFILLER_202_1097 VPWR VGND VPWR VGND sky130_ef_sc_hd__decap_12
XFILLER_100_1349 VGND VGND VPWR VPWR sky130_fd_sc_hd__decap_6
XFILLER_184_34 VPWR VGND VPWR VGND sky130_ef_sc_hd__decap_12
XFILLER_191_670 VPWR VGND VPWR VGND sky130_ef_sc_hd__decap_12
XFILLER_254_1441 VPWR VGND VPWR VGND sky130_ef_sc_hd__decap_12
Xsram0_684 VGND VGND VPWR VPWR net684 sram0_684/LO sky130_fd_sc_hd__conb_1
XTAP_TAPCELL_ROW_170_1691 VGND VPWR sky130_fd_sc_hd__tapvpwrvgnd_1
XFILLER_184_89 VPWR VGND VPWR VGND sky130_ef_sc_hd__decap_12
XFILLER_250_1305 VGND VGND VPWR VPWR sky130_fd_sc_hd__decap_6
XFILLER_137_1261 VPWR VGND VPWR VGND sky130_ef_sc_hd__decap_12
XFILLER_172_1152 VPWR VGND VPWR VGND sky130_ef_sc_hd__decap_12
XFILLER_254_1496 VPWR VGND VPWR VGND sky130_ef_sc_hd__decap_12
XFILLER_238_605 VPWR VGND VPWR VGND sky130_ef_sc_hd__decap_12
XFILLER_2_599 VGND VGND VPWR VPWR sky130_fd_sc_hd__fill_1
XFILLER_46_1177 VGND VGND VPWR VPWR sky130_fd_sc_hd__decap_6
XFILLER_24_1442 VPWR VGND VPWR VGND sky130_ef_sc_hd__decap_12
XFILLER_219_830 VPWR VGND VPWR VGND sky130_ef_sc_hd__decap_12
XFILLER_4_1514 VGND VGND VPWR VPWR sky130_fd_sc_hd__fill_1
XFILLER_20_1306 VGND VGND VPWR VPWR sky130_fd_sc_hd__decap_6
XFILLER_246_660 VGND VGND VPWR VPWR sky130_fd_sc_hd__decap_6
XFILLER_24_1497 VPWR VGND VPWR VGND sky130_ef_sc_hd__decap_12
XFILLER_111_1445 VPWR VGND VPWR VGND sky130_ef_sc_hd__decap_12
XFILLER_219_885 VPWR VGND VPWR VGND sky130_ef_sc_hd__decap_12
XFILLER_244_1109 VPWR VGND VPWR VGND sky130_ef_sc_hd__decap_12
XFILLER_209_1229 VPWR VGND VPWR VGND sky130_ef_sc_hd__decap_12
XFILLER_2_1293 VPWR VGND VPWR VGND sky130_ef_sc_hd__decap_12
X_506_ net179 net76 VGND VGND VPWR VPWR acc_core.adder.cla_blocks\[6\].block.sum\[1\]
+ sky130_fd_sc_hd__xor2_1
XFILLER_178_409 VPWR VGND VPWR VGND sky130_ef_sc_hd__decap_12
XFILLER_57_1273 VPWR VGND VPWR VGND sky130_ef_sc_hd__decap_12
X_437_ net598 net536 dout0_q\[20\] VGND VGND VPWR VPWR _226_ sky130_fd_sc_hd__and3_1
XFILLER_198_280 VPWR VGND VPWR VGND sky130_ef_sc_hd__decap_12
XFILLER_201_240 VPWR VGND VPWR VGND sky130_ef_sc_hd__decap_12
X_368_ net162 _156_ VGND VGND VPWR VPWR _157_ sky130_fd_sc_hd__or2_1
XFILLER_186_464 VPWR VGND VPWR VGND sky130_ef_sc_hd__decap_12
XFILLER_202_796 VPWR VGND VPWR VGND sky130_ef_sc_hd__decap_12
XFILLER_31_1402 VPWR VGND VPWR VGND sky130_ef_sc_hd__decap_12
XFILLER_105_1249 VPWR VGND VPWR VGND sky130_ef_sc_hd__decap_12
XTAP_TAPCELL_ROW_154_2_5891 VGND VPWR sky130_fd_sc_hd__tapvpwrvgnd_1
XFILLER_201_295 VGND VGND VPWR VPWR sky130_fd_sc_hd__decap_6
XFILLER_174_648 VPWR VGND VPWR VGND sky130_ef_sc_hd__decap_12
X_299_ net624 net617 VGND VGND VPWR VPWR _074_ sky130_fd_sc_hd__xnor2_1
XFILLER_9_198 VPWR VGND VPWR VGND sky130_ef_sc_hd__decap_12
XFILLER_31_1457 VGND VGND VPWR VPWR sky130_fd_sc_hd__decap_6
XFILLER_220_1164 VPWR VGND VPWR VGND sky130_ef_sc_hd__decap_12
XFILLER_66_1509 VGND VGND VPWR VPWR sky130_fd_sc_hd__decap_6
XFILLER_6_894 VPWR VGND VPWR VGND sky130_ef_sc_hd__decap_12
XFILLER_170_832 VGND VGND VPWR VPWR sky130_fd_sc_hd__decap_6
XFILLER_47_3 VPWR VGND VPWR VGND sky130_ef_sc_hd__decap_12
XFILLER_244_15 VGND VGND VPWR VPWR sky130_fd_sc_hd__decap_6
XFILLER_68_1380 VPWR VGND VPWR VGND sky130_ef_sc_hd__decap_12
XFILLER_233_1514 VGND VGND VPWR VPWR sky130_fd_sc_hd__fill_1
XTAP_TAPCELL_ROW_146_2_5828 VGND VPWR sky130_fd_sc_hd__tapvpwrvgnd_1
XTAP_TAPCELL_ROW_242_4230 VGND VPWR sky130_fd_sc_hd__tapvpwrvgnd_1
XFILLER_25_1206 VPWR VGND VPWR VGND sky130_ef_sc_hd__decap_12
XTAP_TAPCELL_ROW_242_4241 VGND VPWR sky130_fd_sc_hd__tapvpwrvgnd_1
XFILLER_229_627 VPWR VGND VPWR VGND sky130_ef_sc_hd__decap_12
XFILLER_116_1356 VPWR VGND VPWR VGND sky130_ef_sc_hd__decap_12
XFILLER_231_1260 VPWR VGND VPWR VGND sky130_ef_sc_hd__decap_12
XFILLER_3_1002 VPWR VGND VPWR VGND sky130_ef_sc_hd__decap_12
XFILLER_225_811 VGND VGND VPWR VPWR sky130_fd_sc_hd__decap_6
XFILLER_237_682 VGND VGND VPWR VPWR sky130_fd_sc_hd__decap_6
XFILLER_3_1057 VPWR VGND VPWR VGND sky130_ef_sc_hd__decap_12
XTAP_TAPCELL_ROW_4_1030 VGND VPWR sky130_fd_sc_hd__tapvpwrvgnd_1
XTAP_TAPCELL_ROW_207_2992 VGND VPWR sky130_fd_sc_hd__tapvpwrvgnd_1
XTAP_TAPCELL_ROW_203_2845 VGND VPWR sky130_fd_sc_hd__tapvpwrvgnd_1
XFILLER_184_1023 VPWR VGND VPWR VGND sky130_ef_sc_hd__decap_12
XTAP_TAPCELL_ROW_203_2856 VGND VPWR sky130_fd_sc_hd__tapvpwrvgnd_1
XTAP_TAPCELL_ROW_203_2867 VGND VPWR sky130_fd_sc_hd__tapvpwrvgnd_1
XTAP_TAPCELL_ROW_236_4001 VGND VPWR sky130_fd_sc_hd__tapvpwrvgnd_1
XTAP_TAPCELL_ROW_147_1_1450 VGND VPWR sky130_fd_sc_hd__tapvpwrvgnd_1
XTAP_TAPCELL_ROW_203_2878 VGND VPWR sky130_fd_sc_hd__tapvpwrvgnd_1
XTAP_TAPCELL_ROW_236_4012 VGND VPWR sky130_fd_sc_hd__tapvpwrvgnd_1
XFILLER_149_1165 VPWR VGND VPWR VGND sky130_ef_sc_hd__decap_12
XTAP_TAPCELL_ROW_236_4023 VGND VPWR sky130_fd_sc_hd__tapvpwrvgnd_1
XTAP_TAPCELL_ROW_255_4668 VGND VPWR sky130_fd_sc_hd__tapvpwrvgnd_1
XFILLER_251_173 VPWR VGND VPWR VGND sky130_ef_sc_hd__decap_12
XFILLER_184_1078 VPWR VGND VPWR VGND sky130_ef_sc_hd__decap_12
XFILLER_196_206 VPWR VGND VPWR VGND sky130_ef_sc_hd__decap_12
XTAP_TAPCELL_ROW_255_4679 VGND VPWR sky130_fd_sc_hd__tapvpwrvgnd_1
XTAP_TAPCELL_ROW_44_2_5015 VGND VPWR sky130_fd_sc_hd__tapvpwrvgnd_1
XFILLER_212_538 VPWR VGND VPWR VGND sky130_ef_sc_hd__decap_12
XFILLER_36_1313 VPWR VGND VPWR VGND sky130_ef_sc_hd__decap_12
XFILLER_177_431 VPWR VGND VPWR VGND sky130_ef_sc_hd__decap_12
XFILLER_36_1368 VPWR VGND VPWR VGND sky130_ef_sc_hd__decap_12
XFILLER_123_1316 VPWR VGND VPWR VGND sky130_ef_sc_hd__decap_12
XFILLER_220_593 VPWR VGND VPWR VGND sky130_ef_sc_hd__decap_12
XFILLER_177_486 VPWR VGND VPWR VGND sky130_ef_sc_hd__decap_12
XFILLER_192_445 VGND VGND VPWR VPWR sky130_fd_sc_hd__decap_6
XFILLER_173_670 VPWR VGND VPWR VGND sky130_ef_sc_hd__decap_12
XFILLER_69_1177 VPWR VGND VPWR VGND sky130_ef_sc_hd__decap_12
XFILLER_195_1174 VPWR VGND VPWR VGND sky130_ef_sc_hd__decap_12
XFILLER_154_15 VGND VGND VPWR VPWR sky130_fd_sc_hd__decap_6
XFILLER_47_1464 VPWR VGND VPWR VGND sky130_ef_sc_hd__decap_12
XFILLER_134_1423 VPWR VGND VPWR VGND sky130_ef_sc_hd__decap_12
XFILLER_248_925 VPWR VGND VPWR VGND sky130_ef_sc_hd__decap_12
XFILLER_43_1328 VGND VGND VPWR VPWR sky130_fd_sc_hd__decap_6
XFILLER_232_1035 VPWR VGND VPWR VGND sky130_ef_sc_hd__decap_12
XFILLER_247_424 VGND VGND VPWR VPWR sky130_fd_sc_hd__decap_6
XFILLER_82_1399 VPWR VGND VPWR VGND sky130_ef_sc_hd__decap_12
XFILLER_134_1478 VGND VGND VPWR VPWR sky130_fd_sc_hd__decap_6
XFILLER_228_660 VGND VGND VPWR VPWR sky130_fd_sc_hd__decap_6
XFILLER_170_58 VGND VGND VPWR VPWR sky130_fd_sc_hd__decap_6
XFILLER_210_1355 VPWR VGND VPWR VGND sky130_ef_sc_hd__decap_12
XFILLER_242_151 VPWR VGND VPWR VGND sky130_ef_sc_hd__decap_12
XFILLER_19_1500 VGND VGND VPWR VPWR sky130_fd_sc_hd__decap_6
XFILLER_128_1227 VPWR VGND VPWR VGND sky130_ef_sc_hd__decap_12
XFILLER_63_56 VPWR VGND VPWR VGND sky130_ef_sc_hd__decap_12
XFILLER_151_3 VPWR VGND VPWR VGND sky130_ef_sc_hd__decap_12
XPHY_EDGE_ROW_153_1_Right_809 VGND VGND VPWR VPWR sky130_fd_sc_hd__decap_3
XFILLER_180_1410 VPWR VGND VPWR VGND sky130_ef_sc_hd__decap_12
XFILLER_249_3 VPWR VGND VPWR VGND sky130_ef_sc_hd__decap_12
XFILLER_243_1131 VPWR VGND VPWR VGND sky130_ef_sc_hd__decap_12
XFILLER_187_228 VPWR VGND VPWR VGND sky130_ef_sc_hd__decap_12
XFILLER_230_335 VPWR VGND VPWR VGND sky130_ef_sc_hd__decap_12
XPHY_EDGE_ROW_96_2_Right_187 VGND VGND VPWR VPWR sky130_fd_sc_hd__decap_3
XFILLER_179_56 VPWR VGND VPWR VGND sky130_ef_sc_hd__decap_12
XFILLER_54_1435 VGND VGND VPWR VPWR sky130_fd_sc_hd__decap_6
XFILLER_208_1262 VGND VGND VPWR VPWR sky130_fd_sc_hd__decap_6
XTAP_TAPCELL_ROW_139_2_5771 VGND VPWR sky130_fd_sc_hd__tapvpwrvgnd_1
XFILLER_180_1465 VPWR VGND VPWR VGND sky130_ef_sc_hd__decap_12
XFILLER_211_560 VPWR VGND VPWR VGND sky130_ef_sc_hd__decap_12
XFILLER_243_1186 VPWR VGND VPWR VGND sky130_ef_sc_hd__decap_12
XFILLER_168_464 VPWR VGND VPWR VGND sky130_ef_sc_hd__decap_12
XFILLER_7_603 VGND VGND VPWR VPWR sky130_fd_sc_hd__fill_1
Xwire523 _083_ VGND VGND VPWR VPWR net523 sky130_fd_sc_hd__clkbuf_1
XFILLER_183_412 VPWR VGND VPWR VGND sky130_ef_sc_hd__decap_12
XFILLER_195_283 VPWR VGND VPWR VGND sky130_ef_sc_hd__decap_12
Xwire545 net47 VGND VGND VPWR VPWR net545 sky130_fd_sc_hd__clkbuf_1
XFILLER_184_968 VPWR VGND VPWR VGND sky130_ef_sc_hd__decap_12
XFILLER_195_44 VPWR VGND VPWR VGND sky130_ef_sc_hd__decap_12
Xwire567 net568 VGND VGND VPWR VPWR net567 sky130_fd_sc_hd__clkbuf_1
Xwire578 dout0_q\[9\] VGND VGND VPWR VPWR net578 sky130_fd_sc_hd__clkbuf_1
XFILLER_183_467 VGND VGND VPWR VPWR sky130_fd_sc_hd__decap_6
XFILLER_13_1165 VPWR VGND VPWR VGND sky130_ef_sc_hd__decap_12
XFILLER_104_1282 VPWR VGND VPWR VGND sky130_ef_sc_hd__decap_12
Xwire589 dout0_q\[1\] VGND VGND VPWR VPWR net589 sky130_fd_sc_hd__clkbuf_1
XTAP_TAPCELL_ROW_172_1764 VGND VPWR sky130_fd_sc_hd__tapvpwrvgnd_1
XTAP_TAPCELL_ROW_88_2_5368 VGND VPWR sky130_fd_sc_hd__tapvpwrvgnd_1
XTAP_TAPCELL_ROW_172_1775 VGND VPWR sky130_fd_sc_hd__tapvpwrvgnd_1
XFILLER_195_99 VPWR VGND VPWR VGND sky130_ef_sc_hd__decap_12
XTAP_TAPCELL_ROW_213_3196 VGND VPWR sky130_fd_sc_hd__tapvpwrvgnd_1
XTAP_TAPCELL_ROW_77_1_1345 VGND VPWR sky130_fd_sc_hd__tapvpwrvgnd_1
XTAP_TAPCELL_ROW_172_1786 VGND VPWR sky130_fd_sc_hd__tapvpwrvgnd_1
XTAP_TAPCELL_ROW_132_2_5714 VGND VPWR sky130_fd_sc_hd__tapvpwrvgnd_1
XFILLER_48_1239 VPWR VGND VPWR VGND sky130_ef_sc_hd__decap_12
XTAP_TAPCELL_ROW_101_2_5472 VGND VPWR sky130_fd_sc_hd__tapvpwrvgnd_1
XFILLER_3_864 VGND VGND VPWR VPWR sky130_fd_sc_hd__fill_1
XPHY_EDGE_ROW_118_2_Left_620 VGND VGND VPWR VPWR sky130_fd_sc_hd__decap_3
XFILLER_139_1378 VPWR VGND VPWR VGND sky130_ef_sc_hd__decap_12
XFILLER_174_1269 VPWR VGND VPWR VGND sky130_ef_sc_hd__decap_12
XFILLER_254_1293 VPWR VGND VPWR VGND sky130_ef_sc_hd__decap_12
XFILLER_238_402 VGND VGND VPWR VPWR sky130_fd_sc_hd__decap_6
XFILLER_239_947 VPWR VGND VPWR VGND sky130_ef_sc_hd__decap_12
XFILLER_113_1507 VGND VGND VPWR VPWR sky130_fd_sc_hd__decap_8
XFILLER_211_1119 VPWR VGND VPWR VGND sky130_ef_sc_hd__decap_12
XFILLER_254_906 VPWR VGND VPWR VGND sky130_ef_sc_hd__decap_12
XTAP_TAPCELL_ROW_166_1557 VGND VPWR sky130_fd_sc_hd__tapvpwrvgnd_1
XTAP_TAPCELL_ROW_35_2_4941 VGND VPWR sky130_fd_sc_hd__tapvpwrvgnd_1
XTAP_TAPCELL_ROW_166_1568 VGND VPWR sky130_fd_sc_hd__tapvpwrvgnd_1
XTAP_TAPCELL_ROW_50_2_5058 VGND VPWR sky130_fd_sc_hd__tapvpwrvgnd_1
XTAP_TAPCELL_ROW_166_1579 VGND VPWR sky130_fd_sc_hd__tapvpwrvgnd_1
XFILLER_207_811 VGND VGND VPWR VPWR sky130_fd_sc_hd__decap_6
XFILLER_4_1355 VPWR VGND VPWR VGND sky130_ef_sc_hd__decap_12
XFILLER_219_682 VGND VGND VPWR VPWR sky130_fd_sc_hd__decap_6
XFILLER_24_1294 VPWR VGND VPWR VGND sky130_ef_sc_hd__decap_12
XFILLER_111_1242 VGND VGND VPWR VPWR sky130_fd_sc_hd__decap_6
XFILLER_0_1219 VPWR VGND VPWR VGND sky130_ef_sc_hd__decap_12
XFILLER_59_1335 VPWR VGND VPWR VGND sky130_ef_sc_hd__decap_12
XFILLER_209_1026 VGND VGND VPWR VPWR sky130_fd_sc_hd__decap_6
XFILLER_221_302 VPWR VGND VPWR VGND sky130_ef_sc_hd__decap_12
XFILLER_2_1090 VGND VGND VPWR VPWR sky130_fd_sc_hd__decap_6
XFILLER_248_1097 VPWR VGND VPWR VGND sky130_ef_sc_hd__decap_12
XFILLER_178_206 VPWR VGND VPWR VGND sky130_ef_sc_hd__decap_12
XFILLER_233_173 VPWR VGND VPWR VGND sky130_ef_sc_hd__decap_12
XFILLER_146_1349 VGND VGND VPWR VPWR sky130_fd_sc_hd__decap_6
XFILLER_181_1229 VPWR VGND VPWR VGND sky130_ef_sc_hd__decap_12
XFILLER_221_357 VPWR VGND VPWR VGND sky130_ef_sc_hd__decap_12
XTAP_TAPCELL_ROW_250_4510 VGND VPWR sky130_fd_sc_hd__tapvpwrvgnd_1
XTAP_TAPCELL_ROW_250_4521 VGND VPWR sky130_fd_sc_hd__tapvpwrvgnd_1
XFILLER_239_15 VPWR VGND VPWR VGND sky130_ef_sc_hd__decap_12
XFILLER_193_209 VGND VGND VPWR VPWR sky130_fd_sc_hd__decap_6
XFILLER_222_1226 VPWR VGND VPWR VGND sky130_ef_sc_hd__decap_12
XFILLER_186_261 VPWR VGND VPWR VGND sky130_ef_sc_hd__decap_12
XFILLER_202_593 VPWR VGND VPWR VGND sky130_ef_sc_hd__decap_12
XFILLER_70_1270 VPWR VGND VPWR VGND sky130_ef_sc_hd__decap_12
XFILLER_35_1390 VPWR VGND VPWR VGND sky130_ef_sc_hd__decap_12
XFILLER_174_445 VGND VGND VPWR VPWR sky130_fd_sc_hd__decap_6
XFILLER_190_949 VPWR VGND VPWR VGND sky130_ef_sc_hd__decap_12
XFILLER_183_990 VPWR VGND VPWR VGND sky130_ef_sc_hd__decap_12
XTAP_TAPCELL_ROW_248_4450 VGND VPWR sky130_fd_sc_hd__tapvpwrvgnd_1
XFILLER_66_1306 VGND VGND VPWR VPWR sky130_fd_sc_hd__decap_6
XTAP_TAPCELL_ROW_244_4303 VGND VPWR sky130_fd_sc_hd__tapvpwrvgnd_1
XFILLER_157_1445 VPWR VGND VPWR VGND sky130_ef_sc_hd__decap_12
XFILLER_192_1336 VPWR VGND VPWR VGND sky130_ef_sc_hd__decap_12
XFILLER_155_1180 VPWR VGND VPWR VGND sky130_ef_sc_hd__decap_12
XFILLER_229_424 VGND VGND VPWR VPWR sky130_fd_sc_hd__decap_6
XFILLER_233_1377 VPWR VGND VPWR VGND sky130_ef_sc_hd__decap_12
XFILLER_5_1119 VPWR VGND VPWR VGND sky130_ef_sc_hd__decap_12
XTAP_TAPCELL_ROW_6_1103 VGND VPWR sky130_fd_sc_hd__tapvpwrvgnd_1
XFILLER_245_928 VPWR VGND VPWR VGND sky130_ef_sc_hd__decap_12
XTAP_TAPCELL_ROW_205_2918 VGND VPWR sky130_fd_sc_hd__tapvpwrvgnd_1
XTAP_TAPCELL_ROW_205_2929 VGND VPWR sky130_fd_sc_hd__tapvpwrvgnd_1
XFILLER_238_980 VPWR VGND VPWR VGND sky130_ef_sc_hd__decap_12
XFILLER_17_27 VPWR VGND VPWR VGND sky130_ef_sc_hd__decap_12
XFILLER_77_1402 VPWR VGND VPWR VGND sky130_ef_sc_hd__decap_12
XTAP_TAPCELL_ROW_0_823 VGND VPWR sky130_fd_sc_hd__tapvpwrvgnd_1
XTAP_TAPCELL_ROW_0_834 VGND VPWR sky130_fd_sc_hd__tapvpwrvgnd_1
XTAP_TAPCELL_ROW_0_845 VGND VPWR sky130_fd_sc_hd__tapvpwrvgnd_1
XTAP_TAPCELL_ROW_0_856 VGND VPWR sky130_fd_sc_hd__tapvpwrvgnd_1
XTAP_TAPCELL_ROW_156_2_5910 VGND VPWR sky130_fd_sc_hd__tapvpwrvgnd_1
XFILLER_253_983 VGND VGND VPWR VPWR sky130_fd_sc_hd__decap_6
XTAP_TAPCELL_ROW_0_867 VGND VPWR sky130_fd_sc_hd__tapvpwrvgnd_1
XFILLER_77_1457 VGND VGND VPWR VPWR sky130_fd_sc_hd__decap_6
XFILLER_224_151 VPWR VGND VPWR VGND sky130_ef_sc_hd__decap_12
XTAP_TAPCELL_ROW_0_878 VGND VPWR sky130_fd_sc_hd__tapvpwrvgnd_1
XTAP_TAPCELL_ROW_0_889 VGND VPWR sky130_fd_sc_hd__tapvpwrvgnd_1
XFILLER_169_228 VPWR VGND VPWR VGND sky130_ef_sc_hd__decap_12
XFILLER_212_335 VPWR VGND VPWR VGND sky130_ef_sc_hd__decap_12
XFILLER_33_15 VPWR VGND VPWR VGND sky130_ef_sc_hd__decap_12
XFILLER_205_1413 VGND VGND VPWR VPWR sky130_fd_sc_hd__decap_6
XFILLER_149_15 VPWR VGND VPWR VGND sky130_ef_sc_hd__decap_12
XFILLER_200_519 VPWR VGND VPWR VGND sky130_ef_sc_hd__decap_12
XFILLER_244_1484 VPWR VGND VPWR VGND sky130_ef_sc_hd__decap_12
XFILLER_36_1165 VPWR VGND VPWR VGND sky130_ef_sc_hd__decap_12
XFILLER_240_1348 VGND VGND VPWR VPWR sky130_fd_sc_hd__decap_6
XFILLER_162_1184 VPWR VGND VPWR VGND sky130_ef_sc_hd__decap_12
XFILLER_165_412 VGND VGND VPWR VPWR sky130_fd_sc_hd__decap_8
XPHY_EDGE_ROW_116_1_Left_371 VGND VGND VPWR VPWR sky130_fd_sc_hd__decap_3
XFILLER_177_283 VPWR VGND VPWR VGND sky130_ef_sc_hd__decap_12
XFILLER_193_732 VPWR VGND VPWR VGND sky130_ef_sc_hd__decap_12
XFILLER_220_390 VPWR VGND VPWR VGND sky130_ef_sc_hd__decap_12
XTAP_TAPCELL_ROW_74_2_5254 VGND VPWR sky130_fd_sc_hd__tapvpwrvgnd_1
XFILLER_166_968 VPWR VGND VPWR VGND sky130_ef_sc_hd__decap_12
XFILLER_181_916 VPWR VGND VPWR VGND sky130_ef_sc_hd__decap_12
XFILLER_193_787 VPWR VGND VPWR VGND sky130_ef_sc_hd__decap_12
XFILLER_14_1485 VPWR VGND VPWR VGND sky130_ef_sc_hd__decap_12
XFILLER_101_1433 VPWR VGND VPWR VGND sky130_ef_sc_hd__decap_12
XFILLER_10_1349 VGND VGND VPWR VPWR sky130_fd_sc_hd__decap_6
XFILLER_101_1488 VPWR VGND VPWR VGND sky130_ef_sc_hd__decap_12
XFILLER_245_80 VGND VGND VPWR VPWR sky130_fd_sc_hd__decap_6
XFILLER_47_1261 VPWR VGND VPWR VGND sky130_ef_sc_hd__decap_12
XFILLER_58_34 VPWR VGND VPWR VGND sky130_ef_sc_hd__decap_12
XFILLER_251_1444 VPWR VGND VPWR VGND sky130_ef_sc_hd__decap_12
XFILLER_134_1220 VGND VGND VPWR VPWR sky130_fd_sc_hd__decap_6
XFILLER_248_722 VPWR VGND VPWR VGND sky130_ef_sc_hd__decap_12
XFILLER_173_1291 VPWR VGND VPWR VGND sky130_ef_sc_hd__decap_12
XFILLER_82_1196 VPWR VGND VPWR VGND sky130_ef_sc_hd__decap_12
XFILLER_199_3 VPWR VGND VPWR VGND sky130_ef_sc_hd__decap_12
XFILLER_236_906 VPWR VGND VPWR VGND sky130_ef_sc_hd__decap_12
XFILLER_181_68 VPWR VGND VPWR VGND sky130_ef_sc_hd__decap_12
XFILLER_251_1499 VGND VGND VPWR VPWR sky130_fd_sc_hd__decap_6
XFILLER_248_777 VPWR VGND VPWR VGND sky130_ef_sc_hd__decap_12
XFILLER_74_22 VPWR VGND VPWR VGND sky130_ef_sc_hd__decap_12
XFILLER_169_1327 VGND VGND VPWR VPWR sky130_fd_sc_hd__decap_6
XFILLER_1_1506 VGND VGND VPWR VPWR sky130_fd_sc_hd__decap_8
XFILLER_210_1152 VPWR VGND VPWR VGND sky130_ef_sc_hd__decap_12
XFILLER_21_1445 VPWR VGND VPWR VGND sky130_ef_sc_hd__decap_12
XTAP_TAPCELL_ROW_221_3476 VGND VPWR sky130_fd_sc_hd__tapvpwrvgnd_1
XFILLER_244_961 VGND VGND VPWR VPWR sky130_fd_sc_hd__decap_6
XTAP_TAPCELL_ROW_221_3487 VGND VPWR sky130_fd_sc_hd__tapvpwrvgnd_1
XTAP_TAPCELL_ROW_221_3498 VGND VPWR sky130_fd_sc_hd__tapvpwrvgnd_1
XFILLER_203_302 VPWR VGND VPWR VGND sky130_ef_sc_hd__decap_12
XFILLER_215_173 VPWR VGND VPWR VGND sky130_ef_sc_hd__decap_12
XFILLER_245_1248 VPWR VGND VPWR VGND sky130_ef_sc_hd__decap_12
XFILLER_230_132 VPWR VGND VPWR VGND sky130_ef_sc_hd__decap_12
XFILLER_203_357 VPWR VGND VPWR VGND sky130_ef_sc_hd__decap_12
XFILLER_93_1292 VPWR VGND VPWR VGND sky130_ef_sc_hd__decap_12
XFILLER_90_65 VGND VGND VPWR VPWR sky130_fd_sc_hd__decap_6
XPHY_EDGE_ROW_97_2_Right_188 VGND VGND VPWR VPWR sky130_fd_sc_hd__decap_3
XFILLER_145_1371 VGND VGND VPWR VPWR sky130_fd_sc_hd__decap_6
XFILLER_175_209 VGND VGND VPWR VPWR sky130_fd_sc_hd__decap_6
XTAP_TAPCELL_ROW_178_1973 VGND VPWR sky130_fd_sc_hd__tapvpwrvgnd_1
XFILLER_180_1262 VGND VGND VPWR VPWR sky130_fd_sc_hd__decap_6
XFILLER_230_187 VGND VGND VPWR VPWR sky130_fd_sc_hd__decap_6
XFILLER_168_261 VPWR VGND VPWR VGND sky130_ef_sc_hd__decap_12
XFILLER_184_710 VPWR VGND VPWR VGND sky130_ef_sc_hd__decap_12
XTAP_TAPCELL_ROW_178_1984 VGND VPWR sky130_fd_sc_hd__tapvpwrvgnd_1
XFILLER_196_581 VPWR VGND VPWR VGND sky130_ef_sc_hd__decap_12
XTAP_TAPCELL_ROW_178_1995 VGND VPWR sky130_fd_sc_hd__tapvpwrvgnd_1
XFILLER_15_1249 VPWR VGND VPWR VGND sky130_ef_sc_hd__decap_12
XFILLER_7_411 VGND VGND VPWR VPWR sky130_fd_sc_hd__fill_1
Xwire320 net321 VGND VGND VPWR VPWR net320 sky130_fd_sc_hd__clkbuf_1
XTAP_TAPCELL_ROW_174_1837 VGND VPWR sky130_fd_sc_hd__tapvpwrvgnd_1
XFILLER_102_1208 VPWR VGND VPWR VGND sky130_ef_sc_hd__decap_12
XTAP_TAPCELL_ROW_174_1848 VGND VPWR sky130_fd_sc_hd__tapvpwrvgnd_1
XTAP_TAPCELL_ROW_215_3269 VGND VPWR sky130_fd_sc_hd__tapvpwrvgnd_1
Xwire342 net343 VGND VGND VPWR VPWR net342 sky130_fd_sc_hd__clkbuf_1
XFILLER_89_1328 VGND VGND VPWR VPWR sky130_fd_sc_hd__decap_6
XTAP_TAPCELL_ROW_174_1859 VGND VPWR sky130_fd_sc_hd__tapvpwrvgnd_1
XFILLER_106_1399 VPWR VGND VPWR VGND sky130_ef_sc_hd__decap_12
XFILLER_184_765 VPWR VGND VPWR VGND sky130_ef_sc_hd__decap_12
Xwire353 net354 VGND VGND VPWR VPWR net353 sky130_fd_sc_hd__clkbuf_1
Xwire364 net365 VGND VGND VPWR VPWR net364 sky130_fd_sc_hd__clkbuf_1
Xwire375 net376 VGND VGND VPWR VPWR net375 sky130_fd_sc_hd__clkbuf_1
Xwire386 net387 VGND VGND VPWR VPWR net386 sky130_fd_sc_hd__clkbuf_1
Xwire397 net398 VGND VGND VPWR VPWR net397 sky130_fd_sc_hd__clkbuf_1
Xmax_cap119 net120 VGND VGND VPWR VPWR net119 sky130_fd_sc_hd__clkbuf_1
XFILLER_172_949 VPWR VGND VPWR VGND sky130_ef_sc_hd__decap_12
XFILLER_174_1011 VPWR VGND VPWR VGND sky130_ef_sc_hd__decap_12
XFILLER_252_1219 VGND VGND VPWR VPWR sky130_fd_sc_hd__decap_6
XFILLER_174_1066 VPWR VGND VPWR VGND sky130_ef_sc_hd__decap_12
XFILLER_225_39 VGND VGND VPWR VPWR sky130_fd_sc_hd__decap_4
XTAP_TAPCELL_ROW_168_1619 VGND VPWR sky130_fd_sc_hd__tapvpwrvgnd_1
XFILLER_3_694 VGND VGND VPWR VPWR sky130_fd_sc_hd__fill_1
XFILLER_254_1090 VGND VGND VPWR VPWR sky130_fd_sc_hd__decap_6
XFILLER_239_744 VPWR VGND VPWR VGND sky130_ef_sc_hd__decap_12
XFILLER_26_1356 VPWR VGND VPWR VGND sky130_ef_sc_hd__decap_12
XFILLER_113_1304 VPWR VGND VPWR VGND sky130_ef_sc_hd__decap_12
XFILLER_254_703 VGND VGND VPWR VPWR sky130_fd_sc_hd__decap_6
XFILLER_227_928 VPWR VGND VPWR VGND sky130_ef_sc_hd__decap_12
XFILLER_239_799 VPWR VGND VPWR VGND sky130_ef_sc_hd__decap_12
XFILLER_241_27 VPWR VGND VPWR VGND sky130_ef_sc_hd__decap_12
XFILLER_113_1359 VPWR VGND VPWR VGND sky130_ef_sc_hd__decap_12
XFILLER_4_1152 VPWR VGND VPWR VGND sky130_ef_sc_hd__decap_12
XFILLER_206_151 VPWR VGND VPWR VGND sky130_ef_sc_hd__decap_12
XFILLER_235_983 VGND VGND VPWR VPWR sky130_fd_sc_hd__decap_6
XFILLER_0_85 VPWR VGND VPWR VGND sky130_ef_sc_hd__decap_12
XFILLER_59_1165 VPWR VGND VPWR VGND sky130_ef_sc_hd__decap_12
XFILLER_185_1162 VPWR VGND VPWR VGND sky130_ef_sc_hd__decap_12
XFILLER_181_1026 VGND VGND VPWR VPWR sky130_fd_sc_hd__decap_6
XTAP_TAPCELL_ROW_123_2_5648 VGND VPWR sky130_fd_sc_hd__tapvpwrvgnd_1
XFILLER_221_154 VPWR VGND VPWR VGND sky130_ef_sc_hd__decap_12
XFILLER_194_507 VPWR VGND VPWR VGND sky130_ef_sc_hd__decap_12
XTAP_TAPCELL_ROW_60_2_5140 VGND VPWR sky130_fd_sc_hd__tapvpwrvgnd_1
XFILLER_124_1411 VPWR VGND VPWR VGND sky130_ef_sc_hd__decap_12
XFILLER_210_839 VPWR VGND VPWR VGND sky130_ef_sc_hd__decap_12
XTAP_TAPCELL_ROW_59_2_5134 VGND VPWR sky130_fd_sc_hd__tapvpwrvgnd_1
XFILLER_222_1023 VPWR VGND VPWR VGND sky130_ef_sc_hd__decap_12
XFILLER_33_1316 VPWR VGND VPWR VGND sky130_ef_sc_hd__decap_12
XFILLER_175_732 VPWR VGND VPWR VGND sky130_ef_sc_hd__decap_12
XFILLER_202_390 VPWR VGND VPWR VGND sky130_ef_sc_hd__decap_12
XFILLER_124_1466 VPWR VGND VPWR VGND sky130_ef_sc_hd__decap_12
XFILLER_222_1078 VPWR VGND VPWR VGND sky130_ef_sc_hd__decap_12
XFILLER_159_1507 VGND VGND VPWR VPWR sky130_fd_sc_hd__decap_8
XFILLER_175_787 VPWR VGND VPWR VGND sky130_ef_sc_hd__decap_12
XTAP_TAPCELL_ROW_190_2395 VGND VPWR sky130_fd_sc_hd__tapvpwrvgnd_1
Xmax_cap620 net621 VGND VGND VPWR VPWR net620 sky130_fd_sc_hd__buf_1
XFILLER_190_746 VGND VGND VPWR VPWR sky130_fd_sc_hd__decap_6
XFILLER_200_1398 VPWR VGND VPWR VGND sky130_ef_sc_hd__decap_12
XFILLER_157_1242 VGND VGND VPWR VPWR sky130_fd_sc_hd__decap_6
XFILLER_171_971 VPWR VGND VPWR VGND sky130_ef_sc_hd__decap_12
XFILLER_192_1133 VGND VGND VPWR VPWR sky130_fd_sc_hd__decap_6
XPHY_EDGE_ROW_59_2_Right_150 VGND VGND VPWR VPWR sky130_fd_sc_hd__decap_3
XFILLER_135_39 VGND VGND VPWR VPWR sky130_fd_sc_hd__decap_4
XFILLER_44_1423 VPWR VGND VPWR VGND sky130_ef_sc_hd__decap_12
XFILLER_9_1030 VPWR VGND VPWR VGND sky130_ef_sc_hd__decap_12
XFILLER_9_1063 VGND VGND VPWR VPWR sky130_fd_sc_hd__decap_8
XTAP_TAPCELL_ROW_135_1_1432 VGND VPWR sky130_fd_sc_hd__tapvpwrvgnd_1
XFILLER_170_1453 VPWR VGND VPWR VGND sky130_ef_sc_hd__decap_12
XFILLER_28_15 VGND VGND VPWR VPWR sky130_fd_sc_hd__decap_6
XFILLER_218_906 VPWR VGND VPWR VGND sky130_ef_sc_hd__decap_12
XFILLER_233_1174 VPWR VGND VPWR VGND sky130_ef_sc_hd__decap_12
XFILLER_44_1478 VGND VGND VPWR VPWR sky130_fd_sc_hd__decap_6
XTAP_TAPCELL_ROW_184_2188 VGND VPWR sky130_fd_sc_hd__tapvpwrvgnd_1
XTAP_TAPCELL_ROW_184_2199 VGND VPWR sky130_fd_sc_hd__tapvpwrvgnd_1
XFILLER_245_725 VGND VGND VPWR VPWR sky130_fd_sc_hd__decap_6
XFILLER_151_27 VPWR VGND VPWR VGND sky130_ef_sc_hd__decap_12
XFILLER_42_1180 VGND VGND VPWR VPWR sky130_fd_sc_hd__decap_3
XFILLER_226_961 VGND VGND VPWR VPWR sky130_fd_sc_hd__decap_6
XFILLER_38_1227 VPWR VGND VPWR VGND sky130_ef_sc_hd__decap_12
XFILLER_212_132 VPWR VGND VPWR VGND sky130_ef_sc_hd__decap_12
XFILLER_197_345 VPWR VGND VPWR VGND sky130_ef_sc_hd__decap_12
XFILLER_240_452 VPWR VGND VPWR VGND sky130_ef_sc_hd__decap_12
XFILLER_200_316 VGND VGND VPWR VPWR sky130_fd_sc_hd__decap_6
XFILLER_244_1281 VPWR VGND VPWR VGND sky130_ef_sc_hd__decap_12
XFILLER_90_1454 VPWR VGND VPWR VGND sky130_ef_sc_hd__decap_12
XFILLER_185_529 VPWR VGND VPWR VGND sky130_ef_sc_hd__decap_12
XFILLER_212_187 VGND VGND VPWR VPWR sky130_fd_sc_hd__decap_6
XFILLER_166_710 VPWR VGND VPWR VGND sky130_ef_sc_hd__decap_12
XFILLER_178_581 VPWR VGND VPWR VGND sky130_ef_sc_hd__decap_12
XFILLER_60_46 VPWR VGND VPWR VGND sky130_ef_sc_hd__decap_12
XFILLER_166_765 VPWR VGND VPWR VGND sky130_ef_sc_hd__decap_12
XFILLER_5_904 VPWR VGND VPWR VGND sky130_ef_sc_hd__decap_12
XFILLER_165_253 VPWR VGND VPWR VGND sky130_ef_sc_hd__decap_12
XFILLER_197_1033 VPWR VGND VPWR VGND sky130_ef_sc_hd__decap_12
XFILLER_176_46 VPWR VGND VPWR VGND sky130_ef_sc_hd__decap_12
XFILLER_181_713 VPWR VGND VPWR VGND sky130_ef_sc_hd__decap_12
XTAP_TAPCELL_ROW_210_3100 VGND VPWR sky130_fd_sc_hd__tapvpwrvgnd_1
XTAP_TAPCELL_ROW_210_3111 VGND VPWR sky130_fd_sc_hd__tapvpwrvgnd_1
XFILLER_14_1282 VPWR VGND VPWR VGND sky130_ef_sc_hd__decap_12
XFILLER_101_1230 VPWR VGND VPWR VGND sky130_ef_sc_hd__decap_12
XFILLER_193_584 VPWR VGND VPWR VGND sky130_ef_sc_hd__decap_12
XTAP_TAPCELL_ROW_210_3122 VGND VPWR sky130_fd_sc_hd__tapvpwrvgnd_1
XFILLER_114_3 VPWR VGND VPWR VGND sky130_ef_sc_hd__decap_12
XFILLER_165_286 VGND VGND VPWR VPWR sky130_fd_sc_hd__decap_8
XFILLER_5_959 VPWR VGND VPWR VGND sky130_ef_sc_hd__decap_12
XFILLER_197_1088 VPWR VGND VPWR VGND sky130_ef_sc_hd__decap_12
XFILLER_181_768 VGND VGND VPWR VPWR sky130_fd_sc_hd__decap_6
XFILLER_253_1506 VGND VGND VPWR VPWR sky130_fd_sc_hd__decap_8
XFILLER_101_1285 VGND VGND VPWR VPWR sky130_fd_sc_hd__decap_6
XFILLER_69_44 VPWR VGND VPWR VGND sky130_ef_sc_hd__decap_12
XFILLER_192_34 VPWR VGND VPWR VGND sky130_ef_sc_hd__decap_12
XFILLER_49_1378 VPWR VGND VPWR VGND sky130_ef_sc_hd__decap_12
XFILLER_136_1337 VPWR VGND VPWR VGND sky130_ef_sc_hd__decap_12
XFILLER_171_1217 VPWR VGND VPWR VGND sky130_ef_sc_hd__decap_12
XTAP_TAPCELL_ROW_116_2_5591 VGND VPWR sky130_fd_sc_hd__tapvpwrvgnd_1
XFILLER_251_1241 VGND VGND VPWR VPWR sky130_fd_sc_hd__decap_6
XFILLER_192_89 VPWR VGND VPWR VGND sky130_ef_sc_hd__decap_12
XTAP_TAPCELL_ROW_208_3040 VGND VPWR sky130_fd_sc_hd__tapvpwrvgnd_1
XTAP_TAPCELL_ROW_208_3051 VGND VPWR sky130_fd_sc_hd__tapvpwrvgnd_1
XFILLER_23_1507 VGND VGND VPWR VPWR sky130_fd_sc_hd__decap_8
XTAP_TAPCELL_ROW_227_3685 VGND VPWR sky130_fd_sc_hd__tapvpwrvgnd_1
XTAP_TAPCELL_ROW_227_3696 VGND VPWR sky130_fd_sc_hd__tapvpwrvgnd_1
XFILLER_236_703 VGND VGND VPWR VPWR sky130_fd_sc_hd__decap_6
XFILLER_248_574 VGND VGND VPWR VPWR sky130_fd_sc_hd__decap_6
XFILLER_209_928 VPWR VGND VPWR VGND sky130_ef_sc_hd__decap_12
XTAP_TAPCELL_ROW_223_3549 VGND VPWR sky130_fd_sc_hd__tapvpwrvgnd_1
XFILLER_212_1269 VPWR VGND VPWR VGND sky130_ef_sc_hd__decap_12
XFILLER_1_1303 VPWR VGND VPWR VGND sky130_ef_sc_hd__decap_12
XFILLER_21_1242 VGND VGND VPWR VPWR sky130_fd_sc_hd__decap_6
XFILLER_112_1392 VGND VGND VPWR VPWR sky130_fd_sc_hd__decap_6
XFILLER_217_983 VGND VGND VPWR VPWR sky130_fd_sc_hd__decap_6
XFILLER_1_1358 VPWR VGND VPWR VGND sky130_ef_sc_hd__decap_12
XTAP_TAPCELL_ROW_108_2_5528 VGND VPWR sky130_fd_sc_hd__tapvpwrvgnd_1
XFILLER_147_1433 VPWR VGND VPWR VGND sky130_ef_sc_hd__decap_12
XFILLER_250_249 VPWR VGND VPWR VGND sky130_ef_sc_hd__decap_12
XFILLER_182_1324 VPWR VGND VPWR VGND sky130_ef_sc_hd__decap_12
XFILLER_245_1045 VPWR VGND VPWR VGND sky130_ef_sc_hd__decap_12
XTAP_TAPCELL_ROW_45_2_5020 VGND VPWR sky130_fd_sc_hd__tapvpwrvgnd_1
XFILLER_91_1218 VPWR VGND VPWR VGND sky130_ef_sc_hd__decap_12
XFILLER_188_323 VPWR VGND VPWR VGND sky130_ef_sc_hd__decap_12
XFILLER_56_1349 VGND VGND VPWR VPWR sky130_fd_sc_hd__decap_6
XFILLER_203_154 VPWR VGND VPWR VGND sky130_ef_sc_hd__decap_12
XFILLER_147_1488 VPWR VGND VPWR VGND sky130_ef_sc_hd__decap_12
XFILLER_176_507 VPWR VGND VPWR VGND sky130_ef_sc_hd__decap_12
XFILLER_182_1379 VPWR VGND VPWR VGND sky130_ef_sc_hd__decap_12
XFILLER_231_474 VPWR VGND VPWR VGND sky130_ef_sc_hd__decap_12
XTAP_TAPCELL_ROW_65_1_1327 VGND VPWR sky130_fd_sc_hd__tapvpwrvgnd_1
XFILLER_188_378 VPWR VGND VPWR VGND sky130_ef_sc_hd__decap_12
XPHY_EDGE_ROW_98_2_Right_189 VGND VGND VPWR VPWR sky130_fd_sc_hd__decap_3
XTAP_TAPCELL_ROW_12_2_4761 VGND VPWR sky130_fd_sc_hd__tapvpwrvgnd_1
XFILLER_8_753 VPWR VGND VPWR VGND sky130_ef_sc_hd__decap_12
XFILLER_184_562 VPWR VGND VPWR VGND sky130_ef_sc_hd__decap_12
Xwire150 _181_ VGND VGND VPWR VPWR net150 sky130_fd_sc_hd__clkbuf_1
XFILLER_106_1196 VPWR VGND VPWR VGND sky130_ef_sc_hd__decap_12
XFILLER_200_894 VPWR VGND VPWR VGND sky130_ef_sc_hd__decap_12
Xwire161 net162 VGND VGND VPWR VPWR net161 sky130_fd_sc_hd__clkbuf_1
Xwire172 _124_ VGND VGND VPWR VPWR net172 sky130_fd_sc_hd__clkbuf_1
XFILLER_172_746 VGND VGND VPWR VPWR sky130_fd_sc_hd__decap_6
XFILLER_193_1420 VPWR VGND VPWR VGND sky130_ef_sc_hd__decap_12
XFILLER_67_1445 VPWR VGND VPWR VGND sky130_ef_sc_hd__decap_12
XFILLER_193_1475 VPWR VGND VPWR VGND sky130_ef_sc_hd__decap_12
XFILLER_4_992 VPWR VGND VPWR VGND sky130_ef_sc_hd__decap_12
XFILLER_252_15 VGND VGND VPWR VPWR sky130_fd_sc_hd__decap_6
XFILLER_239_541 VPWR VGND VPWR VGND sky130_ef_sc_hd__decap_12
XFILLER_117_1292 VPWR VGND VPWR VGND sky130_ef_sc_hd__decap_12
XFILLER_230_1336 VPWR VGND VPWR VGND sky130_ef_sc_hd__decap_12
XFILLER_227_725 VGND VGND VPWR VPWR sky130_fd_sc_hd__decap_6
XFILLER_6_1269 VPWR VGND VPWR VGND sky130_ef_sc_hd__decap_12
XTAP_TAPCELL_ROW_2_929 VGND VPWR sky130_fd_sc_hd__tapvpwrvgnd_1
XFILLER_239_596 VGND VGND VPWR VPWR sky130_fd_sc_hd__decap_6
XFILLER_113_1189 VPWR VGND VPWR VGND sky130_ef_sc_hd__decap_12
XFILLER_208_961 VGND VGND VPWR VPWR sky130_fd_sc_hd__decap_6
XFILLER_148_1208 VPWR VGND VPWR VGND sky130_ef_sc_hd__decap_12
XFILLER_241_216 VPWR VGND VPWR VGND sky130_ef_sc_hd__decap_12
XFILLER_179_345 VPWR VGND VPWR VGND sky130_ef_sc_hd__decap_12
XFILLER_222_452 VPWR VGND VPWR VGND sky130_ef_sc_hd__decap_12
XFILLER_194_304 VPWR VGND VPWR VGND sky130_ef_sc_hd__decap_12
XFILLER_210_636 VPWR VGND VPWR VGND sky130_ef_sc_hd__decap_12
XFILLER_241_1432 VPWR VGND VPWR VGND sky130_ef_sc_hd__decap_12
XFILLER_167_529 VPWR VGND VPWR VGND sky130_ef_sc_hd__decap_12
XFILLER_72_1184 VPWR VGND VPWR VGND sky130_ef_sc_hd__decap_12
XTAP_TAPCELL_ROW_192_2468 VGND VPWR sky130_fd_sc_hd__tapvpwrvgnd_1
XFILLER_124_1263 VGND VGND VPWR VPWR sky130_fd_sc_hd__decap_6
XTAP_TAPCELL_ROW_192_2479 VGND VPWR sky130_fd_sc_hd__tapvpwrvgnd_1
XFILLER_194_359 VGND VGND VPWR VPWR sky130_fd_sc_hd__decap_6
XFILLER_241_1487 VPWR VGND VPWR VGND sky130_ef_sc_hd__decap_12
XTAP_TAPCELL_ROW_153_2_5887 VGND VPWR sky130_fd_sc_hd__tapvpwrvgnd_1
XFILLER_159_1304 VPWR VGND VPWR VGND sky130_ef_sc_hd__decap_12
XFILLER_175_584 VPWR VGND VPWR VGND sky130_ef_sc_hd__decap_12
XFILLER_11_1433 VPWR VGND VPWR VGND sky130_ef_sc_hd__decap_12
XFILLER_200_1140 VPWR VGND VPWR VGND sky130_ef_sc_hd__decap_12
XTAP_TAPCELL_ROW_89_2_5373 VGND VPWR sky130_fd_sc_hd__tapvpwrvgnd_1
XFILLER_159_1359 VPWR VGND VPWR VGND sky130_ef_sc_hd__decap_12
XFILLER_11_1488 VPWR VGND VPWR VGND sky130_ef_sc_hd__decap_12
XFILLER_2_918 VGND VGND VPWR VPWR sky130_fd_sc_hd__decap_6
XFILLER_200_1195 VPWR VGND VPWR VGND sky130_ef_sc_hd__decap_12
Xmax_cap494 net495 VGND VGND VPWR VPWR net494 sky130_fd_sc_hd__clkbuf_1
XFILLER_249_338 VGND VGND VPWR VPWR sky130_fd_sc_hd__decap_6
XFILLER_44_1220 VGND VGND VPWR VPWR sky130_fd_sc_hd__decap_6
XFILLER_162_15 VGND VGND VPWR VPWR sky130_fd_sc_hd__decap_6
XFILLER_39_69 VGND VGND VPWR VPWR sky130_fd_sc_hd__fill_2
XTAP_TAPCELL_ROW_82_2_5316 VGND VPWR sky130_fd_sc_hd__tapvpwrvgnd_1
XFILLER_131_1201 VGND VGND VPWR VPWR sky130_fd_sc_hd__decap_4
XFILLER_170_1250 VPWR VGND VPWR VGND sky130_ef_sc_hd__decap_12
XFILLER_218_703 VGND VGND VPWR VPWR sky130_fd_sc_hd__decap_6
XFILLER_79_1316 VPWR VGND VPWR VGND sky130_ef_sc_hd__decap_12
XFILLER_211_1291 VPWR VGND VPWR VGND sky130_ef_sc_hd__decap_12
XFILLER_55_68 VGND VGND VPWR VPWR sky130_fd_sc_hd__decap_3
X_470_ net149 net123 VGND VGND VPWR VPWR acc_core.adder.cla_blocks\[1\].block.sum\[0\]
+ sky130_fd_sc_hd__xnor2_1
XTAP_TAPCELL_ROW_17_2_4798 VGND VPWR sky130_fd_sc_hd__tapvpwrvgnd_1
XFILLER_232_249 VPWR VGND VPWR VGND sky130_ef_sc_hd__decap_12
XFILLER_242_1207 VPWR VGND VPWR VGND sky130_ef_sc_hd__decap_12
XFILLER_207_1327 VGND VGND VPWR VPWR sky130_fd_sc_hd__decap_6
XFILLER_201_603 VPWR VGND VPWR VGND sky130_ef_sc_hd__decap_12
XFILLER_246_1398 VPWR VGND VPWR VGND sky130_ef_sc_hd__decap_12
XFILLER_197_142 VPWR VGND VPWR VGND sky130_ef_sc_hd__decap_12
XFILLER_213_474 VPWR VGND VPWR VGND sky130_ef_sc_hd__decap_12
XFILLER_71_56 VPWR VGND VPWR VGND sky130_ef_sc_hd__decap_12
XFILLER_9_517 VGND VGND VPWR VPWR sky130_fd_sc_hd__decap_8
XTAP_TAPCELL_ROW_216_3320 VGND VPWR sky130_fd_sc_hd__tapvpwrvgnd_1
XFILLER_55_1371 VGND VGND VPWR VPWR sky130_fd_sc_hd__decap_6
XFILLER_90_1251 VPWR VGND VPWR VGND sky130_ef_sc_hd__decap_12
XFILLER_185_326 VPWR VGND VPWR VGND sky130_ef_sc_hd__decap_12
XTAP_TAPCELL_ROW_216_3331 VGND VPWR sky130_fd_sc_hd__tapvpwrvgnd_1
XFILLER_231_3 VPWR VGND VPWR VGND sky130_ef_sc_hd__decap_12
XFILLER_201_658 VPWR VGND VPWR VGND sky130_ef_sc_hd__decap_12
XFILLER_197_197 VPWR VGND VPWR VGND sky130_ef_sc_hd__decap_12
XTAP_TAPCELL_ROW_235_3965 VGND VPWR sky130_fd_sc_hd__tapvpwrvgnd_1
XFILLER_187_56 VPWR VGND VPWR VGND sky130_ef_sc_hd__decap_12
XTAP_TAPCELL_ROW_235_3976 VGND VPWR sky130_fd_sc_hd__tapvpwrvgnd_1
XTAP_TAPCELL_ROW_235_3987 VGND VPWR sky130_fd_sc_hd__tapvpwrvgnd_1
XTAP_TAPCELL_ROW_231_3829 VGND VPWR sky130_fd_sc_hd__tapvpwrvgnd_1
XTAP_TAPCELL_ROW_235_3998 VGND VPWR sky130_fd_sc_hd__tapvpwrvgnd_1
XFILLER_12_1208 VPWR VGND VPWR VGND sky130_ef_sc_hd__decap_12
XFILLER_166_562 VPWR VGND VPWR VGND sky130_ef_sc_hd__decap_12
XFILLER_194_882 VPWR VGND VPWR VGND sky130_ef_sc_hd__decap_12
XFILLER_16_1399 VPWR VGND VPWR VGND sky130_ef_sc_hd__decap_12
XFILLER_103_1347 VPWR VGND VPWR VGND sky130_ef_sc_hd__decap_12
XFILLER_181_510 VGND VGND VPWR VPWR sky130_fd_sc_hd__decap_6
XFILLER_193_381 VGND VGND VPWR VPWR sky130_fd_sc_hd__decap_6
XFILLER_253_1303 VPWR VGND VPWR VGND sky130_ef_sc_hd__decap_12
XFILLER_218_1434 VGND VGND VPWR VPWR sky130_fd_sc_hd__decap_6
XTAP_TAPCELL_ROW_229_3758 VGND VPWR sky130_fd_sc_hd__tapvpwrvgnd_1
XFILLER_171_1014 VPWR VGND VPWR VGND sky130_ef_sc_hd__decap_12
XTAP_TAPCELL_ROW_229_3769 VGND VPWR sky130_fd_sc_hd__tapvpwrvgnd_1
XFILLER_253_1358 VPWR VGND VPWR VGND sky130_ef_sc_hd__decap_12
XFILLER_1_940 VGND VGND VPWR VPWR sky130_fd_sc_hd__decap_6
XFILLER_171_1069 VGND VGND VPWR VPWR sky130_fd_sc_hd__decap_6
XFILLER_249_861 VPWR VGND VPWR VGND sky130_ef_sc_hd__decap_12
XFILLER_23_1304 VPWR VGND VPWR VGND sky130_ef_sc_hd__decap_12
XFILLER_212_1011 VPWR VGND VPWR VGND sky130_ef_sc_hd__decap_12
XFILLER_209_725 VGND VGND VPWR VPWR sky130_fd_sc_hd__decap_6
XFILLER_114_1454 VPWR VGND VPWR VGND sky130_ef_sc_hd__decap_12
XFILLER_23_1359 VPWR VGND VPWR VGND sky130_ef_sc_hd__decap_12
XFILLER_212_1066 VPWR VGND VPWR VGND sky130_ef_sc_hd__decap_12
XFILLER_1_1100 VPWR VGND VPWR VGND sky130_ef_sc_hd__decap_12
XFILLER_5_1291 VPWR VGND VPWR VGND sky130_ef_sc_hd__decap_12
XFILLER_223_216 VPWR VGND VPWR VGND sky130_ef_sc_hd__decap_12
XFILLER_1_1155 VGND VGND VPWR VPWR sky130_fd_sc_hd__decap_6
XPHY_EDGE_ROW_59_2_Left_561 VGND VGND VPWR VPWR sky130_fd_sc_hd__decap_3
XFILLER_147_1230 VPWR VGND VPWR VGND sky130_ef_sc_hd__decap_12
XFILLER_182_1121 VPWR VGND VPWR VGND sky130_ef_sc_hd__decap_12
XFILLER_188_120 VPWR VGND VPWR VGND sky130_ef_sc_hd__decap_12
XFILLER_204_452 VPWR VGND VPWR VGND sky130_ef_sc_hd__decap_12
X_599_ clknet_3_2__leaf_clk _081_ _007_ VGND VGND VPWR VPWR rd_addr\[7\] sky130_fd_sc_hd__dfrtp_1
XFILLER_147_1285 VGND VGND VPWR VPWR sky130_fd_sc_hd__decap_6
XFILLER_176_304 VPWR VGND VPWR VGND sky130_ef_sc_hd__decap_12
XFILLER_231_271 VPWR VGND VPWR VGND sky130_ef_sc_hd__decap_12
XFILLER_182_1176 VGND VGND VPWR VPWR sky130_fd_sc_hd__decap_6
XFILLER_34_1411 VPWR VGND VPWR VGND sky130_ef_sc_hd__decap_12
XFILLER_188_175 VPWR VGND VPWR VGND sky130_ef_sc_hd__decap_12
XTAP_TAPCELL_ROW_138_2_5767 VGND VPWR sky130_fd_sc_hd__tapvpwrvgnd_1
XFILLER_176_359 VGND VGND VPWR VPWR sky130_fd_sc_hd__decap_6
XFILLER_192_808 VPWR VGND VPWR VGND sky130_ef_sc_hd__decap_12
XFILLER_223_1162 VPWR VGND VPWR VGND sky130_ef_sc_hd__decap_12
XFILLER_34_1466 VPWR VGND VPWR VGND sky130_ef_sc_hd__decap_12
XFILLER_121_1414 VGND VGND VPWR VPWR sky130_fd_sc_hd__decap_6
XFILLER_247_15 VPWR VGND VPWR VGND sky130_ef_sc_hd__decap_12
XFILLER_77_3 VPWR VGND VPWR VGND sky130_ef_sc_hd__decap_12
XFILLER_160_1485 VPWR VGND VPWR VGND sky130_ef_sc_hd__decap_12
XFILLER_69_1507 VGND VGND VPWR VPWR sky130_fd_sc_hd__decap_8
XFILLER_200_691 VPWR VGND VPWR VGND sky130_ef_sc_hd__decap_12
XFILLER_67_1242 VGND VGND VPWR VPWR sky130_fd_sc_hd__decap_6
XFILLER_158_1392 VGND VGND VPWR VPWR sky130_fd_sc_hd__decap_6
XFILLER_193_1272 VPWR VGND VPWR VGND sky130_ef_sc_hd__decap_12
XFILLER_115_1218 VPWR VGND VPWR VGND sky130_ef_sc_hd__decap_12
XFILLER_6_1011 VPWR VGND VPWR VGND sky130_ef_sc_hd__decap_12
XFILLER_80_1442 VPWR VGND VPWR VGND sky130_ef_sc_hd__decap_12
XTAP_TAPCELL_ROW_181_2103 VGND VPWR sky130_fd_sc_hd__tapvpwrvgnd_1
XFILLER_230_1133 VGND VGND VPWR VPWR sky130_fd_sc_hd__decap_6
XFILLER_255_820 VPWR VGND VPWR VGND sky130_ef_sc_hd__decap_12
XFILLER_6_1066 VPWR VGND VPWR VGND sky130_ef_sc_hd__decap_12
XFILLER_80_1497 VPWR VGND VPWR VGND sky130_ef_sc_hd__decap_12
XTAP_TAPCELL_ROW_34_2_4937 VGND VPWR sky130_fd_sc_hd__tapvpwrvgnd_1
XFILLER_255_853 VGND VGND VPWR VPWR sky130_fd_sc_hd__decap_8
XPHY_EDGE_ROW_125_1_Left_380 VGND VGND VPWR VPWR sky130_fd_sc_hd__decap_3
XTAP_TAPCELL_ROW_179_2010 VGND VPWR sky130_fd_sc_hd__tapvpwrvgnd_1
XFILLER_187_1076 VPWR VGND VPWR VGND sky130_ef_sc_hd__decap_12
XTAP_TAPCELL_ROW_179_2021 VGND VPWR sky130_fd_sc_hd__tapvpwrvgnd_1
XFILLER_25_27 VGND VGND VPWR VPWR sky130_fd_sc_hd__decap_6
XTAP_TAPCELL_ROW_179_2032 VGND VPWR sky130_fd_sc_hd__tapvpwrvgnd_1
XFILLER_214_249 VPWR VGND VPWR VGND sky130_ef_sc_hd__decap_12
XTAP_TAPCELL_ROW_198_2677 VGND VPWR sky130_fd_sc_hd__tapvpwrvgnd_1
XTAP_TAPCELL_ROW_198_2688 VGND VPWR sky130_fd_sc_hd__tapvpwrvgnd_1
XFILLER_179_142 VPWR VGND VPWR VGND sky130_ef_sc_hd__decap_12
XTAP_TAPCELL_ROW_198_2699 VGND VPWR sky130_fd_sc_hd__tapvpwrvgnd_1
XFILLER_126_1325 VPWR VGND VPWR VGND sky130_ef_sc_hd__decap_12
XFILLER_194_101 VGND VGND VPWR VPWR sky130_fd_sc_hd__decap_6
XTAP_TAPCELL_ROW_35_1_1282 VGND VPWR sky130_fd_sc_hd__tapvpwrvgnd_1
XFILLER_167_326 VPWR VGND VPWR VGND sky130_ef_sc_hd__decap_12
XFILLER_210_433 VPWR VGND VPWR VGND sky130_ef_sc_hd__decap_12
XFILLER_161_1249 VPWR VGND VPWR VGND sky130_ef_sc_hd__decap_12
XFILLER_179_197 VPWR VGND VPWR VGND sky130_ef_sc_hd__decap_12
XFILLER_195_646 VPWR VGND VPWR VGND sky130_ef_sc_hd__decap_12
XFILLER_41_15 VPWR VGND VPWR VGND sky130_ef_sc_hd__decap_12
XFILLER_157_15 VPWR VGND VPWR VGND sky130_ef_sc_hd__decap_12
XFILLER_210_488 VGND VGND VPWR VPWR sky130_fd_sc_hd__decap_6
XFILLER_241_1284 VGND VGND VPWR VPWR sky130_fd_sc_hd__decap_6
XFILLER_176_882 VPWR VGND VPWR VGND sky130_ef_sc_hd__decap_12
XFILLER_100_1509 VGND VGND VPWR VPWR sky130_fd_sc_hd__decap_6
XFILLER_175_381 VGND VGND VPWR VPWR sky130_fd_sc_hd__decap_6
XFILLER_191_830 VPWR VGND VPWR VGND sky130_ef_sc_hd__decap_12
XFILLER_11_1230 VPWR VGND VPWR VGND sky130_ef_sc_hd__decap_12
XTAP_TAPCELL_ROW_123_1_1414 VGND VPWR sky130_fd_sc_hd__tapvpwrvgnd_1
XFILLER_198_1183 VPWR VGND VPWR VGND sky130_ef_sc_hd__decap_12
XFILLER_102_1380 VPWR VGND VPWR VGND sky130_ef_sc_hd__decap_12
XFILLER_191_885 VPWR VGND VPWR VGND sky130_ef_sc_hd__decap_12
XFILLER_194_1047 VGND VGND VPWR VPWR sky130_fd_sc_hd__decap_6
XFILLER_11_1285 VGND VGND VPWR VPWR sky130_fd_sc_hd__decap_6
XFILLER_159_1189 VPWR VGND VPWR VGND sky130_ef_sc_hd__decap_12
XFILLER_137_1421 VPWR VGND VPWR VGND sky130_ef_sc_hd__decap_12
XFILLER_1_214 VGND VGND VPWR VPWR sky130_fd_sc_hd__fill_1
XFILLER_172_1312 VPWR VGND VPWR VGND sky130_ef_sc_hd__decap_12
XFILLER_81_1206 VPWR VGND VPWR VGND sky130_ef_sc_hd__decap_12
XFILLER_235_1033 VPWR VGND VPWR VGND sky130_ef_sc_hd__decap_12
XFILLER_46_1337 VPWR VGND VPWR VGND sky130_ef_sc_hd__decap_12
XFILLER_137_1476 VPWR VGND VPWR VGND sky130_ef_sc_hd__decap_12
XFILLER_172_1367 VPWR VGND VPWR VGND sky130_ef_sc_hd__decap_12
XTAP_TAPCELL_ROW_224_3600 VGND VPWR sky130_fd_sc_hd__tapvpwrvgnd_1
XFILLER_235_1088 VPWR VGND VPWR VGND sky130_ef_sc_hd__decap_12
XTAP_TAPCELL_ROW_224_3611 VGND VPWR sky130_fd_sc_hd__tapvpwrvgnd_1
XFILLER_253_80 VGND VGND VPWR VPWR sky130_fd_sc_hd__decap_6
XFILLER_252_1391 VGND VGND VPWR VPWR sky130_fd_sc_hd__decap_6
XFILLER_246_820 VPWR VGND VPWR VGND sky130_ef_sc_hd__decap_12
XFILLER_66_34 VPWR VGND VPWR VGND sky130_ef_sc_hd__decap_12
XFILLER_181_3 VPWR VGND VPWR VGND sky130_ef_sc_hd__decap_12
XFILLER_246_875 VGND VGND VPWR VPWR sky130_fd_sc_hd__decap_6
X_522_ net665 VGND VGND VPWR VPWR _004_ sky130_fd_sc_hd__inv_2
XFILLER_2_1453 VPWR VGND VPWR VGND sky130_ef_sc_hd__decap_12
XFILLER_205_216 VPWR VGND VPWR VGND sky130_ef_sc_hd__decap_12
XFILLER_22_1392 VGND VGND VPWR VPWR sky130_fd_sc_hd__decap_6
XFILLER_82_22 VPWR VGND VPWR VGND sky130_ef_sc_hd__decap_12
XFILLER_246_1140 VPWR VGND VPWR VGND sky130_ef_sc_hd__decap_12
XFILLER_57_1433 VPWR VGND VPWR VGND sky130_ef_sc_hd__decap_12
XFILLER_92_1313 VPWR VGND VPWR VGND sky130_ef_sc_hd__decap_12
X_453_ net199 _239_ VGND VGND VPWR VPWR acc_core.adder.cla_blocks\[0\].block.p\[0\]
+ sky130_fd_sc_hd__nor2_1
XFILLER_198_22 VPWR VGND VPWR VGND sky130_ef_sc_hd__decap_12
XTAP_TAPCELL_ROW_124_2_5653 VGND VPWR sky130_fd_sc_hd__tapvpwrvgnd_1
XFILLER_242_1004 VGND VGND VPWR VPWR sky130_fd_sc_hd__decap_6
XFILLER_183_1463 VPWR VGND VPWR VGND sky130_ef_sc_hd__decap_12
XFILLER_201_400 VPWR VGND VPWR VGND sky130_ef_sc_hd__decap_12
XFILLER_246_1195 VPWR VGND VPWR VGND sky130_ef_sc_hd__decap_12
XFILLER_57_1488 VPWR VGND VPWR VGND sky130_ef_sc_hd__decap_12
XFILLER_92_1368 VPWR VGND VPWR VGND sky130_ef_sc_hd__decap_12
XFILLER_213_271 VPWR VGND VPWR VGND sky130_ef_sc_hd__decap_12
X_384_ net214 net211 VGND VGND VPWR VPWR _173_ sky130_fd_sc_hd__nor2_1
XFILLER_186_624 VPWR VGND VPWR VGND sky130_ef_sc_hd__decap_12
XFILLER_198_77 VPWR VGND VPWR VGND sky130_ef_sc_hd__decap_12
XFILLER_9_303 VGND VGND VPWR VPWR sky130_fd_sc_hd__decap_3
XFILLER_198_495 VPWR VGND VPWR VGND sky130_ef_sc_hd__decap_12
XFILLER_185_123 VGND VGND VPWR VPWR sky130_fd_sc_hd__decap_6
XFILLER_201_455 VPWR VGND VPWR VGND sky130_ef_sc_hd__decap_12
XFILLER_174_808 VPWR VGND VPWR VGND sky130_ef_sc_hd__decap_12
XFILLER_186_679 VPWR VGND VPWR VGND sky130_ef_sc_hd__decap_12
XFILLER_9_358 VPWR VGND VPWR VGND sky130_ef_sc_hd__decap_12
XFILLER_220_1324 VPWR VGND VPWR VGND sky130_ef_sc_hd__decap_12
XFILLER_16_1196 VPWR VGND VPWR VGND sky130_ef_sc_hd__decap_12
XTAP_TAPCELL_ROW_27_2_4880 VGND VPWR sky130_fd_sc_hd__tapvpwrvgnd_1
XFILLER_220_1379 VPWR VGND VPWR VGND sky130_ef_sc_hd__decap_12
XFILLER_31_70 VGND VGND VPWR VPWR sky130_fd_sc_hd__fill_1
XPHY_EDGE_ROW_80_1_Right_736 VGND VGND VPWR VPWR sky130_fd_sc_hd__decap_3
XFILLER_103_1177 VPWR VGND VPWR VGND sky130_ef_sc_hd__decap_12
XFILLER_182_863 VPWR VGND VPWR VGND sky130_ef_sc_hd__decap_12
XFILLER_253_1100 VPWR VGND VPWR VGND sky130_ef_sc_hd__decap_12
XFILLER_190_1434 VGND VGND VPWR VPWR sky130_fd_sc_hd__decap_6
XFILLER_253_1155 VGND VGND VPWR VPWR sky130_fd_sc_hd__decap_6
Xoutput70 net557 VGND VGND VPWR VPWR acc_out[5] sky130_fd_sc_hd__buf_2
XTAP_TAPCELL_ROW_20_2_4823 VGND VPWR sky130_fd_sc_hd__tapvpwrvgnd_1
XFILLER_231_1420 VPWR VGND VPWR VGND sky130_ef_sc_hd__decap_12
XTAP_TAPCELL_ROW_19_2_4817 VGND VPWR sky130_fd_sc_hd__tapvpwrvgnd_1
XFILLER_233_39 VGND VGND VPWR VPWR sky130_fd_sc_hd__decap_4
XFILLER_27_1292 VPWR VGND VPWR VGND sky130_ef_sc_hd__decap_12
XFILLER_255_127 VPWR VGND VPWR VGND sky130_ef_sc_hd__decap_12
XFILLER_114_1251 VPWR VGND VPWR VGND sky130_ef_sc_hd__decap_12
XFILLER_231_1475 VPWR VGND VPWR VGND sky130_ef_sc_hd__decap_12
XFILLER_237_842 VPWR VGND VPWR VGND sky130_ef_sc_hd__decap_12
XFILLER_3_1217 VPWR VGND VPWR VGND sky130_ef_sc_hd__decap_12
XTAP_TAPCELL_ROW_53_1_1309 VGND VPWR sky130_fd_sc_hd__tapvpwrvgnd_1
XFILLER_23_1189 VPWR VGND VPWR VGND sky130_ef_sc_hd__decap_12
XFILLER_237_897 VGND VGND VPWR VPWR sky130_fd_sc_hd__decap_6
XFILLER_58_1208 VPWR VGND VPWR VGND sky130_ef_sc_hd__decap_12
XFILLER_75_1500 VGND VGND VPWR VPWR sky130_fd_sc_hd__decap_6
XFILLER_149_1347 VPWR VGND VPWR VGND sky130_ef_sc_hd__decap_12
XFILLER_184_1238 VPWR VGND VPWR VGND sky130_ef_sc_hd__decap_12
XFILLER_251_388 VPWR VGND VPWR VGND sky130_ef_sc_hd__decap_12
XTAP_TAPCELL_ROW_201_2784 VGND VPWR sky130_fd_sc_hd__tapvpwrvgnd_1
XTAP_TAPCELL_ROW_201_2795 VGND VPWR sky130_fd_sc_hd__tapvpwrvgnd_1
XFILLER_176_101 VGND VGND VPWR VPWR sky130_fd_sc_hd__decap_6
XFILLER_177_646 VPWR VGND VPWR VGND sky130_ef_sc_hd__decap_12
XFILLER_220_753 VPWR VGND VPWR VGND sky130_ef_sc_hd__decap_12
XTAP_TAPCELL_ROW_253_4596 VGND VPWR sky130_fd_sc_hd__tapvpwrvgnd_1
XFILLER_192_605 VPWR VGND VPWR VGND sky130_ef_sc_hd__decap_12
XFILLER_34_1263 VGND VGND VPWR VPWR sky130_fd_sc_hd__decap_6
XFILLER_160_1282 VPWR VGND VPWR VGND sky130_ef_sc_hd__decap_12
XFILLER_69_1304 VPWR VGND VPWR VGND sky130_ef_sc_hd__decap_12
XFILLER_173_830 VPWR VGND VPWR VGND sky130_ef_sc_hd__decap_12
XFILLER_195_1334 VPWR VGND VPWR VGND sky130_ef_sc_hd__decap_12
XFILLER_69_1359 VPWR VGND VPWR VGND sky130_ef_sc_hd__decap_12
XFILLER_173_885 VPWR VGND VPWR VGND sky130_ef_sc_hd__decap_12
XTAP_TAPCELL_ROW_187_2301 VGND VPWR sky130_fd_sc_hd__tapvpwrvgnd_1
XTAP_TAPCELL_ROW_187_2312 VGND VPWR sky130_fd_sc_hd__tapvpwrvgnd_1
XFILLER_195_1389 VPWR VGND VPWR VGND sky130_ef_sc_hd__decap_12
XTAP_TAPCELL_ROW_247_4389 VGND VPWR sky130_fd_sc_hd__tapvpwrvgnd_1
XFILLER_143_39 VGND VGND VPWR VPWR sky130_fd_sc_hd__decap_4
XFILLER_247_639 VGND VGND VPWR VPWR sky130_fd_sc_hd__decap_6
XFILLER_41_1201 VGND VGND VPWR VPWR sky130_fd_sc_hd__decap_4
XTAP_TAPCELL_ROW_161_2_5949 VGND VPWR sky130_fd_sc_hd__tapvpwrvgnd_1
XFILLER_228_820 VPWR VGND VPWR VGND sky130_ef_sc_hd__decap_12
XTAP_TAPCELL_ROW_9_1178 VGND VPWR sky130_fd_sc_hd__tapvpwrvgnd_1
XFILLER_80_1294 VPWR VGND VPWR VGND sky130_ef_sc_hd__decap_12
XTAP_TAPCELL_ROW_9_1189 VGND VPWR sky130_fd_sc_hd__tapvpwrvgnd_1
XTAP_TAPCELL_ROW_97_2_5435 VGND VPWR sky130_fd_sc_hd__tapvpwrvgnd_1
XFILLER_36_15 VGND VGND VPWR VPWR sky130_fd_sc_hd__decap_6
XFILLER_228_875 VGND VGND VPWR VPWR sky130_fd_sc_hd__decap_6
XTAP_TAPCELL_ROW_66_2_5193 VGND VPWR sky130_fd_sc_hd__tapvpwrvgnd_1
XFILLER_255_694 VPWR VGND VPWR VGND sky130_ef_sc_hd__decap_12
XTAP_TAPCELL_ROW_109_2_5533 VGND VPWR sky130_fd_sc_hd__tapvpwrvgnd_1
XFILLER_242_366 VPWR VGND VPWR VGND sky130_ef_sc_hd__decap_12
XFILLER_199_259 VPWR VGND VPWR VGND sky130_ef_sc_hd__decap_12
XFILLER_208_1422 VPWR VGND VPWR VGND sky130_ef_sc_hd__decap_12
XFILLER_243_1346 VPWR VGND VPWR VGND sky130_ef_sc_hd__decap_12
XFILLER_168_624 VPWR VGND VPWR VGND sky130_ef_sc_hd__decap_12
XFILLER_208_1477 VGND VGND VPWR VPWR sky130_fd_sc_hd__decap_6
XFILLER_210_230 VGND VGND VPWR VPWR sky130_fd_sc_hd__decap_6
XFILLER_167_123 VGND VGND VPWR VPWR sky130_fd_sc_hd__decap_6
XFILLER_195_443 VPWR VGND VPWR VGND sky130_ef_sc_hd__decap_12
XFILLER_211_775 VPWR VGND VPWR VGND sky130_ef_sc_hd__decap_12
XFILLER_126_1177 VGND VGND VPWR VPWR sky130_fd_sc_hd__decap_6
XFILLER_91_1390 VPWR VGND VPWR VGND sky130_ef_sc_hd__decap_12
XFILLER_168_58 VGND VGND VPWR VPWR sky130_fd_sc_hd__decap_6
XFILLER_168_679 VPWR VGND VPWR VGND sky130_ef_sc_hd__decap_12
XFILLER_183_627 VPWR VGND VPWR VGND sky130_ef_sc_hd__decap_12
XFILLER_104_1442 VPWR VGND VPWR VGND sky130_ef_sc_hd__decap_12
XFILLER_195_498 VPWR VGND VPWR VGND sky130_ef_sc_hd__decap_12
XFILLER_196_1109 VPWR VGND VPWR VGND sky130_ef_sc_hd__decap_12
XFILLER_202_1054 VPWR VGND VPWR VGND sky130_ef_sc_hd__decap_12
XFILLER_13_1347 VPWR VGND VPWR VGND sky130_ef_sc_hd__decap_12
XFILLER_100_1306 VGND VGND VPWR VPWR sky130_fd_sc_hd__decap_6
XFILLER_104_1497 VPWR VGND VPWR VGND sky130_ef_sc_hd__decap_12
XFILLER_184_46 VPWR VGND VPWR VGND sky130_ef_sc_hd__decap_12
XFILLER_191_682 VGND VGND VPWR VPWR sky130_fd_sc_hd__decap_6
Xsram0_674 VGND VGND VPWR VPWR sram0_674/HI net674 sky130_fd_sc_hd__conb_1
Xsram0_685 VGND VGND VPWR VPWR net685 sram0_685/LO sky130_fd_sc_hd__conb_1
XTAP_TAPCELL_ROW_170_1692 VGND VPWR sky130_fd_sc_hd__tapvpwrvgnd_1
XFILLER_254_1453 VPWR VGND VPWR VGND sky130_ef_sc_hd__decap_12
XFILLER_77_44 VPWR VGND VPWR VGND sky130_ef_sc_hd__decap_12
XFILLER_137_1273 VPWR VGND VPWR VGND sky130_ef_sc_hd__decap_12
XFILLER_172_1164 VPWR VGND VPWR VGND sky130_ef_sc_hd__decap_12
XFILLER_238_617 VGND VGND VPWR VPWR sky130_fd_sc_hd__decap_6
XFILLER_24_1454 VPWR VGND VPWR VGND sky130_ef_sc_hd__decap_12
XFILLER_111_1402 VPWR VGND VPWR VGND sky130_ef_sc_hd__decap_12
XFILLER_219_842 VPWR VGND VPWR VGND sky130_ef_sc_hd__decap_12
XFILLER_252_108 VPWR VGND VPWR VGND sky130_ef_sc_hd__decap_12
XFILLER_111_1457 VGND VGND VPWR VPWR sky130_fd_sc_hd__decap_6
XFILLER_219_897 VGND VGND VPWR VPWR sky130_fd_sc_hd__decap_6
XFILLER_185_1514 VGND VGND VPWR VPWR sky130_fd_sc_hd__fill_1
XFILLER_2_1250 VPWR VGND VPWR VGND sky130_ef_sc_hd__decap_12
XFILLER_146_1509 VGND VGND VPWR VPWR sky130_fd_sc_hd__decap_6
X_505_ _108_ _256_ _258_ VGND VGND VPWR VPWR acc_core.adder.cla_blocks\[6\].block.sum\[2\]
+ sky130_fd_sc_hd__nor3_1
XFILLER_57_1230 VPWR VGND VPWR VGND sky130_ef_sc_hd__decap_12
XFILLER_221_517 VPWR VGND VPWR VGND sky130_ef_sc_hd__decap_12
XFILLER_233_388 VPWR VGND VPWR VGND sky130_ef_sc_hd__decap_12
XFILLER_183_1260 VPWR VGND VPWR VGND sky130_ef_sc_hd__decap_12
X_436_ net598 dout0_q\[20\] net536 VGND VGND VPWR VPWR _225_ sky130_fd_sc_hd__a21oi_1
XFILLER_148_1380 VPWR VGND VPWR VGND sky130_ef_sc_hd__decap_12
XFILLER_57_1285 VGND VGND VPWR VPWR sky130_fd_sc_hd__decap_6
XFILLER_92_1165 VPWR VGND VPWR VGND sky130_ef_sc_hd__decap_12
XFILLER_186_421 VPWR VGND VPWR VGND sky130_ef_sc_hd__decap_12
XFILLER_202_753 VPWR VGND VPWR VGND sky130_ef_sc_hd__decap_12
XFILLER_105_1206 VPWR VGND VPWR VGND sky130_ef_sc_hd__decap_12
XFILLER_198_292 VPWR VGND VPWR VGND sky130_ef_sc_hd__decap_12
X_367_ net247 _155_ VGND VGND VPWR VPWR _156_ sky130_fd_sc_hd__nand2b_1
XFILLER_201_252 VGND VGND VPWR VPWR sky130_fd_sc_hd__decap_6
XFILLER_174_605 VPWR VGND VPWR VGND sky130_ef_sc_hd__decap_12
XFILLER_186_476 VPWR VGND VPWR VGND sky130_ef_sc_hd__decap_12
XFILLER_31_1414 VGND VGND VPWR VPWR sky130_fd_sc_hd__decap_6
XTAP_TAPCELL_ROW_154_2_5892 VGND VPWR sky130_fd_sc_hd__tapvpwrvgnd_1
XFILLER_220_1121 VPWR VGND VPWR VGND sky130_ef_sc_hd__decap_12
XFILLER_70_1485 VPWR VGND VPWR VGND sky130_ef_sc_hd__decap_12
X_298_ net690 net524 VGND VGND VPWR VPWR _075_ sky130_fd_sc_hd__xnor2_1
XFILLER_220_1176 VGND VGND VPWR VPWR sky130_fd_sc_hd__decap_6
XFILLER_182_660 VGND VGND VPWR VPWR sky130_fd_sc_hd__decap_6
XPHY_EDGE_ROW_81_1_Right_737 VGND VGND VPWR VPWR sky130_fd_sc_hd__decap_3
XFILLER_68_1392 VGND VGND VPWR VPWR sky130_fd_sc_hd__decap_6
XTAP_TAPCELL_ROW_146_2_5829 VGND VPWR sky130_fd_sc_hd__tapvpwrvgnd_1
XTAP_TAPCELL_ROW_242_4220 VGND VPWR sky130_fd_sc_hd__tapvpwrvgnd_1
XFILLER_116_1313 VPWR VGND VPWR VGND sky130_ef_sc_hd__decap_12
XTAP_TAPCELL_ROW_242_4231 VGND VPWR sky130_fd_sc_hd__tapvpwrvgnd_1
XTAP_TAPCELL_ROW_242_4242 VGND VPWR sky130_fd_sc_hd__tapvpwrvgnd_1
XFILLER_25_1218 VPWR VGND VPWR VGND sky130_ef_sc_hd__decap_12
XFILLER_229_639 VGND VGND VPWR VPWR sky130_fd_sc_hd__decap_6
XFILLER_116_1368 VPWR VGND VPWR VGND sky130_ef_sc_hd__decap_12
XFILLER_231_1272 VPWR VGND VPWR VGND sky130_ef_sc_hd__decap_12
XFILLER_3_1014 VPWR VGND VPWR VGND sky130_ef_sc_hd__decap_12
XTAP_TAPCELL_ROW_4_1020 VGND VPWR sky130_fd_sc_hd__tapvpwrvgnd_1
XTAP_TAPCELL_ROW_207_2993 VGND VPWR sky130_fd_sc_hd__tapvpwrvgnd_1
XTAP_TAPCELL_ROW_4_1031 VGND VPWR sky130_fd_sc_hd__tapvpwrvgnd_1
XFILLER_3_1069 VGND VGND VPWR VPWR sky130_fd_sc_hd__decap_6
XTAP_TAPCELL_ROW_203_2846 VGND VPWR sky130_fd_sc_hd__tapvpwrvgnd_1
XTAP_TAPCELL_ROW_203_2857 VGND VPWR sky130_fd_sc_hd__tapvpwrvgnd_1
XTAP_TAPCELL_ROW_236_4002 VGND VPWR sky130_fd_sc_hd__tapvpwrvgnd_1
XFILLER_251_130 VPWR VGND VPWR VGND sky130_ef_sc_hd__decap_12
XFILLER_184_1035 VPWR VGND VPWR VGND sky130_ef_sc_hd__decap_12
XTAP_TAPCELL_ROW_203_2868 VGND VPWR sky130_fd_sc_hd__tapvpwrvgnd_1
XTAP_TAPCELL_ROW_236_4013 VGND VPWR sky130_fd_sc_hd__tapvpwrvgnd_1
XFILLER_224_366 VPWR VGND VPWR VGND sky130_ef_sc_hd__decap_12
XTAP_TAPCELL_ROW_236_4024 VGND VPWR sky130_fd_sc_hd__tapvpwrvgnd_1
XFILLER_149_1177 VPWR VGND VPWR VGND sky130_ef_sc_hd__decap_12
XTAP_TAPCELL_ROW_255_4669 VGND VPWR sky130_fd_sc_hd__tapvpwrvgnd_1
XFILLER_251_185 VPWR VGND VPWR VGND sky130_ef_sc_hd__decap_12
XTAP_TAPCELL_ROW_44_2_5016 VGND VPWR sky130_fd_sc_hd__tapvpwrvgnd_1
XFILLER_196_218 VPWR VGND VPWR VGND sky130_ef_sc_hd__decap_12
XFILLER_36_1325 VPWR VGND VPWR VGND sky130_ef_sc_hd__decap_12
XFILLER_240_1508 VGND VGND VPWR VPWR sky130_fd_sc_hd__decap_6
XFILLER_127_1464 VPWR VGND VPWR VGND sky130_ef_sc_hd__decap_12
XFILLER_177_443 VPWR VGND VPWR VGND sky130_ef_sc_hd__decap_12
XFILLER_220_550 VPWR VGND VPWR VGND sky130_ef_sc_hd__decap_12
XFILLER_71_1249 VPWR VGND VPWR VGND sky130_ef_sc_hd__decap_12
XFILLER_225_1076 VPWR VGND VPWR VGND sky130_ef_sc_hd__decap_12
XFILLER_123_1328 VGND VGND VPWR VPWR sky130_fd_sc_hd__decap_6
XFILLER_192_402 VGND VGND VPWR VPWR sky130_fd_sc_hd__decap_6
XFILLER_162_1399 VPWR VGND VPWR VGND sky130_ef_sc_hd__decap_12
XFILLER_177_498 VPWR VGND VPWR VGND sky130_ef_sc_hd__decap_12
XFILLER_193_947 VPWR VGND VPWR VGND sky130_ef_sc_hd__decap_12
XTAP_TAPCELL_ROW_11_2_4746 VGND VPWR sky130_fd_sc_hd__tapvpwrvgnd_1
XFILLER_10_1509 VGND VGND VPWR VPWR sky130_fd_sc_hd__decap_6
XFILLER_195_1131 VPWR VGND VPWR VGND sky130_ef_sc_hd__decap_12
XFILLER_173_682 VGND VGND VPWR VPWR sky130_fd_sc_hd__decap_6
XFILLER_12_1380 VPWR VGND VPWR VGND sky130_ef_sc_hd__decap_12
XFILLER_69_1189 VPWR VGND VPWR VGND sky130_ef_sc_hd__decap_12
XFILLER_195_1186 VPWR VGND VPWR VGND sky130_ef_sc_hd__decap_12
XFILLER_47_1421 VPWR VGND VPWR VGND sky130_ef_sc_hd__decap_12
XPHY_EDGE_ROW_11_2_Left_513 VGND VGND VPWR VPWR sky130_fd_sc_hd__decap_3
XFILLER_236_1183 VPWR VGND VPWR VGND sky130_ef_sc_hd__decap_12
XFILLER_47_1476 VPWR VGND VPWR VGND sky130_ef_sc_hd__decap_12
XFILLER_82_1356 VPWR VGND VPWR VGND sky130_ef_sc_hd__decap_12
XFILLER_134_1435 VGND VGND VPWR VPWR sky130_fd_sc_hd__decap_6
XFILLER_248_937 VPWR VGND VPWR VGND sky130_ef_sc_hd__decap_12
XFILLER_232_1047 VGND VGND VPWR VPWR sky130_fd_sc_hd__decap_6
XFILLER_170_15 VGND VGND VPWR VPWR sky130_fd_sc_hd__decap_6
XFILLER_210_1312 VPWR VGND VPWR VGND sky130_ef_sc_hd__decap_12
XFILLER_234_108 VPWR VGND VPWR VGND sky130_ef_sc_hd__decap_12
XTAP_TAPCELL_ROW_23_1_1264 VGND VPWR sky130_fd_sc_hd__tapvpwrvgnd_1
XFILLER_210_1367 VPWR VGND VPWR VGND sky130_ef_sc_hd__decap_12
XFILLER_203_517 VPWR VGND VPWR VGND sky130_ef_sc_hd__decap_12
XFILLER_242_163 VPWR VGND VPWR VGND sky130_ef_sc_hd__decap_12
XFILLER_128_1239 VPWR VGND VPWR VGND sky130_ef_sc_hd__decap_12
XFILLER_215_388 VPWR VGND VPWR VGND sky130_ef_sc_hd__decap_12
XFILLER_63_68 VGND VGND VPWR VPWR sky130_fd_sc_hd__decap_3
XFILLER_180_1422 VPWR VGND VPWR VGND sky130_ef_sc_hd__decap_12
XFILLER_230_347 VPWR VGND VPWR VGND sky130_ef_sc_hd__decap_12
XFILLER_243_1143 VPWR VGND VPWR VGND sky130_ef_sc_hd__decap_12
XFILLER_168_421 VPWR VGND VPWR VGND sky130_ef_sc_hd__decap_12
XFILLER_144_3 VPWR VGND VPWR VGND sky130_ef_sc_hd__decap_12
XFILLER_179_68 VPWR VGND VPWR VGND sky130_ef_sc_hd__decap_12
XTAP_TAPCELL_ROW_139_2_5772 VGND VPWR sky130_fd_sc_hd__tapvpwrvgnd_1
XFILLER_195_240 VPWR VGND VPWR VGND sky130_ef_sc_hd__decap_12
XFILLER_180_1477 VGND VGND VPWR VPWR sky130_fd_sc_hd__decap_6
XFILLER_211_572 VPWR VGND VPWR VGND sky130_ef_sc_hd__decap_12
XFILLER_243_1198 VGND VGND VPWR VPWR sky130_fd_sc_hd__decap_6
XFILLER_168_476 VPWR VGND VPWR VGND sky130_ef_sc_hd__decap_12
XFILLER_184_925 VPWR VGND VPWR VGND sky130_ef_sc_hd__decap_12
XFILLER_196_796 VPWR VGND VPWR VGND sky130_ef_sc_hd__decap_12
XFILLER_183_424 VGND VGND VPWR VPWR sky130_fd_sc_hd__decap_6
Xwire546 net547 VGND VGND VPWR VPWR net546 sky130_fd_sc_hd__clkbuf_1
XFILLER_195_295 VGND VGND VPWR VPWR sky130_fd_sc_hd__decap_6
XFILLER_221_1463 VPWR VGND VPWR VGND sky130_ef_sc_hd__decap_12
Xwire557 net558 VGND VGND VPWR VPWR net557 sky130_fd_sc_hd__buf_1
Xwire568 net54 VGND VGND VPWR VPWR net568 sky130_fd_sc_hd__clkbuf_1
XFILLER_87_1201 VGND VGND VPWR VPWR sky130_fd_sc_hd__decap_4
XFILLER_195_56 VPWR VGND VPWR VGND sky130_ef_sc_hd__decap_12
Xwire579 dout0_q\[8\] VGND VGND VPWR VPWR net579 sky130_fd_sc_hd__clkbuf_1
XFILLER_13_1177 VPWR VGND VPWR VGND sky130_ef_sc_hd__decap_12
XFILLER_104_1294 VPWR VGND VPWR VGND sky130_ef_sc_hd__decap_12
XTAP_TAPCELL_ROW_172_1765 VGND VPWR sky130_fd_sc_hd__tapvpwrvgnd_1
XTAP_TAPCELL_ROW_172_1776 VGND VPWR sky130_fd_sc_hd__tapvpwrvgnd_1
XFILLER_192_980 VPWR VGND VPWR VGND sky130_ef_sc_hd__decap_12
XTAP_TAPCELL_ROW_213_3197 VGND VPWR sky130_fd_sc_hd__tapvpwrvgnd_1
XTAP_TAPCELL_ROW_88_2_5369 VGND VPWR sky130_fd_sc_hd__tapvpwrvgnd_1
XTAP_TAPCELL_ROW_172_1787 VGND VPWR sky130_fd_sc_hd__tapvpwrvgnd_1
XTAP_TAPCELL_ROW_132_2_5715 VGND VPWR sky130_fd_sc_hd__tapvpwrvgnd_1
XFILLER_139_1335 VPWR VGND VPWR VGND sky130_ef_sc_hd__decap_12
XFILLER_174_1226 VPWR VGND VPWR VGND sky130_ef_sc_hd__decap_12
XTAP_TAPCELL_ROW_101_2_5473 VGND VPWR sky130_fd_sc_hd__tapvpwrvgnd_1
XFILLER_88_65 VGND VGND VPWR VPWR sky130_fd_sc_hd__decap_6
XFILLER_254_1250 VPWR VGND VPWR VGND sky130_ef_sc_hd__decap_12
XFILLER_219_1370 VGND VGND VPWR VPWR sky130_fd_sc_hd__decap_6
XPHY_EDGE_ROW_68_2_Left_570 VGND VGND VPWR VPWR sky130_fd_sc_hd__decap_3
XFILLER_239_904 VPWR VGND VPWR VGND sky130_ef_sc_hd__decap_12
XFILLER_239_959 VPWR VGND VPWR VGND sky130_ef_sc_hd__decap_12
XFILLER_4_1312 VPWR VGND VPWR VGND sky130_ef_sc_hd__decap_12
XTAP_TAPCELL_ROW_166_1558 VGND VPWR sky130_fd_sc_hd__tapvpwrvgnd_1
XFILLER_254_918 VGND VGND VPWR VPWR sky130_fd_sc_hd__decap_6
XTAP_TAPCELL_ROW_35_2_4942 VGND VPWR sky130_fd_sc_hd__tapvpwrvgnd_1
XFILLER_24_1251 VPWR VGND VPWR VGND sky130_ef_sc_hd__decap_12
XTAP_TAPCELL_ROW_166_1569 VGND VPWR sky130_fd_sc_hd__tapvpwrvgnd_1
XTAP_TAPCELL_ROW_50_2_5059 VGND VPWR sky130_fd_sc_hd__tapvpwrvgnd_1
XFILLER_115_1390 VPWR VGND VPWR VGND sky130_ef_sc_hd__decap_12
XFILLER_150_1270 VPWR VGND VPWR VGND sky130_ef_sc_hd__decap_12
XFILLER_4_1367 VPWR VGND VPWR VGND sky130_ef_sc_hd__decap_12
XFILLER_233_130 VPWR VGND VPWR VGND sky130_ef_sc_hd__decap_12
XFILLER_248_1054 VPWR VGND VPWR VGND sky130_ef_sc_hd__decap_12
XFILLER_59_1347 VPWR VGND VPWR VGND sky130_ef_sc_hd__decap_12
XFILLER_94_1227 VPWR VGND VPWR VGND sky130_ef_sc_hd__decap_12
XFILLER_146_1306 VGND VGND VPWR VPWR sky130_fd_sc_hd__decap_6
XFILLER_206_366 VPWR VGND VPWR VGND sky130_ef_sc_hd__decap_12
XFILLER_185_1377 VPWR VGND VPWR VGND sky130_ef_sc_hd__decap_12
XFILLER_221_314 VPWR VGND VPWR VGND sky130_ef_sc_hd__decap_12
XFILLER_233_185 VPWR VGND VPWR VGND sky130_ef_sc_hd__decap_12
XFILLER_178_218 VPWR VGND VPWR VGND sky130_ef_sc_hd__decap_12
XTAP_TAPCELL_ROW_250_4500 VGND VPWR sky130_fd_sc_hd__tapvpwrvgnd_1
XTAP_TAPCELL_ROW_250_4511 VGND VPWR sky130_fd_sc_hd__tapvpwrvgnd_1
XFILLER_221_369 VPWR VGND VPWR VGND sky130_ef_sc_hd__decap_12
XTAP_TAPCELL_ROW_250_4522 VGND VPWR sky130_fd_sc_hd__tapvpwrvgnd_1
X_419_ _145_ _146_ net250 VGND VGND VPWR VPWR _208_ sky130_fd_sc_hd__and3_1
XFILLER_202_550 VPWR VGND VPWR VGND sky130_ef_sc_hd__decap_12
XFILLER_239_27 VPWR VGND VPWR VGND sky130_ef_sc_hd__decap_12
XFILLER_222_1238 VPWR VGND VPWR VGND sky130_ef_sc_hd__decap_12
XFILLER_174_402 VGND VGND VPWR VPWR sky130_fd_sc_hd__decap_6
XFILLER_186_273 VGND VGND VPWR VPWR sky130_fd_sc_hd__decap_6
XFILLER_175_947 VPWR VGND VPWR VGND sky130_ef_sc_hd__decap_12
XFILLER_70_1282 VPWR VGND VPWR VGND sky130_ef_sc_hd__decap_12
XFILLER_200_1514 VGND VGND VPWR VPWR sky130_fd_sc_hd__fill_1
XFILLER_190_906 VPWR VGND VPWR VGND sky130_ef_sc_hd__decap_12
XFILLER_255_15 VGND VGND VPWR VPWR sky130_fd_sc_hd__decap_6
XFILLER_157_1402 VPWR VGND VPWR VGND sky130_ef_sc_hd__decap_12
XTAP_TAPCELL_ROW_248_4440 VGND VPWR sky130_fd_sc_hd__tapvpwrvgnd_1
XTAP_TAPCELL_ROW_248_4451 VGND VPWR sky130_fd_sc_hd__tapvpwrvgnd_1
XFILLER_196_1484 VPWR VGND VPWR VGND sky130_ef_sc_hd__decap_12
XTAP_TAPCELL_ROW_244_4304 VGND VPWR sky130_fd_sc_hd__tapvpwrvgnd_1
XFILLER_157_1457 VGND VGND VPWR VPWR sky130_fd_sc_hd__decap_6
XPHY_EDGE_ROW_82_1_Right_738 VGND VGND VPWR VPWR sky130_fd_sc_hd__decap_3
XFILLER_192_1348 VGND VGND VPWR VPWR sky130_fd_sc_hd__decap_6
XFILLER_233_1334 VPWR VGND VPWR VGND sky130_ef_sc_hd__decap_12
XFILLER_155_1192 VPWR VGND VPWR VGND sky130_ef_sc_hd__decap_12
XFILLER_116_1165 VPWR VGND VPWR VGND sky130_ef_sc_hd__decap_12
XFILLER_233_1389 VPWR VGND VPWR VGND sky130_ef_sc_hd__decap_12
XTAP_TAPCELL_ROW_205_2919 VGND VPWR sky130_fd_sc_hd__tapvpwrvgnd_1
XPHY_EDGE_ROW_153_1_Left_408 VGND VGND VPWR VPWR sky130_fd_sc_hd__decap_3
XFILLER_216_108 VPWR VGND VPWR VGND sky130_ef_sc_hd__decap_12
XFILLER_238_992 VPWR VGND VPWR VGND sky130_ef_sc_hd__decap_12
XFILLER_253_940 VGND VGND VPWR VPWR sky130_fd_sc_hd__decap_6
XFILLER_17_39 VGND VGND VPWR VPWR sky130_fd_sc_hd__decap_4
XTAP_TAPCELL_ROW_0_824 VGND VPWR sky130_fd_sc_hd__tapvpwrvgnd_1
XFILLER_77_1414 VGND VGND VPWR VPWR sky130_fd_sc_hd__decap_6
XTAP_TAPCELL_ROW_0_835 VGND VPWR sky130_fd_sc_hd__tapvpwrvgnd_1
XTAP_TAPCELL_ROW_0_846 VGND VPWR sky130_fd_sc_hd__tapvpwrvgnd_1
XTAP_TAPCELL_ROW_0_857 VGND VPWR sky130_fd_sc_hd__tapvpwrvgnd_1
XTAP_TAPCELL_ROW_156_2_5911 VGND VPWR sky130_fd_sc_hd__tapvpwrvgnd_1
XTAP_TAPCELL_ROW_0_868 VGND VPWR sky130_fd_sc_hd__tapvpwrvgnd_1
XTAP_TAPCELL_ROW_0_879 VGND VPWR sky130_fd_sc_hd__tapvpwrvgnd_1
XFILLER_224_163 VPWR VGND VPWR VGND sky130_ef_sc_hd__decap_12
XFILLER_244_1441 VPWR VGND VPWR VGND sky130_ef_sc_hd__decap_12
XFILLER_212_347 VPWR VGND VPWR VGND sky130_ef_sc_hd__decap_12
XFILLER_33_27 VPWR VGND VPWR VGND sky130_ef_sc_hd__decap_12
XFILLER_240_667 VPWR VGND VPWR VGND sky130_ef_sc_hd__decap_12
XFILLER_240_1305 VGND VGND VPWR VPWR sky130_fd_sc_hd__decap_6
XFILLER_127_1261 VPWR VGND VPWR VGND sky130_ef_sc_hd__decap_12
XFILLER_149_27 VPWR VGND VPWR VGND sky130_ef_sc_hd__decap_12
XFILLER_177_240 VPWR VGND VPWR VGND sky130_ef_sc_hd__decap_12
XFILLER_244_1496 VPWR VGND VPWR VGND sky130_ef_sc_hd__decap_12
XFILLER_36_1177 VGND VGND VPWR VPWR sky130_fd_sc_hd__decap_6
XFILLER_166_925 VPWR VGND VPWR VGND sky130_ef_sc_hd__decap_12
XFILLER_178_796 VPWR VGND VPWR VGND sky130_ef_sc_hd__decap_12
XFILLER_162_1196 VPWR VGND VPWR VGND sky130_ef_sc_hd__decap_12
XFILLER_177_295 VGND VGND VPWR VPWR sky130_fd_sc_hd__decap_6
XFILLER_193_744 VPWR VGND VPWR VGND sky130_ef_sc_hd__decap_12
XFILLER_14_1442 VPWR VGND VPWR VGND sky130_ef_sc_hd__decap_12
XTAP_TAPCELL_ROW_74_2_5255 VGND VPWR sky130_fd_sc_hd__tapvpwrvgnd_1
XFILLER_10_1306 VGND VGND VPWR VPWR sky130_fd_sc_hd__decap_6
XFILLER_181_928 VPWR VGND VPWR VGND sky130_ef_sc_hd__decap_12
XFILLER_197_1248 VPWR VGND VPWR VGND sky130_ef_sc_hd__decap_12
XFILLER_4_618 VGND VGND VPWR VPWR sky130_fd_sc_hd__fill_2
XFILLER_193_799 VPWR VGND VPWR VGND sky130_ef_sc_hd__decap_12
XFILLER_14_1497 VPWR VGND VPWR VGND sky130_ef_sc_hd__decap_12
XFILLER_101_1445 VPWR VGND VPWR VGND sky130_ef_sc_hd__decap_12
XFILLER_165_15 VGND VGND VPWR VPWR sky130_fd_sc_hd__decap_6
XFILLER_174_980 VPWR VGND VPWR VGND sky130_ef_sc_hd__decap_12
XFILLER_234_1109 VPWR VGND VPWR VGND sky130_ef_sc_hd__decap_12
XFILLER_251_1401 VPWR VGND VPWR VGND sky130_ef_sc_hd__decap_12
XFILLER_47_1273 VPWR VGND VPWR VGND sky130_ef_sc_hd__decap_12
XFILLER_58_46 VPWR VGND VPWR VGND sky130_ef_sc_hd__decap_12
XFILLER_251_1456 VGND VGND VPWR VPWR sky130_fd_sc_hd__decap_6
XFILLER_248_734 VPWR VGND VPWR VGND sky130_ef_sc_hd__decap_12
XFILLER_236_918 VGND VGND VPWR VPWR sky130_fd_sc_hd__decap_6
XFILLER_21_1402 VPWR VGND VPWR VGND sky130_ef_sc_hd__decap_12
XFILLER_248_789 VGND VGND VPWR VPWR sky130_fd_sc_hd__decap_6
XFILLER_74_34 VPWR VGND VPWR VGND sky130_ef_sc_hd__decap_12
XFILLER_21_1457 VGND VGND VPWR VPWR sky130_fd_sc_hd__decap_6
XFILLER_210_1164 VPWR VGND VPWR VGND sky130_ef_sc_hd__decap_12
XPHY_EDGE_ROW_44_1_Right_700 VGND VGND VPWR VPWR sky130_fd_sc_hd__decap_3
XTAP_TAPCELL_ROW_221_3477 VGND VPWR sky130_fd_sc_hd__tapvpwrvgnd_1
XFILLER_250_409 VPWR VGND VPWR VGND sky130_ef_sc_hd__decap_12
XFILLER_215_130 VPWR VGND VPWR VGND sky130_ef_sc_hd__decap_12
XTAP_TAPCELL_ROW_221_3488 VGND VPWR sky130_fd_sc_hd__tapvpwrvgnd_1
XFILLER_245_1205 VPWR VGND VPWR VGND sky130_ef_sc_hd__decap_12
XTAP_TAPCELL_ROW_221_3499 VGND VPWR sky130_fd_sc_hd__tapvpwrvgnd_1
XFILLER_56_1509 VGND VGND VPWR VPWR sky130_fd_sc_hd__decap_6
XFILLER_203_314 VPWR VGND VPWR VGND sky130_ef_sc_hd__decap_12
XTAP_TAPCELL_ROW_129_1_1423 VGND VPWR sky130_fd_sc_hd__tapvpwrvgnd_1
XFILLER_215_185 VPWR VGND VPWR VGND sky130_ef_sc_hd__decap_12
XFILLER_188_538 VPWR VGND VPWR VGND sky130_ef_sc_hd__decap_12
XFILLER_58_1380 VPWR VGND VPWR VGND sky130_ef_sc_hd__decap_12
XFILLER_90_22 VPWR VGND VPWR VGND sky130_ef_sc_hd__decap_12
XFILLER_230_144 VGND VGND VPWR VPWR sky130_fd_sc_hd__decap_6
XFILLER_203_369 VPWR VGND VPWR VGND sky130_ef_sc_hd__decap_12
XFILLER_223_1514 VGND VGND VPWR VPWR sky130_fd_sc_hd__fill_1
XFILLER_231_689 VPWR VGND VPWR VGND sky130_ef_sc_hd__decap_12
XFILLER_15_1206 VPWR VGND VPWR VGND sky130_ef_sc_hd__decap_12
XTAP_TAPCELL_ROW_178_1974 VGND VPWR sky130_fd_sc_hd__tapvpwrvgnd_1
XTAP_TAPCELL_ROW_178_1985 VGND VPWR sky130_fd_sc_hd__tapvpwrvgnd_1
Xwire310 net311 VGND VGND VPWR VPWR net310 sky130_fd_sc_hd__clkbuf_1
XFILLER_106_1356 VPWR VGND VPWR VGND sky130_ef_sc_hd__decap_12
XFILLER_168_273 VGND VGND VPWR VPWR sky130_fd_sc_hd__decap_6
XTAP_TAPCELL_ROW_178_1996 VGND VPWR sky130_fd_sc_hd__tapvpwrvgnd_1
XFILLER_184_722 VPWR VGND VPWR VGND sky130_ef_sc_hd__decap_12
XTAP_TAPCELL_ROW_174_1838 VGND VPWR sky130_fd_sc_hd__tapvpwrvgnd_1
XFILLER_196_593 VPWR VGND VPWR VGND sky130_ef_sc_hd__decap_12
Xwire321 net322 VGND VGND VPWR VPWR net321 sky130_fd_sc_hd__clkbuf_1
XTAP_TAPCELL_ROW_174_1849 VGND VPWR sky130_fd_sc_hd__tapvpwrvgnd_1
Xwire343 net344 VGND VGND VPWR VPWR net343 sky130_fd_sc_hd__clkbuf_1
XFILLER_172_906 VPWR VGND VPWR VGND sky130_ef_sc_hd__decap_12
XFILLER_221_1260 VPWR VGND VPWR VGND sky130_ef_sc_hd__decap_12
XFILLER_8_968 VPWR VGND VPWR VGND sky130_ef_sc_hd__decap_12
Xwire354 net355 VGND VGND VPWR VPWR net354 sky130_fd_sc_hd__clkbuf_1
Xwire365 net366 VGND VGND VPWR VPWR net365 sky130_fd_sc_hd__clkbuf_1
XFILLER_184_777 VPWR VGND VPWR VGND sky130_ef_sc_hd__decap_12
Xwire376 net377 VGND VGND VPWR VPWR net376 sky130_fd_sc_hd__clkbuf_1
Xwire387 net388 VGND VGND VPWR VPWR net387 sky130_fd_sc_hd__clkbuf_1
Xwire398 net399 VGND VGND VPWR VPWR net398 sky130_fd_sc_hd__clkbuf_1
XFILLER_3_640 VGND VGND VPWR VPWR sky130_fd_sc_hd__fill_1
XFILLER_174_1023 VPWR VGND VPWR VGND sky130_ef_sc_hd__decap_12
XFILLER_180_961 VGND VGND VPWR VPWR sky130_fd_sc_hd__decap_6
XFILLER_139_1165 VPWR VGND VPWR VGND sky130_ef_sc_hd__decap_12
XFILLER_174_1078 VPWR VGND VPWR VGND sky130_ef_sc_hd__decap_12
XFILLER_239_701 VPWR VGND VPWR VGND sky130_ef_sc_hd__decap_12
XFILLER_26_1313 VPWR VGND VPWR VGND sky130_ef_sc_hd__decap_12
XFILLER_191_1370 VGND VGND VPWR VPWR sky130_fd_sc_hd__decap_6
XFILLER_2_194 VGND VGND VPWR VPWR sky130_fd_sc_hd__decap_8
XTAP_TAPCELL_ROW_162_2_5954 VGND VPWR sky130_fd_sc_hd__tapvpwrvgnd_1
XPHY_EDGE_ROW_219_Right_64 VGND VGND VPWR VPWR sky130_fd_sc_hd__decap_3
XFILLER_239_756 VPWR VGND VPWR VGND sky130_ef_sc_hd__decap_12
XFILLER_26_1368 VPWR VGND VPWR VGND sky130_ef_sc_hd__decap_12
XFILLER_113_1316 VPWR VGND VPWR VGND sky130_ef_sc_hd__decap_12
XFILLER_241_39 VGND VGND VPWR VPWR sky130_fd_sc_hd__decap_4
XFILLER_171_80 VGND VGND VPWR VPWR sky130_fd_sc_hd__decap_6
XFILLER_4_1164 VPWR VGND VPWR VGND sky130_ef_sc_hd__decap_12
XFILLER_235_940 VGND VGND VPWR VPWR sky130_fd_sc_hd__decap_6
XFILLER_0_64 VGND VGND VPWR VPWR sky130_fd_sc_hd__fill_2
XTAP_TAPCELL_ROW_164_1_1475 VGND VPWR sky130_fd_sc_hd__tapvpwrvgnd_1
XFILLER_206_163 VPWR VGND VPWR VGND sky130_ef_sc_hd__decap_12
XFILLER_0_97 VGND VGND VPWR VPWR sky130_fd_sc_hd__decap_8
XTAP_TAPCELL_ROW_80_2_5298 VGND VPWR sky130_fd_sc_hd__tapvpwrvgnd_1
XFILLER_59_1177 VPWR VGND VPWR VGND sky130_ef_sc_hd__decap_12
XFILLER_185_1174 VPWR VGND VPWR VGND sky130_ef_sc_hd__decap_12
XFILLER_221_111 VPWR VGND VPWR VGND sky130_ef_sc_hd__decap_12
XTAP_TAPCELL_ROW_123_2_5649 VGND VPWR sky130_fd_sc_hd__tapvpwrvgnd_1
XFILLER_222_667 VPWR VGND VPWR VGND sky130_ef_sc_hd__decap_12
XTAP_TAPCELL_ROW_60_2_5141 VGND VPWR sky130_fd_sc_hd__tapvpwrvgnd_1
XFILLER_37_1464 VPWR VGND VPWR VGND sky130_ef_sc_hd__decap_12
XFILLER_221_166 VGND VGND VPWR VPWR sky130_fd_sc_hd__decap_6
XPHY_EDGE_ROW_228_Right_73 VGND VGND VPWR VPWR sky130_fd_sc_hd__decap_3
XTAP_TAPCELL_ROW_59_2_5135 VGND VPWR sky130_fd_sc_hd__tapvpwrvgnd_1
XFILLER_124_1423 VPWR VGND VPWR VGND sky130_ef_sc_hd__decap_12
XFILLER_194_519 VPWR VGND VPWR VGND sky130_ef_sc_hd__decap_12
XFILLER_187_560 VPWR VGND VPWR VGND sky130_ef_sc_hd__decap_12
XFILLER_222_1035 VPWR VGND VPWR VGND sky130_ef_sc_hd__decap_12
XFILLER_33_1328 VGND VGND VPWR VPWR sky130_fd_sc_hd__decap_6
XFILLER_72_1399 VPWR VGND VPWR VGND sky130_ef_sc_hd__decap_12
XFILLER_175_744 VPWR VGND VPWR VGND sky130_ef_sc_hd__decap_12
XFILLER_124_1478 VGND VGND VPWR VPWR sky130_fd_sc_hd__decap_6
XFILLER_190_703 VGND VGND VPWR VPWR sky130_fd_sc_hd__decap_6
XFILLER_175_799 VPWR VGND VPWR VGND sky130_ef_sc_hd__decap_12
XTAP_TAPCELL_ROW_190_2396 VGND VPWR sky130_fd_sc_hd__tapvpwrvgnd_1
Xmax_cap610 net611 VGND VGND VPWR VPWR net610 sky130_fd_sc_hd__clkbuf_1
XFILLER_200_1355 VPWR VGND VPWR VGND sky130_ef_sc_hd__decap_12
Xmax_cap621 web0 VGND VGND VPWR VPWR net621 sky130_fd_sc_hd__clkbuf_2
XFILLER_7_990 VPWR VGND VPWR VGND sky130_ef_sc_hd__decap_12
XFILLER_196_1281 VPWR VGND VPWR VGND sky130_ef_sc_hd__decap_12
XTAP_TAPCELL_ROW_59_1_1318 VGND VPWR sky130_fd_sc_hd__tapvpwrvgnd_1
XFILLER_171_983 VGND VGND VPWR VPWR sky130_fd_sc_hd__decap_6
XFILLER_118_1227 VPWR VGND VPWR VGND sky130_ef_sc_hd__decap_12
XPHY_EDGE_ROW_83_1_Right_739 VGND VGND VPWR VPWR sky130_fd_sc_hd__decap_3
XPHY_EDGE_ROW_237_Right_82 VGND VGND VPWR VPWR sky130_fd_sc_hd__decap_3
XFILLER_170_1410 VPWR VGND VPWR VGND sky130_ef_sc_hd__decap_12
XFILLER_9_1042 VGND VGND VPWR VPWR sky130_fd_sc_hd__decap_8
XFILLER_233_1131 VPWR VGND VPWR VGND sky130_ef_sc_hd__decap_12
XFILLER_44_1435 VGND VGND VPWR VPWR sky130_fd_sc_hd__decap_6
XFILLER_170_1465 VPWR VGND VPWR VGND sky130_ef_sc_hd__decap_12
XTAP_TAPCELL_ROW_184_2189 VGND VPWR sky130_fd_sc_hd__tapvpwrvgnd_1
XFILLER_218_918 VGND VGND VPWR VPWR sky130_fd_sc_hd__decap_6
XFILLER_233_1186 VPWR VGND VPWR VGND sky130_ef_sc_hd__decap_12
XFILLER_151_39 VGND VGND VPWR VPWR sky130_fd_sc_hd__decap_4
XFILLER_232_409 VPWR VGND VPWR VGND sky130_ef_sc_hd__decap_12
XFILLER_246_1514 VGND VGND VPWR VPWR sky130_fd_sc_hd__fill_1
XFILLER_44_15 VGND VGND VPWR VPWR sky130_fd_sc_hd__decap_6
XFILLER_197_302 VPWR VGND VPWR VGND sky130_ef_sc_hd__decap_12
XFILLER_252_280 VPWR VGND VPWR VGND sky130_ef_sc_hd__decap_12
XFILLER_38_1239 VPWR VGND VPWR VGND sky130_ef_sc_hd__decap_12
XPHY_EDGE_ROW_246_Right_91 VGND VGND VPWR VPWR sky130_fd_sc_hd__decap_3
XFILLER_90_1411 VPWR VGND VPWR VGND sky130_ef_sc_hd__decap_12
XFILLER_129_1378 VPWR VGND VPWR VGND sky130_ef_sc_hd__decap_12
XFILLER_201_818 VPWR VGND VPWR VGND sky130_ef_sc_hd__decap_12
XFILLER_212_144 VGND VGND VPWR VPWR sky130_fd_sc_hd__decap_6
XFILLER_197_357 VPWR VGND VPWR VGND sky130_ef_sc_hd__decap_12
XFILLER_240_464 VPWR VGND VPWR VGND sky130_ef_sc_hd__decap_12
XFILLER_213_689 VPWR VGND VPWR VGND sky130_ef_sc_hd__decap_12
XFILLER_244_1293 VPWR VGND VPWR VGND sky130_ef_sc_hd__decap_12
XFILLER_90_1466 VPWR VGND VPWR VGND sky130_ef_sc_hd__decap_12
XFILLER_100_65 VGND VGND VPWR VPWR sky130_fd_sc_hd__decap_6
XFILLER_166_722 VPWR VGND VPWR VGND sky130_ef_sc_hd__decap_12
XFILLER_103_1507 VGND VGND VPWR VPWR sky130_fd_sc_hd__decap_8
XFILLER_178_593 VPWR VGND VPWR VGND sky130_ef_sc_hd__decap_12
XFILLER_165_232 VPWR VGND VPWR VGND sky130_ef_sc_hd__decap_12
XFILLER_193_541 VPWR VGND VPWR VGND sky130_ef_sc_hd__decap_12
XFILLER_201_1119 VPWR VGND VPWR VGND sky130_ef_sc_hd__decap_12
XFILLER_60_58 VGND VGND VPWR VPWR sky130_fd_sc_hd__decap_6
XFILLER_166_777 VPWR VGND VPWR VGND sky130_ef_sc_hd__decap_12
XFILLER_5_916 VPWR VGND VPWR VGND sky130_ef_sc_hd__decap_12
XFILLER_165_265 VGND VGND VPWR VPWR sky130_fd_sc_hd__decap_8
XFILLER_176_58 VGND VGND VPWR VPWR sky130_fd_sc_hd__decap_6
XFILLER_197_1045 VPWR VGND VPWR VGND sky130_ef_sc_hd__decap_12
XTAP_TAPCELL_ROW_210_3101 VGND VPWR sky130_fd_sc_hd__tapvpwrvgnd_1
XFILLER_181_725 VGND VGND VPWR VPWR sky130_fd_sc_hd__decap_6
XTAP_TAPCELL_ROW_210_3112 VGND VPWR sky130_fd_sc_hd__tapvpwrvgnd_1
XFILLER_193_596 VGND VGND VPWR VPWR sky130_fd_sc_hd__decap_6
XTAP_TAPCELL_ROW_210_3123 VGND VPWR sky130_fd_sc_hd__tapvpwrvgnd_1
XFILLER_14_1294 VPWR VGND VPWR VGND sky130_ef_sc_hd__decap_12
XFILLER_101_1242 VGND VGND VPWR VPWR sky130_fd_sc_hd__decap_6
XFILLER_49_1335 VPWR VGND VPWR VGND sky130_ef_sc_hd__decap_12
XFILLER_107_3 VPWR VGND VPWR VGND sky130_ef_sc_hd__decap_12
XFILLER_69_56 VPWR VGND VPWR VGND sky130_ef_sc_hd__decap_12
XTAP_TAPCELL_ROW_147_2_5834 VGND VPWR sky130_fd_sc_hd__tapvpwrvgnd_1
XTAP_TAPCELL_ROW_11_1_1246 VGND VPWR sky130_fd_sc_hd__tapvpwrvgnd_1
XFILLER_192_46 VPWR VGND VPWR VGND sky130_ef_sc_hd__decap_12
XFILLER_238_1097 VPWR VGND VPWR VGND sky130_ef_sc_hd__decap_12
XFILLER_171_1229 VPWR VGND VPWR VGND sky130_ef_sc_hd__decap_12
XFILLER_136_1349 VGND VGND VPWR VPWR sky130_fd_sc_hd__decap_6
XTAP_TAPCELL_ROW_116_2_5592 VGND VPWR sky130_fd_sc_hd__tapvpwrvgnd_1
XTAP_TAPCELL_ROW_208_3030 VGND VPWR sky130_fd_sc_hd__tapvpwrvgnd_1
XTAP_TAPCELL_ROW_208_3041 VGND VPWR sky130_fd_sc_hd__tapvpwrvgnd_1
XFILLER_248_531 VGND VGND VPWR VPWR sky130_fd_sc_hd__decap_6
XTAP_TAPCELL_ROW_208_3052 VGND VPWR sky130_fd_sc_hd__tapvpwrvgnd_1
XFILLER_212_1226 VPWR VGND VPWR VGND sky130_ef_sc_hd__decap_12
XTAP_TAPCELL_ROW_227_3686 VGND VPWR sky130_fd_sc_hd__tapvpwrvgnd_1
XTAP_TAPCELL_ROW_227_3697 VGND VPWR sky130_fd_sc_hd__tapvpwrvgnd_1
XFILLER_85_44 VPWR VGND VPWR VGND sky130_ef_sc_hd__decap_12
XFILLER_60_1270 VPWR VGND VPWR VGND sky130_ef_sc_hd__decap_12
XFILLER_25_1390 VPWR VGND VPWR VGND sky130_ef_sc_hd__decap_12
XFILLER_217_940 VGND VGND VPWR VPWR sky130_fd_sc_hd__decap_6
XFILLER_1_1315 VPWR VGND VPWR VGND sky130_ef_sc_hd__decap_12
XTAP_TAPCELL_ROW_65_2_5178 VGND VPWR sky130_fd_sc_hd__tapvpwrvgnd_1
XFILLER_250_206 VPWR VGND VPWR VGND sky130_ef_sc_hd__decap_12
XFILLER_245_1002 VPWR VGND VPWR VGND sky130_ef_sc_hd__decap_12
XTAP_TAPCELL_ROW_108_2_5529 VGND VPWR sky130_fd_sc_hd__tapvpwrvgnd_1
XFILLER_56_1306 VGND VGND VPWR VPWR sky130_fd_sc_hd__decap_6
XPHY_EDGE_ROW_45_1_Right_701 VGND VGND VPWR VPWR sky130_fd_sc_hd__decap_3
XFILLER_203_111 VPWR VGND VPWR VGND sky130_ef_sc_hd__decap_12
XTAP_TAPCELL_ROW_45_2_5021 VGND VPWR sky130_fd_sc_hd__tapvpwrvgnd_1
XFILLER_147_1445 VPWR VGND VPWR VGND sky130_ef_sc_hd__decap_12
XFILLER_231_431 VPWR VGND VPWR VGND sky130_ef_sc_hd__decap_12
XFILLER_182_1336 VPWR VGND VPWR VGND sky130_ef_sc_hd__decap_12
XFILLER_245_1057 VPWR VGND VPWR VGND sky130_ef_sc_hd__decap_12
XFILLER_188_335 VPWR VGND VPWR VGND sky130_ef_sc_hd__decap_12
XFILLER_204_667 VPWR VGND VPWR VGND sky130_ef_sc_hd__decap_12
XFILLER_203_166 VGND VGND VPWR VPWR sky130_fd_sc_hd__decap_6
XFILLER_231_486 VPWR VGND VPWR VGND sky130_ef_sc_hd__decap_12
XFILLER_169_560 VPWR VGND VPWR VGND sky130_ef_sc_hd__decap_12
XFILLER_176_519 VPWR VGND VPWR VGND sky130_ef_sc_hd__decap_12
XFILLER_8_710 VGND VGND VPWR VPWR sky130_fd_sc_hd__decap_8
XFILLER_200_851 VPWR VGND VPWR VGND sky130_ef_sc_hd__decap_12
XFILLER_196_390 VPWR VGND VPWR VGND sky130_ef_sc_hd__decap_12
XFILLER_223_1377 VPWR VGND VPWR VGND sky130_ef_sc_hd__decap_12
Xwire140 _085_ VGND VGND VPWR VPWR net140 sky130_fd_sc_hd__clkbuf_1
XFILLER_8_765 VPWR VGND VPWR VGND sky130_ef_sc_hd__decap_12
XFILLER_172_703 VGND VGND VPWR VPWR sky130_fd_sc_hd__decap_6
XFILLER_184_574 VGND VGND VPWR VPWR sky130_fd_sc_hd__decap_6
Xwire162 _153_ VGND VGND VPWR VPWR net162 sky130_fd_sc_hd__clkbuf_1
Xwire173 _120_ VGND VGND VPWR VPWR net173 sky130_fd_sc_hd__clkbuf_1
XFILLER_67_1402 VPWR VGND VPWR VGND sky130_ef_sc_hd__decap_12
XFILLER_193_1432 VPWR VGND VPWR VGND sky130_ef_sc_hd__decap_12
XFILLER_67_1457 VGND VGND VPWR VPWR sky130_fd_sc_hd__decap_6
XFILLER_193_1487 VPWR VGND VPWR VGND sky130_ef_sc_hd__decap_12
XFILLER_22_3 VPWR VGND VPWR VGND sky130_ef_sc_hd__decap_12
XFILLER_234_1484 VPWR VGND VPWR VGND sky130_ef_sc_hd__decap_12
XFILLER_26_1165 VPWR VGND VPWR VGND sky130_ef_sc_hd__decap_12
XFILLER_6_1226 VPWR VGND VPWR VGND sky130_ef_sc_hd__decap_12
XFILLER_239_553 VGND VGND VPWR VPWR sky130_fd_sc_hd__decap_6
XFILLER_230_1348 VGND VGND VPWR VPWR sky130_fd_sc_hd__decap_6
XFILLER_152_1184 VPWR VGND VPWR VGND sky130_ef_sc_hd__decap_12
XFILLER_214_409 VPWR VGND VPWR VGND sky130_ef_sc_hd__decap_12
XFILLER_241_228 VPWR VGND VPWR VGND sky130_ef_sc_hd__decap_12
XFILLER_179_302 VPWR VGND VPWR VGND sky130_ef_sc_hd__decap_12
XFILLER_234_280 VPWR VGND VPWR VGND sky130_ef_sc_hd__decap_12
XFILLER_222_464 VPWR VGND VPWR VGND sky130_ef_sc_hd__decap_12
XPHY_EDGE_ROW_20_2_Left_522 VGND VGND VPWR VPWR sky130_fd_sc_hd__decap_3
XFILLER_179_357 VPWR VGND VPWR VGND sky130_ef_sc_hd__decap_12
XFILLER_37_1261 VPWR VGND VPWR VGND sky130_ef_sc_hd__decap_12
XFILLER_124_1220 VGND VGND VPWR VPWR sky130_fd_sc_hd__decap_6
XFILLER_194_316 VGND VGND VPWR VPWR sky130_fd_sc_hd__decap_6
XFILLER_210_648 VPWR VGND VPWR VGND sky130_ef_sc_hd__decap_12
XFILLER_241_1444 VPWR VGND VPWR VGND sky130_ef_sc_hd__decap_12
XTAP_TAPCELL_ROW_192_2469 VGND VPWR sky130_fd_sc_hd__tapvpwrvgnd_1
XFILLER_72_1196 VPWR VGND VPWR VGND sky130_ef_sc_hd__decap_12
XFILLER_175_541 VPWR VGND VPWR VGND sky130_ef_sc_hd__decap_12
XFILLER_241_1499 VGND VGND VPWR VPWR sky130_fd_sc_hd__decap_6
XTAP_TAPCELL_ROW_153_2_5888 VGND VPWR sky130_fd_sc_hd__tapvpwrvgnd_1
XFILLER_159_1316 VPWR VGND VPWR VGND sky130_ef_sc_hd__decap_12
XTAP_TAPCELL_ROW_90_2_5380 VGND VPWR sky130_fd_sc_hd__tapvpwrvgnd_1
XFILLER_175_596 VGND VGND VPWR VPWR sky130_fd_sc_hd__decap_6
XFILLER_194_1207 VPWR VGND VPWR VGND sky130_ef_sc_hd__decap_12
XTAP_TAPCELL_ROW_89_2_5374 VGND VPWR sky130_fd_sc_hd__tapvpwrvgnd_1
XFILLER_11_1445 VPWR VGND VPWR VGND sky130_ef_sc_hd__decap_12
XFILLER_200_1152 VPWR VGND VPWR VGND sky130_ef_sc_hd__decap_12
XFILLER_198_1398 VPWR VGND VPWR VGND sky130_ef_sc_hd__decap_12
Xmax_cap495 net496 VGND VGND VPWR VPWR net495 sky130_fd_sc_hd__clkbuf_1
XFILLER_39_15 VPWR VGND VPWR VGND sky130_ef_sc_hd__decap_12
XFILLER_235_1248 VPWR VGND VPWR VGND sky130_ef_sc_hd__decap_12
XFILLER_83_1292 VPWR VGND VPWR VGND sky130_ef_sc_hd__decap_12
XTAP_TAPCELL_ROW_82_2_5317 VGND VPWR sky130_fd_sc_hd__tapvpwrvgnd_1
XFILLER_135_1371 VGND VGND VPWR VPWR sky130_fd_sc_hd__decap_6
XFILLER_170_1262 VGND VGND VPWR VPWR sky130_fd_sc_hd__decap_6
XFILLER_79_1328 VGND VGND VPWR VPWR sky130_fd_sc_hd__decap_6
XFILLER_232_206 VPWR VGND VPWR VGND sky130_ef_sc_hd__decap_12
XTAP_TAPCELL_ROW_17_2_4799 VGND VPWR sky130_fd_sc_hd__tapvpwrvgnd_1
XFILLER_246_1355 VPWR VGND VPWR VGND sky130_ef_sc_hd__decap_12
XFILLER_213_431 VPWR VGND VPWR VGND sky130_ef_sc_hd__decap_12
XFILLER_242_1219 VGND VGND VPWR VPWR sky130_fd_sc_hd__decap_6
XFILLER_201_615 VPWR VGND VPWR VGND sky130_ef_sc_hd__decap_12
XFILLER_240_261 VPWR VGND VPWR VGND sky130_ef_sc_hd__decap_12
XFILLER_197_154 VPWR VGND VPWR VGND sky130_ef_sc_hd__decap_12
XFILLER_213_486 VPWR VGND VPWR VGND sky130_ef_sc_hd__decap_12
XTAP_TAPCELL_ROW_216_3310 VGND VPWR sky130_fd_sc_hd__tapvpwrvgnd_1
XFILLER_186_839 VPWR VGND VPWR VGND sky130_ef_sc_hd__decap_12
XTAP_TAPCELL_ROW_216_3321 VGND VPWR sky130_fd_sc_hd__tapvpwrvgnd_1
XFILLER_71_68 VGND VGND VPWR VPWR sky130_fd_sc_hd__decap_3
XTAP_TAPCELL_ROW_216_3332 VGND VPWR sky130_fd_sc_hd__tapvpwrvgnd_1
XFILLER_244_1090 VGND VGND VPWR VPWR sky130_fd_sc_hd__decap_6
XFILLER_90_1263 VGND VGND VPWR VPWR sky130_fd_sc_hd__decap_6
XFILLER_185_338 VGND VGND VPWR VPWR sky130_fd_sc_hd__decap_6
XTAP_TAPCELL_ROW_235_3966 VGND VPWR sky130_fd_sc_hd__tapvpwrvgnd_1
XTAP_TAPCELL_ROW_235_3977 VGND VPWR sky130_fd_sc_hd__tapvpwrvgnd_1
XFILLER_16_1356 VPWR VGND VPWR VGND sky130_ef_sc_hd__decap_12
XFILLER_103_1304 VPWR VGND VPWR VGND sky130_ef_sc_hd__decap_12
XFILLER_178_390 VPWR VGND VPWR VGND sky130_ef_sc_hd__decap_12
XFILLER_187_68 VPWR VGND VPWR VGND sky130_ef_sc_hd__decap_12
XFILLER_224_3 VPWR VGND VPWR VGND sky130_ef_sc_hd__decap_12
XTAP_TAPCELL_ROW_235_3988 VGND VPWR sky130_fd_sc_hd__tapvpwrvgnd_1
XFILLER_166_574 VGND VGND VPWR VPWR sky130_fd_sc_hd__decap_6
XFILLER_103_1359 VPWR VGND VPWR VGND sky130_ef_sc_hd__decap_12
XFILLER_194_894 VPWR VGND VPWR VGND sky130_ef_sc_hd__decap_12
XFILLER_5_779 VGND VGND VPWR VPWR sky130_fd_sc_hd__fill_2
XTAP_TAPCELL_ROW_29_1_1273 VGND VPWR sky130_fd_sc_hd__tapvpwrvgnd_1
XFILLER_253_1315 VPWR VGND VPWR VGND sky130_ef_sc_hd__decap_12
XPHY_EDGE_ROW_29_1_Left_284 VGND VGND VPWR VPWR sky130_fd_sc_hd__decap_3
XFILLER_49_1165 VPWR VGND VPWR VGND sky130_ef_sc_hd__decap_12
XFILLER_175_1162 VPWR VGND VPWR VGND sky130_ef_sc_hd__decap_12
XTAP_TAPCELL_ROW_229_3759 VGND VPWR sky130_fd_sc_hd__tapvpwrvgnd_1
XFILLER_171_1026 VGND VGND VPWR VPWR sky130_fd_sc_hd__decap_6
XFILLER_96_65 VGND VGND VPWR VPWR sky130_fd_sc_hd__decap_6
XFILLER_114_1411 VPWR VGND VPWR VGND sky130_ef_sc_hd__decap_12
XFILLER_249_873 VPWR VGND VPWR VGND sky130_ef_sc_hd__decap_12
XFILLER_23_1316 VPWR VGND VPWR VGND sky130_ef_sc_hd__decap_12
XFILLER_0_484 VGND VGND VPWR VPWR sky130_fd_sc_hd__fill_1
XFILLER_212_1023 VPWR VGND VPWR VGND sky130_ef_sc_hd__decap_12
XTAP_TAPCELL_ROW_117_1_1405 VGND VPWR sky130_fd_sc_hd__tapvpwrvgnd_1
XFILLER_29_70 VGND VGND VPWR VPWR sky130_fd_sc_hd__fill_1
XFILLER_114_1466 VPWR VGND VPWR VGND sky130_ef_sc_hd__decap_12
XFILLER_212_1078 VPWR VGND VPWR VGND sky130_ef_sc_hd__decap_12
XFILLER_149_1507 VGND VGND VPWR VPWR sky130_fd_sc_hd__decap_8
XFILLER_1_1112 VGND VGND VPWR VPWR sky130_fd_sc_hd__decap_6
XFILLER_247_1119 VPWR VGND VPWR VGND sky130_ef_sc_hd__decap_12
XFILLER_223_228 VPWR VGND VPWR VGND sky130_ef_sc_hd__decap_12
XFILLER_216_280 VPWR VGND VPWR VGND sky130_ef_sc_hd__decap_12
XPHY_EDGE_ROW_46_1_Right_702 VGND VGND VPWR VPWR sky130_fd_sc_hd__decap_3
XFILLER_147_1242 VGND VGND VPWR VPWR sky130_fd_sc_hd__decap_6
XFILLER_182_1133 VGND VGND VPWR VPWR sky130_fd_sc_hd__decap_6
X_598_ clknet_3_2__leaf_clk _080_ _006_ VGND VGND VPWR VPWR rd_addr\[6\] sky130_fd_sc_hd__dfrtp_1
XFILLER_188_132 VPWR VGND VPWR VGND sky130_ef_sc_hd__decap_12
XFILLER_204_464 VPWR VGND VPWR VGND sky130_ef_sc_hd__decap_12
XFILLER_176_316 VGND VGND VPWR VPWR sky130_fd_sc_hd__decap_6
XFILLER_231_283 VPWR VGND VPWR VGND sky130_ef_sc_hd__decap_12
XFILLER_34_1423 VPWR VGND VPWR VGND sky130_ef_sc_hd__decap_12
XTAP_TAPCELL_ROW_138_2_5768 VGND VPWR sky130_fd_sc_hd__tapvpwrvgnd_1
XFILLER_188_187 VGND VGND VPWR VPWR sky130_fd_sc_hd__decap_6
XFILLER_220_968 VPWR VGND VPWR VGND sky130_ef_sc_hd__decap_12
XFILLER_160_1442 VPWR VGND VPWR VGND sky130_ef_sc_hd__decap_12
XTAP_TAPCELL_ROW_75_2_5260 VGND VPWR sky130_fd_sc_hd__tapvpwrvgnd_1
XFILLER_223_1174 VPWR VGND VPWR VGND sky130_ef_sc_hd__decap_12
XFILLER_185_861 VPWR VGND VPWR VGND sky130_ef_sc_hd__decap_12
XFILLER_34_1478 VGND VGND VPWR VPWR sky130_fd_sc_hd__decap_6
XFILLER_247_27 VPWR VGND VPWR VGND sky130_ef_sc_hd__decap_12
XFILLER_160_1497 VPWR VGND VPWR VGND sky130_ef_sc_hd__decap_12
XPHY_EDGE_ROW_162_1_Left_417 VGND VGND VPWR VPWR sky130_fd_sc_hd__decap_3
XANTENNA_1 dout0\[1\] VGND VGND VPWR VPWR sky130_fd_sc_hd__diode_2
XFILLER_28_1227 VPWR VGND VPWR VGND sky130_ef_sc_hd__decap_12
XTAP_TAPCELL_ROW_100_2_5458 VGND VPWR sky130_fd_sc_hd__tapvpwrvgnd_1
XFILLER_193_1284 VGND VGND VPWR VPWR sky130_fd_sc_hd__decap_6
XTAP_TAPCELL_ROW_185_2240 VGND VPWR sky130_fd_sc_hd__tapvpwrvgnd_1
XTAP_TAPCELL_ROW_152_1_1457 VGND VPWR sky130_fd_sc_hd__tapvpwrvgnd_1
XTAP_TAPCELL_ROW_181_2104 VGND VPWR sky130_fd_sc_hd__tapvpwrvgnd_1
XFILLER_6_1023 VPWR VGND VPWR VGND sky130_ef_sc_hd__decap_12
XFILLER_80_1454 VPWR VGND VPWR VGND sky130_ef_sc_hd__decap_12
XFILLER_234_1281 VPWR VGND VPWR VGND sky130_ef_sc_hd__decap_12
XFILLER_255_832 VGND VGND VPWR VPWR sky130_fd_sc_hd__decap_8
XFILLER_6_1078 VPWR VGND VPWR VGND sky130_ef_sc_hd__decap_12
XFILLER_187_1033 VPWR VGND VPWR VGND sky130_ef_sc_hd__decap_12
XFILLER_214_206 VPWR VGND VPWR VGND sky130_ef_sc_hd__decap_12
XTAP_TAPCELL_ROW_179_2011 VGND VPWR sky130_fd_sc_hd__tapvpwrvgnd_1
XTAP_TAPCELL_ROW_179_2022 VGND VPWR sky130_fd_sc_hd__tapvpwrvgnd_1
XFILLER_187_1088 VPWR VGND VPWR VGND sky130_ef_sc_hd__decap_12
XTAP_TAPCELL_ROW_179_2033 VGND VPWR sky130_fd_sc_hd__tapvpwrvgnd_1
XFILLER_243_1506 VGND VGND VPWR VPWR sky130_fd_sc_hd__decap_8
XTAP_TAPCELL_ROW_198_2678 VGND VPWR sky130_fd_sc_hd__tapvpwrvgnd_1
XTAP_TAPCELL_ROW_198_2689 VGND VPWR sky130_fd_sc_hd__tapvpwrvgnd_1
XFILLER_39_1378 VPWR VGND VPWR VGND sky130_ef_sc_hd__decap_12
XFILLER_161_1206 VPWR VGND VPWR VGND sky130_ef_sc_hd__decap_12
XFILLER_179_154 VPWR VGND VPWR VGND sky130_ef_sc_hd__decap_12
XFILLER_195_603 VPWR VGND VPWR VGND sky130_ef_sc_hd__decap_12
XFILLER_222_261 VPWR VGND VPWR VGND sky130_ef_sc_hd__decap_12
XFILLER_250_581 VPWR VGND VPWR VGND sky130_ef_sc_hd__decap_12
XFILLER_126_1337 VPWR VGND VPWR VGND sky130_ef_sc_hd__decap_12
XFILLER_168_839 VPWR VGND VPWR VGND sky130_ef_sc_hd__decap_12
XFILLER_241_1241 VGND VGND VPWR VPWR sky130_fd_sc_hd__decap_6
XFILLER_167_338 VGND VGND VPWR VPWR sky130_fd_sc_hd__decap_6
XFILLER_210_445 VGND VGND VPWR VPWR sky130_fd_sc_hd__decap_6
XFILLER_195_658 VPWR VGND VPWR VGND sky130_ef_sc_hd__decap_12
XFILLER_41_27 VPWR VGND VPWR VGND sky130_ef_sc_hd__decap_12
XFILLER_13_1507 VGND VGND VPWR VPWR sky130_fd_sc_hd__decap_8
XPHY_EDGE_ROW_94_1_Left_349 VGND VGND VPWR VPWR sky130_fd_sc_hd__decap_3
XFILLER_157_27 VPWR VGND VPWR VGND sky130_ef_sc_hd__decap_12
XFILLER_198_1140 VPWR VGND VPWR VGND sky130_ef_sc_hd__decap_12
XFILLER_176_894 VPWR VGND VPWR VGND sky130_ef_sc_hd__decap_12
XFILLER_202_1269 VPWR VGND VPWR VGND sky130_ef_sc_hd__decap_12
XFILLER_191_842 VPWR VGND VPWR VGND sky130_ef_sc_hd__decap_12
XFILLER_194_1004 VGND VGND VPWR VPWR sky130_fd_sc_hd__decap_6
XFILLER_11_1242 VGND VGND VPWR VPWR sky130_fd_sc_hd__decap_6
XFILLER_198_1195 VPWR VGND VPWR VGND sky130_ef_sc_hd__decap_12
XFILLER_2_705 VGND VGND VPWR VPWR sky130_fd_sc_hd__decap_4
XFILLER_102_1392 VGND VGND VPWR VPWR sky130_fd_sc_hd__decap_6
XFILLER_191_897 VGND VGND VPWR VPWR sky130_fd_sc_hd__decap_6
XFILLER_173_15 VPWR VGND VPWR VGND sky130_ef_sc_hd__decap_12
XFILLER_137_1433 VPWR VGND VPWR VGND sky130_ef_sc_hd__decap_12
XFILLER_172_1324 VPWR VGND VPWR VGND sky130_ef_sc_hd__decap_12
XFILLER_81_1218 VPWR VGND VPWR VGND sky130_ef_sc_hd__decap_12
XFILLER_235_1045 VPWR VGND VPWR VGND sky130_ef_sc_hd__decap_12
XFILLER_46_1349 VGND VGND VPWR VPWR sky130_fd_sc_hd__decap_6
XFILLER_137_1488 VPWR VGND VPWR VGND sky130_ef_sc_hd__decap_12
XTAP_TAPCELL_ROW_224_3601 VGND VPWR sky130_fd_sc_hd__tapvpwrvgnd_1
XFILLER_172_1379 VPWR VGND VPWR VGND sky130_ef_sc_hd__decap_12
XTAP_TAPCELL_ROW_224_3612 VGND VPWR sky130_fd_sc_hd__tapvpwrvgnd_1
XFILLER_246_832 VGND VGND VPWR VPWR sky130_fd_sc_hd__decap_6
XFILLER_66_46 VPWR VGND VPWR VGND sky130_ef_sc_hd__decap_12
XFILLER_2_1410 VPWR VGND VPWR VGND sky130_ef_sc_hd__decap_12
XFILLER_174_3 VPWR VGND VPWR VGND sky130_ef_sc_hd__decap_12
X_521_ net665 VGND VGND VPWR VPWR _003_ sky130_fd_sc_hd__inv_2
XFILLER_2_1465 VPWR VGND VPWR VGND sky130_ef_sc_hd__decap_12
XFILLER_205_228 VPWR VGND VPWR VGND sky130_ef_sc_hd__decap_12
XFILLER_82_34 VPWR VGND VPWR VGND sky130_ef_sc_hd__decap_12
XFILLER_183_1420 VPWR VGND VPWR VGND sky130_ef_sc_hd__decap_12
X_452_ net591 net590 net571 VGND VGND VPWR VPWR _239_ sky130_fd_sc_hd__a21oi_1
XFILLER_246_1152 VPWR VGND VPWR VGND sky130_ef_sc_hd__decap_12
XFILLER_57_1445 VPWR VGND VPWR VGND sky130_ef_sc_hd__decap_12
XFILLER_92_1325 VPWR VGND VPWR VGND sky130_ef_sc_hd__decap_12
XTAP_TAPCELL_ROW_124_2_5654 VGND VPWR sky130_fd_sc_hd__tapvpwrvgnd_1
XFILLER_198_34 VPWR VGND VPWR VGND sky130_ef_sc_hd__decap_12
XFILLER_198_452 VPWR VGND VPWR VGND sky130_ef_sc_hd__decap_12
X_383_ net591 net583 net556 VGND VGND VPWR VPWR _172_ sky130_fd_sc_hd__a21oi_1
XFILLER_183_1475 VPWR VGND VPWR VGND sky130_ef_sc_hd__decap_12
XFILLER_201_412 VPWR VGND VPWR VGND sky130_ef_sc_hd__decap_12
XFILLER_213_283 VPWR VGND VPWR VGND sky130_ef_sc_hd__decap_12
XFILLER_186_636 VPWR VGND VPWR VGND sky130_ef_sc_hd__decap_12
XFILLER_198_89 VPWR VGND VPWR VGND sky130_ef_sc_hd__decap_12
XFILLER_202_968 VPWR VGND VPWR VGND sky130_ef_sc_hd__decap_12
XFILLER_9_337 VPWR VGND VPWR VGND sky130_ef_sc_hd__decap_12
XFILLER_201_467 VGND VGND VPWR VPWR sky130_fd_sc_hd__decap_6
XFILLER_167_861 VPWR VGND VPWR VGND sky130_ef_sc_hd__decap_12
XFILLER_220_1336 VPWR VGND VPWR VGND sky130_ef_sc_hd__decap_12
XFILLER_107_1292 VPWR VGND VPWR VGND sky130_ef_sc_hd__decap_12
XFILLER_182_820 VPWR VGND VPWR VGND sky130_ef_sc_hd__decap_12
XFILLER_194_691 VPWR VGND VPWR VGND sky130_ef_sc_hd__decap_12
XTAP_TAPCELL_ROW_27_2_4881 VGND VPWR sky130_fd_sc_hd__tapvpwrvgnd_1
XFILLER_103_1189 VPWR VGND VPWR VGND sky130_ef_sc_hd__decap_12
XFILLER_182_875 VGND VGND VPWR VPWR sky130_fd_sc_hd__decap_6
XFILLER_138_1208 VPWR VGND VPWR VGND sky130_ef_sc_hd__decap_12
XFILLER_155_1500 VGND VGND VPWR VPWR sky130_fd_sc_hd__decap_6
XFILLER_253_1112 VGND VGND VPWR VPWR sky130_fd_sc_hd__decap_6
Xoutput60 net60 VGND VGND VPWR VPWR acc_out[25] sky130_fd_sc_hd__buf_2
Xoutput71 net555 VGND VGND VPWR VPWR acc_out[6] sky130_fd_sc_hd__buf_2
XTAP_TAPCELL_ROW_20_2_4824 VGND VPWR sky130_fd_sc_hd__tapvpwrvgnd_1
XFILLER_231_1432 VPWR VGND VPWR VGND sky130_ef_sc_hd__decap_12
XFILLER_255_106 VPWR VGND VPWR VGND sky130_ef_sc_hd__decap_12
XFILLER_249_670 VPWR VGND VPWR VGND sky130_ef_sc_hd__decap_12
XFILLER_0_281 VPWR VGND VPWR VGND sky130_ef_sc_hd__decap_12
XFILLER_255_139 VGND VGND VPWR VPWR sky130_fd_sc_hd__decap_8
XFILLER_62_1184 VPWR VGND VPWR VGND sky130_ef_sc_hd__decap_12
XTAP_TAPCELL_ROW_240_4170 VGND VPWR sky130_fd_sc_hd__tapvpwrvgnd_1
XFILLER_114_1263 VGND VGND VPWR VPWR sky130_fd_sc_hd__decap_6
XFILLER_231_1487 VPWR VGND VPWR VGND sky130_ef_sc_hd__decap_12
XFILLER_237_854 VGND VGND VPWR VPWR sky130_fd_sc_hd__decap_6
XFILLER_3_1229 VPWR VGND VPWR VGND sky130_ef_sc_hd__decap_12
XFILLER_149_1304 VPWR VGND VPWR VGND sky130_ef_sc_hd__decap_12
XFILLER_149_1359 VPWR VGND VPWR VGND sky130_ef_sc_hd__decap_12
XFILLER_251_345 VPWR VGND VPWR VGND sky130_ef_sc_hd__decap_12
XPHY_EDGE_ROW_169_Right_14 VGND VGND VPWR VPWR sky130_fd_sc_hd__decap_3
XFILLER_211_209 VGND VGND VPWR VPWR sky130_fd_sc_hd__decap_6
XTAP_TAPCELL_ROW_201_2774 VGND VPWR sky130_fd_sc_hd__tapvpwrvgnd_1
XFILLER_220_710 VPWR VGND VPWR VGND sky130_ef_sc_hd__decap_12
XPHY_EDGE_ROW_47_1_Right_703 VGND VGND VPWR VPWR sky130_fd_sc_hd__decap_3
XFILLER_177_603 VPWR VGND VPWR VGND sky130_ef_sc_hd__decap_12
XTAP_TAPCELL_ROW_201_2785 VGND VPWR sky130_fd_sc_hd__tapvpwrvgnd_1
XFILLER_204_261 VPWR VGND VPWR VGND sky130_ef_sc_hd__decap_12
XFILLER_189_474 VPWR VGND VPWR VGND sky130_ef_sc_hd__decap_12
XTAP_TAPCELL_ROW_201_2796 VGND VPWR sky130_fd_sc_hd__tapvpwrvgnd_1
XFILLER_232_581 VPWR VGND VPWR VGND sky130_ef_sc_hd__decap_12
XTAP_TAPCELL_ROW_193_2520 VGND VPWR sky130_fd_sc_hd__tapvpwrvgnd_1
XTAP_TAPCELL_ROW_253_4597 VGND VPWR sky130_fd_sc_hd__tapvpwrvgnd_1
XFILLER_34_1220 VGND VGND VPWR VPWR sky130_fd_sc_hd__decap_6
XFILLER_220_765 VPWR VGND VPWR VGND sky130_ef_sc_hd__decap_12
XFILLER_177_658 VPWR VGND VPWR VGND sky130_ef_sc_hd__decap_12
XFILLER_121_1201 VGND VGND VPWR VPWR sky130_fd_sc_hd__decap_4
XFILLER_192_617 VGND VGND VPWR VPWR sky130_fd_sc_hd__decap_6
XFILLER_201_990 VPWR VGND VPWR VGND sky130_ef_sc_hd__decap_12
XFILLER_8_370 VGND VGND VPWR VPWR sky130_fd_sc_hd__decap_8
XFILLER_160_1294 VPWR VGND VPWR VGND sky130_ef_sc_hd__decap_12
XFILLER_69_1316 VPWR VGND VPWR VGND sky130_ef_sc_hd__decap_12
XFILLER_173_842 VPWR VGND VPWR VGND sky130_ef_sc_hd__decap_12
XFILLER_195_1346 VPWR VGND VPWR VGND sky130_ef_sc_hd__decap_12
XFILLER_201_1291 VPWR VGND VPWR VGND sky130_ef_sc_hd__decap_12
XFILLER_173_897 VGND VGND VPWR VPWR sky130_fd_sc_hd__decap_6
XTAP_TAPCELL_ROW_187_2302 VGND VPWR sky130_fd_sc_hd__tapvpwrvgnd_1
XTAP_TAPCELL_ROW_187_2313 VGND VPWR sky130_fd_sc_hd__tapvpwrvgnd_1
XPHY_EDGE_ROW_178_Right_23 VGND VGND VPWR VPWR sky130_fd_sc_hd__decap_3
XFILLER_232_1207 VPWR VGND VPWR VGND sky130_ef_sc_hd__decap_12
XFILLER_236_1398 VPWR VGND VPWR VGND sky130_ef_sc_hd__decap_12
XFILLER_45_1371 VGND VGND VPWR VPWR sky130_fd_sc_hd__decap_6
XFILLER_80_1251 VPWR VGND VPWR VGND sky130_ef_sc_hd__decap_12
XFILLER_228_832 VGND VGND VPWR VPWR sky130_fd_sc_hd__decap_6
XTAP_TAPCELL_ROW_9_1179 VGND VPWR sky130_fd_sc_hd__tapvpwrvgnd_1
XTAP_TAPCELL_ROW_97_2_5436 VGND VPWR sky130_fd_sc_hd__tapvpwrvgnd_1
XFILLER_255_673 VPWR VGND VPWR VGND sky130_ef_sc_hd__decap_12
XTAP_TAPCELL_ROW_110_2_5540 VGND VPWR sky130_fd_sc_hd__tapvpwrvgnd_1
XFILLER_242_323 VPWR VGND VPWR VGND sky130_ef_sc_hd__decap_12
XTAP_TAPCELL_ROW_109_2_5534 VGND VPWR sky130_fd_sc_hd__tapvpwrvgnd_1
XFILLER_199_216 VPWR VGND VPWR VGND sky130_ef_sc_hd__decap_12
XFILLER_254_194 VPWR VGND VPWR VGND sky130_ef_sc_hd__decap_12
XPHY_EDGE_ROW_187_Right_32 VGND VGND VPWR VPWR sky130_fd_sc_hd__decap_3
XFILLER_243_1303 VPWR VGND VPWR VGND sky130_ef_sc_hd__decap_12
XFILLER_230_507 VPWR VGND VPWR VGND sky130_ef_sc_hd__decap_12
XFILLER_242_378 VPWR VGND VPWR VGND sky130_ef_sc_hd__decap_12
XFILLER_208_1434 VGND VGND VPWR VPWR sky130_fd_sc_hd__decap_6
XFILLER_52_15 VGND VGND VPWR VPWR sky130_fd_sc_hd__decap_6
XFILLER_195_400 VPWR VGND VPWR VGND sky130_ef_sc_hd__decap_12
XFILLER_211_732 VPWR VGND VPWR VGND sky130_ef_sc_hd__decap_12
XFILLER_243_1358 VPWR VGND VPWR VGND sky130_ef_sc_hd__decap_12
XFILLER_168_15 VGND VGND VPWR VPWR sky130_fd_sc_hd__decap_6
XFILLER_168_636 VPWR VGND VPWR VGND sky130_ef_sc_hd__decap_12
XFILLER_195_455 VPWR VGND VPWR VGND sky130_ef_sc_hd__decap_12
XFILLER_211_787 VPWR VGND VPWR VGND sky130_ef_sc_hd__decap_12
XFILLER_202_1011 VPWR VGND VPWR VGND sky130_ef_sc_hd__decap_12
XFILLER_13_1304 VPWR VGND VPWR VGND sky130_ef_sc_hd__decap_12
XFILLER_183_639 VGND VGND VPWR VPWR sky130_fd_sc_hd__decap_6
XFILLER_104_1454 VPWR VGND VPWR VGND sky130_ef_sc_hd__decap_12
XFILLER_176_691 VPWR VGND VPWR VGND sky130_ef_sc_hd__decap_12
XFILLER_202_1066 VPWR VGND VPWR VGND sky130_ef_sc_hd__decap_12
XFILLER_13_1359 VPWR VGND VPWR VGND sky130_ef_sc_hd__decap_12
XPHY_EDGE_ROW_196_Right_41 VGND VGND VPWR VPWR sky130_fd_sc_hd__decap_3
XPHY_EDGE_ROW_108_2_Left_610 VGND VGND VPWR VPWR sky130_fd_sc_hd__decap_3
XFILLER_254_1410 VPWR VGND VPWR VGND sky130_ef_sc_hd__decap_12
XFILLER_184_58 VGND VGND VPWR VPWR sky130_fd_sc_hd__decap_6
Xsram0_675 VGND VGND VPWR VPWR sram0_675/HI net675 sky130_fd_sc_hd__conb_1
Xsram0_686 VGND VGND VPWR VPWR net686 sram0_686/LO sky130_fd_sc_hd__conb_1
XTAP_TAPCELL_ROW_170_1693 VGND VPWR sky130_fd_sc_hd__tapvpwrvgnd_1
XFILLER_137_1230 VPWR VGND VPWR VGND sky130_ef_sc_hd__decap_12
XFILLER_172_1121 VPWR VGND VPWR VGND sky130_ef_sc_hd__decap_12
XFILLER_254_1465 VPWR VGND VPWR VGND sky130_ef_sc_hd__decap_12
XFILLER_77_56 VPWR VGND VPWR VGND sky130_ef_sc_hd__decap_12
XFILLER_137_1285 VGND VGND VPWR VPWR sky130_fd_sc_hd__decap_6
XFILLER_172_1176 VGND VGND VPWR VPWR sky130_fd_sc_hd__decap_6
XFILLER_24_1411 VPWR VGND VPWR VGND sky130_ef_sc_hd__decap_12
XFILLER_213_1162 VPWR VGND VPWR VGND sky130_ef_sc_hd__decap_12
XFILLER_219_854 VGND VGND VPWR VPWR sky130_fd_sc_hd__decap_6
XFILLER_24_1466 VPWR VGND VPWR VGND sky130_ef_sc_hd__decap_12
XFILLER_111_1414 VGND VGND VPWR VPWR sky130_fd_sc_hd__decap_6
XFILLER_150_1485 VPWR VGND VPWR VGND sky130_ef_sc_hd__decap_12
XFILLER_59_1507 VGND VGND VPWR VPWR sky130_fd_sc_hd__decap_8
XFILLER_93_44 VPWR VGND VPWR VGND sky130_ef_sc_hd__decap_12
XFILLER_2_1262 VGND VGND VPWR VPWR sky130_fd_sc_hd__decap_6
XFILLER_248_1269 VPWR VGND VPWR VGND sky130_ef_sc_hd__decap_12
X_504_ net180 _255_ net176 _097_ VGND VGND VPWR VPWR _258_ sky130_fd_sc_hd__o211a_1
XFILLER_233_345 VPWR VGND VPWR VGND sky130_ef_sc_hd__decap_12
XFILLER_57_1242 VGND VGND VPWR VPWR sky130_fd_sc_hd__decap_6
XFILLER_221_529 VPWR VGND VPWR VGND sky130_ef_sc_hd__decap_12
XFILLER_202_710 VPWR VGND VPWR VGND sky130_ef_sc_hd__decap_12
X_435_ _219_ _223_ VGND VGND VPWR VPWR _224_ sky130_fd_sc_hd__nor2_1
XFILLER_214_581 VPWR VGND VPWR VGND sky130_ef_sc_hd__decap_12
XFILLER_148_1392 VGND VGND VPWR VPWR sky130_fd_sc_hd__decap_6
XFILLER_183_1272 VPWR VGND VPWR VGND sky130_ef_sc_hd__decap_12
XFILLER_92_1177 VGND VGND VPWR VPWR sky130_fd_sc_hd__decap_6
XFILLER_186_433 VPWR VGND VPWR VGND sky130_ef_sc_hd__decap_12
XFILLER_202_765 VPWR VGND VPWR VGND sky130_ef_sc_hd__decap_12
X_366_ net593 net577 net550 VGND VGND VPWR VPWR _155_ sky130_fd_sc_hd__a21o_1
XFILLER_105_1218 VPWR VGND VPWR VGND sky130_ef_sc_hd__decap_12
XFILLER_70_1442 VPWR VGND VPWR VGND sky130_ef_sc_hd__decap_12
XTAP_TAPCELL_ROW_17_1_1255 VGND VPWR sky130_fd_sc_hd__tapvpwrvgnd_1
XFILLER_174_617 VGND VGND VPWR VPWR sky130_fd_sc_hd__decap_6
XTAP_TAPCELL_ROW_154_2_5893 VGND VPWR sky130_fd_sc_hd__tapvpwrvgnd_1
X_297_ net523 _088_ VGND VGND VPWR VPWR _076_ sky130_fd_sc_hd__and2b_1
XFILLER_186_488 VGND VGND VPWR VPWR sky130_fd_sc_hd__decap_6
XFILLER_220_1133 VGND VGND VPWR VPWR sky130_fd_sc_hd__decap_6
XFILLER_70_1497 VPWR VGND VPWR VGND sky130_ef_sc_hd__decap_12
XFILLER_6_852 VGND VGND VPWR VPWR sky130_fd_sc_hd__fill_2
XFILLER_192_1508 VGND VGND VPWR VPWR sky130_fd_sc_hd__decap_6
XFILLER_177_1076 VPWR VGND VPWR VGND sky130_ef_sc_hd__decap_12
XTAP_TAPCELL_ROW_242_4210 VGND VPWR sky130_fd_sc_hd__tapvpwrvgnd_1
XTAP_TAPCELL_ROW_242_4221 VGND VPWR sky130_fd_sc_hd__tapvpwrvgnd_1
XPHY_EDGE_ROW_200_Right_45 VGND VGND VPWR VPWR sky130_fd_sc_hd__decap_3
XTAP_TAPCELL_ROW_242_4232 VGND VPWR sky130_fd_sc_hd__tapvpwrvgnd_1
XFILLER_116_1325 VPWR VGND VPWR VGND sky130_ef_sc_hd__decap_12
XTAP_TAPCELL_ROW_242_4243 VGND VPWR sky130_fd_sc_hd__tapvpwrvgnd_1
XTAP_TAPCELL_ROW_83_2_5322 VGND VPWR sky130_fd_sc_hd__tapvpwrvgnd_1
XFILLER_151_1249 VPWR VGND VPWR VGND sky130_ef_sc_hd__decap_12
XTAP_TAPCELL_ROW_52_2_5080 VGND VPWR sky130_fd_sc_hd__tapvpwrvgnd_1
XFILLER_7_1162 VPWR VGND VPWR VGND sky130_ef_sc_hd__decap_12
XFILLER_3_1026 VGND VGND VPWR VPWR sky130_fd_sc_hd__decap_6
XFILLER_231_1284 VGND VGND VPWR VPWR sky130_fd_sc_hd__decap_6
XTAP_TAPCELL_ROW_4_1010 VGND VPWR sky130_fd_sc_hd__tapvpwrvgnd_1
XTAP_TAPCELL_ROW_4_1021 VGND VPWR sky130_fd_sc_hd__tapvpwrvgnd_1
XTAP_TAPCELL_ROW_4_1032 VGND VPWR sky130_fd_sc_hd__tapvpwrvgnd_1
XTAP_TAPCELL_ROW_207_2994 VGND VPWR sky130_fd_sc_hd__tapvpwrvgnd_1
XTAP_TAPCELL_ROW_203_2847 VGND VPWR sky130_fd_sc_hd__tapvpwrvgnd_1
XFILLER_224_323 VPWR VGND VPWR VGND sky130_ef_sc_hd__decap_12
XFILLER_188_1183 VPWR VGND VPWR VGND sky130_ef_sc_hd__decap_12
XTAP_TAPCELL_ROW_203_2858 VGND VPWR sky130_fd_sc_hd__tapvpwrvgnd_1
XFILLER_236_194 VPWR VGND VPWR VGND sky130_ef_sc_hd__decap_12
XTAP_TAPCELL_ROW_203_2869 VGND VPWR sky130_fd_sc_hd__tapvpwrvgnd_1
XTAP_TAPCELL_ROW_236_4003 VGND VPWR sky130_fd_sc_hd__tapvpwrvgnd_1
XPHY_EDGE_ROW_110_2_Right_201 VGND VGND VPWR VPWR sky130_fd_sc_hd__decap_3
XTAP_TAPCELL_ROW_236_4014 VGND VPWR sky130_fd_sc_hd__tapvpwrvgnd_1
XFILLER_251_142 VPWR VGND VPWR VGND sky130_ef_sc_hd__decap_12
XFILLER_184_1047 VGND VGND VPWR VPWR sky130_fd_sc_hd__decap_6
XFILLER_212_507 VPWR VGND VPWR VGND sky130_ef_sc_hd__decap_12
XTAP_TAPCELL_ROW_236_4025 VGND VPWR sky130_fd_sc_hd__tapvpwrvgnd_1
XFILLER_224_378 VPWR VGND VPWR VGND sky130_ef_sc_hd__decap_12
XFILLER_149_1189 VPWR VGND VPWR VGND sky130_ef_sc_hd__decap_12
XFILLER_127_1421 VPWR VGND VPWR VGND sky130_ef_sc_hd__decap_12
XTAP_TAPCELL_ROW_44_2_5017 VGND VPWR sky130_fd_sc_hd__tapvpwrvgnd_1
XFILLER_177_400 VPWR VGND VPWR VGND sky130_ef_sc_hd__decap_12
XFILLER_251_197 VPWR VGND VPWR VGND sky130_ef_sc_hd__decap_12
XFILLER_71_1206 VPWR VGND VPWR VGND sky130_ef_sc_hd__decap_12
XFILLER_225_1033 VPWR VGND VPWR VGND sky130_ef_sc_hd__decap_12
XFILLER_36_1337 VPWR VGND VPWR VGND sky130_ef_sc_hd__decap_12
XFILLER_189_271 VPWR VGND VPWR VGND sky130_ef_sc_hd__decap_12
XPHY_EDGE_ROW_48_1_Right_704 VGND VGND VPWR VPWR sky130_fd_sc_hd__decap_3
XPHY_EDGE_ROW_106_1_Left_361 VGND VGND VPWR VPWR sky130_fd_sc_hd__decap_3
XFILLER_127_1476 VPWR VGND VPWR VGND sky130_ef_sc_hd__decap_12
XFILLER_162_1356 VPWR VGND VPWR VGND sky130_ef_sc_hd__decap_12
XFILLER_177_455 VPWR VGND VPWR VGND sky130_ef_sc_hd__decap_12
XFILLER_193_904 VPWR VGND VPWR VGND sky130_ef_sc_hd__decap_12
XFILLER_220_562 VPWR VGND VPWR VGND sky130_ef_sc_hd__decap_12
XFILLER_225_1088 VPWR VGND VPWR VGND sky130_ef_sc_hd__decap_12
XFILLER_242_1391 VGND VGND VPWR VPWR sky130_fd_sc_hd__decap_6
XTAP_TAPCELL_ROW_11_2_4747 VGND VPWR sky130_fd_sc_hd__tapvpwrvgnd_1
XFILLER_193_959 VPWR VGND VPWR VGND sky130_ef_sc_hd__decap_12
XTAP_TAPCELL_ROW_140_1_1439 VGND VPWR sky130_fd_sc_hd__tapvpwrvgnd_1
XFILLER_195_1143 VPWR VGND VPWR VGND sky130_ef_sc_hd__decap_12
XFILLER_12_1392 VGND VGND VPWR VPWR sky130_fd_sc_hd__decap_6
XFILLER_195_1198 VGND VGND VPWR VPWR sky130_fd_sc_hd__decap_6
XFILLER_47_1433 VPWR VGND VPWR VGND sky130_ef_sc_hd__decap_12
XFILLER_82_1313 VPWR VGND VPWR VGND sky130_ef_sc_hd__decap_12
XFILLER_236_1140 VPWR VGND VPWR VGND sky130_ef_sc_hd__decap_12
XFILLER_173_1463 VPWR VGND VPWR VGND sky130_ef_sc_hd__decap_12
XFILLER_232_1004 VGND VGND VPWR VPWR sky130_fd_sc_hd__decap_6
XFILLER_82_1368 VPWR VGND VPWR VGND sky130_ef_sc_hd__decap_12
XFILLER_236_1195 VPWR VGND VPWR VGND sky130_ef_sc_hd__decap_12
XFILLER_47_1488 VPWR VGND VPWR VGND sky130_ef_sc_hd__decap_12
XFILLER_248_949 VPWR VGND VPWR VGND sky130_ef_sc_hd__decap_12
XFILLER_47_15 VPWR VGND VPWR VGND sky130_ef_sc_hd__decap_12
XFILLER_210_1324 VPWR VGND VPWR VGND sky130_ef_sc_hd__decap_12
XFILLER_210_1379 VPWR VGND VPWR VGND sky130_ef_sc_hd__decap_12
XFILLER_242_120 VPWR VGND VPWR VGND sky130_ef_sc_hd__decap_12
XFILLER_215_345 VPWR VGND VPWR VGND sky130_ef_sc_hd__decap_12
XFILLER_230_304 VPWR VGND VPWR VGND sky130_ef_sc_hd__decap_12
XFILLER_243_1100 VPWR VGND VPWR VGND sky130_ef_sc_hd__decap_12
XFILLER_203_529 VPWR VGND VPWR VGND sky130_ef_sc_hd__decap_12
XFILLER_242_175 VPWR VGND VPWR VGND sky130_ef_sc_hd__decap_12
XFILLER_247_1291 VPWR VGND VPWR VGND sky130_ef_sc_hd__decap_12
XPHY_EDGE_ROW_38_1_Left_293 VGND VGND VPWR VPWR sky130_fd_sc_hd__decap_3
XFILLER_93_1464 VPWR VGND VPWR VGND sky130_ef_sc_hd__decap_12
XFILLER_180_1434 VGND VGND VPWR VPWR sky130_fd_sc_hd__decap_6
XFILLER_230_359 VGND VGND VPWR VPWR sky130_fd_sc_hd__decap_6
XFILLER_243_1155 VGND VGND VPWR VPWR sky130_fd_sc_hd__decap_6
XTAP_TAPCELL_ROW_139_2_5773 VGND VPWR sky130_fd_sc_hd__tapvpwrvgnd_1
XFILLER_168_433 VPWR VGND VPWR VGND sky130_ef_sc_hd__decap_12
XFILLER_196_753 VPWR VGND VPWR VGND sky130_ef_sc_hd__decap_12
Xwire503 net504 VGND VGND VPWR VPWR net503 sky130_fd_sc_hd__clkbuf_1
XFILLER_137_3 VPWR VGND VPWR VGND sky130_ef_sc_hd__decap_12
XFILLER_195_252 VGND VGND VPWR VPWR sky130_fd_sc_hd__decap_6
Xwire514 _092_ VGND VGND VPWR VPWR net514 sky130_fd_sc_hd__clkbuf_1
XFILLER_211_584 VPWR VGND VPWR VGND sky130_ef_sc_hd__decap_12
XFILLER_221_1420 VPWR VGND VPWR VGND sky130_ef_sc_hd__decap_12
XFILLER_168_488 VGND VGND VPWR VPWR sky130_fd_sc_hd__decap_6
XFILLER_184_937 VPWR VGND VPWR VGND sky130_ef_sc_hd__decap_12
XFILLER_17_1292 VPWR VGND VPWR VGND sky130_ef_sc_hd__decap_12
Xwire547 net46 VGND VGND VPWR VPWR net547 sky130_fd_sc_hd__clkbuf_1
XFILLER_104_1251 VPWR VGND VPWR VGND sky130_ef_sc_hd__decap_12
XFILLER_221_1475 VPWR VGND VPWR VGND sky130_ef_sc_hd__decap_12
XFILLER_195_68 VPWR VGND VPWR VGND sky130_ef_sc_hd__decap_12
XFILLER_170_108 VPWR VGND VPWR VGND sky130_ef_sc_hd__decap_12
XTAP_TAPCELL_ROW_172_1766 VGND VPWR sky130_fd_sc_hd__tapvpwrvgnd_1
XFILLER_13_1189 VPWR VGND VPWR VGND sky130_ef_sc_hd__decap_12
XTAP_TAPCELL_ROW_172_1777 VGND VPWR sky130_fd_sc_hd__tapvpwrvgnd_1
XTAP_TAPCELL_ROW_213_3198 VGND VPWR sky130_fd_sc_hd__tapvpwrvgnd_1
XFILLER_48_1208 VPWR VGND VPWR VGND sky130_ef_sc_hd__decap_12
XTAP_TAPCELL_ROW_172_1788 VGND VPWR sky130_fd_sc_hd__tapvpwrvgnd_1
XFILLER_192_992 VPWR VGND VPWR VGND sky130_ef_sc_hd__decap_12
XFILLER_88_22 VPWR VGND VPWR VGND sky130_ef_sc_hd__decap_12
XTAP_TAPCELL_ROW_132_2_5716 VGND VPWR sky130_fd_sc_hd__tapvpwrvgnd_1
XFILLER_65_1500 VGND VGND VPWR VPWR sky130_fd_sc_hd__decap_6
XFILLER_139_1347 VPWR VGND VPWR VGND sky130_ef_sc_hd__decap_12
XFILLER_174_1238 VPWR VGND VPWR VGND sky130_ef_sc_hd__decap_12
XTAP_TAPCELL_ROW_68_2_5202 VGND VPWR sky130_fd_sc_hd__tapvpwrvgnd_1
XFILLER_254_1262 VGND VGND VPWR VPWR sky130_fd_sc_hd__decap_6
XFILLER_239_916 VPWR VGND VPWR VGND sky130_ef_sc_hd__decap_12
XTAP_TAPCELL_ROW_166_1559 VGND VPWR sky130_fd_sc_hd__tapvpwrvgnd_1
XTAP_TAPCELL_ROW_35_2_4943 VGND VPWR sky130_fd_sc_hd__tapvpwrvgnd_1
XFILLER_4_1324 VPWR VGND VPWR VGND sky130_ef_sc_hd__decap_12
XFILLER_247_971 VPWR VGND VPWR VGND sky130_ef_sc_hd__decap_12
XFILLER_24_1263 VGND VGND VPWR VPWR sky130_fd_sc_hd__decap_6
XFILLER_150_1282 VPWR VGND VPWR VGND sky130_ef_sc_hd__decap_12
XFILLER_248_1011 VPWR VGND VPWR VGND sky130_ef_sc_hd__decap_12
XFILLER_59_1304 VPWR VGND VPWR VGND sky130_ef_sc_hd__decap_12
XFILLER_4_1379 VPWR VGND VPWR VGND sky130_ef_sc_hd__decap_12
XFILLER_206_323 VPWR VGND VPWR VGND sky130_ef_sc_hd__decap_12
XFILLER_185_1334 VPWR VGND VPWR VGND sky130_ef_sc_hd__decap_12
XFILLER_218_194 VPWR VGND VPWR VGND sky130_ef_sc_hd__decap_12
XFILLER_248_1066 VPWR VGND VPWR VGND sky130_ef_sc_hd__decap_12
XFILLER_94_1239 VPWR VGND VPWR VGND sky130_ef_sc_hd__decap_12
XFILLER_233_142 VPWR VGND VPWR VGND sky130_ef_sc_hd__decap_12
XFILLER_59_1359 VPWR VGND VPWR VGND sky130_ef_sc_hd__decap_12
XFILLER_206_378 VPWR VGND VPWR VGND sky130_ef_sc_hd__decap_12
XFILLER_185_1389 VPWR VGND VPWR VGND sky130_ef_sc_hd__decap_12
XFILLER_221_326 VPWR VGND VPWR VGND sky130_ef_sc_hd__decap_12
XFILLER_233_197 VPWR VGND VPWR VGND sky130_ef_sc_hd__decap_12
XTAP_TAPCELL_ROW_250_4501 VGND VPWR sky130_fd_sc_hd__tapvpwrvgnd_1
XTAP_TAPCELL_ROW_250_4512 VGND VPWR sky130_fd_sc_hd__tapvpwrvgnd_1
XTAP_TAPCELL_ROW_250_4523 VGND VPWR sky130_fd_sc_hd__tapvpwrvgnd_1
X_418_ _160_ net121 net113 net164 VGND VGND VPWR VPWR _207_ sky130_fd_sc_hd__a31o_1
XFILLER_186_230 VGND VGND VPWR VPWR sky130_fd_sc_hd__decap_6
XFILLER_175_904 VPWR VGND VPWR VGND sky130_ef_sc_hd__decap_12
XFILLER_202_562 VPWR VGND VPWR VGND sky130_ef_sc_hd__decap_12
XFILLER_187_775 VPWR VGND VPWR VGND sky130_ef_sc_hd__decap_12
XFILLER_230_882 VPWR VGND VPWR VGND sky130_ef_sc_hd__decap_12
XFILLER_239_39 VGND VGND VPWR VPWR sky130_fd_sc_hd__decap_4
XFILLER_169_80 VGND VGND VPWR VPWR sky130_fd_sc_hd__decap_6
XFILLER_31_1201 VGND VGND VPWR VPWR sky130_fd_sc_hd__decap_4
X_349_ net336 VGND VGND VPWR VPWR _138_ sky130_fd_sc_hd__inv_2
XFILLER_175_959 VPWR VGND VPWR VGND sky130_ef_sc_hd__decap_12
XFILLER_70_1294 VPWR VGND VPWR VGND sky130_ef_sc_hd__decap_12
XFILLER_190_918 VGND VGND VPWR VPWR sky130_fd_sc_hd__decap_6
XFILLER_196_1441 VPWR VGND VPWR VGND sky130_ef_sc_hd__decap_12
XTAP_TAPCELL_ROW_248_4430 VGND VPWR sky130_fd_sc_hd__tapvpwrvgnd_1
XTAP_TAPCELL_ROW_248_4441 VGND VPWR sky130_fd_sc_hd__tapvpwrvgnd_1
XFILLER_6_671 VGND VGND VPWR VPWR sky130_fd_sc_hd__decap_8
XFILLER_157_1414 VGND VGND VPWR VPWR sky130_fd_sc_hd__decap_6
XTAP_TAPCELL_ROW_248_4452 VGND VPWR sky130_fd_sc_hd__tapvpwrvgnd_1
XFILLER_52_3 VPWR VGND VPWR VGND sky130_ef_sc_hd__decap_12
XFILLER_192_1305 VGND VGND VPWR VPWR sky130_fd_sc_hd__decap_6
XTAP_TAPCELL_ROW_244_4305 VGND VPWR sky130_fd_sc_hd__tapvpwrvgnd_1
XFILLER_5_181 VGND VGND VPWR VPWR sky130_fd_sc_hd__decap_8
XFILLER_196_1496 VPWR VGND VPWR VGND sky130_ef_sc_hd__decap_12
XFILLER_233_1346 VPWR VGND VPWR VGND sky130_ef_sc_hd__decap_12
XFILLER_116_1177 VGND VGND VPWR VPWR sky130_fd_sc_hd__decap_6
XFILLER_81_1390 VPWR VGND VPWR VGND sky130_ef_sc_hd__decap_12
XFILLER_186_1109 VPWR VGND VPWR VGND sky130_ef_sc_hd__decap_12
XTAP_TAPCELL_ROW_0_825 VGND VPWR sky130_fd_sc_hd__tapvpwrvgnd_1
XTAP_TAPCELL_ROW_0_836 VGND VPWR sky130_fd_sc_hd__tapvpwrvgnd_1
XFILLER_224_120 VPWR VGND VPWR VGND sky130_ef_sc_hd__decap_12
XTAP_TAPCELL_ROW_0_847 VGND VPWR sky130_fd_sc_hd__tapvpwrvgnd_1
XTAP_TAPCELL_ROW_0_858 VGND VPWR sky130_fd_sc_hd__tapvpwrvgnd_1
XTAP_TAPCELL_ROW_156_2_5912 VGND VPWR sky130_fd_sc_hd__tapvpwrvgnd_1
XTAP_TAPCELL_ROW_0_869 VGND VPWR sky130_fd_sc_hd__tapvpwrvgnd_1
XFILLER_212_304 VPWR VGND VPWR VGND sky130_ef_sc_hd__decap_12
XFILLER_197_517 VPWR VGND VPWR VGND sky130_ef_sc_hd__decap_12
XFILLER_224_175 VPWR VGND VPWR VGND sky130_ef_sc_hd__decap_12
XFILLER_240_624 VPWR VGND VPWR VGND sky130_ef_sc_hd__decap_12
XFILLER_252_495 VPWR VGND VPWR VGND sky130_ef_sc_hd__decap_12
XPHY_EDGE_ROW_111_2_Right_202 VGND VGND VPWR VPWR sky130_fd_sc_hd__decap_3
XFILLER_244_1453 VPWR VGND VPWR VGND sky130_ef_sc_hd__decap_12
XFILLER_212_359 VGND VGND VPWR VPWR sky130_fd_sc_hd__decap_6
XFILLER_33_39 VGND VGND VPWR VPWR sky130_fd_sc_hd__decap_4
XFILLER_240_679 VPWR VGND VPWR VGND sky130_ef_sc_hd__decap_12
XFILLER_178_753 VPWR VGND VPWR VGND sky130_ef_sc_hd__decap_12
XFILLER_127_1273 VPWR VGND VPWR VGND sky130_ef_sc_hd__decap_12
XFILLER_149_39 VGND VGND VPWR VPWR sky130_fd_sc_hd__decap_4
XFILLER_177_252 VGND VGND VPWR VPWR sky130_fd_sc_hd__decap_6
XFILLER_193_701 VPWR VGND VPWR VGND sky130_ef_sc_hd__decap_12
XPHY_EDGE_ROW_49_1_Right_705 VGND VGND VPWR VPWR sky130_fd_sc_hd__decap_3
XFILLER_166_937 VPWR VGND VPWR VGND sky130_ef_sc_hd__decap_12
XFILLER_197_1205 VPWR VGND VPWR VGND sky130_ef_sc_hd__decap_12
XTAP_TAPCELL_ROW_74_2_5256 VGND VPWR sky130_fd_sc_hd__tapvpwrvgnd_1
XTAP_TAPCELL_ROW_158_1_1466 VGND VPWR sky130_fd_sc_hd__tapvpwrvgnd_1
XFILLER_193_756 VPWR VGND VPWR VGND sky130_ef_sc_hd__decap_12
XFILLER_14_1454 VPWR VGND VPWR VGND sky130_ef_sc_hd__decap_12
XFILLER_101_1402 VPWR VGND VPWR VGND sky130_ef_sc_hd__decap_12
XFILLER_174_992 VPWR VGND VPWR VGND sky130_ef_sc_hd__decap_12
XFILLER_101_1457 VGND VGND VPWR VPWR sky130_fd_sc_hd__decap_6
XFILLER_175_1514 VGND VGND VPWR VPWR sky130_fd_sc_hd__fill_1
XTAP_TAPCELL_ROW_41_2_4986 VGND VPWR sky130_fd_sc_hd__tapvpwrvgnd_1
XFILLER_136_1509 VGND VGND VPWR VPWR sky130_fd_sc_hd__decap_6
XFILLER_47_1230 VPWR VGND VPWR VGND sky130_ef_sc_hd__decap_12
XFILLER_251_1413 VGND VGND VPWR VPWR sky130_fd_sc_hd__decap_6
XFILLER_138_1380 VPWR VGND VPWR VGND sky130_ef_sc_hd__decap_12
XFILLER_173_1260 VPWR VGND VPWR VGND sky130_ef_sc_hd__decap_12
XPHY_EDGE_ROW_206_Left_461 VGND VGND VPWR VPWR sky130_fd_sc_hd__decap_3
XFILLER_181_15 VPWR VGND VPWR VGND sky130_ef_sc_hd__decap_12
XFILLER_58_58 VGND VGND VPWR VPWR sky130_fd_sc_hd__decap_6
XFILLER_47_1285 VGND VGND VPWR VPWR sky130_fd_sc_hd__decap_6
XFILLER_82_1165 VPWR VGND VPWR VGND sky130_ef_sc_hd__decap_12
XFILLER_248_746 VGND VGND VPWR VPWR sky130_fd_sc_hd__decap_6
XFILLER_21_1414 VGND VGND VPWR VPWR sky130_fd_sc_hd__decap_6
XFILLER_210_1121 VPWR VGND VPWR VGND sky130_ef_sc_hd__decap_12
XFILLER_229_971 VPWR VGND VPWR VGND sky130_ef_sc_hd__decap_12
XFILLER_60_1485 VPWR VGND VPWR VGND sky130_ef_sc_hd__decap_12
XFILLER_74_46 VPWR VGND VPWR VGND sky130_ef_sc_hd__decap_12
XFILLER_210_1176 VGND VGND VPWR VPWR sky130_fd_sc_hd__decap_6
XTAP_TAPCELL_ROW_221_3478 VGND VPWR sky130_fd_sc_hd__tapvpwrvgnd_1
XTAP_TAPCELL_ROW_221_3489 VGND VPWR sky130_fd_sc_hd__tapvpwrvgnd_1
XFILLER_215_142 VPWR VGND VPWR VGND sky130_ef_sc_hd__decap_12
XFILLER_245_1217 VPWR VGND VPWR VGND sky130_ef_sc_hd__decap_12
XFILLER_254_3 VPWR VGND VPWR VGND sky130_ef_sc_hd__decap_12
XFILLER_230_101 VGND VGND VPWR VPWR sky130_fd_sc_hd__decap_6
XFILLER_203_326 VPWR VGND VPWR VGND sky130_ef_sc_hd__decap_12
XFILLER_215_197 VPWR VGND VPWR VGND sky130_ef_sc_hd__decap_12
XFILLER_231_646 VPWR VGND VPWR VGND sky130_ef_sc_hd__decap_12
XFILLER_93_1261 VPWR VGND VPWR VGND sky130_ef_sc_hd__decap_12
XPHY_EDGE_ROW_215_Left_470 VGND VGND VPWR VPWR sky130_fd_sc_hd__decap_3
XFILLER_58_1392 VGND VGND VPWR VPWR sky130_fd_sc_hd__decap_6
XFILLER_90_34 VPWR VGND VPWR VGND sky130_ef_sc_hd__decap_12
XFILLER_106_1313 VPWR VGND VPWR VGND sky130_ef_sc_hd__decap_12
XFILLER_168_230 VGND VGND VPWR VPWR sky130_fd_sc_hd__decap_6
XFILLER_196_550 VPWR VGND VPWR VGND sky130_ef_sc_hd__decap_12
XFILLER_212_882 VPWR VGND VPWR VGND sky130_ef_sc_hd__decap_12
XFILLER_15_1218 VPWR VGND VPWR VGND sky130_ef_sc_hd__decap_12
XFILLER_169_775 VPWR VGND VPWR VGND sky130_ef_sc_hd__decap_12
XTAP_TAPCELL_ROW_178_1975 VGND VPWR sky130_fd_sc_hd__tapvpwrvgnd_1
XFILLER_8_925 VPWR VGND VPWR VGND sky130_ef_sc_hd__decap_12
Xwire300 net301 VGND VGND VPWR VPWR net300 sky130_fd_sc_hd__clkbuf_1
XTAP_TAPCELL_ROW_178_1986 VGND VPWR sky130_fd_sc_hd__tapvpwrvgnd_1
XFILLER_211_381 VGND VGND VPWR VPWR sky130_fd_sc_hd__decap_6
Xwire311 net312 VGND VGND VPWR VPWR net311 sky130_fd_sc_hd__clkbuf_1
XTAP_TAPCELL_ROW_178_1997 VGND VPWR sky130_fd_sc_hd__tapvpwrvgnd_1
Xwire322 net323 VGND VGND VPWR VPWR net322 sky130_fd_sc_hd__clkbuf_1
XFILLER_106_1368 VPWR VGND VPWR VGND sky130_ef_sc_hd__decap_12
XTAP_TAPCELL_ROW_174_1839 VGND VPWR sky130_fd_sc_hd__tapvpwrvgnd_1
XFILLER_184_734 VPWR VGND VPWR VGND sky130_ef_sc_hd__decap_12
Xwire344 net345 VGND VGND VPWR VPWR net344 sky130_fd_sc_hd__clkbuf_1
Xwire355 net356 VGND VGND VPWR VPWR net355 sky130_fd_sc_hd__clkbuf_1
XFILLER_172_918 VGND VGND VPWR VPWR sky130_fd_sc_hd__decap_6
XFILLER_221_1272 VPWR VGND VPWR VGND sky130_ef_sc_hd__decap_12
Xwire366 net367 VGND VGND VPWR VPWR net366 sky130_fd_sc_hd__clkbuf_1
Xwire377 net378 VGND VGND VPWR VPWR net377 sky130_fd_sc_hd__clkbuf_1
XFILLER_184_789 VGND VGND VPWR VPWR sky130_fd_sc_hd__decap_6
Xwire388 net389 VGND VGND VPWR VPWR net388 sky130_fd_sc_hd__clkbuf_1
XTAP_TAPCELL_ROW_110_1_1394 VGND VPWR sky130_fd_sc_hd__tapvpwrvgnd_1
Xwire399 net400 VGND VGND VPWR VPWR net399 sky130_fd_sc_hd__clkbuf_1
XFILLER_174_1035 VPWR VGND VPWR VGND sky130_ef_sc_hd__decap_12
XFILLER_139_1177 VPWR VGND VPWR VGND sky130_ef_sc_hd__decap_12
XFILLER_2_151 VPWR VGND VPWR VGND sky130_ef_sc_hd__decap_12
XPHY_EDGE_ROW_11_1_Right_667 VGND VGND VPWR VPWR sky130_fd_sc_hd__decap_3
XFILLER_239_713 VPWR VGND VPWR VGND sky130_ef_sc_hd__decap_12
XFILLER_26_1325 VPWR VGND VPWR VGND sky130_ef_sc_hd__decap_12
XFILLER_117_1464 VPWR VGND VPWR VGND sky130_ef_sc_hd__decap_12
XTAP_TAPCELL_ROW_162_2_5955 VGND VPWR sky130_fd_sc_hd__tapvpwrvgnd_1
XFILLER_230_1508 VGND VGND VPWR VPWR sky130_fd_sc_hd__decap_6
XFILLER_61_1249 VPWR VGND VPWR VGND sky130_ef_sc_hd__decap_12
XFILLER_215_1076 VPWR VGND VPWR VGND sky130_ef_sc_hd__decap_12
XFILLER_239_768 VGND VGND VPWR VPWR sky130_fd_sc_hd__decap_6
XFILLER_113_1328 VGND VGND VPWR VPWR sky130_fd_sc_hd__decap_6
XFILLER_4_1121 VPWR VGND VPWR VGND sky130_ef_sc_hd__decap_12
XFILLER_152_1399 VPWR VGND VPWR VGND sky130_ef_sc_hd__decap_12
XFILLER_0_43 VPWR VGND VPWR VGND sky130_ef_sc_hd__decap_12
XFILLER_4_1176 VGND VGND VPWR VPWR sky130_fd_sc_hd__decap_6
XFILLER_253_259 VPWR VGND VPWR VGND sky130_ef_sc_hd__decap_12
XFILLER_206_120 VPWR VGND VPWR VGND sky130_ef_sc_hd__decap_12
XFILLER_185_1131 VPWR VGND VPWR VGND sky130_ef_sc_hd__decap_12
XTAP_TAPCELL_ROW_164_1_1476 VGND VPWR sky130_fd_sc_hd__tapvpwrvgnd_1
XTAP_TAPCELL_ROW_80_2_5299 VGND VPWR sky130_fd_sc_hd__tapvpwrvgnd_1
XFILLER_179_517 VPWR VGND VPWR VGND sky130_ef_sc_hd__decap_12
XFILLER_206_175 VPWR VGND VPWR VGND sky130_ef_sc_hd__decap_12
XFILLER_222_624 VPWR VGND VPWR VGND sky130_ef_sc_hd__decap_12
XFILLER_234_495 VPWR VGND VPWR VGND sky130_ef_sc_hd__decap_12
XFILLER_59_1189 VPWR VGND VPWR VGND sky130_ef_sc_hd__decap_12
XFILLER_185_1186 VPWR VGND VPWR VGND sky130_ef_sc_hd__decap_12
XFILLER_221_123 VGND VGND VPWR VPWR sky130_fd_sc_hd__decap_6
XFILLER_37_1421 VPWR VGND VPWR VGND sky130_ef_sc_hd__decap_12
XFILLER_210_808 VPWR VGND VPWR VGND sky130_ef_sc_hd__decap_12
XFILLER_222_679 VPWR VGND VPWR VGND sky130_ef_sc_hd__decap_12
XTAP_TAPCELL_ROW_60_2_5142 VGND VPWR sky130_fd_sc_hd__tapvpwrvgnd_1
XTAP_TAPCELL_ROW_59_2_5136 VGND VPWR sky130_fd_sc_hd__tapvpwrvgnd_1
XFILLER_37_1476 VPWR VGND VPWR VGND sky130_ef_sc_hd__decap_12
XFILLER_72_1356 VPWR VGND VPWR VGND sky130_ef_sc_hd__decap_12
XFILLER_175_701 VPWR VGND VPWR VGND sky130_ef_sc_hd__decap_12
XFILLER_226_1183 VPWR VGND VPWR VGND sky130_ef_sc_hd__decap_12
XFILLER_124_1435 VGND VGND VPWR VPWR sky130_fd_sc_hd__decap_6
XFILLER_187_572 VPWR VGND VPWR VGND sky130_ef_sc_hd__decap_12
XFILLER_9_85 VPWR VGND VPWR VGND sky130_ef_sc_hd__decap_12
XFILLER_222_1047 VGND VGND VPWR VPWR sky130_fd_sc_hd__decap_6
XFILLER_198_1514 VGND VGND VPWR VPWR sky130_fd_sc_hd__fill_1
XFILLER_175_756 VPWR VGND VPWR VGND sky130_ef_sc_hd__decap_12
XFILLER_200_1312 VPWR VGND VPWR VGND sky130_ef_sc_hd__decap_12
XTAP_TAPCELL_ROW_26_2_4866 VGND VPWR sky130_fd_sc_hd__tapvpwrvgnd_1
XTAP_TAPCELL_ROW_190_2397 VGND VPWR sky130_fd_sc_hd__tapvpwrvgnd_1
Xmax_cap611 rd_addr\[4\] VGND VGND VPWR VPWR net611 sky130_fd_sc_hd__clkbuf_1
XFILLER_200_1367 VPWR VGND VPWR VGND sky130_ef_sc_hd__decap_12
XFILLER_171_940 VGND VGND VPWR VPWR sky130_fd_sc_hd__decap_6
XFILLER_196_1293 VPWR VGND VPWR VGND sky130_ef_sc_hd__decap_12
XFILLER_118_1239 VPWR VGND VPWR VGND sky130_ef_sc_hd__decap_12
XFILLER_9_1021 VGND VGND VPWR VPWR sky130_fd_sc_hd__decap_8
XFILLER_170_1422 VPWR VGND VPWR VGND sky130_ef_sc_hd__decap_12
XFILLER_233_1143 VPWR VGND VPWR VGND sky130_ef_sc_hd__decap_12
XTAP_TAPCELL_ROW_184_2179 VGND VPWR sky130_fd_sc_hd__tapvpwrvgnd_1
XFILLER_170_1477 VGND VGND VPWR VPWR sky130_fd_sc_hd__decap_6
XFILLER_233_1198 VGND VGND VPWR VPWR sky130_fd_sc_hd__decap_6
XFILLER_211_1463 VPWR VGND VPWR VGND sky130_ef_sc_hd__decap_12
XFILLER_244_237 VPWR VGND VPWR VGND sky130_ef_sc_hd__decap_12
XTAP_TAPCELL_ROW_40_1_1289 VGND VPWR sky130_fd_sc_hd__tapvpwrvgnd_1
XFILLER_77_1201 VGND VGND VPWR VPWR sky130_fd_sc_hd__decap_4
XFILLER_129_1335 VPWR VGND VPWR VGND sky130_ef_sc_hd__decap_12
XFILLER_212_101 VGND VGND VPWR VPWR sky130_fd_sc_hd__decap_6
XFILLER_197_314 VPWR VGND VPWR VGND sky130_ef_sc_hd__decap_12
XFILLER_213_646 VPWR VGND VPWR VGND sky130_ef_sc_hd__decap_12
XFILLER_240_421 VPWR VGND VPWR VGND sky130_ef_sc_hd__decap_12
XFILLER_252_292 VPWR VGND VPWR VGND sky130_ef_sc_hd__decap_12
XFILLER_244_1250 VPWR VGND VPWR VGND sky130_ef_sc_hd__decap_12
XFILLER_90_1423 VPWR VGND VPWR VGND sky130_ef_sc_hd__decap_12
XPHY_EDGE_ROW_112_2_Right_203 VGND VGND VPWR VPWR sky130_fd_sc_hd__decap_3
XFILLER_209_1370 VGND VGND VPWR VPWR sky130_fd_sc_hd__decap_6
XFILLER_100_22 VPWR VGND VPWR VGND sky130_ef_sc_hd__decap_12
XFILLER_197_369 VPWR VGND VPWR VGND sky130_ef_sc_hd__decap_12
XFILLER_240_476 VPWR VGND VPWR VGND sky130_ef_sc_hd__decap_12
XFILLER_178_550 VPWR VGND VPWR VGND sky130_ef_sc_hd__decap_12
XFILLER_90_1478 VGND VGND VPWR VPWR sky130_fd_sc_hd__decap_6
XFILLER_166_734 VPWR VGND VPWR VGND sky130_ef_sc_hd__decap_12
XFILLER_165_211 VPWR VGND VPWR VGND sky130_ef_sc_hd__decap_12
XFILLER_176_15 VGND VGND VPWR VPWR sky130_fd_sc_hd__decap_6
XFILLER_197_1002 VPWR VGND VPWR VGND sky130_ef_sc_hd__decap_12
XFILLER_165_244 VGND VGND VPWR VPWR sky130_fd_sc_hd__decap_8
XFILLER_193_553 VGND VGND VPWR VPWR sky130_fd_sc_hd__decap_6
XFILLER_14_1251 VPWR VGND VPWR VGND sky130_ef_sc_hd__decap_12
XTAP_TAPCELL_ROW_214_3260 VGND VPWR sky130_fd_sc_hd__tapvpwrvgnd_1
XFILLER_166_789 VGND VGND VPWR VPWR sky130_fd_sc_hd__decap_6
XTAP_TAPCELL_ROW_210_3102 VGND VPWR sky130_fd_sc_hd__tapvpwrvgnd_1
XTAP_TAPCELL_ROW_210_3113 VGND VPWR sky130_fd_sc_hd__tapvpwrvgnd_1
XTAP_TAPCELL_ROW_233_3894 VGND VPWR sky130_fd_sc_hd__tapvpwrvgnd_1
XFILLER_5_928 VPWR VGND VPWR VGND sky130_ef_sc_hd__decap_12
XFILLER_105_1390 VPWR VGND VPWR VGND sky130_ef_sc_hd__decap_12
XFILLER_140_1270 VPWR VGND VPWR VGND sky130_ef_sc_hd__decap_12
XFILLER_197_1057 VPWR VGND VPWR VGND sky130_ef_sc_hd__decap_12
XFILLER_49_1347 VPWR VGND VPWR VGND sky130_ef_sc_hd__decap_12
XFILLER_84_1227 VPWR VGND VPWR VGND sky130_ef_sc_hd__decap_12
XFILLER_238_1054 VPWR VGND VPWR VGND sky130_ef_sc_hd__decap_12
XFILLER_136_1306 VGND VGND VPWR VPWR sky130_fd_sc_hd__decap_6
XFILLER_69_68 VGND VGND VPWR VPWR sky130_fd_sc_hd__decap_3
XTAP_TAPCELL_ROW_147_2_5835 VGND VPWR sky130_fd_sc_hd__tapvpwrvgnd_1
XFILLER_175_1377 VPWR VGND VPWR VGND sky130_ef_sc_hd__decap_12
XFILLER_192_58 VGND VGND VPWR VPWR sky130_fd_sc_hd__decap_6
XTAP_TAPCELL_ROW_208_3020 VGND VPWR sky130_fd_sc_hd__tapvpwrvgnd_1
XTAP_TAPCELL_ROW_116_2_5593 VGND VPWR sky130_fd_sc_hd__tapvpwrvgnd_1
XTAP_TAPCELL_ROW_208_3031 VGND VPWR sky130_fd_sc_hd__tapvpwrvgnd_1
XTAP_TAPCELL_ROW_167_1610 VGND VPWR sky130_fd_sc_hd__tapvpwrvgnd_1
XTAP_TAPCELL_ROW_208_3042 VGND VPWR sky130_fd_sc_hd__tapvpwrvgnd_1
XTAP_TAPCELL_ROW_208_3053 VGND VPWR sky130_fd_sc_hd__tapvpwrvgnd_1
XTAP_TAPCELL_ROW_227_3687 VGND VPWR sky130_fd_sc_hd__tapvpwrvgnd_1
XTAP_TAPCELL_ROW_227_3698 VGND VPWR sky130_fd_sc_hd__tapvpwrvgnd_1
XFILLER_212_1238 VPWR VGND VPWR VGND sky130_ef_sc_hd__decap_12
XFILLER_85_56 VPWR VGND VPWR VGND sky130_ef_sc_hd__decap_12
XFILLER_60_1282 VPWR VGND VPWR VGND sky130_ef_sc_hd__decap_12
XFILLER_5_1463 VPWR VGND VPWR VGND sky130_ef_sc_hd__decap_12
XTAP_TAPCELL_ROW_65_2_5179 VGND VPWR sky130_fd_sc_hd__tapvpwrvgnd_1
XFILLER_1_1327 VGND VGND VPWR VPWR sky130_fd_sc_hd__decap_6
XFILLER_235_259 VPWR VGND VPWR VGND sky130_ef_sc_hd__decap_12
XPHY_EDGE_ROW_49_2_Left_551 VGND VGND VPWR VPWR sky130_fd_sc_hd__decap_3
XFILLER_147_1402 VPWR VGND VPWR VGND sky130_ef_sc_hd__decap_12
XFILLER_250_218 VPWR VGND VPWR VGND sky130_ef_sc_hd__decap_12
XFILLER_245_1014 VPWR VGND VPWR VGND sky130_ef_sc_hd__decap_12
XFILLER_204_624 VPWR VGND VPWR VGND sky130_ef_sc_hd__decap_12
XFILLER_186_1484 VPWR VGND VPWR VGND sky130_ef_sc_hd__decap_12
XFILLER_95_1378 VPWR VGND VPWR VGND sky130_ef_sc_hd__decap_12
XFILLER_216_495 VPWR VGND VPWR VGND sky130_ef_sc_hd__decap_12
XTAP_TAPCELL_ROW_45_2_5022 VGND VPWR sky130_fd_sc_hd__tapvpwrvgnd_1
XFILLER_203_123 VGND VGND VPWR VPWR sky130_fd_sc_hd__decap_6
XFILLER_147_1457 VGND VGND VPWR VPWR sky130_fd_sc_hd__decap_6
XFILLER_231_443 VPWR VGND VPWR VGND sky130_ef_sc_hd__decap_12
XFILLER_182_1348 VGND VGND VPWR VPWR sky130_fd_sc_hd__decap_6
XFILLER_245_1069 VGND VGND VPWR VPWR sky130_fd_sc_hd__decap_6
XFILLER_188_347 VPWR VGND VPWR VGND sky130_ef_sc_hd__decap_12
XFILLER_204_679 VPWR VGND VPWR VGND sky130_ef_sc_hd__decap_12
XFILLER_223_1334 VPWR VGND VPWR VGND sky130_ef_sc_hd__decap_12
XFILLER_231_498 VPWR VGND VPWR VGND sky130_ef_sc_hd__decap_12
XFILLER_169_572 VPWR VGND VPWR VGND sky130_ef_sc_hd__decap_12
XFILLER_184_531 VGND VGND VPWR VPWR sky130_fd_sc_hd__decap_6
XFILLER_106_1165 VPWR VGND VPWR VGND sky130_ef_sc_hd__decap_12
XFILLER_200_863 VPWR VGND VPWR VGND sky130_ef_sc_hd__decap_12
XFILLER_223_1389 VPWR VGND VPWR VGND sky130_ef_sc_hd__decap_12
XFILLER_8_777 VPWR VGND VPWR VGND sky130_ef_sc_hd__decap_12
XFILLER_67_1414 VGND VGND VPWR VPWR sky130_fd_sc_hd__decap_6
XFILLER_4_961 VGND VGND VPWR VPWR sky130_fd_sc_hd__decap_6
XFILLER_193_1444 VPWR VGND VPWR VGND sky130_ef_sc_hd__decap_12
XFILLER_3_471 VGND VGND VPWR VPWR sky130_fd_sc_hd__fill_2
XFILLER_193_1499 VGND VGND VPWR VPWR sky130_fd_sc_hd__decap_6
XFILLER_234_1441 VPWR VGND VPWR VGND sky130_ef_sc_hd__decap_12
XPHY_EDGE_ROW_12_1_Right_668 VGND VGND VPWR VPWR sky130_fd_sc_hd__decap_3
XFILLER_239_510 VGND VGND VPWR VPWR sky130_fd_sc_hd__decap_6
XFILLER_230_1305 VGND VGND VPWR VPWR sky130_fd_sc_hd__decap_6
XFILLER_117_1261 VPWR VGND VPWR VGND sky130_ef_sc_hd__decap_12
XFILLER_6_1238 VPWR VGND VPWR VGND sky130_ef_sc_hd__decap_12
XFILLER_234_1496 VPWR VGND VPWR VGND sky130_ef_sc_hd__decap_12
XFILLER_26_1177 VGND VGND VPWR VPWR sky130_fd_sc_hd__decap_6
XPHY_EDGE_ROW_115_1_Left_370 VGND VGND VPWR VPWR sky130_fd_sc_hd__decap_3
XFILLER_15_3 VPWR VGND VPWR VGND sky130_ef_sc_hd__decap_12
XFILLER_152_1196 VPWR VGND VPWR VGND sky130_ef_sc_hd__decap_12
XFILLER_226_237 VPWR VGND VPWR VGND sky130_ef_sc_hd__decap_12
XFILLER_187_1248 VPWR VGND VPWR VGND sky130_ef_sc_hd__decap_12
XFILLER_165_1513 VGND VGND VPWR VPWR sky130_fd_sc_hd__fill_2
XFILLER_179_314 VPWR VGND VPWR VGND sky130_ef_sc_hd__decap_12
XFILLER_222_421 VPWR VGND VPWR VGND sky130_ef_sc_hd__decap_12
XFILLER_234_292 VPWR VGND VPWR VGND sky130_ef_sc_hd__decap_12
XFILLER_224_1109 VPWR VGND VPWR VGND sky130_ef_sc_hd__decap_12
XFILLER_210_605 VPWR VGND VPWR VGND sky130_ef_sc_hd__decap_12
XFILLER_241_1401 VPWR VGND VPWR VGND sky130_ef_sc_hd__decap_12
XFILLER_195_818 VPWR VGND VPWR VGND sky130_ef_sc_hd__decap_12
XFILLER_222_476 VPWR VGND VPWR VGND sky130_ef_sc_hd__decap_12
XFILLER_250_796 VPWR VGND VPWR VGND sky130_ef_sc_hd__decap_12
XFILLER_179_369 VPWR VGND VPWR VGND sky130_ef_sc_hd__decap_12
XFILLER_201_87 VPWR VGND VPWR VGND sky130_ef_sc_hd__decap_12
XFILLER_37_1273 VPWR VGND VPWR VGND sky130_ef_sc_hd__decap_12
XFILLER_241_1456 VGND VGND VPWR VPWR sky130_fd_sc_hd__decap_6
XFILLER_163_1292 VPWR VGND VPWR VGND sky130_ef_sc_hd__decap_12
XTAP_TAPCELL_ROW_192_2459 VGND VPWR sky130_fd_sc_hd__tapvpwrvgnd_1
XFILLER_175_553 VGND VGND VPWR VPWR sky130_fd_sc_hd__decap_6
XTAP_TAPCELL_ROW_153_2_5889 VGND VPWR sky130_fd_sc_hd__tapvpwrvgnd_1
XFILLER_11_1402 VPWR VGND VPWR VGND sky130_ef_sc_hd__decap_12
XFILLER_198_1355 VPWR VGND VPWR VGND sky130_ef_sc_hd__decap_12
XTAP_TAPCELL_ROW_90_2_5381 VGND VPWR sky130_fd_sc_hd__tapvpwrvgnd_1
XFILLER_159_1328 VGND VGND VPWR VPWR sky130_fd_sc_hd__decap_6
XTAP_TAPCELL_ROW_89_2_5375 VGND VPWR sky130_fd_sc_hd__tapvpwrvgnd_1
XFILLER_194_1219 VGND VGND VPWR VPWR sky130_fd_sc_hd__decap_6
XFILLER_200_1164 VPWR VGND VPWR VGND sky130_ef_sc_hd__decap_12
XFILLER_11_1457 VGND VGND VPWR VPWR sky130_fd_sc_hd__decap_6
XFILLER_235_1205 VPWR VGND VPWR VGND sky130_ef_sc_hd__decap_12
XFILLER_196_1090 VGND VGND VPWR VPWR sky130_fd_sc_hd__decap_6
XFILLER_46_1509 VGND VGND VPWR VPWR sky130_fd_sc_hd__decap_6
Xmax_cap496 _130_ VGND VGND VPWR VPWR net496 sky130_fd_sc_hd__clkbuf_1
XFILLER_170_280 VPWR VGND VPWR VGND sky130_ef_sc_hd__decap_12
XFILLER_39_27 VPWR VGND VPWR VGND sky130_ef_sc_hd__decap_12
XFILLER_48_1380 VPWR VGND VPWR VGND sky130_ef_sc_hd__decap_12
XFILLER_213_1514 VGND VGND VPWR VPWR sky130_fd_sc_hd__fill_1
XTAP_TAPCELL_ROW_82_2_5318 VGND VPWR sky130_fd_sc_hd__tapvpwrvgnd_1
XTAP_TAPCELL_ROW_222_3540 VGND VPWR sky130_fd_sc_hd__tapvpwrvgnd_1
XFILLER_55_15 VPWR VGND VPWR VGND sky130_ef_sc_hd__decap_12
XTAP_TAPCELL_ROW_1_920 VGND VPWR sky130_fd_sc_hd__tapvpwrvgnd_1
XFILLER_211_1260 VPWR VGND VPWR VGND sky130_ef_sc_hd__decap_12
XFILLER_217_259 VPWR VGND VPWR VGND sky130_ef_sc_hd__decap_12
XFILLER_246_1312 VPWR VGND VPWR VGND sky130_ef_sc_hd__decap_12
XFILLER_232_218 VPWR VGND VPWR VGND sky130_ef_sc_hd__decap_12
XTAP_TAPCELL_ROW_146_1_1448 VGND VPWR sky130_fd_sc_hd__tapvpwrvgnd_1
XFILLER_197_111 VPWR VGND VPWR VGND sky130_ef_sc_hd__decap_12
XFILLER_246_1367 VPWR VGND VPWR VGND sky130_ef_sc_hd__decap_12
XFILLER_213_443 VPWR VGND VPWR VGND sky130_ef_sc_hd__decap_12
XFILLER_129_1165 VPWR VGND VPWR VGND sky130_ef_sc_hd__decap_12
XFILLER_198_667 VPWR VGND VPWR VGND sky130_ef_sc_hd__decap_12
XFILLER_90_1220 VGND VGND VPWR VPWR sky130_fd_sc_hd__decap_6
XTAP_TAPCELL_ROW_216_3300 VGND VPWR sky130_fd_sc_hd__tapvpwrvgnd_1
XFILLER_197_166 VGND VGND VPWR VPWR sky130_fd_sc_hd__decap_6
XFILLER_201_627 VPWR VGND VPWR VGND sky130_ef_sc_hd__decap_12
XTAP_TAPCELL_ROW_216_3311 VGND VPWR sky130_fd_sc_hd__tapvpwrvgnd_1
XFILLER_240_273 VGND VGND VPWR VPWR sky130_fd_sc_hd__decap_6
XFILLER_16_1313 VPWR VGND VPWR VGND sky130_ef_sc_hd__decap_12
XFILLER_213_498 VPWR VGND VPWR VGND sky130_ef_sc_hd__decap_12
XTAP_TAPCELL_ROW_216_3322 VGND VPWR sky130_fd_sc_hd__tapvpwrvgnd_1
XPHY_EDGE_ROW_113_2_Right_204 VGND VGND VPWR VPWR sky130_fd_sc_hd__decap_3
XFILLER_181_1370 VGND VGND VPWR VPWR sky130_fd_sc_hd__decap_6
XTAP_TAPCELL_ROW_216_3333 VGND VPWR sky130_fd_sc_hd__tapvpwrvgnd_1
XFILLER_199_1119 VPWR VGND VPWR VGND sky130_ef_sc_hd__decap_12
XTAP_TAPCELL_ROW_235_3967 VGND VPWR sky130_fd_sc_hd__tapvpwrvgnd_1
XTAP_TAPCELL_ROW_235_3978 VGND VPWR sky130_fd_sc_hd__tapvpwrvgnd_1
XFILLER_166_531 VGND VGND VPWR VPWR sky130_fd_sc_hd__decap_6
XTAP_TAPCELL_ROW_235_3989 VGND VPWR sky130_fd_sc_hd__tapvpwrvgnd_1
XFILLER_16_1368 VPWR VGND VPWR VGND sky130_ef_sc_hd__decap_12
XFILLER_103_1316 VPWR VGND VPWR VGND sky130_ef_sc_hd__decap_12
XFILLER_194_851 VPWR VGND VPWR VGND sky130_ef_sc_hd__decap_12
XFILLER_5_703 VGND VGND VPWR VPWR sky130_fd_sc_hd__decap_8
XFILLER_217_3 VPWR VGND VPWR VGND sky130_ef_sc_hd__decap_12
XFILLER_4_213 VGND VGND VPWR VPWR sky130_fd_sc_hd__decap_6
XFILLER_5_758 VGND VGND VPWR VPWR sky130_fd_sc_hd__fill_1
XFILLER_4_235 VGND VGND VPWR VPWR sky130_fd_sc_hd__fill_1
XFILLER_253_1327 VGND VGND VPWR VPWR sky130_fd_sc_hd__decap_6
XFILLER_49_1177 VPWR VGND VPWR VGND sky130_ef_sc_hd__decap_12
XFILLER_175_1174 VPWR VGND VPWR VGND sky130_ef_sc_hd__decap_12
XFILLER_96_22 VPWR VGND VPWR VGND sky130_ef_sc_hd__decap_12
XFILLER_249_830 VPWR VGND VPWR VGND sky130_ef_sc_hd__decap_12
XFILLER_7_1514 VGND VGND VPWR VPWR sky130_fd_sc_hd__fill_1
XFILLER_27_1464 VPWR VGND VPWR VGND sky130_ef_sc_hd__decap_12
XFILLER_0_463 VGND VGND VPWR VPWR sky130_fd_sc_hd__fill_2
XFILLER_114_1423 VPWR VGND VPWR VGND sky130_ef_sc_hd__decap_12
XFILLER_249_885 VPWR VGND VPWR VGND sky130_ef_sc_hd__decap_12
XFILLER_23_1328 VGND VGND VPWR VPWR sky130_fd_sc_hd__decap_6
XFILLER_212_1035 VPWR VGND VPWR VGND sky130_ef_sc_hd__decap_12
XFILLER_62_1399 VPWR VGND VPWR VGND sky130_ef_sc_hd__decap_12
XFILLER_114_1478 VGND VGND VPWR VPWR sky130_fd_sc_hd__decap_6
XFILLER_208_237 VPWR VGND VPWR VGND sky130_ef_sc_hd__decap_12
XFILLER_5_1260 VPWR VGND VPWR VGND sky130_ef_sc_hd__decap_12
XFILLER_204_421 VPWR VGND VPWR VGND sky130_ef_sc_hd__decap_12
XFILLER_45_70 VGND VGND VPWR VPWR sky130_fd_sc_hd__fill_1
XFILLER_186_1281 VPWR VGND VPWR VGND sky130_ef_sc_hd__decap_12
XFILLER_216_292 VPWR VGND VPWR VGND sky130_ef_sc_hd__decap_12
X_597_ clknet_3_2__leaf_clk _079_ _005_ VGND VGND VPWR VPWR rd_addr\[5\] sky130_fd_sc_hd__dfrtp_1
XFILLER_231_240 VPWR VGND VPWR VGND sky130_ef_sc_hd__decap_12
XFILLER_188_144 VGND VGND VPWR VPWR sky130_fd_sc_hd__decap_6
XFILLER_108_1227 VPWR VGND VPWR VGND sky130_ef_sc_hd__decap_12
XFILLER_177_818 VPWR VGND VPWR VGND sky130_ef_sc_hd__decap_12
XFILLER_204_476 VPWR VGND VPWR VGND sky130_ef_sc_hd__decap_12
XFILLER_220_925 VPWR VGND VPWR VGND sky130_ef_sc_hd__decap_12
XFILLER_189_689 VPWR VGND VPWR VGND sky130_ef_sc_hd__decap_12
XFILLER_232_796 VPWR VGND VPWR VGND sky130_ef_sc_hd__decap_12
XFILLER_223_1131 VPWR VGND VPWR VGND sky130_ef_sc_hd__decap_12
XFILLER_231_295 VGND VGND VPWR VPWR sky130_fd_sc_hd__decap_6
XFILLER_34_1435 VGND VGND VPWR VPWR sky130_fd_sc_hd__decap_6
XTAP_TAPCELL_ROW_138_2_5769 VGND VPWR sky130_fd_sc_hd__tapvpwrvgnd_1
XTAP_TAPCELL_ROW_75_2_5261 VGND VPWR sky130_fd_sc_hd__tapvpwrvgnd_1
XFILLER_160_1454 VPWR VGND VPWR VGND sky130_ef_sc_hd__decap_12
XFILLER_200_660 VGND VGND VPWR VPWR sky130_fd_sc_hd__decap_6
XFILLER_223_1186 VPWR VGND VPWR VGND sky130_ef_sc_hd__decap_12
XFILLER_185_873 VPWR VGND VPWR VGND sky130_ef_sc_hd__decap_12
XFILLER_247_39 VGND VGND VPWR VPWR sky130_fd_sc_hd__decap_4
XFILLER_195_1506 VGND VGND VPWR VPWR sky130_fd_sc_hd__decap_8
XFILLER_177_80 VGND VGND VPWR VPWR sky130_fd_sc_hd__decap_6
XANTENNA_2 dout0\[2\] VGND VGND VPWR VPWR sky130_fd_sc_hd__diode_2
XFILLER_236_1514 VGND VGND VPWR VPWR sky130_fd_sc_hd__fill_1
XFILLER_193_1241 VGND VGND VPWR VPWR sky130_fd_sc_hd__decap_6
XTAP_TAPCELL_ROW_100_2_5459 VGND VPWR sky130_fd_sc_hd__tapvpwrvgnd_1
XFILLER_28_1239 VPWR VGND VPWR VGND sky130_ef_sc_hd__decap_12
XFILLER_80_1411 VPWR VGND VPWR VGND sky130_ef_sc_hd__decap_12
XTAP_TAPCELL_ROW_185_2230 VGND VPWR sky130_fd_sc_hd__tapvpwrvgnd_1
XFILLER_119_1378 VPWR VGND VPWR VGND sky130_ef_sc_hd__decap_12
XTAP_TAPCELL_ROW_185_2241 VGND VPWR sky130_fd_sc_hd__tapvpwrvgnd_1
XTAP_TAPCELL_ROW_152_1_1458 VGND VPWR sky130_fd_sc_hd__tapvpwrvgnd_1
XTAP_TAPCELL_ROW_181_2105 VGND VPWR sky130_fd_sc_hd__tapvpwrvgnd_1
XPHY_EDGE_ROW_13_1_Right_669 VGND VGND VPWR VPWR sky130_fd_sc_hd__decap_3
XFILLER_234_1293 VPWR VGND VPWR VGND sky130_ef_sc_hd__decap_12
XFILLER_255_811 VGND VGND VPWR VPWR sky130_fd_sc_hd__decap_8
XFILLER_6_1035 VPWR VGND VPWR VGND sky130_ef_sc_hd__decap_12
XFILLER_80_1466 VPWR VGND VPWR VGND sky130_ef_sc_hd__decap_12
XFILLER_187_1045 VPWR VGND VPWR VGND sky130_ef_sc_hd__decap_12
XFILLER_214_218 VPWR VGND VPWR VGND sky130_ef_sc_hd__decap_12
XFILLER_242_538 VPWR VGND VPWR VGND sky130_ef_sc_hd__decap_12
XTAP_TAPCELL_ROW_179_2012 VGND VPWR sky130_fd_sc_hd__tapvpwrvgnd_1
XTAP_TAPCELL_ROW_179_2023 VGND VPWR sky130_fd_sc_hd__tapvpwrvgnd_1
XTAP_TAPCELL_ROW_179_2034 VGND VPWR sky130_fd_sc_hd__tapvpwrvgnd_1
XFILLER_39_1335 VPWR VGND VPWR VGND sky130_ef_sc_hd__decap_12
XFILLER_179_111 VPWR VGND VPWR VGND sky130_ef_sc_hd__decap_12
XTAP_TAPCELL_ROW_198_2679 VGND VPWR sky130_fd_sc_hd__tapvpwrvgnd_1
XFILLER_210_402 VGND VGND VPWR VPWR sky130_fd_sc_hd__decap_6
XFILLER_161_1218 VPWR VGND VPWR VGND sky130_ef_sc_hd__decap_12
XFILLER_228_1097 VPWR VGND VPWR VGND sky130_ef_sc_hd__decap_12
XFILLER_165_1387 VPWR VGND VPWR VGND sky130_ef_sc_hd__decap_12
XFILLER_179_166 VGND VGND VPWR VPWR sky130_fd_sc_hd__decap_6
XFILLER_195_615 VPWR VGND VPWR VGND sky130_ef_sc_hd__decap_12
XFILLER_211_947 VPWR VGND VPWR VGND sky130_ef_sc_hd__decap_12
XFILLER_222_273 VGND VGND VPWR VPWR sky130_fd_sc_hd__decap_6
XFILLER_250_593 VPWR VGND VPWR VGND sky130_ef_sc_hd__decap_12
XFILLER_126_1349 VGND VGND VPWR VPWR sky130_fd_sc_hd__decap_6
XFILLER_41_39 VGND VGND VPWR VPWR sky130_fd_sc_hd__decap_4
XFILLER_176_851 VPWR VGND VPWR VGND sky130_ef_sc_hd__decap_12
XFILLER_202_1226 VPWR VGND VPWR VGND sky130_ef_sc_hd__decap_12
XTAP_TAPCELL_ROW_230_3820 VGND VPWR sky130_fd_sc_hd__tapvpwrvgnd_1
XFILLER_157_39 VGND VGND VPWR VPWR sky130_fd_sc_hd__decap_4
XFILLER_198_1152 VPWR VGND VPWR VGND sky130_ef_sc_hd__decap_12
XFILLER_50_1270 VPWR VGND VPWR VGND sky130_ef_sc_hd__decap_12
XFILLER_15_1390 VPWR VGND VPWR VGND sky130_ef_sc_hd__decap_12
XFILLER_191_854 VGND VGND VPWR VPWR sky130_fd_sc_hd__decap_6
XFILLER_235_1002 VPWR VGND VPWR VGND sky130_ef_sc_hd__decap_12
XFILLER_46_1306 VGND VGND VPWR VPWR sky130_fd_sc_hd__decap_6
XFILLER_1_216 VGND VGND VPWR VPWR sky130_fd_sc_hd__decap_4
XFILLER_173_27 VPWR VGND VPWR VGND sky130_ef_sc_hd__decap_12
XFILLER_137_1445 VPWR VGND VPWR VGND sky130_ef_sc_hd__decap_12
XFILLER_172_1336 VPWR VGND VPWR VGND sky130_ef_sc_hd__decap_12
XFILLER_235_1057 VPWR VGND VPWR VGND sky130_ef_sc_hd__decap_12
XTAP_TAPCELL_ROW_224_3602 VGND VPWR sky130_fd_sc_hd__tapvpwrvgnd_1
XTAP_TAPCELL_ROW_224_3613 VGND VPWR sky130_fd_sc_hd__tapvpwrvgnd_1
XFILLER_106_65 VGND VGND VPWR VPWR sky130_fd_sc_hd__decap_6
XFILLER_66_58 VGND VGND VPWR VPWR sky130_fd_sc_hd__decap_6
XFILLER_213_1377 VPWR VGND VPWR VGND sky130_ef_sc_hd__decap_12
XFILLER_2_1422 VPWR VGND VPWR VGND sky130_ef_sc_hd__decap_12
X_520_ net665 VGND VGND VPWR VPWR _002_ sky130_fd_sc_hd__inv_2
XFILLER_57_1402 VPWR VGND VPWR VGND sky130_ef_sc_hd__decap_12
XFILLER_2_1477 VGND VGND VPWR VPWR sky130_fd_sc_hd__decap_6
XFILLER_167_3 VPWR VGND VPWR VGND sky130_ef_sc_hd__decap_12
X_451_ net181 net83 VGND VGND VPWR VPWR acc_core.adder.cla_blocks\[7\].block.sum\[0\]
+ sky130_fd_sc_hd__xnor2_1
XFILLER_82_46 VPWR VGND VPWR VGND sky130_ef_sc_hd__decap_12
XFILLER_183_1432 VPWR VGND VPWR VGND sky130_ef_sc_hd__decap_12
XTAP_TAPCELL_ROW_124_2_5655 VGND VPWR sky130_fd_sc_hd__tapvpwrvgnd_1
XFILLER_213_240 VPWR VGND VPWR VGND sky130_ef_sc_hd__decap_12
XFILLER_246_1164 VPWR VGND VPWR VGND sky130_ef_sc_hd__decap_12
XFILLER_57_1457 VGND VGND VPWR VPWR sky130_fd_sc_hd__decap_6
XFILLER_92_1337 VPWR VGND VPWR VGND sky130_ef_sc_hd__decap_12
XTAP_TAPCELL_ROW_92_2_5400 VGND VPWR sky130_fd_sc_hd__tapvpwrvgnd_1
XFILLER_241_560 VPWR VGND VPWR VGND sky130_ef_sc_hd__decap_12
XFILLER_198_46 VPWR VGND VPWR VGND sky130_ef_sc_hd__decap_12
XFILLER_202_925 VPWR VGND VPWR VGND sky130_ef_sc_hd__decap_12
X_382_ net591 net583 net556 VGND VGND VPWR VPWR _171_ sky130_fd_sc_hd__and3_1
XFILLER_198_464 VPWR VGND VPWR VGND sky130_ef_sc_hd__decap_12
XFILLER_183_1487 VPWR VGND VPWR VGND sky130_ef_sc_hd__decap_12
XFILLER_214_796 VPWR VGND VPWR VGND sky130_ef_sc_hd__decap_12
XFILLER_201_424 VGND VGND VPWR VPWR sky130_fd_sc_hd__decap_6
XFILLER_213_295 VGND VGND VPWR VPWR sky130_fd_sc_hd__decap_6
XFILLER_186_648 VPWR VGND VPWR VGND sky130_ef_sc_hd__decap_12
XFILLER_9_349 VGND VGND VPWR VPWR sky130_fd_sc_hd__decap_8
XPHY_EDGE_ROW_114_2_Right_205 VGND VGND VPWR VPWR sky130_fd_sc_hd__decap_3
XFILLER_224_1484 VPWR VGND VPWR VGND sky130_ef_sc_hd__decap_12
XFILLER_16_1165 VPWR VGND VPWR VGND sky130_ef_sc_hd__decap_12
XFILLER_167_873 VPWR VGND VPWR VGND sky130_ef_sc_hd__decap_12
XFILLER_210_980 VPWR VGND VPWR VGND sky130_ef_sc_hd__decap_12
XFILLER_142_1184 VPWR VGND VPWR VGND sky130_ef_sc_hd__decap_12
XFILLER_220_1348 VGND VGND VPWR VPWR sky130_fd_sc_hd__decap_6
XFILLER_182_832 VGND VGND VPWR VPWR sky130_fd_sc_hd__decap_6
XPHY_EDGE_ROW_165_Left_420 VGND VGND VPWR VPWR sky130_fd_sc_hd__decap_3
Xoutput50 net50 VGND VGND VPWR VPWR acc_out[16] sky130_fd_sc_hd__buf_2
Xoutput61 net530 VGND VGND VPWR VPWR acc_out[26] sky130_fd_sc_hd__buf_2
Xoutput72 net553 VGND VGND VPWR VPWR acc_out[7] sky130_fd_sc_hd__buf_2
XPHY_EDGE_ROW_140_1_Right_796 VGND VGND VPWR VPWR sky130_fd_sc_hd__decap_3
XTAP_TAPCELL_ROW_20_2_4825 VGND VPWR sky130_fd_sc_hd__tapvpwrvgnd_1
XFILLER_27_1261 VPWR VGND VPWR VGND sky130_ef_sc_hd__decap_12
XFILLER_114_1220 VGND VGND VPWR VPWR sky130_fd_sc_hd__decap_6
XFILLER_231_1444 VPWR VGND VPWR VGND sky130_ef_sc_hd__decap_12
XFILLER_237_811 VGND VGND VPWR VPWR sky130_fd_sc_hd__decap_6
XFILLER_255_118 VGND VGND VPWR VPWR sky130_fd_sc_hd__decap_8
XFILLER_249_682 VGND VGND VPWR VPWR sky130_fd_sc_hd__decap_6
XFILLER_0_293 VGND VGND VPWR VPWR sky130_fd_sc_hd__fill_1
XTAP_TAPCELL_ROW_240_4160 VGND VPWR sky130_fd_sc_hd__tapvpwrvgnd_1
XFILLER_7_1377 VPWR VGND VPWR VGND sky130_ef_sc_hd__decap_12
XTAP_TAPCELL_ROW_240_4171 VGND VPWR sky130_fd_sc_hd__tapvpwrvgnd_1
XFILLER_62_1196 VPWR VGND VPWR VGND sky130_ef_sc_hd__decap_12
XFILLER_231_1499 VGND VGND VPWR VPWR sky130_fd_sc_hd__decap_6
XFILLER_149_1316 VPWR VGND VPWR VGND sky130_ef_sc_hd__decap_12
XFILLER_251_302 VPWR VGND VPWR VGND sky130_ef_sc_hd__decap_12
XFILLER_184_1207 VPWR VGND VPWR VGND sky130_ef_sc_hd__decap_12
XFILLER_224_538 VPWR VGND VPWR VGND sky130_ef_sc_hd__decap_12
XFILLER_188_1398 VPWR VGND VPWR VGND sky130_ef_sc_hd__decap_12
X_649_ clknet_3_6__leaf_clk acc_core.adder.cla_blocks\[3\].block.sum\[3\] _057_ VGND
+ VGND VPWR VPWR net49 sky130_fd_sc_hd__dfrtp_1
XFILLER_251_357 VPWR VGND VPWR VGND sky130_ef_sc_hd__decap_12
XFILLER_189_431 VPWR VGND VPWR VGND sky130_ef_sc_hd__decap_12
XTAP_TAPCELL_ROW_201_2775 VGND VPWR sky130_fd_sc_hd__tapvpwrvgnd_1
XFILLER_177_615 VPWR VGND VPWR VGND sky130_ef_sc_hd__decap_12
XTAP_TAPCELL_ROW_193_2510 VGND VPWR sky130_fd_sc_hd__tapvpwrvgnd_1
XTAP_TAPCELL_ROW_201_2786 VGND VPWR sky130_fd_sc_hd__tapvpwrvgnd_1
XFILLER_204_273 VGND VGND VPWR VPWR sky130_fd_sc_hd__decap_6
XFILLER_220_722 VPWR VGND VPWR VGND sky130_ef_sc_hd__decap_12
XTAP_TAPCELL_ROW_193_2521 VGND VPWR sky130_fd_sc_hd__tapvpwrvgnd_1
XTAP_TAPCELL_ROW_201_2797 VGND VPWR sky130_fd_sc_hd__tapvpwrvgnd_1
XFILLER_225_1248 VPWR VGND VPWR VGND sky130_ef_sc_hd__decap_12
XFILLER_189_486 VPWR VGND VPWR VGND sky130_ef_sc_hd__decap_12
XFILLER_232_593 VPWR VGND VPWR VGND sky130_ef_sc_hd__decap_12
XTAP_TAPCELL_ROW_253_4598 VGND VPWR sky130_fd_sc_hd__tapvpwrvgnd_1
XFILLER_82_3 VPWR VGND VPWR VGND sky130_ef_sc_hd__decap_12
XFILLER_220_777 VPWR VGND VPWR VGND sky130_ef_sc_hd__decap_12
XFILLER_73_1292 VPWR VGND VPWR VGND sky130_ef_sc_hd__decap_12
XFILLER_160_1251 VPWR VGND VPWR VGND sky130_ef_sc_hd__decap_12
XFILLER_125_1371 VGND VGND VPWR VPWR sky130_fd_sc_hd__decap_6
XFILLER_185_670 VPWR VGND VPWR VGND sky130_ef_sc_hd__decap_12
XFILLER_9_883 VPWR VGND VPWR VGND sky130_ef_sc_hd__decap_12
XFILLER_195_1303 VPWR VGND VPWR VGND sky130_ef_sc_hd__decap_12
XFILLER_69_1328 VGND VGND VPWR VPWR sky130_fd_sc_hd__decap_6
XFILLER_173_854 VGND VGND VPWR VPWR sky130_fd_sc_hd__decap_6
XFILLER_195_1358 VPWR VGND VPWR VGND sky130_ef_sc_hd__decap_12
XTAP_TAPCELL_ROW_187_2303 VGND VPWR sky130_fd_sc_hd__tapvpwrvgnd_1
XTAP_TAPCELL_ROW_187_2314 VGND VPWR sky130_fd_sc_hd__tapvpwrvgnd_1
XFILLER_236_1355 VPWR VGND VPWR VGND sky130_ef_sc_hd__decap_12
XFILLER_232_1219 VGND VGND VPWR VPWR sky130_fd_sc_hd__decap_6
XFILLER_80_1263 VGND VGND VPWR VPWR sky130_fd_sc_hd__decap_6
XFILLER_234_1090 VGND VGND VPWR VPWR sky130_fd_sc_hd__decap_6
XTAP_TAPCELL_ROW_130_2_5698 VGND VPWR sky130_fd_sc_hd__tapvpwrvgnd_1
XTAP_TAPCELL_ROW_97_2_5437 VGND VPWR sky130_fd_sc_hd__tapvpwrvgnd_1
XFILLER_255_652 VPWR VGND VPWR VGND sky130_ef_sc_hd__decap_12
XFILLER_254_151 VPWR VGND VPWR VGND sky130_ef_sc_hd__decap_12
XFILLER_255_685 VGND VGND VPWR VPWR sky130_fd_sc_hd__decap_8
XTAP_TAPCELL_ROW_110_2_5541 VGND VPWR sky130_fd_sc_hd__tapvpwrvgnd_1
XTAP_TAPCELL_ROW_109_2_5535 VGND VPWR sky130_fd_sc_hd__tapvpwrvgnd_1
XFILLER_242_335 VPWR VGND VPWR VGND sky130_ef_sc_hd__decap_12
XFILLER_199_228 VPWR VGND VPWR VGND sky130_ef_sc_hd__decap_12
XFILLER_230_519 VPWR VGND VPWR VGND sky130_ef_sc_hd__decap_12
XFILLER_243_1315 VPWR VGND VPWR VGND sky130_ef_sc_hd__decap_12
XFILLER_223_560 VPWR VGND VPWR VGND sky130_ef_sc_hd__decap_12
XFILLER_195_412 VPWR VGND VPWR VGND sky130_ef_sc_hd__decap_12
XFILLER_211_744 VPWR VGND VPWR VGND sky130_ef_sc_hd__decap_12
XFILLER_250_390 VPWR VGND VPWR VGND sky130_ef_sc_hd__decap_12
XFILLER_168_648 VPWR VGND VPWR VGND sky130_ef_sc_hd__decap_12
XFILLER_196_968 VPWR VGND VPWR VGND sky130_ef_sc_hd__decap_12
XFILLER_104_1411 VPWR VGND VPWR VGND sky130_ef_sc_hd__decap_12
XFILLER_195_467 VGND VGND VPWR VPWR sky130_fd_sc_hd__decap_6
XFILLER_211_799 VPWR VGND VPWR VGND sky130_ef_sc_hd__decap_12
XFILLER_13_1316 VPWR VGND VPWR VGND sky130_ef_sc_hd__decap_12
XFILLER_202_1023 VPWR VGND VPWR VGND sky130_ef_sc_hd__decap_12
XFILLER_104_1466 VPWR VGND VPWR VGND sky130_ef_sc_hd__decap_12
XFILLER_202_1078 VPWR VGND VPWR VGND sky130_ef_sc_hd__decap_12
XFILLER_184_15 VGND VGND VPWR VPWR sky130_fd_sc_hd__decap_6
XFILLER_139_1507 VGND VGND VPWR VPWR sky130_fd_sc_hd__decap_8
XFILLER_237_1119 VPWR VGND VPWR VGND sky130_ef_sc_hd__decap_12
XTAP_TAPCELL_ROW_46_1_1298 VGND VPWR sky130_fd_sc_hd__tapvpwrvgnd_1
XFILLER_254_1422 VPWR VGND VPWR VGND sky130_ef_sc_hd__decap_12
XPHY_EDGE_ROW_58_2_Left_560 VGND VGND VPWR VPWR sky130_fd_sc_hd__decap_3
Xsram0_676 VGND VGND VPWR VPWR sram0_676/HI net676 sky130_fd_sc_hd__conb_1
XFILLER_190_194 VPWR VGND VPWR VGND sky130_ef_sc_hd__decap_12
Xsram0_687 VGND VGND VPWR VPWR net687 sram0_687/LO sky130_fd_sc_hd__conb_1
XTAP_TAPCELL_ROW_170_1694 VGND VPWR sky130_fd_sc_hd__tapvpwrvgnd_1
XFILLER_137_1242 VGND VGND VPWR VPWR sky130_fd_sc_hd__decap_6
XFILLER_2_569 VGND VGND VPWR VPWR sky130_fd_sc_hd__fill_2
XFILLER_172_1133 VGND VGND VPWR VPWR sky130_fd_sc_hd__decap_6
XFILLER_254_1477 VGND VGND VPWR VPWR sky130_fd_sc_hd__decap_6
XFILLER_77_68 VGND VGND VPWR VPWR sky130_fd_sc_hd__decap_3
XFILLER_219_811 VGND VGND VPWR VPWR sky130_fd_sc_hd__decap_6
XFILLER_24_1423 VPWR VGND VPWR VGND sky130_ef_sc_hd__decap_12
XFILLER_150_1442 VPWR VGND VPWR VGND sky130_ef_sc_hd__decap_12
XFILLER_213_1174 VPWR VGND VPWR VGND sky130_ef_sc_hd__decap_12
XFILLER_24_1478 VGND VGND VPWR VPWR sky130_fd_sc_hd__decap_6
XFILLER_150_1497 VPWR VGND VPWR VGND sky130_ef_sc_hd__decap_12
XFILLER_233_302 VPWR VGND VPWR VGND sky130_ef_sc_hd__decap_12
XFILLER_248_1226 VPWR VGND VPWR VGND sky130_ef_sc_hd__decap_12
XFILLER_93_56 VPWR VGND VPWR VGND sky130_ef_sc_hd__decap_12
XFILLER_245_173 VPWR VGND VPWR VGND sky130_ef_sc_hd__decap_12
XFILLER_206_538 VPWR VGND VPWR VGND sky130_ef_sc_hd__decap_12
X_503_ _103_ _257_ VGND VGND VPWR VPWR acc_core.adder.cla_blocks\[6\].block.sum\[3\]
+ sky130_fd_sc_hd__xnor2_1
XFILLER_96_1270 VPWR VGND VPWR VGND sky130_ef_sc_hd__decap_12
XFILLER_233_357 VPWR VGND VPWR VGND sky130_ef_sc_hd__decap_12
X_434_ _221_ net191 VGND VGND VPWR VPWR _223_ sky130_fd_sc_hd__or2_1
XFILLER_202_722 VPWR VGND VPWR VGND sky130_ef_sc_hd__decap_12
XFILLER_18_1227 VPWR VGND VPWR VGND sky130_ef_sc_hd__decap_12
XFILLER_198_261 VPWR VGND VPWR VGND sky130_ef_sc_hd__decap_12
XFILLER_214_593 VPWR VGND VPWR VGND sky130_ef_sc_hd__decap_12
XFILLER_183_1284 VGND VGND VPWR VPWR sky130_fd_sc_hd__decap_6
X_365_ net593 net577 net549 VGND VGND VPWR VPWR _154_ sky130_fd_sc_hd__and3_1
XFILLER_186_445 VGND VGND VPWR VPWR sky130_fd_sc_hd__decap_6
Xsram0 net663 net650 net637 net634 net633 net632 net631 net630 net627 net626 net662
+ net661 net660 net659 net658 net657 net656 net655 net654 net651 net649 net648 net647
+ net646 net645 net644 net643 net642 net639 net638 net636 net635 addr0\[0\] addr0\[1\]
+ addr0\[2\] addr0\[3\] addr0\[4\] addr0\[5\] addr0\[6\] addr0\[7\] net674 net675
+ net676 net677 net678 net679 net680 net681 net683 net684 net621 clknet_3_2__leaf_clk
+ net682 net685 net686 net687 net688 dout0\[0\] dout0\[1\] dout0\[2\] dout0\[3\] dout0\[4\]
+ dout0\[5\] dout0\[6\] dout0\[7\] dout0\[8\] dout0\[9\] dout0\[10\] dout0\[11\] dout0\[12\]
+ dout0\[13\] dout0\[14\] dout0\[15\] dout0\[16\] dout0\[17\] dout0\[18\] dout0\[19\]
+ dout0\[20\] dout0\[21\] dout0\[22\] dout0\[23\] dout0\[24\] dout0\[25\] dout0\[26\]
+ dout0\[27\] dout0\[28\] dout0\[29\] dout0\[30\] dout0\[31\] sram0/dout1[0] sram0/dout1[1]
+ sram0/dout1[2] sram0/dout1[3] sram0/dout1[4] sram0/dout1[5] sram0/dout1[6] sram0/dout1[7]
+ sram0/dout1[8] sram0/dout1[9] sram0/dout1[10] sram0/dout1[11] sram0/dout1[12] sram0/dout1[13]
+ sram0/dout1[14] sram0/dout1[15] sram0/dout1[16] sram0/dout1[17] sram0/dout1[18]
+ sram0/dout1[19] sram0/dout1[20] sram0/dout1[21] sram0/dout1[22] sram0/dout1[23]
+ sram0/dout1[24] sram0/dout1[25] sram0/dout1[26] sram0/dout1[27] sram0/dout1[28]
+ sram0/dout1[29] sram0/dout1[30] sram0/dout1[31] sram0/vccd1 sram0/vssd1 sky130_sram_1kbyte_1rw1r_32x256_8
XFILLER_202_777 VPWR VGND VPWR VGND sky130_ef_sc_hd__decap_12
XFILLER_70_1454 VPWR VGND VPWR VGND sky130_ef_sc_hd__decap_12
XFILLER_224_1281 VPWR VGND VPWR VGND sky130_ef_sc_hd__decap_12
X_296_ web0 net616 net619 net614 VGND VGND VPWR VPWR _088_ sky130_fd_sc_hd__a31o_1
XTAP_TAPCELL_ROW_154_2_5894 VGND VPWR sky130_fd_sc_hd__tapvpwrvgnd_1
XFILLER_167_670 VPWR VGND VPWR VGND sky130_ef_sc_hd__decap_12
XPHY_EDGE_ROW_115_2_Right_206 VGND VGND VPWR VPWR sky130_fd_sc_hd__decap_3
XFILLER_195_990 VPWR VGND VPWR VGND sky130_ef_sc_hd__decap_12
XFILLER_177_1033 VPWR VGND VPWR VGND sky130_ef_sc_hd__decap_12
XFILLER_255_1219 VPWR VGND VPWR VGND sky130_ef_sc_hd__decap_12
XFILLER_177_1088 VPWR VGND VPWR VGND sky130_ef_sc_hd__decap_12
XFILLER_233_1506 VGND VGND VPWR VPWR sky130_fd_sc_hd__decap_8
XFILLER_194_1391 VGND VGND VPWR VPWR sky130_fd_sc_hd__decap_6
XTAP_TAPCELL_ROW_246_4380 VGND VPWR sky130_fd_sc_hd__tapvpwrvgnd_1
XTAP_TAPCELL_ROW_242_4211 VGND VPWR sky130_fd_sc_hd__tapvpwrvgnd_1
XTAP_TAPCELL_ROW_242_4222 VGND VPWR sky130_fd_sc_hd__tapvpwrvgnd_1
XTAP_TAPCELL_ROW_242_4233 VGND VPWR sky130_fd_sc_hd__tapvpwrvgnd_1
XFILLER_29_1378 VPWR VGND VPWR VGND sky130_ef_sc_hd__decap_12
XFILLER_151_1206 VPWR VGND VPWR VGND sky130_ef_sc_hd__decap_12
XTAP_TAPCELL_ROW_115_2_5578 VGND VPWR sky130_fd_sc_hd__tapvpwrvgnd_1
XFILLER_116_1337 VPWR VGND VPWR VGND sky130_ef_sc_hd__decap_12
XTAP_TAPCELL_ROW_83_2_5323 VGND VPWR sky130_fd_sc_hd__tapvpwrvgnd_1
XPHY_EDGE_ROW_141_1_Right_797 VGND VGND VPWR VPWR sky130_fd_sc_hd__decap_3
XTAP_TAPCELL_ROW_52_2_5081 VGND VPWR sky130_fd_sc_hd__tapvpwrvgnd_1
XFILLER_3_87 VPWR VGND VPWR VGND sky130_ef_sc_hd__decap_12
XFILLER_231_1241 VGND VGND VPWR VPWR sky130_fd_sc_hd__decap_6
XFILLER_7_1174 VPWR VGND VPWR VGND sky130_ef_sc_hd__decap_12
XTAP_TAPCELL_ROW_4_1000 VGND VPWR sky130_fd_sc_hd__tapvpwrvgnd_1
XTAP_TAPCELL_ROW_4_1011 VGND VPWR sky130_fd_sc_hd__tapvpwrvgnd_1
XFILLER_188_1140 VPWR VGND VPWR VGND sky130_ef_sc_hd__decap_12
XTAP_TAPCELL_ROW_207_2984 VGND VPWR sky130_fd_sc_hd__tapvpwrvgnd_1
XFILLER_236_151 VPWR VGND VPWR VGND sky130_ef_sc_hd__decap_12
XTAP_TAPCELL_ROW_4_1022 VGND VPWR sky130_fd_sc_hd__tapvpwrvgnd_1
XTAP_TAPCELL_ROW_207_2995 VGND VPWR sky130_fd_sc_hd__tapvpwrvgnd_1
XTAP_TAPCELL_ROW_4_1033 VGND VPWR sky130_fd_sc_hd__tapvpwrvgnd_1
XFILLER_184_1004 VGND VGND VPWR VPWR sky130_fd_sc_hd__decap_6
XTAP_TAPCELL_ROW_199_2730 VGND VPWR sky130_fd_sc_hd__tapvpwrvgnd_1
XTAP_TAPCELL_ROW_203_2848 VGND VPWR sky130_fd_sc_hd__tapvpwrvgnd_1
XFILLER_224_335 VPWR VGND VPWR VGND sky130_ef_sc_hd__decap_12
XFILLER_188_1195 VPWR VGND VPWR VGND sky130_ef_sc_hd__decap_12
XTAP_TAPCELL_ROW_203_2859 VGND VPWR sky130_fd_sc_hd__tapvpwrvgnd_1
XTAP_TAPCELL_ROW_236_4004 VGND VPWR sky130_fd_sc_hd__tapvpwrvgnd_1
XTAP_TAPCELL_ROW_236_4015 VGND VPWR sky130_fd_sc_hd__tapvpwrvgnd_1
XFILLER_251_154 VPWR VGND VPWR VGND sky130_ef_sc_hd__decap_12
XTAP_TAPCELL_ROW_236_4026 VGND VPWR sky130_fd_sc_hd__tapvpwrvgnd_1
XFILLER_212_519 VPWR VGND VPWR VGND sky130_ef_sc_hd__decap_12
XFILLER_240_839 VPWR VGND VPWR VGND sky130_ef_sc_hd__decap_12
XFILLER_205_560 VPWR VGND VPWR VGND sky130_ef_sc_hd__decap_12
XFILLER_162_1313 VPWR VGND VPWR VGND sky130_ef_sc_hd__decap_12
XFILLER_127_1433 VPWR VGND VPWR VGND sky130_ef_sc_hd__decap_12
XFILLER_177_412 VPWR VGND VPWR VGND sky130_ef_sc_hd__decap_12
XFILLER_225_1045 VPWR VGND VPWR VGND sky130_ef_sc_hd__decap_12
XFILLER_71_1218 VPWR VGND VPWR VGND sky130_ef_sc_hd__decap_12
XFILLER_189_283 VPWR VGND VPWR VGND sky130_ef_sc_hd__decap_12
XFILLER_232_390 VPWR VGND VPWR VGND sky130_ef_sc_hd__decap_12
XFILLER_36_1349 VGND VGND VPWR VPWR sky130_fd_sc_hd__decap_6
XFILLER_178_968 VPWR VGND VPWR VGND sky130_ef_sc_hd__decap_12
XFILLER_162_1368 VPWR VGND VPWR VGND sky130_ef_sc_hd__decap_12
XFILLER_127_1488 VPWR VGND VPWR VGND sky130_ef_sc_hd__decap_12
XFILLER_177_467 VGND VGND VPWR VPWR sky130_fd_sc_hd__decap_6
XFILLER_193_916 VPWR VGND VPWR VGND sky130_ef_sc_hd__decap_12
XFILLER_220_574 VGND VGND VPWR VPWR sky130_fd_sc_hd__decap_6
XTAP_TAPCELL_ROW_11_2_4748 VGND VPWR sky130_fd_sc_hd__tapvpwrvgnd_1
XFILLER_195_1100 VPWR VGND VPWR VGND sky130_ef_sc_hd__decap_12
XFILLER_199_1291 VPWR VGND VPWR VGND sky130_ef_sc_hd__decap_12
XFILLER_195_1155 VGND VGND VPWR VPWR sky130_fd_sc_hd__decap_6
XFILLER_172_194 VPWR VGND VPWR VGND sky130_ef_sc_hd__decap_12
XFILLER_173_1420 VPWR VGND VPWR VGND sky130_ef_sc_hd__decap_12
XFILLER_47_1445 VPWR VGND VPWR VGND sky130_ef_sc_hd__decap_12
XFILLER_82_1325 VPWR VGND VPWR VGND sky130_ef_sc_hd__decap_12
XFILLER_236_1152 VPWR VGND VPWR VGND sky130_ef_sc_hd__decap_12
XFILLER_248_906 VPWR VGND VPWR VGND sky130_ef_sc_hd__decap_12
XFILLER_173_1475 VPWR VGND VPWR VGND sky130_ef_sc_hd__decap_12
XFILLER_47_27 VPWR VGND VPWR VGND sky130_ef_sc_hd__decap_12
XFILLER_45_1180 VPWR VGND VPWR VGND sky130_ef_sc_hd__decap_12
XFILLER_210_1336 VPWR VGND VPWR VGND sky130_ef_sc_hd__decap_12
XFILLER_215_302 VPWR VGND VPWR VGND sky130_ef_sc_hd__decap_12
XFILLER_227_173 VPWR VGND VPWR VGND sky130_ef_sc_hd__decap_12
XFILLER_103_44 VPWR VGND VPWR VGND sky130_ef_sc_hd__decap_12
XFILLER_242_132 VPWR VGND VPWR VGND sky130_ef_sc_hd__decap_12
XFILLER_63_15 VPWR VGND VPWR VGND sky130_ef_sc_hd__decap_12
XFILLER_128_1208 VPWR VGND VPWR VGND sky130_ef_sc_hd__decap_12
XFILLER_215_357 VPWR VGND VPWR VGND sky130_ef_sc_hd__decap_12
XFILLER_93_1421 VPWR VGND VPWR VGND sky130_ef_sc_hd__decap_12
XFILLER_145_1500 VGND VGND VPWR VPWR sky130_fd_sc_hd__decap_6
XFILLER_179_15 VPWR VGND VPWR VGND sky130_ef_sc_hd__decap_12
XFILLER_187_209 VGND VGND VPWR VPWR sky130_fd_sc_hd__decap_6
XFILLER_230_316 VGND VGND VPWR VPWR sky130_fd_sc_hd__decap_6
XFILLER_243_1112 VGND VGND VPWR VPWR sky130_fd_sc_hd__decap_6
XFILLER_242_187 VGND VGND VPWR VPWR sky130_fd_sc_hd__decap_6
XFILLER_196_710 VPWR VGND VPWR VGND sky130_ef_sc_hd__decap_12
XFILLER_93_1476 VPWR VGND VPWR VGND sky130_ef_sc_hd__decap_12
XTAP_TAPCELL_ROW_140_2_5780 VGND VPWR sky130_fd_sc_hd__tapvpwrvgnd_1
XFILLER_211_541 VPWR VGND VPWR VGND sky130_ef_sc_hd__decap_12
XTAP_TAPCELL_ROW_139_2_5774 VGND VPWR sky130_fd_sc_hd__tapvpwrvgnd_1
XFILLER_168_445 VGND VGND VPWR VPWR sky130_fd_sc_hd__decap_6
XFILLER_196_765 VPWR VGND VPWR VGND sky130_ef_sc_hd__decap_12
Xwire504 net505 VGND VGND VPWR VPWR net504 sky130_fd_sc_hd__clkbuf_1
XFILLER_221_1432 VPWR VGND VPWR VGND sky130_ef_sc_hd__decap_12
XFILLER_211_596 VGND VGND VPWR VPWR sky130_fd_sc_hd__decap_6
XFILLER_184_949 VPWR VGND VPWR VGND sky130_ef_sc_hd__decap_12
XFILLER_177_990 VPWR VGND VPWR VGND sky130_ef_sc_hd__decap_12
XFILLER_52_1184 VPWR VGND VPWR VGND sky130_ef_sc_hd__decap_12
Xwire559 net560 VGND VGND VPWR VPWR net559 sky130_fd_sc_hd__clkbuf_1
XFILLER_104_1263 VGND VGND VPWR VPWR sky130_fd_sc_hd__decap_6
XFILLER_221_1487 VPWR VGND VPWR VGND sky130_ef_sc_hd__decap_12
XTAP_TAPCELL_ROW_172_1767 VGND VPWR sky130_fd_sc_hd__tapvpwrvgnd_1
XFILLER_139_1304 VPWR VGND VPWR VGND sky130_ef_sc_hd__decap_12
XTAP_TAPCELL_ROW_213_3199 VGND VPWR sky130_fd_sc_hd__tapvpwrvgnd_1
XTAP_TAPCELL_ROW_172_1778 VGND VPWR sky130_fd_sc_hd__tapvpwrvgnd_1
XTAP_TAPCELL_ROW_172_1789 VGND VPWR sky130_fd_sc_hd__tapvpwrvgnd_1
XTAP_TAPCELL_ROW_132_2_5717 VGND VPWR sky130_fd_sc_hd__tapvpwrvgnd_1
XFILLER_88_34 VPWR VGND VPWR VGND sky130_ef_sc_hd__decap_12
XFILLER_139_1359 VPWR VGND VPWR VGND sky130_ef_sc_hd__decap_12
XTAP_TAPCELL_ROW_68_2_5203 VGND VPWR sky130_fd_sc_hd__tapvpwrvgnd_1
XFILLER_3_878 VGND VGND VPWR VPWR sky130_fd_sc_hd__fill_1
XFILLER_2_366 VGND VGND VPWR VPWR sky130_fd_sc_hd__fill_2
XFILLER_239_928 VPWR VGND VPWR VGND sky130_ef_sc_hd__decap_12
XFILLER_24_1220 VGND VGND VPWR VPWR sky130_fd_sc_hd__decap_6
Xfanout670 net672 VGND VGND VPWR VPWR net670 sky130_fd_sc_hd__buf_4
XTAP_TAPCELL_ROW_166_1549 VGND VPWR sky130_fd_sc_hd__tapvpwrvgnd_1
XTAP_TAPCELL_ROW_35_2_4944 VGND VPWR sky130_fd_sc_hd__tapvpwrvgnd_1
XFILLER_111_1201 VGND VGND VPWR VPWR sky130_fd_sc_hd__decap_4
XFILLER_4_1336 VPWR VGND VPWR VGND sky130_ef_sc_hd__decap_12
XFILLER_247_983 VGND VGND VPWR VPWR sky130_fd_sc_hd__decap_6
XFILLER_218_151 VPWR VGND VPWR VGND sky130_ef_sc_hd__decap_12
XFILLER_150_1294 VPWR VGND VPWR VGND sky130_ef_sc_hd__decap_12
XFILLER_248_1023 VPWR VGND VPWR VGND sky130_ef_sc_hd__decap_12
XFILLER_59_1316 VPWR VGND VPWR VGND sky130_ef_sc_hd__decap_12
XFILLER_206_335 VPWR VGND VPWR VGND sky130_ef_sc_hd__decap_12
XFILLER_185_1346 VPWR VGND VPWR VGND sky130_ef_sc_hd__decap_12
XFILLER_248_1078 VPWR VGND VPWR VGND sky130_ef_sc_hd__decap_12
XFILLER_233_154 VPWR VGND VPWR VGND sky130_ef_sc_hd__decap_12
XFILLER_222_839 VPWR VGND VPWR VGND sky130_ef_sc_hd__decap_12
XTAP_TAPCELL_ROW_254_4660 VGND VPWR sky130_fd_sc_hd__tapvpwrvgnd_1
XFILLER_221_338 VGND VGND VPWR VPWR sky130_fd_sc_hd__decap_6
XTAP_TAPCELL_ROW_250_4502 VGND VPWR sky130_fd_sc_hd__tapvpwrvgnd_1
XPHY_EDGE_ROW_1_Left_257 VGND VGND VPWR VPWR sky130_fd_sc_hd__decap_3
X_417_ _160_ _204_ net114 VGND VGND VPWR VPWR _206_ sky130_fd_sc_hd__and3_1
XFILLER_187_732 VPWR VGND VPWR VGND sky130_ef_sc_hd__decap_12
XFILLER_214_390 VPWR VGND VPWR VGND sky130_ef_sc_hd__decap_12
XTAP_TAPCELL_ROW_250_4513 VGND VPWR sky130_fd_sc_hd__tapvpwrvgnd_1
XFILLER_222_1207 VPWR VGND VPWR VGND sky130_ef_sc_hd__decap_12
XFILLER_175_916 VPWR VGND VPWR VGND sky130_ef_sc_hd__decap_12
XFILLER_202_574 VGND VGND VPWR VPWR sky130_fd_sc_hd__decap_6
XFILLER_226_1398 VPWR VGND VPWR VGND sky130_ef_sc_hd__decap_12
X_348_ net594 dout0_q\[15\] net541 VGND VGND VPWR VPWR _137_ sky130_fd_sc_hd__a21oi_1
XFILLER_187_787 VPWR VGND VPWR VGND sky130_ef_sc_hd__decap_12
XFILLER_230_894 VPWR VGND VPWR VGND sky130_ef_sc_hd__decap_12
XFILLER_70_1251 VPWR VGND VPWR VGND sky130_ef_sc_hd__decap_12
XFILLER_35_1371 VGND VGND VPWR VPWR sky130_fd_sc_hd__decap_6
XFILLER_161_1390 VPWR VGND VPWR VGND sky130_ef_sc_hd__decap_12
XPHY_EDGE_ROW_116_2_Right_207 VGND VGND VPWR VPWR sky130_fd_sc_hd__decap_3
XTAP_TAPCELL_ROW_248_4420 VGND VPWR sky130_fd_sc_hd__tapvpwrvgnd_1
XFILLER_183_971 VPWR VGND VPWR VGND sky130_ef_sc_hd__decap_12
XTAP_TAPCELL_ROW_248_4431 VGND VPWR sky130_fd_sc_hd__tapvpwrvgnd_1
XFILLER_196_1453 VPWR VGND VPWR VGND sky130_ef_sc_hd__decap_12
XTAP_TAPCELL_ROW_248_4442 VGND VPWR sky130_fd_sc_hd__tapvpwrvgnd_1
XTAP_TAPCELL_ROW_248_4453 VGND VPWR sky130_fd_sc_hd__tapvpwrvgnd_1
XFILLER_185_80 VGND VGND VPWR VPWR sky130_fd_sc_hd__decap_6
XTAP_TAPCELL_ROW_244_4306 VGND VPWR sky130_fd_sc_hd__tapvpwrvgnd_1
XFILLER_45_3 VPWR VGND VPWR VGND sky130_ef_sc_hd__decap_12
XFILLER_233_1303 VPWR VGND VPWR VGND sky130_ef_sc_hd__decap_12
XFILLER_233_1358 VPWR VGND VPWR VGND sky130_ef_sc_hd__decap_12
XTAP_TAPCELL_ROW_104_1_1385 VGND VPWR sky130_fd_sc_hd__tapvpwrvgnd_1
XPHY_EDGE_ROW_142_1_Right_798 VGND VGND VPWR VPWR sky130_fd_sc_hd__decap_3
XFILLER_238_961 VGND VGND VPWR VPWR sky130_fd_sc_hd__decap_6
XFILLER_204_65 VPWR VGND VPWR VGND sky130_ef_sc_hd__decap_12
XFILLER_209_173 VPWR VGND VPWR VGND sky130_ef_sc_hd__decap_12
XTAP_TAPCELL_ROW_0_826 VGND VPWR sky130_fd_sc_hd__tapvpwrvgnd_1
XTAP_TAPCELL_ROW_0_837 VGND VPWR sky130_fd_sc_hd__tapvpwrvgnd_1
XTAP_TAPCELL_ROW_0_848 VGND VPWR sky130_fd_sc_hd__tapvpwrvgnd_1
XFILLER_224_132 VPWR VGND VPWR VGND sky130_ef_sc_hd__decap_12
XFILLER_252_452 VPWR VGND VPWR VGND sky130_ef_sc_hd__decap_12
XTAP_TAPCELL_ROW_0_859 VGND VPWR sky130_fd_sc_hd__tapvpwrvgnd_1
XTAP_TAPCELL_ROW_156_2_5913 VGND VPWR sky130_fd_sc_hd__tapvpwrvgnd_1
XFILLER_244_1410 VPWR VGND VPWR VGND sky130_ef_sc_hd__decap_12
XTAP_TAPCELL_ROW_125_2_5660 VGND VPWR sky130_fd_sc_hd__tapvpwrvgnd_1
XFILLER_169_209 VGND VGND VPWR VPWR sky130_fd_sc_hd__decap_6
XFILLER_212_316 VGND VGND VPWR VPWR sky130_fd_sc_hd__decap_6
XFILLER_197_529 VPWR VGND VPWR VGND sky130_ef_sc_hd__decap_12
XFILLER_224_187 VGND VGND VPWR VPWR sky130_fd_sc_hd__decap_6
XFILLER_240_636 VPWR VGND VPWR VGND sky130_ef_sc_hd__decap_12
XFILLER_178_710 VPWR VGND VPWR VGND sky130_ef_sc_hd__decap_12
XFILLER_127_1230 VPWR VGND VPWR VGND sky130_ef_sc_hd__decap_12
XFILLER_244_1465 VPWR VGND VPWR VGND sky130_ef_sc_hd__decap_12
XFILLER_221_861 VPWR VGND VPWR VGND sky130_ef_sc_hd__decap_12
XFILLER_178_765 VPWR VGND VPWR VGND sky130_ef_sc_hd__decap_12
XFILLER_127_1285 VGND VGND VPWR VPWR sky130_fd_sc_hd__decap_6
XFILLER_162_1165 VPWR VGND VPWR VGND sky130_ef_sc_hd__decap_12
XFILLER_193_713 VPWR VGND VPWR VGND sky130_ef_sc_hd__decap_12
XFILLER_14_1411 VPWR VGND VPWR VGND sky130_ef_sc_hd__decap_12
XFILLER_166_949 VPWR VGND VPWR VGND sky130_ef_sc_hd__decap_12
XFILLER_197_1217 VPWR VGND VPWR VGND sky130_ef_sc_hd__decap_12
XTAP_TAPCELL_ROW_74_2_5257 VGND VPWR sky130_fd_sc_hd__tapvpwrvgnd_1
XTAP_TAPCELL_ROW_158_1_1467 VGND VPWR sky130_fd_sc_hd__tapvpwrvgnd_1
XFILLER_193_768 VGND VGND VPWR VPWR sky130_fd_sc_hd__decap_6
XFILLER_203_1162 VPWR VGND VPWR VGND sky130_ef_sc_hd__decap_12
XFILLER_14_1466 VPWR VGND VPWR VGND sky130_ef_sc_hd__decap_12
XFILLER_101_1414 VGND VGND VPWR VPWR sky130_fd_sc_hd__decap_6
XFILLER_140_1485 VPWR VGND VPWR VGND sky130_ef_sc_hd__decap_12
XFILLER_49_1507 VGND VGND VPWR VPWR sky130_fd_sc_hd__decap_8
XTAP_TAPCELL_ROW_41_2_4987 VGND VPWR sky130_fd_sc_hd__tapvpwrvgnd_1
XFILLER_238_1269 VPWR VGND VPWR VGND sky130_ef_sc_hd__decap_12
XFILLER_58_15 VGND VGND VPWR VPWR sky130_fd_sc_hd__decap_6
XFILLER_47_1242 VGND VGND VPWR VPWR sky130_fd_sc_hd__decap_6
XFILLER_0_826 VGND VGND VPWR VPWR sky130_fd_sc_hd__decap_8
XFILLER_248_703 VGND VGND VPWR VPWR sky130_fd_sc_hd__decap_6
XFILLER_0_837 VGND VGND VPWR VPWR sky130_fd_sc_hd__decap_3
XFILLER_173_1272 VPWR VGND VPWR VGND sky130_ef_sc_hd__decap_12
XTAP_TAPCELL_ROW_21_2_4830 VGND VPWR sky130_fd_sc_hd__tapvpwrvgnd_1
XFILLER_138_1392 VGND VGND VPWR VPWR sky130_fd_sc_hd__decap_6
XFILLER_181_27 VPWR VGND VPWR VGND sky130_ef_sc_hd__decap_12
XFILLER_82_1177 VGND VGND VPWR VPWR sky130_fd_sc_hd__decap_6
XFILLER_60_1442 VPWR VGND VPWR VGND sky130_ef_sc_hd__decap_12
XFILLER_114_65 VGND VGND VPWR VPWR sky130_fd_sc_hd__decap_6
XFILLER_210_1133 VGND VGND VPWR VPWR sky130_fd_sc_hd__decap_6
XFILLER_229_983 VGND VGND VPWR VPWR sky130_fd_sc_hd__decap_6
XFILLER_60_1497 VPWR VGND VPWR VGND sky130_ef_sc_hd__decap_12
XFILLER_74_58 VGND VGND VPWR VPWR sky130_fd_sc_hd__decap_6
XTAP_TAPCELL_ROW_221_3479 VGND VPWR sky130_fd_sc_hd__tapvpwrvgnd_1
XFILLER_231_603 VPWR VGND VPWR VGND sky130_ef_sc_hd__decap_12
XFILLER_182_1508 VGND VGND VPWR VPWR sky130_fd_sc_hd__decap_6
XFILLER_215_154 VPWR VGND VPWR VGND sky130_ef_sc_hd__decap_12
XFILLER_245_1229 VPWR VGND VPWR VGND sky130_ef_sc_hd__decap_12
XFILLER_243_474 VPWR VGND VPWR VGND sky130_ef_sc_hd__decap_12
XFILLER_188_507 VPWR VGND VPWR VGND sky130_ef_sc_hd__decap_12
XFILLER_167_1076 VPWR VGND VPWR VGND sky130_ef_sc_hd__decap_12
XFILLER_204_839 VPWR VGND VPWR VGND sky130_ef_sc_hd__decap_12
XFILLER_203_338 VGND VGND VPWR VPWR sky130_fd_sc_hd__decap_6
XFILLER_247_3 VPWR VGND VPWR VGND sky130_ef_sc_hd__decap_12
XFILLER_169_732 VPWR VGND VPWR VGND sky130_ef_sc_hd__decap_12
XFILLER_231_658 VPWR VGND VPWR VGND sky130_ef_sc_hd__decap_12
XFILLER_93_1273 VPWR VGND VPWR VGND sky130_ef_sc_hd__decap_12
XFILLER_90_46 VPWR VGND VPWR VGND sky130_ef_sc_hd__decap_12
XPHY_EDGE_ROW_104_1_Right_760 VGND VGND VPWR VPWR sky130_fd_sc_hd__decap_3
XFILLER_106_1325 VPWR VGND VPWR VGND sky130_ef_sc_hd__decap_12
XTAP_TAPCELL_ROW_178_1976 VGND VPWR sky130_fd_sc_hd__tapvpwrvgnd_1
XFILLER_196_562 VPWR VGND VPWR VGND sky130_ef_sc_hd__decap_12
XFILLER_212_894 VPWR VGND VPWR VGND sky130_ef_sc_hd__decap_12
Xwire301 net302 VGND VGND VPWR VPWR net301 sky130_fd_sc_hd__clkbuf_1
XFILLER_169_787 VPWR VGND VPWR VGND sky130_ef_sc_hd__decap_12
XTAP_TAPCELL_ROW_178_1987 VGND VPWR sky130_fd_sc_hd__tapvpwrvgnd_1
XTAP_TAPCELL_ROW_174_1829 VGND VPWR sky130_fd_sc_hd__tapvpwrvgnd_1
XFILLER_8_937 VPWR VGND VPWR VGND sky130_ef_sc_hd__decap_12
Xwire312 net313 VGND VGND VPWR VPWR net312 sky130_fd_sc_hd__clkbuf_1
XFILLER_141_1249 VPWR VGND VPWR VGND sky130_ef_sc_hd__decap_12
XTAP_TAPCELL_ROW_178_1998 VGND VPWR sky130_fd_sc_hd__tapvpwrvgnd_1
Xwire323 net324 VGND VGND VPWR VPWR net323 sky130_fd_sc_hd__clkbuf_1
XFILLER_184_746 VGND VGND VPWR VPWR sky130_fd_sc_hd__decap_6
Xwire334 _142_ VGND VGND VPWR VPWR net334 sky130_fd_sc_hd__clkbuf_1
Xwire345 net346 VGND VGND VPWR VPWR net345 sky130_fd_sc_hd__clkbuf_1
Xwire356 net357 VGND VGND VPWR VPWR net356 sky130_fd_sc_hd__clkbuf_1
Xwire367 net368 VGND VGND VPWR VPWR net367 sky130_fd_sc_hd__clkbuf_1
XFILLER_221_1284 VGND VGND VPWR VPWR sky130_fd_sc_hd__decap_6
Xwire378 net379 VGND VGND VPWR VPWR net378 sky130_fd_sc_hd__clkbuf_1
Xwire389 net390 VGND VGND VPWR VPWR net389 sky130_fd_sc_hd__clkbuf_1
XFILLER_99_44 VPWR VGND VPWR VGND sky130_ef_sc_hd__decap_12
XTAP_TAPCELL_ROW_110_1_1395 VGND VPWR sky130_fd_sc_hd__tapvpwrvgnd_1
XFILLER_178_1183 VPWR VGND VPWR VGND sky130_ef_sc_hd__decap_12
XPHY_EDGE_ROW_40_2_Right_131 VGND VGND VPWR VPWR sky130_fd_sc_hd__decap_3
XFILLER_174_1047 VGND VGND VPWR VPWR sky130_fd_sc_hd__decap_6
XFILLER_139_1189 VPWR VGND VPWR VGND sky130_ef_sc_hd__decap_12
XFILLER_2_163 VPWR VGND VPWR VGND sky130_ef_sc_hd__decap_12
XFILLER_117_1421 VPWR VGND VPWR VGND sky130_ef_sc_hd__decap_12
XFILLER_61_1206 VPWR VGND VPWR VGND sky130_ef_sc_hd__decap_12
XFILLER_215_1033 VPWR VGND VPWR VGND sky130_ef_sc_hd__decap_12
XFILLER_26_1337 VPWR VGND VPWR VGND sky130_ef_sc_hd__decap_12
XFILLER_239_725 VGND VGND VPWR VPWR sky130_fd_sc_hd__decap_6
XTAP_TAPCELL_ROW_162_2_5956 VGND VPWR sky130_fd_sc_hd__tapvpwrvgnd_1
XFILLER_117_1476 VPWR VGND VPWR VGND sky130_ef_sc_hd__decap_12
XFILLER_152_1356 VPWR VGND VPWR VGND sky130_ef_sc_hd__decap_12
XFILLER_215_1088 VPWR VGND VPWR VGND sky130_ef_sc_hd__decap_12
XTAP_TAPCELL_ROW_98_2_5442 VGND VPWR sky130_fd_sc_hd__tapvpwrvgnd_1
XFILLER_4_1133 VGND VGND VPWR VPWR sky130_fd_sc_hd__decap_6
XFILLER_232_1391 VGND VGND VPWR VPWR sky130_fd_sc_hd__decap_6
XFILLER_253_216 VPWR VGND VPWR VGND sky130_ef_sc_hd__decap_12
XTAP_TAPCELL_ROW_204_2910 VGND VPWR sky130_fd_sc_hd__tapvpwrvgnd_1
XFILLER_0_22 VPWR VGND VPWR VGND sky130_ef_sc_hd__decap_12
XFILLER_0_55 VGND VGND VPWR VPWR sky130_fd_sc_hd__decap_8
XFILLER_98_1184 VPWR VGND VPWR VGND sky130_ef_sc_hd__decap_12
XFILLER_206_132 VPWR VGND VPWR VGND sky130_ef_sc_hd__decap_12
XFILLER_234_452 VPWR VGND VPWR VGND sky130_ef_sc_hd__decap_12
XFILLER_185_1143 VPWR VGND VPWR VGND sky130_ef_sc_hd__decap_12
XPHY_EDGE_ROW_10_2_Left_512 VGND VGND VPWR VPWR sky130_fd_sc_hd__decap_3
XFILLER_222_636 VPWR VGND VPWR VGND sky130_ef_sc_hd__decap_12
XFILLER_179_529 VPWR VGND VPWR VGND sky130_ef_sc_hd__decap_12
XFILLER_206_187 VGND VGND VPWR VPWR sky130_fd_sc_hd__decap_6
XFILLER_185_1198 VGND VGND VPWR VPWR sky130_fd_sc_hd__decap_6
XFILLER_226_1140 VPWR VGND VPWR VGND sky130_ef_sc_hd__decap_12
XFILLER_37_1433 VPWR VGND VPWR VGND sky130_ef_sc_hd__decap_12
XFILLER_72_1313 VPWR VGND VPWR VGND sky130_ef_sc_hd__decap_12
XFILLER_203_861 VPWR VGND VPWR VGND sky130_ef_sc_hd__decap_12
XTAP_TAPCELL_ROW_60_2_5143 VGND VPWR sky130_fd_sc_hd__tapvpwrvgnd_1
XFILLER_222_1004 VGND VGND VPWR VPWR sky130_fd_sc_hd__decap_6
XTAP_TAPCELL_ROW_59_2_5137 VGND VPWR sky130_fd_sc_hd__tapvpwrvgnd_1
XFILLER_37_1488 VPWR VGND VPWR VGND sky130_ef_sc_hd__decap_12
XFILLER_9_64 VPWR VGND VPWR VGND sky130_ef_sc_hd__decap_12
XFILLER_72_1368 VPWR VGND VPWR VGND sky130_ef_sc_hd__decap_12
XFILLER_175_713 VPWR VGND VPWR VGND sky130_ef_sc_hd__decap_12
XFILLER_226_1195 VPWR VGND VPWR VGND sky130_ef_sc_hd__decap_12
XFILLER_187_584 VPWR VGND VPWR VGND sky130_ef_sc_hd__decap_12
XFILLER_230_691 VPWR VGND VPWR VGND sky130_ef_sc_hd__decap_12
XFILLER_9_97 VGND VGND VPWR VPWR sky130_fd_sc_hd__decap_8
XFILLER_175_768 VGND VGND VPWR VPWR sky130_fd_sc_hd__decap_6
XFILLER_200_1324 VPWR VGND VPWR VGND sky130_ef_sc_hd__decap_12
Xmax_cap612 rd_addr\[3\] VGND VGND VPWR VPWR net612 sky130_fd_sc_hd__clkbuf_1
XTAP_TAPCELL_ROW_26_2_4867 VGND VPWR sky130_fd_sc_hd__tapvpwrvgnd_1
XTAP_TAPCELL_ROW_190_2398 VGND VPWR sky130_fd_sc_hd__tapvpwrvgnd_1
XFILLER_157_1201 VGND VGND VPWR VPWR sky130_fd_sc_hd__decap_4
XFILLER_196_1250 VPWR VGND VPWR VGND sky130_ef_sc_hd__decap_12
XPHY_EDGE_ROW_117_2_Right_208 VGND VGND VPWR VPWR sky130_fd_sc_hd__decap_3
XFILLER_200_1379 VPWR VGND VPWR VGND sky130_ef_sc_hd__decap_12
XFILLER_233_1100 VPWR VGND VPWR VGND sky130_ef_sc_hd__decap_12
XFILLER_170_495 VPWR VGND VPWR VGND sky130_ef_sc_hd__decap_12
XFILLER_83_1464 VPWR VGND VPWR VGND sky130_ef_sc_hd__decap_12
XFILLER_237_1291 VPWR VGND VPWR VGND sky130_ef_sc_hd__decap_12
XFILLER_170_1434 VGND VGND VPWR VPWR sky130_fd_sc_hd__decap_6
XFILLER_233_1155 VGND VGND VPWR VPWR sky130_fd_sc_hd__decap_6
XFILLER_211_1420 VPWR VGND VPWR VGND sky130_ef_sc_hd__decap_12
XPHY_EDGE_ROW_143_1_Right_799 VGND VGND VPWR VPWR sky130_fd_sc_hd__decap_3
XFILLER_211_1475 VPWR VGND VPWR VGND sky130_ef_sc_hd__decap_12
XFILLER_244_249 VPWR VGND VPWR VGND sky130_ef_sc_hd__decap_12
XFILLER_213_603 VPWR VGND VPWR VGND sky130_ef_sc_hd__decap_12
XFILLER_38_1208 VPWR VGND VPWR VGND sky130_ef_sc_hd__decap_12
XFILLER_225_474 VPWR VGND VPWR VGND sky130_ef_sc_hd__decap_12
XFILLER_55_1500 VGND VGND VPWR VPWR sky130_fd_sc_hd__decap_6
XFILLER_129_1347 VPWR VGND VPWR VGND sky130_ef_sc_hd__decap_12
XFILLER_164_1227 VPWR VGND VPWR VGND sky130_ef_sc_hd__decap_12
XFILLER_240_433 VPWR VGND VPWR VGND sky130_ef_sc_hd__decap_12
XFILLER_197_326 VPWR VGND VPWR VGND sky130_ef_sc_hd__decap_12
XFILLER_213_658 VPWR VGND VPWR VGND sky130_ef_sc_hd__decap_12
XFILLER_244_1262 VGND VGND VPWR VPWR sky130_fd_sc_hd__decap_6
XFILLER_90_1435 VGND VGND VPWR VPWR sky130_fd_sc_hd__decap_6
XFILLER_100_34 VPWR VGND VPWR VGND sky130_ef_sc_hd__decap_12
XFILLER_240_488 VGND VGND VPWR VPWR sky130_fd_sc_hd__decap_6
XFILLER_178_562 VPWR VGND VPWR VGND sky130_ef_sc_hd__decap_12
XFILLER_193_510 VGND VGND VPWR VPWR sky130_fd_sc_hd__decap_6
XFILLER_165_223 VGND VGND VPWR VPWR sky130_fd_sc_hd__decap_8
XFILLER_166_746 VGND VGND VPWR VPWR sky130_fd_sc_hd__decap_6
XFILLER_197_1014 VPWR VGND VPWR VGND sky130_ef_sc_hd__decap_12
XTAP_TAPCELL_ROW_214_3250 VGND VPWR sky130_fd_sc_hd__tapvpwrvgnd_1
XTAP_TAPCELL_ROW_214_3261 VGND VPWR sky130_fd_sc_hd__tapvpwrvgnd_1
XFILLER_14_1263 VGND VGND VPWR VPWR sky130_fd_sc_hd__decap_6
XTAP_TAPCELL_ROW_210_3103 VGND VPWR sky130_fd_sc_hd__tapvpwrvgnd_1
XTAP_TAPCELL_ROW_233_3895 VGND VPWR sky130_fd_sc_hd__tapvpwrvgnd_1
Xclkbuf_3_0__f_clk clknet_0_clk VGND VGND VPWR VPWR clknet_3_0__leaf_clk sky130_fd_sc_hd__clkbuf_16
XTAP_TAPCELL_ROW_210_3114 VGND VPWR sky130_fd_sc_hd__tapvpwrvgnd_1
XFILLER_140_1282 VPWR VGND VPWR VGND sky130_ef_sc_hd__decap_12
XFILLER_197_1069 VGND VGND VPWR VPWR sky130_fd_sc_hd__decap_6
XFILLER_49_1304 VPWR VGND VPWR VGND sky130_ef_sc_hd__decap_12
XFILLER_238_1011 VPWR VGND VPWR VGND sky130_ef_sc_hd__decap_12
XPHY_EDGE_ROW_19_1_Left_274 VGND VGND VPWR VPWR sky130_fd_sc_hd__decap_3
XFILLER_180_237 VPWR VGND VPWR VGND sky130_ef_sc_hd__decap_12
XFILLER_175_1334 VPWR VGND VPWR VGND sky130_ef_sc_hd__decap_12
XFILLER_49_1359 VPWR VGND VPWR VGND sky130_ef_sc_hd__decap_12
XFILLER_84_1239 VPWR VGND VPWR VGND sky130_ef_sc_hd__decap_12
XFILLER_192_15 VGND VGND VPWR VPWR sky130_fd_sc_hd__decap_6
XFILLER_238_1066 VPWR VGND VPWR VGND sky130_ef_sc_hd__decap_12
XTAP_TAPCELL_ROW_147_2_5836 VGND VPWR sky130_fd_sc_hd__tapvpwrvgnd_1
XFILLER_175_1389 VPWR VGND VPWR VGND sky130_ef_sc_hd__decap_12
XTAP_TAPCELL_ROW_167_1600 VGND VPWR sky130_fd_sc_hd__tapvpwrvgnd_1
XTAP_TAPCELL_ROW_208_3021 VGND VPWR sky130_fd_sc_hd__tapvpwrvgnd_1
XTAP_TAPCELL_ROW_167_1611 VGND VPWR sky130_fd_sc_hd__tapvpwrvgnd_1
XTAP_TAPCELL_ROW_208_3032 VGND VPWR sky130_fd_sc_hd__tapvpwrvgnd_1
XTAP_TAPCELL_ROW_208_3043 VGND VPWR sky130_fd_sc_hd__tapvpwrvgnd_1
XFILLER_0_667 VGND VGND VPWR VPWR sky130_fd_sc_hd__fill_1
XFILLER_0_678 VGND VGND VPWR VPWR sky130_fd_sc_hd__decap_4
XFILLER_197_3 VPWR VGND VPWR VGND sky130_ef_sc_hd__decap_12
XTAP_TAPCELL_ROW_227_3688 VGND VPWR sky130_fd_sc_hd__tapvpwrvgnd_1
XTAP_TAPCELL_ROW_227_3699 VGND VPWR sky130_fd_sc_hd__tapvpwrvgnd_1
XFILLER_5_1420 VPWR VGND VPWR VGND sky130_ef_sc_hd__decap_12
XFILLER_21_1201 VGND VGND VPWR VPWR sky130_fd_sc_hd__decap_4
XFILLER_85_68 VGND VGND VPWR VPWR sky130_fd_sc_hd__decap_3
XFILLER_235_216 VPWR VGND VPWR VGND sky130_ef_sc_hd__decap_12
XFILLER_5_1475 VPWR VGND VPWR VGND sky130_ef_sc_hd__decap_12
XFILLER_60_1294 VPWR VGND VPWR VGND sky130_ef_sc_hd__decap_12
XFILLER_186_1441 VPWR VGND VPWR VGND sky130_ef_sc_hd__decap_12
XFILLER_216_452 VPWR VGND VPWR VGND sky130_ef_sc_hd__decap_12
XFILLER_249_1162 VPWR VGND VPWR VGND sky130_ef_sc_hd__decap_12
XFILLER_95_1335 VPWR VGND VPWR VGND sky130_ef_sc_hd__decap_12
XFILLER_147_1414 VGND VGND VPWR VPWR sky130_fd_sc_hd__decap_6
XFILLER_182_1305 VGND VGND VPWR VPWR sky130_fd_sc_hd__decap_6
XFILLER_231_400 VPWR VGND VPWR VGND sky130_ef_sc_hd__decap_12
XFILLER_245_1026 VGND VGND VPWR VPWR sky130_fd_sc_hd__decap_6
XFILLER_243_271 VPWR VGND VPWR VGND sky130_ef_sc_hd__decap_12
XFILLER_188_304 VPWR VGND VPWR VGND sky130_ef_sc_hd__decap_12
XFILLER_204_636 VPWR VGND VPWR VGND sky130_ef_sc_hd__decap_12
XTAP_TAPCELL_ROW_45_2_5023 VGND VPWR sky130_fd_sc_hd__tapvpwrvgnd_1
XFILLER_186_1496 VPWR VGND VPWR VGND sky130_ef_sc_hd__decap_12
XFILLER_231_455 VPWR VGND VPWR VGND sky130_ef_sc_hd__decap_12
XFILLER_188_359 VGND VGND VPWR VPWR sky130_fd_sc_hd__decap_6
XFILLER_200_820 VPWR VGND VPWR VGND sky130_ef_sc_hd__decap_12
XFILLER_223_1346 VPWR VGND VPWR VGND sky130_ef_sc_hd__decap_12
XFILLER_169_584 VPWR VGND VPWR VGND sky130_ef_sc_hd__decap_12
XFILLER_212_691 VPWR VGND VPWR VGND sky130_ef_sc_hd__decap_12
XPHY_EDGE_ROW_105_1_Right_761 VGND VGND VPWR VPWR sky130_fd_sc_hd__decap_3
Xwire120 _208_ VGND VGND VPWR VPWR net120 sky130_fd_sc_hd__clkbuf_1
XFILLER_106_1177 VGND VGND VPWR VPWR sky130_fd_sc_hd__decap_6
XFILLER_200_875 VGND VGND VPWR VPWR sky130_fd_sc_hd__decap_6
XFILLER_71_1390 VPWR VGND VPWR VGND sky130_ef_sc_hd__decap_12
XPHY_EDGE_ROW_152_1_Left_407 VGND VGND VPWR VPWR sky130_fd_sc_hd__decap_3
Xwire164 _150_ VGND VGND VPWR VPWR net164 sky130_fd_sc_hd__clkbuf_1
XFILLER_8_789 VGND VGND VPWR VPWR sky130_fd_sc_hd__decap_6
XFILLER_176_1109 VPWR VGND VPWR VGND sky130_ef_sc_hd__decap_12
Xwire186 _262_ VGND VGND VPWR VPWR net186 sky130_fd_sc_hd__clkbuf_1
XFILLER_165_790 VGND VGND VPWR VPWR sky130_fd_sc_hd__decap_8
XFILLER_193_1401 VPWR VGND VPWR VGND sky130_ef_sc_hd__decap_12
XFILLER_171_259 VPWR VGND VPWR VGND sky130_ef_sc_hd__decap_12
XFILLER_193_1456 VGND VGND VPWR VPWR sky130_fd_sc_hd__decap_6
XPHY_EDGE_ROW_41_2_Right_132 VGND VGND VPWR VPWR sky130_fd_sc_hd__decap_3
XFILLER_234_1453 VPWR VGND VPWR VGND sky130_ef_sc_hd__decap_12
XFILLER_117_1273 VPWR VGND VPWR VGND sky130_ef_sc_hd__decap_12
XFILLER_187_1205 VPWR VGND VPWR VGND sky130_ef_sc_hd__decap_12
XFILLER_226_249 VPWR VGND VPWR VGND sky130_ef_sc_hd__decap_12
XFILLER_207_474 VPWR VGND VPWR VGND sky130_ef_sc_hd__decap_12
XFILLER_179_326 VPWR VGND VPWR VGND sky130_ef_sc_hd__decap_12
XFILLER_201_44 VPWR VGND VPWR VGND sky130_ef_sc_hd__decap_12
XFILLER_222_433 VPWR VGND VPWR VGND sky130_ef_sc_hd__decap_12
XFILLER_250_753 VPWR VGND VPWR VGND sky130_ef_sc_hd__decap_12
XFILLER_126_1509 VGND VGND VPWR VPWR sky130_fd_sc_hd__decap_6
XFILLER_37_1230 VPWR VGND VPWR VGND sky130_ef_sc_hd__decap_12
XFILLER_241_1413 VGND VGND VPWR VPWR sky130_fd_sc_hd__decap_6
XFILLER_210_617 VGND VGND VPWR VPWR sky130_fd_sc_hd__decap_6
XFILLER_201_99 VPWR VGND VPWR VGND sky130_ef_sc_hd__decap_12
XFILLER_222_488 VGND VGND VPWR VPWR sky130_fd_sc_hd__decap_6
XFILLER_128_1380 VPWR VGND VPWR VGND sky130_ef_sc_hd__decap_12
XFILLER_188_882 VPWR VGND VPWR VGND sky130_ef_sc_hd__decap_12
XFILLER_37_1285 VGND VGND VPWR VPWR sky130_fd_sc_hd__decap_6
XFILLER_72_1165 VPWR VGND VPWR VGND sky130_ef_sc_hd__decap_12
XPHY_EDGE_ROW_84_1_Left_339 VGND VGND VPWR VPWR sky130_fd_sc_hd__decap_3
XFILLER_175_510 VGND VGND VPWR VPWR sky130_fd_sc_hd__decap_6
XFILLER_187_381 VGND VGND VPWR VPWR sky130_fd_sc_hd__decap_6
XFILLER_198_1312 VPWR VGND VPWR VGND sky130_ef_sc_hd__decap_12
XFILLER_200_1121 VPWR VGND VPWR VGND sky130_ef_sc_hd__decap_12
XPHY_EDGE_ROW_234_Left_489 VGND VGND VPWR VPWR sky130_fd_sc_hd__decap_3
XFILLER_11_1414 VGND VGND VPWR VPWR sky130_fd_sc_hd__decap_6
XFILLER_198_1367 VPWR VGND VPWR VGND sky130_ef_sc_hd__decap_12
XTAP_TAPCELL_ROW_90_2_5382 VGND VPWR sky130_fd_sc_hd__tapvpwrvgnd_1
XFILLER_50_1485 VPWR VGND VPWR VGND sky130_ef_sc_hd__decap_12
XTAP_TAPCELL_ROW_89_2_5376 VGND VPWR sky130_fd_sc_hd__tapvpwrvgnd_1
XTAP_TAPCELL_ROW_133_2_5722 VGND VPWR sky130_fd_sc_hd__tapvpwrvgnd_1
XFILLER_200_1176 VGND VGND VPWR VPWR sky130_fd_sc_hd__decap_6
XTAP_TAPCELL_ROW_102_2_5480 VGND VPWR sky130_fd_sc_hd__tapvpwrvgnd_1
XPHY_EDGE_ROW_118_2_Right_209 VGND VGND VPWR VPWR sky130_fd_sc_hd__decap_3
XFILLER_235_1217 VPWR VGND VPWR VGND sky130_ef_sc_hd__decap_12
XFILLER_83_1261 VPWR VGND VPWR VGND sky130_ef_sc_hd__decap_12
XFILLER_170_292 VPWR VGND VPWR VGND sky130_ef_sc_hd__decap_12
XFILLER_39_39 VGND VGND VPWR VPWR sky130_fd_sc_hd__decap_4
XFILLER_48_1392 VGND VGND VPWR VPWR sky130_fd_sc_hd__decap_6
XTAP_TAPCELL_ROW_82_2_5319 VGND VPWR sky130_fd_sc_hd__tapvpwrvgnd_1
XTAP_TAPCELL_ROW_51_2_5066 VGND VPWR sky130_fd_sc_hd__tapvpwrvgnd_1
XPHY_EDGE_ROW_243_Left_498 VGND VGND VPWR VPWR sky130_fd_sc_hd__decap_3
XFILLER_217_216 VPWR VGND VPWR VGND sky130_ef_sc_hd__decap_12
XTAP_TAPCELL_ROW_222_3530 VGND VPWR sky130_fd_sc_hd__tapvpwrvgnd_1
XPHY_EDGE_ROW_2_Right_2 VGND VGND VPWR VPWR sky130_fd_sc_hd__decap_3
XTAP_TAPCELL_ROW_222_3541 VGND VPWR sky130_fd_sc_hd__tapvpwrvgnd_1
XTAP_TAPCELL_ROW_1_910 VGND VPWR sky130_fd_sc_hd__tapvpwrvgnd_1
XFILLER_55_27 VPWR VGND VPWR VGND sky130_ef_sc_hd__decap_12
XTAP_TAPCELL_ROW_1_921 VGND VPWR sky130_fd_sc_hd__tapvpwrvgnd_1
XFILLER_211_1272 VPWR VGND VPWR VGND sky130_ef_sc_hd__decap_12
XFILLER_246_1324 VPWR VGND VPWR VGND sky130_ef_sc_hd__decap_12
XFILLER_213_400 VPWR VGND VPWR VGND sky130_ef_sc_hd__decap_12
XFILLER_225_271 VPWR VGND VPWR VGND sky130_ef_sc_hd__decap_12
XFILLER_198_624 VPWR VGND VPWR VGND sky130_ef_sc_hd__decap_12
XTAP_TAPCELL_ROW_146_1_1449 VGND VPWR sky130_fd_sc_hd__tapvpwrvgnd_1
XFILLER_111_44 VPWR VGND VPWR VGND sky130_ef_sc_hd__decap_12
XFILLER_197_123 VGND VGND VPWR VPWR sky130_fd_sc_hd__decap_6
XFILLER_240_230 VGND VGND VPWR VPWR sky130_fd_sc_hd__decap_6
XFILLER_246_1379 VPWR VGND VPWR VGND sky130_ef_sc_hd__decap_12
XFILLER_71_15 VPWR VGND VPWR VGND sky130_ef_sc_hd__decap_12
XFILLER_213_455 VPWR VGND VPWR VGND sky130_ef_sc_hd__decap_12
XFILLER_241_775 VPWR VGND VPWR VGND sky130_ef_sc_hd__decap_12
XFILLER_129_1177 VPWR VGND VPWR VGND sky130_ef_sc_hd__decap_12
XFILLER_186_808 VPWR VGND VPWR VGND sky130_ef_sc_hd__decap_12
XFILLER_198_679 VPWR VGND VPWR VGND sky130_ef_sc_hd__decap_12
XTAP_TAPCELL_ROW_216_3301 VGND VPWR sky130_fd_sc_hd__tapvpwrvgnd_1
XFILLER_187_15 VPWR VGND VPWR VGND sky130_ef_sc_hd__decap_12
XFILLER_201_639 VGND VGND VPWR VPWR sky130_fd_sc_hd__decap_6
XTAP_TAPCELL_ROW_216_3312 VGND VPWR sky130_fd_sc_hd__tapvpwrvgnd_1
XTAP_TAPCELL_ROW_216_3323 VGND VPWR sky130_fd_sc_hd__tapvpwrvgnd_1
XFILLER_16_1325 VPWR VGND VPWR VGND sky130_ef_sc_hd__decap_12
XTAP_TAPCELL_ROW_235_3968 VGND VPWR sky130_fd_sc_hd__tapvpwrvgnd_1
XFILLER_220_1508 VGND VGND VPWR VPWR sky130_fd_sc_hd__decap_6
XFILLER_107_1464 VPWR VGND VPWR VGND sky130_ef_sc_hd__decap_12
XTAP_TAPCELL_ROW_235_3979 VGND VPWR sky130_fd_sc_hd__tapvpwrvgnd_1
XFILLER_205_1076 VPWR VGND VPWR VGND sky130_ef_sc_hd__decap_12
XFILLER_51_1249 VPWR VGND VPWR VGND sky130_ef_sc_hd__decap_12
XFILLER_103_1328 VGND VGND VPWR VPWR sky130_fd_sc_hd__decap_6
XFILLER_194_863 VPWR VGND VPWR VGND sky130_ef_sc_hd__decap_12
XFILLER_142_1399 VPWR VGND VPWR VGND sky130_ef_sc_hd__decap_12
XFILLER_112_3 VPWR VGND VPWR VGND sky130_ef_sc_hd__decap_12
XFILLER_175_1131 VPWR VGND VPWR VGND sky130_ef_sc_hd__decap_12
XFILLER_49_1189 VPWR VGND VPWR VGND sky130_ef_sc_hd__decap_12
XFILLER_175_1186 VPWR VGND VPWR VGND sky130_ef_sc_hd__decap_12
XFILLER_27_1421 VPWR VGND VPWR VGND sky130_ef_sc_hd__decap_12
XFILLER_96_34 VPWR VGND VPWR VGND sky130_ef_sc_hd__decap_12
XFILLER_249_842 VPWR VGND VPWR VGND sky130_ef_sc_hd__decap_12
XFILLER_0_442 VGND VGND VPWR VPWR sky130_fd_sc_hd__fill_2
XFILLER_62_1356 VPWR VGND VPWR VGND sky130_ef_sc_hd__decap_12
XFILLER_27_1476 VPWR VGND VPWR VGND sky130_ef_sc_hd__decap_12
XFILLER_216_1183 VPWR VGND VPWR VGND sky130_ef_sc_hd__decap_12
XFILLER_114_1435 VGND VGND VPWR VPWR sky130_fd_sc_hd__decap_6
XFILLER_249_897 VGND VGND VPWR VPWR sky130_fd_sc_hd__decap_6
XFILLER_212_1047 VGND VGND VPWR VPWR sky130_fd_sc_hd__decap_6
XFILLER_188_1514 VGND VGND VPWR VPWR sky130_fd_sc_hd__fill_1
XFILLER_208_249 VPWR VGND VPWR VGND sky130_ef_sc_hd__decap_12
XFILLER_5_1272 VPWR VGND VPWR VGND sky130_ef_sc_hd__decap_12
X_665_ clknet_3_5__leaf_clk acc_core.adder.cla_blocks\[7\].block.sum\[3\] _073_ VGND
+ VGND VPWR VPWR net67 sky130_fd_sc_hd__dfrtp_1
XFILLER_251_517 VPWR VGND VPWR VGND sky130_ef_sc_hd__decap_12
X_596_ clknet_3_2__leaf_clk _078_ _004_ VGND VGND VPWR VPWR rd_addr\[4\] sky130_fd_sc_hd__dfrtp_1
XFILLER_95_1165 VPWR VGND VPWR VGND sky130_ef_sc_hd__decap_12
XFILLER_188_101 VGND VGND VPWR VPWR sky130_fd_sc_hd__decap_6
XFILLER_204_433 VPWR VGND VPWR VGND sky130_ef_sc_hd__decap_12
XFILLER_186_1293 VPWR VGND VPWR VGND sky130_ef_sc_hd__decap_12
XFILLER_189_646 VPWR VGND VPWR VGND sky130_ef_sc_hd__decap_12
XFILLER_232_753 VPWR VGND VPWR VGND sky130_ef_sc_hd__decap_12
XFILLER_231_252 VGND VGND VPWR VPWR sky130_fd_sc_hd__decap_6
XFILLER_108_1239 VPWR VGND VPWR VGND sky130_ef_sc_hd__decap_12
XFILLER_220_937 VPWR VGND VPWR VGND sky130_ef_sc_hd__decap_12
XFILLER_204_488 VGND VGND VPWR VPWR sky130_fd_sc_hd__decap_6
XFILLER_160_1411 VPWR VGND VPWR VGND sky130_ef_sc_hd__decap_12
XFILLER_185_830 VPWR VGND VPWR VGND sky130_ef_sc_hd__decap_12
XFILLER_223_1143 VPWR VGND VPWR VGND sky130_ef_sc_hd__decap_12
XFILLER_169_381 VGND VGND VPWR VPWR sky130_fd_sc_hd__decap_6
XTAP_TAPCELL_ROW_75_2_5262 VGND VPWR sky130_fd_sc_hd__tapvpwrvgnd_1
XFILLER_160_1466 VPWR VGND VPWR VGND sky130_ef_sc_hd__decap_12
XPHY_EDGE_ROW_106_1_Right_762 VGND VGND VPWR VPWR sky130_fd_sc_hd__decap_3
XTAP_TAPCELL_ROW_118_2_5602 VGND VPWR sky130_fd_sc_hd__tapvpwrvgnd_1
XFILLER_185_885 VPWR VGND VPWR VGND sky130_ef_sc_hd__decap_12
XFILLER_223_1198 VGND VGND VPWR VPWR sky130_fd_sc_hd__decap_6
XFILLER_201_1463 VPWR VGND VPWR VGND sky130_ef_sc_hd__decap_12
XANTENNA_3 dout0\[3\] VGND VGND VPWR VPWR sky130_fd_sc_hd__diode_2
XFILLER_67_1201 VGND VGND VPWR VPWR sky130_fd_sc_hd__decap_4
XFILLER_6_65 VPWR VGND VPWR VGND sky130_ef_sc_hd__decap_12
XFILLER_119_1335 VPWR VGND VPWR VGND sky130_ef_sc_hd__decap_12
XTAP_TAPCELL_ROW_185_2220 VGND VPWR sky130_fd_sc_hd__tapvpwrvgnd_1
XFILLER_193_80 VGND VGND VPWR VPWR sky130_fd_sc_hd__decap_6
XTAP_TAPCELL_ROW_185_2231 VGND VPWR sky130_fd_sc_hd__tapvpwrvgnd_1
XTAP_TAPCELL_ROW_185_2242 VGND VPWR sky130_fd_sc_hd__tapvpwrvgnd_1
XPHY_EDGE_ROW_42_2_Right_133 VGND VGND VPWR VPWR sky130_fd_sc_hd__decap_3
XFILLER_80_1423 VPWR VGND VPWR VGND sky130_ef_sc_hd__decap_12
XFILLER_234_1250 VPWR VGND VPWR VGND sky130_ef_sc_hd__decap_12
XTAP_TAPCELL_ROW_181_2106 VGND VPWR sky130_fd_sc_hd__tapvpwrvgnd_1
XFILLER_80_1478 VGND VGND VPWR VPWR sky130_fd_sc_hd__decap_6
XFILLER_6_1047 VGND VGND VPWR VPWR sky130_fd_sc_hd__decap_6
XFILLER_187_1002 VPWR VGND VPWR VGND sky130_ef_sc_hd__decap_12
XFILLER_254_366 VPWR VGND VPWR VGND sky130_ef_sc_hd__decap_12
XFILLER_130_1270 VPWR VGND VPWR VGND sky130_ef_sc_hd__decap_12
XFILLER_187_1057 VPWR VGND VPWR VGND sky130_ef_sc_hd__decap_12
XTAP_TAPCELL_ROW_179_2013 VGND VPWR sky130_fd_sc_hd__tapvpwrvgnd_1
XFILLER_212_65 VPWR VGND VPWR VGND sky130_ef_sc_hd__decap_12
XTAP_TAPCELL_ROW_179_2024 VGND VPWR sky130_fd_sc_hd__tapvpwrvgnd_1
XFILLER_207_271 VPWR VGND VPWR VGND sky130_ef_sc_hd__decap_12
XTAP_TAPCELL_ROW_179_2035 VGND VPWR sky130_fd_sc_hd__tapvpwrvgnd_1
XFILLER_39_1347 VPWR VGND VPWR VGND sky130_ef_sc_hd__decap_12
XFILLER_74_1227 VPWR VGND VPWR VGND sky130_ef_sc_hd__decap_12
XTAP_TAPCELL_ROW_198_2669 VGND VPWR sky130_fd_sc_hd__tapvpwrvgnd_1
XFILLER_228_1054 VPWR VGND VPWR VGND sky130_ef_sc_hd__decap_12
XFILLER_179_123 VGND VGND VPWR VPWR sky130_fd_sc_hd__decap_6
XFILLER_211_904 VPWR VGND VPWR VGND sky130_ef_sc_hd__decap_12
XFILLER_222_230 VGND VGND VPWR VPWR sky130_fd_sc_hd__decap_6
XFILLER_250_550 VPWR VGND VPWR VGND sky130_ef_sc_hd__decap_12
XFILLER_126_1306 VGND VGND VPWR VPWR sky130_fd_sc_hd__decap_6
XFILLER_165_1366 VPWR VGND VPWR VGND sky130_ef_sc_hd__decap_12
XFILLER_168_808 VPWR VGND VPWR VGND sky130_ef_sc_hd__decap_12
XFILLER_223_775 VPWR VGND VPWR VGND sky130_ef_sc_hd__decap_12
XFILLER_165_1399 VGND VGND VPWR VPWR sky130_fd_sc_hd__decap_8
XFILLER_195_627 VPWR VGND VPWR VGND sky130_ef_sc_hd__decap_12
XFILLER_211_959 VPWR VGND VPWR VGND sky130_ef_sc_hd__decap_12
XFILLER_176_863 VPWR VGND VPWR VGND sky130_ef_sc_hd__decap_12
XFILLER_202_1238 VPWR VGND VPWR VGND sky130_ef_sc_hd__decap_12
XTAP_TAPCELL_ROW_230_3810 VGND VPWR sky130_fd_sc_hd__tapvpwrvgnd_1
XFILLER_191_811 VGND VGND VPWR VPWR sky130_fd_sc_hd__decap_6
XTAP_TAPCELL_ROW_230_3821 VGND VPWR sky130_fd_sc_hd__tapvpwrvgnd_1
XFILLER_198_1164 VPWR VGND VPWR VGND sky130_ef_sc_hd__decap_12
XFILLER_50_1282 VPWR VGND VPWR VGND sky130_ef_sc_hd__decap_12
XFILLER_137_1402 VPWR VGND VPWR VGND sky130_ef_sc_hd__decap_12
XFILLER_235_1014 VPWR VGND VPWR VGND sky130_ef_sc_hd__decap_12
XFILLER_9_9 VPWR VGND VPWR VGND sky130_ef_sc_hd__decap_12
XFILLER_173_39 VGND VGND VPWR VPWR sky130_fd_sc_hd__decap_4
XFILLER_176_1484 VPWR VGND VPWR VGND sky130_ef_sc_hd__decap_12
XFILLER_85_1378 VPWR VGND VPWR VGND sky130_ef_sc_hd__decap_12
XFILLER_137_1457 VGND VGND VPWR VPWR sky130_fd_sc_hd__decap_6
XFILLER_106_22 VPWR VGND VPWR VGND sky130_ef_sc_hd__decap_12
XFILLER_172_1348 VGND VGND VPWR VPWR sky130_fd_sc_hd__decap_6
XTAP_TAPCELL_ROW_228_3750 VGND VPWR sky130_fd_sc_hd__tapvpwrvgnd_1
XFILLER_235_1069 VGND VGND VPWR VPWR sky130_fd_sc_hd__decap_6
XTAP_TAPCELL_ROW_224_3603 VGND VPWR sky130_fd_sc_hd__tapvpwrvgnd_1
XPHY_EDGE_ROW_251_Left_506 VGND VGND VPWR VPWR sky130_fd_sc_hd__decap_3
XFILLER_213_1334 VPWR VGND VPWR VGND sky130_ef_sc_hd__decap_12
XFILLER_213_1389 VPWR VGND VPWR VGND sky130_ef_sc_hd__decap_12
XFILLER_2_1434 VGND VGND VPWR VPWR sky130_fd_sc_hd__decap_6
XFILLER_233_517 VPWR VGND VPWR VGND sky130_ef_sc_hd__decap_12
XFILLER_245_388 VPWR VGND VPWR VGND sky130_ef_sc_hd__decap_12
XFILLER_122_65 VGND VGND VPWR VPWR sky130_fd_sc_hd__decap_6
XFILLER_246_1121 VPWR VGND VPWR VGND sky130_ef_sc_hd__decap_12
X_450_ _237_ _238_ VGND VGND VPWR VPWR acc_core.adder.cla_blocks\[7\].block.sum\[1\]
+ sky130_fd_sc_hd__nand2_1
XFILLER_57_1414 VGND VGND VPWR VPWR sky130_fd_sc_hd__decap_6
XFILLER_96_1485 VPWR VGND VPWR VGND sky130_ef_sc_hd__decap_12
XFILLER_198_421 VPWR VGND VPWR VGND sky130_ef_sc_hd__decap_12
XFILLER_214_753 VPWR VGND VPWR VGND sky130_ef_sc_hd__decap_12
XFILLER_82_58 VGND VGND VPWR VPWR sky130_fd_sc_hd__decap_6
XFILLER_183_1444 VPWR VGND VPWR VGND sky130_ef_sc_hd__decap_12
XTAP_TAPCELL_ROW_124_2_5656 VGND VPWR sky130_fd_sc_hd__tapvpwrvgnd_1
XFILLER_246_1176 VGND VGND VPWR VPWR sky130_fd_sc_hd__decap_6
XFILLER_15_30 VPWR VGND VPWR VGND sky130_ef_sc_hd__decap_12
X_381_ net217 _168_ VGND VGND VPWR VPWR _170_ sky130_fd_sc_hd__or2_1
XFILLER_92_1349 VGND VGND VPWR VPWR sky130_fd_sc_hd__decap_6
XTAP_TAPCELL_ROW_92_2_5401 VGND VPWR sky130_fd_sc_hd__tapvpwrvgnd_1
XFILLER_213_252 VGND VGND VPWR VPWR sky130_fd_sc_hd__decap_6
XFILLER_241_572 VPWR VGND VPWR VGND sky130_ef_sc_hd__decap_12
XFILLER_186_605 VPWR VGND VPWR VGND sky130_ef_sc_hd__decap_12
XFILLER_198_58 VGND VGND VPWR VPWR sky130_fd_sc_hd__decap_6
XFILLER_202_937 VPWR VGND VPWR VGND sky130_ef_sc_hd__decap_12
XFILLER_198_476 VPWR VGND VPWR VGND sky130_ef_sc_hd__decap_12
XFILLER_183_1499 VGND VGND VPWR VPWR sky130_fd_sc_hd__decap_6
XFILLER_224_1441 VPWR VGND VPWR VGND sky130_ef_sc_hd__decap_12
XFILLER_167_830 VPWR VGND VPWR VGND sky130_ef_sc_hd__decap_12
XFILLER_107_1261 VPWR VGND VPWR VGND sky130_ef_sc_hd__decap_12
XFILLER_220_1305 VGND VGND VPWR VPWR sky130_fd_sc_hd__decap_6
XFILLER_224_1496 VPWR VGND VPWR VGND sky130_ef_sc_hd__decap_12
XFILLER_194_660 VGND VGND VPWR VPWR sky130_fd_sc_hd__decap_6
XFILLER_16_1177 VGND VGND VPWR VPWR sky130_fd_sc_hd__decap_6
XFILLER_167_885 VPWR VGND VPWR VGND sky130_ef_sc_hd__decap_12
XFILLER_210_992 VPWR VGND VPWR VGND sky130_ef_sc_hd__decap_12
XFILLER_142_1196 VPWR VGND VPWR VGND sky130_ef_sc_hd__decap_12
XFILLER_177_1248 VPWR VGND VPWR VGND sky130_ef_sc_hd__decap_12
Xoutput51 net539 VGND VGND VPWR VPWR acc_out[17] sky130_fd_sc_hd__buf_2
Xoutput62 net62 VGND VGND VPWR VPWR acc_out[27] sky130_fd_sc_hd__buf_2
XFILLER_214_1109 VPWR VGND VPWR VGND sky130_ef_sc_hd__decap_12
Xoutput73 net73 VGND VGND VPWR VPWR acc_out[8] sky130_fd_sc_hd__buf_2
XFILLER_231_1401 VPWR VGND VPWR VGND sky130_ef_sc_hd__decap_12
XFILLER_7_1334 VPWR VGND VPWR VGND sky130_ef_sc_hd__decap_12
XFILLER_27_1273 VPWR VGND VPWR VGND sky130_ef_sc_hd__decap_12
XFILLER_153_1292 VPWR VGND VPWR VGND sky130_ef_sc_hd__decap_12
XFILLER_231_1456 VGND VGND VPWR VPWR sky130_fd_sc_hd__decap_6
XTAP_TAPCELL_ROW_240_4150 VGND VPWR sky130_fd_sc_hd__tapvpwrvgnd_1
XTAP_TAPCELL_ROW_240_4161 VGND VPWR sky130_fd_sc_hd__tapvpwrvgnd_1
XTAP_TAPCELL_ROW_240_4172 VGND VPWR sky130_fd_sc_hd__tapvpwrvgnd_1
XFILLER_7_1389 VPWR VGND VPWR VGND sky130_ef_sc_hd__decap_12
XFILLER_188_1355 VPWR VGND VPWR VGND sky130_ef_sc_hd__decap_12
XFILLER_236_366 VPWR VGND VPWR VGND sky130_ef_sc_hd__decap_12
XFILLER_97_1249 VPWR VGND VPWR VGND sky130_ef_sc_hd__decap_12
XFILLER_149_1328 VGND VGND VPWR VPWR sky130_fd_sc_hd__decap_6
XFILLER_251_314 VPWR VGND VPWR VGND sky130_ef_sc_hd__decap_12
XFILLER_184_1219 VGND VGND VPWR VPWR sky130_fd_sc_hd__decap_6
X_648_ clknet_3_6__leaf_clk acc_core.adder.cla_blocks\[3\].block.sum\[2\] _056_ VGND
+ VGND VPWR VPWR net48 sky130_fd_sc_hd__dfrtp_1
XFILLER_204_230 VGND VGND VPWR VPWR sky130_fd_sc_hd__decap_6
XFILLER_251_369 VPWR VGND VPWR VGND sky130_ef_sc_hd__decap_12
XFILLER_186_1090 VGND VGND VPWR VPWR sky130_fd_sc_hd__decap_6
XFILLER_225_1205 VPWR VGND VPWR VGND sky130_ef_sc_hd__decap_12
XFILLER_232_550 VPWR VGND VPWR VGND sky130_ef_sc_hd__decap_12
XFILLER_36_1509 VGND VGND VPWR VPWR sky130_fd_sc_hd__decap_6
XFILLER_189_443 VPWR VGND VPWR VGND sky130_ef_sc_hd__decap_12
XFILLER_205_775 VPWR VGND VPWR VGND sky130_ef_sc_hd__decap_12
XTAP_TAPCELL_ROW_201_2776 VGND VPWR sky130_fd_sc_hd__tapvpwrvgnd_1
X_579_ net669 VGND VGND VPWR VPWR _061_ sky130_fd_sc_hd__inv_2
XTAP_TAPCELL_ROW_193_2500 VGND VPWR sky130_fd_sc_hd__tapvpwrvgnd_1
XTAP_TAPCELL_ROW_201_2787 VGND VPWR sky130_fd_sc_hd__tapvpwrvgnd_1
XTAP_TAPCELL_ROW_238_4090 VGND VPWR sky130_fd_sc_hd__tapvpwrvgnd_1
XTAP_TAPCELL_ROW_193_2511 VGND VPWR sky130_fd_sc_hd__tapvpwrvgnd_1
XTAP_TAPCELL_ROW_201_2798 VGND VPWR sky130_fd_sc_hd__tapvpwrvgnd_1
XFILLER_177_627 VPWR VGND VPWR VGND sky130_ef_sc_hd__decap_12
XTAP_TAPCELL_ROW_193_2522 VGND VPWR sky130_fd_sc_hd__tapvpwrvgnd_1
XFILLER_220_734 VPWR VGND VPWR VGND sky130_ef_sc_hd__decap_12
XFILLER_38_1380 VPWR VGND VPWR VGND sky130_ef_sc_hd__decap_12
XFILLER_189_498 VPWR VGND VPWR VGND sky130_ef_sc_hd__decap_12
XTAP_TAPCELL_ROW_253_4599 VGND VPWR sky130_fd_sc_hd__tapvpwrvgnd_1
XFILLER_203_1514 VGND VGND VPWR VPWR sky130_fd_sc_hd__fill_1
XFILLER_220_789 VGND VGND VPWR VPWR sky130_fd_sc_hd__decap_6
XFILLER_160_1263 VGND VGND VPWR VPWR sky130_fd_sc_hd__decap_6
XFILLER_9_862 VPWR VGND VPWR VGND sky130_ef_sc_hd__decap_12
XFILLER_75_3 VPWR VGND VPWR VGND sky130_ef_sc_hd__decap_12
XFILLER_8_350 VPWR VGND VPWR VGND sky130_ef_sc_hd__decap_12
XFILLER_173_811 VGND VGND VPWR VPWR sky130_fd_sc_hd__decap_6
XFILLER_185_682 VGND VGND VPWR VPWR sky130_fd_sc_hd__decap_6
XFILLER_9_895 VGND VGND VPWR VPWR sky130_fd_sc_hd__decap_8
XPHY_EDGE_ROW_107_1_Right_763 VGND VGND VPWR VPWR sky130_fd_sc_hd__decap_3
XFILLER_195_1315 VPWR VGND VPWR VGND sky130_ef_sc_hd__decap_12
XFILLER_201_1260 VPWR VGND VPWR VGND sky130_ef_sc_hd__decap_12
XTAP_TAPCELL_ROW_187_2304 VGND VPWR sky130_fd_sc_hd__tapvpwrvgnd_1
XFILLER_236_1312 VPWR VGND VPWR VGND sky130_ef_sc_hd__decap_12
XTAP_TAPCELL_ROW_187_2315 VGND VPWR sky130_fd_sc_hd__tapvpwrvgnd_1
XFILLER_236_1367 VPWR VGND VPWR VGND sky130_ef_sc_hd__decap_12
XFILLER_8_1109 VPWR VGND VPWR VGND sky130_ef_sc_hd__decap_12
XFILLER_119_1165 VPWR VGND VPWR VGND sky130_ef_sc_hd__decap_12
XFILLER_207_87 VPWR VGND VPWR VGND sky130_ef_sc_hd__decap_12
XFILLER_80_1220 VGND VGND VPWR VPWR sky130_fd_sc_hd__decap_6
XFILLER_246_108 VPWR VGND VPWR VGND sky130_ef_sc_hd__decap_12
XPHY_EDGE_ROW_43_2_Right_134 VGND VGND VPWR VPWR sky130_fd_sc_hd__decap_3
XFILLER_171_1370 VGND VGND VPWR VPWR sky130_fd_sc_hd__decap_6
XFILLER_189_1119 VPWR VGND VPWR VGND sky130_ef_sc_hd__decap_12
XTAP_TAPCELL_ROW_130_2_5699 VGND VPWR sky130_fd_sc_hd__tapvpwrvgnd_1
XFILLER_255_631 VPWR VGND VPWR VGND sky130_ef_sc_hd__decap_12
XTAP_TAPCELL_ROW_97_2_5438 VGND VPWR sky130_fd_sc_hd__tapvpwrvgnd_1
XFILLER_255_664 VGND VGND VPWR VPWR sky130_fd_sc_hd__decap_8
XFILLER_215_517 VPWR VGND VPWR VGND sky130_ef_sc_hd__decap_12
XFILLER_254_163 VPWR VGND VPWR VGND sky130_ef_sc_hd__decap_12
XTAP_TAPCELL_ROW_110_2_5542 VGND VPWR sky130_fd_sc_hd__tapvpwrvgnd_1
XFILLER_227_388 VPWR VGND VPWR VGND sky130_ef_sc_hd__decap_12
XTAP_TAPCELL_ROW_109_2_5536 VGND VPWR sky130_fd_sc_hd__tapvpwrvgnd_1
XFILLER_242_347 VPWR VGND VPWR VGND sky130_ef_sc_hd__decap_12
XPHY_EDGE_ROW_28_1_Left_283 VGND VGND VPWR VPWR sky130_fd_sc_hd__decap_3
XFILLER_247_1463 VPWR VGND VPWR VGND sky130_ef_sc_hd__decap_12
XFILLER_211_701 VPWR VGND VPWR VGND sky130_ef_sc_hd__decap_12
XFILLER_243_1327 VGND VGND VPWR VPWR sky130_fd_sc_hd__decap_6
XFILLER_168_605 VPWR VGND VPWR VGND sky130_ef_sc_hd__decap_12
XFILLER_223_572 VPWR VGND VPWR VGND sky130_ef_sc_hd__decap_12
XFILLER_196_925 VPWR VGND VPWR VGND sky130_ef_sc_hd__decap_12
XFILLER_195_424 VGND VGND VPWR VPWR sky130_fd_sc_hd__decap_6
XFILLER_211_756 VPWR VGND VPWR VGND sky130_ef_sc_hd__decap_12
XFILLER_91_1371 VGND VGND VPWR VPWR sky130_fd_sc_hd__decap_6
XFILLER_17_1464 VPWR VGND VPWR VGND sky130_ef_sc_hd__decap_12
XFILLER_104_1423 VPWR VGND VPWR VGND sky130_ef_sc_hd__decap_12
XFILLER_176_660 VGND VGND VPWR VPWR sky130_fd_sc_hd__decap_6
XFILLER_13_1328 VGND VGND VPWR VPWR sky130_fd_sc_hd__decap_6
XFILLER_202_1035 VPWR VGND VPWR VGND sky130_ef_sc_hd__decap_12
XFILLER_52_1399 VPWR VGND VPWR VGND sky130_ef_sc_hd__decap_12
XFILLER_104_1478 VGND VGND VPWR VPWR sky130_fd_sc_hd__decap_6
XFILLER_190_151 VPWR VGND VPWR VGND sky130_ef_sc_hd__decap_12
XFILLER_2_504 VGND VGND VPWR VPWR sky130_fd_sc_hd__fill_2
XFILLER_2_515 VGND VGND VPWR VPWR sky130_fd_sc_hd__fill_1
XTAP_TAPCELL_ROW_46_1_1299 VGND VPWR sky130_fd_sc_hd__tapvpwrvgnd_1
XFILLER_254_1434 VGND VGND VPWR VPWR sky130_fd_sc_hd__decap_6
Xsram0_677 VGND VGND VPWR VPWR sram0_677/HI net677 sky130_fd_sc_hd__conb_1
Xsram0_688 VGND VGND VPWR VPWR net688 sram0_688/LO sky130_fd_sc_hd__conb_1
XFILLER_7_6 VPWR VGND VPWR VGND sky130_ef_sc_hd__decap_12
XTAP_TAPCELL_ROW_170_1695 VGND VPWR sky130_fd_sc_hd__tapvpwrvgnd_1
XFILLER_176_1281 VPWR VGND VPWR VGND sky130_ef_sc_hd__decap_12
XFILLER_213_1131 VPWR VGND VPWR VGND sky130_ef_sc_hd__decap_12
XFILLER_24_1435 VGND VGND VPWR VPWR sky130_fd_sc_hd__decap_6
XFILLER_150_1454 VPWR VGND VPWR VGND sky130_ef_sc_hd__decap_12
XFILLER_213_1186 VPWR VGND VPWR VGND sky130_ef_sc_hd__decap_12
XFILLER_245_130 VPWR VGND VPWR VGND sky130_ef_sc_hd__decap_12
XPHY_EDGE_ROW_161_1_Left_416 VGND VGND VPWR VPWR sky130_fd_sc_hd__decap_3
XFILLER_185_1506 VGND VGND VPWR VPWR sky130_fd_sc_hd__decap_8
XFILLER_218_366 VPWR VGND VPWR VGND sky130_ef_sc_hd__decap_12
XFILLER_248_1238 VPWR VGND VPWR VGND sky130_ef_sc_hd__decap_12
XFILLER_233_314 VPWR VGND VPWR VGND sky130_ef_sc_hd__decap_12
XFILLER_93_68 VGND VGND VPWR VPWR sky130_fd_sc_hd__decap_3
XFILLER_245_185 VPWR VGND VPWR VGND sky130_ef_sc_hd__decap_12
X_502_ net507 net139 _256_ VGND VGND VPWR VPWR _257_ sky130_fd_sc_hd__or3_1
XFILLER_226_1514 VGND VGND VPWR VPWR sky130_fd_sc_hd__fill_1
XFILLER_233_369 VPWR VGND VPWR VGND sky130_ef_sc_hd__decap_12
XFILLER_96_1282 VPWR VGND VPWR VGND sky130_ef_sc_hd__decap_12
XFILLER_214_550 VPWR VGND VPWR VGND sky130_ef_sc_hd__decap_12
X_433_ net598 net535 dout0_q\[21\] VGND VGND VPWR VPWR _222_ sky130_fd_sc_hd__and3_1
XFILLER_183_1241 VGND VGND VPWR VPWR sky130_fd_sc_hd__decap_6
XFILLER_186_402 VGND VGND VPWR VPWR sky130_fd_sc_hd__decap_6
XFILLER_202_734 VPWR VGND VPWR VGND sky130_ef_sc_hd__decap_12
XFILLER_18_1239 VPWR VGND VPWR VGND sky130_ef_sc_hd__decap_12
X_364_ net249 _152_ VGND VGND VPWR VPWR _153_ sky130_fd_sc_hd__nand2b_1
XFILLER_187_947 VPWR VGND VPWR VGND sky130_ef_sc_hd__decap_12
XFILLER_198_273 VGND VGND VPWR VPWR sky130_fd_sc_hd__decap_6
XFILLER_70_1411 VPWR VGND VPWR VGND sky130_ef_sc_hd__decap_12
XFILLER_109_1378 VPWR VGND VPWR VGND sky130_ef_sc_hd__decap_12
XFILLER_42_50 VGND VGND VPWR VPWR sky130_fd_sc_hd__fill_1
XFILLER_202_789 VGND VGND VPWR VPWR sky130_fd_sc_hd__decap_6
X_295_ net613 net522 VGND VGND VPWR VPWR _077_ sky130_fd_sc_hd__xor2_1
XFILLER_70_1466 VPWR VGND VPWR VGND sky130_ef_sc_hd__decap_12
XFILLER_9_169 VPWR VGND VPWR VGND sky130_ef_sc_hd__decap_12
XTAP_TAPCELL_ROW_154_2_5895 VGND VPWR sky130_fd_sc_hd__tapvpwrvgnd_1
XFILLER_224_1293 VPWR VGND VPWR VGND sky130_ef_sc_hd__decap_12
XFILLER_167_682 VGND VGND VPWR VPWR sky130_fd_sc_hd__decap_6
XFILLER_177_1045 VPWR VGND VPWR VGND sky130_ef_sc_hd__decap_12
XFILLER_181_173 VPWR VGND VPWR VGND sky130_ef_sc_hd__decap_12
XFILLER_29_1335 VPWR VGND VPWR VGND sky130_ef_sc_hd__decap_12
XTAP_TAPCELL_ROW_246_4370 VGND VPWR sky130_fd_sc_hd__tapvpwrvgnd_1
XTAP_TAPCELL_ROW_246_4381 VGND VPWR sky130_fd_sc_hd__tapvpwrvgnd_1
XTAP_TAPCELL_ROW_242_4212 VGND VPWR sky130_fd_sc_hd__tapvpwrvgnd_1
XTAP_TAPCELL_ROW_242_4223 VGND VPWR sky130_fd_sc_hd__tapvpwrvgnd_1
XFILLER_9_1429 VPWR VGND VPWR VGND sky130_ef_sc_hd__decap_12
XTAP_TAPCELL_ROW_242_4234 VGND VPWR sky130_fd_sc_hd__tapvpwrvgnd_1
XFILLER_3_44 VPWR VGND VPWR VGND sky130_ef_sc_hd__decap_12
XTAP_TAPCELL_ROW_115_2_5579 VGND VPWR sky130_fd_sc_hd__tapvpwrvgnd_1
XFILLER_151_1218 VPWR VGND VPWR VGND sky130_ef_sc_hd__decap_12
XFILLER_218_1097 VPWR VGND VPWR VGND sky130_ef_sc_hd__decap_12
XTAP_TAPCELL_ROW_83_2_5324 VGND VPWR sky130_fd_sc_hd__tapvpwrvgnd_1
XFILLER_116_1349 VGND VGND VPWR VPWR sky130_fd_sc_hd__decap_6
XFILLER_228_108 VPWR VGND VPWR VGND sky130_ef_sc_hd__decap_12
XFILLER_7_1131 VPWR VGND VPWR VGND sky130_ef_sc_hd__decap_12
XFILLER_3_99 VPWR VGND VPWR VGND sky130_ef_sc_hd__decap_12
XPHY_EDGE_ROW_93_1_Left_348 VGND VGND VPWR VPWR sky130_fd_sc_hd__decap_3
XFILLER_7_1186 VPWR VGND VPWR VGND sky130_ef_sc_hd__decap_12
XTAP_TAPCELL_ROW_8_1170 VGND VPWR sky130_fd_sc_hd__tapvpwrvgnd_1
XTAP_TAPCELL_ROW_4_1001 VGND VPWR sky130_fd_sc_hd__tapvpwrvgnd_1
XTAP_TAPCELL_ROW_4_1012 VGND VPWR sky130_fd_sc_hd__tapvpwrvgnd_1
XTAP_TAPCELL_ROW_4_1023 VGND VPWR sky130_fd_sc_hd__tapvpwrvgnd_1
XFILLER_188_1152 VPWR VGND VPWR VGND sky130_ef_sc_hd__decap_12
XTAP_TAPCELL_ROW_207_2985 VGND VPWR sky130_fd_sc_hd__tapvpwrvgnd_1
XTAP_TAPCELL_ROW_207_2996 VGND VPWR sky130_fd_sc_hd__tapvpwrvgnd_1
XFILLER_209_388 VPWR VGND VPWR VGND sky130_ef_sc_hd__decap_12
XFILLER_236_163 VPWR VGND VPWR VGND sky130_ef_sc_hd__decap_12
XFILLER_40_1270 VPWR VGND VPWR VGND sky130_ef_sc_hd__decap_12
XTAP_TAPCELL_ROW_199_2720 VGND VPWR sky130_fd_sc_hd__tapvpwrvgnd_1
XFILLER_251_111 VPWR VGND VPWR VGND sky130_ef_sc_hd__decap_12
XTAP_TAPCELL_ROW_199_2731 VGND VPWR sky130_fd_sc_hd__tapvpwrvgnd_1
XTAP_TAPCELL_ROW_203_2849 VGND VPWR sky130_fd_sc_hd__tapvpwrvgnd_1
XFILLER_224_347 VPWR VGND VPWR VGND sky130_ef_sc_hd__decap_12
XTAP_TAPCELL_ROW_236_4005 VGND VPWR sky130_fd_sc_hd__tapvpwrvgnd_1
XFILLER_252_667 VPWR VGND VPWR VGND sky130_ef_sc_hd__decap_12
XTAP_TAPCELL_ROW_236_4016 VGND VPWR sky130_fd_sc_hd__tapvpwrvgnd_1
XTAP_TAPCELL_ROW_236_4027 VGND VPWR sky130_fd_sc_hd__tapvpwrvgnd_1
XFILLER_251_166 VGND VGND VPWR VPWR sky130_fd_sc_hd__decap_6
XFILLER_225_1002 VPWR VGND VPWR VGND sky130_ef_sc_hd__decap_12
XFILLER_189_240 VPWR VGND VPWR VGND sky130_ef_sc_hd__decap_12
XFILLER_36_1306 VGND VGND VPWR VPWR sky130_fd_sc_hd__decap_6
XFILLER_205_572 VPWR VGND VPWR VGND sky130_ef_sc_hd__decap_12
XFILLER_178_925 VPWR VGND VPWR VGND sky130_ef_sc_hd__decap_12
XFILLER_127_1445 VPWR VGND VPWR VGND sky130_ef_sc_hd__decap_12
XFILLER_162_1325 VPWR VGND VPWR VGND sky130_ef_sc_hd__decap_12
XFILLER_177_424 VGND VGND VPWR VPWR sky130_fd_sc_hd__decap_6
XFILLER_220_531 VGND VGND VPWR VPWR sky130_fd_sc_hd__decap_6
XFILLER_225_1057 VPWR VGND VPWR VGND sky130_ef_sc_hd__decap_12
XFILLER_189_295 VGND VGND VPWR VPWR sky130_fd_sc_hd__decap_6
XFILLER_193_928 VPWR VGND VPWR VGND sky130_ef_sc_hd__decap_12
XFILLER_186_980 VPWR VGND VPWR VGND sky130_ef_sc_hd__decap_12
XTAP_TAPCELL_ROW_11_2_4749 VGND VPWR sky130_fd_sc_hd__tapvpwrvgnd_1
XFILLER_203_1377 VPWR VGND VPWR VGND sky130_ef_sc_hd__decap_12
XFILLER_195_1112 VGND VGND VPWR VPWR sky130_fd_sc_hd__decap_6
XFILLER_8_191 VGND VGND VPWR VPWR sky130_fd_sc_hd__fill_2
XPHY_EDGE_ROW_108_1_Right_764 VGND VGND VPWR VPWR sky130_fd_sc_hd__decap_3
XFILLER_172_151 VPWR VGND VPWR VGND sky130_ef_sc_hd__decap_12
XFILLER_47_1402 VPWR VGND VPWR VGND sky130_ef_sc_hd__decap_12
XFILLER_173_1432 VPWR VGND VPWR VGND sky130_ef_sc_hd__decap_12
XFILLER_47_1457 VGND VGND VPWR VPWR sky130_fd_sc_hd__decap_6
XFILLER_82_1337 VPWR VGND VPWR VGND sky130_ef_sc_hd__decap_12
XFILLER_236_1164 VPWR VGND VPWR VGND sky130_ef_sc_hd__decap_12
XFILLER_248_918 VGND VGND VPWR VPWR sky130_fd_sc_hd__decap_6
XFILLER_173_1487 VPWR VGND VPWR VGND sky130_ef_sc_hd__decap_12
XPHY_EDGE_ROW_184_Left_439 VGND VGND VPWR VPWR sky130_fd_sc_hd__decap_3
XFILLER_47_39 VGND VGND VPWR VPWR sky130_fd_sc_hd__decap_4
XFILLER_45_1192 VPWR VGND VPWR VGND sky130_ef_sc_hd__decap_12
XPHY_EDGE_ROW_44_2_Right_135 VGND VGND VPWR VPWR sky130_fd_sc_hd__decap_3
XFILLER_214_1484 VPWR VGND VPWR VGND sky130_ef_sc_hd__decap_12
XFILLER_227_130 VPWR VGND VPWR VGND sky130_ef_sc_hd__decap_12
XFILLER_249_1514 VGND VGND VPWR VPWR sky130_fd_sc_hd__fill_1
XFILLER_132_1184 VPWR VGND VPWR VGND sky130_ef_sc_hd__decap_12
XFILLER_210_1348 VGND VGND VPWR VPWR sky130_fd_sc_hd__decap_6
XFILLER_215_314 VPWR VGND VPWR VGND sky130_ef_sc_hd__decap_12
XFILLER_227_185 VPWR VGND VPWR VGND sky130_ef_sc_hd__decap_12
XFILLER_103_56 VPWR VGND VPWR VGND sky130_ef_sc_hd__decap_12
XFILLER_242_144 VGND VGND VPWR VPWR sky130_fd_sc_hd__decap_6
XFILLER_63_27 VPWR VGND VPWR VGND sky130_ef_sc_hd__decap_12
XFILLER_215_369 VPWR VGND VPWR VGND sky130_ef_sc_hd__decap_12
XFILLER_231_818 VPWR VGND VPWR VGND sky130_ef_sc_hd__decap_12
XFILLER_247_1260 VPWR VGND VPWR VGND sky130_ef_sc_hd__decap_12
XFILLER_243_689 VPWR VGND VPWR VGND sky130_ef_sc_hd__decap_12
XFILLER_93_1433 VPWR VGND VPWR VGND sky130_ef_sc_hd__decap_12
XFILLER_179_27 VPWR VGND VPWR VGND sky130_ef_sc_hd__decap_12
XFILLER_168_402 VGND VGND VPWR VPWR sky130_fd_sc_hd__decap_6
XFILLER_196_722 VPWR VGND VPWR VGND sky130_ef_sc_hd__decap_12
XFILLER_93_1488 VPWR VGND VPWR VGND sky130_ef_sc_hd__decap_12
XTAP_TAPCELL_ROW_140_2_5781 VGND VPWR sky130_fd_sc_hd__tapvpwrvgnd_1
XFILLER_169_947 VPWR VGND VPWR VGND sky130_ef_sc_hd__decap_12
XPHY_EDGE_ROW_193_Left_448 VGND VGND VPWR VPWR sky130_fd_sc_hd__decap_3
XTAP_TAPCELL_ROW_139_2_5775 VGND VPWR sky130_fd_sc_hd__tapvpwrvgnd_1
XFILLER_211_553 VGND VGND VPWR VPWR sky130_fd_sc_hd__decap_6
XFILLER_184_906 VPWR VGND VPWR VGND sky130_ef_sc_hd__decap_12
Xwire505 net506 VGND VGND VPWR VPWR net505 sky130_fd_sc_hd__clkbuf_1
XFILLER_196_777 VPWR VGND VPWR VGND sky130_ef_sc_hd__decap_12
XFILLER_17_1261 VPWR VGND VPWR VGND sky130_ef_sc_hd__decap_12
XFILLER_104_1220 VGND VGND VPWR VPWR sky130_fd_sc_hd__decap_6
XFILLER_195_15 VPWR VGND VPWR VGND sky130_ef_sc_hd__decap_12
XFILLER_221_1444 VPWR VGND VPWR VGND sky130_ef_sc_hd__decap_12
XFILLER_52_1196 VPWR VGND VPWR VGND sky130_ef_sc_hd__decap_12
XFILLER_192_961 VGND VGND VPWR VPWR sky130_fd_sc_hd__decap_6
XFILLER_221_1499 VGND VGND VPWR VPWR sky130_fd_sc_hd__decap_6
XTAP_TAPCELL_ROW_172_1768 VGND VPWR sky130_fd_sc_hd__tapvpwrvgnd_1
XTAP_TAPCELL_ROW_172_1779 VGND VPWR sky130_fd_sc_hd__tapvpwrvgnd_1
XFILLER_139_1316 VPWR VGND VPWR VGND sky130_ef_sc_hd__decap_12
XTAP_TAPCELL_ROW_132_2_5718 VGND VPWR sky130_fd_sc_hd__tapvpwrvgnd_1
XFILLER_174_1207 VPWR VGND VPWR VGND sky130_ef_sc_hd__decap_12
XFILLER_178_1398 VPWR VGND VPWR VGND sky130_ef_sc_hd__decap_12
XFILLER_88_46 VPWR VGND VPWR VGND sky130_ef_sc_hd__decap_12
XTAP_TAPCELL_ROW_68_2_5204 VGND VPWR sky130_fd_sc_hd__tapvpwrvgnd_1
XFILLER_215_1248 VPWR VGND VPWR VGND sky130_ef_sc_hd__decap_12
Xfanout671 net672 VGND VGND VPWR VPWR net671 sky130_fd_sc_hd__buf_4
XFILLER_247_940 VGND VGND VPWR VPWR sky130_fd_sc_hd__decap_6
XFILLER_63_1292 VPWR VGND VPWR VGND sky130_ef_sc_hd__decap_12
XFILLER_8_1484 VPWR VGND VPWR VGND sky130_ef_sc_hd__decap_12
XTAP_TAPCELL_ROW_35_2_4945 VGND VPWR sky130_fd_sc_hd__tapvpwrvgnd_1
XFILLER_115_1371 VGND VGND VPWR VPWR sky130_fd_sc_hd__decap_6
XFILLER_150_1251 VPWR VGND VPWR VGND sky130_ef_sc_hd__decap_12
XFILLER_4_1348 VGND VGND VPWR VPWR sky130_fd_sc_hd__decap_6
XFILLER_37_50 VGND VGND VPWR VPWR sky130_fd_sc_hd__fill_1
XFILLER_218_163 VPWR VGND VPWR VGND sky130_ef_sc_hd__decap_12
XFILLER_185_1303 VPWR VGND VPWR VGND sky130_ef_sc_hd__decap_12
XFILLER_248_1035 VPWR VGND VPWR VGND sky130_ef_sc_hd__decap_12
XFILLER_59_1328 VGND VGND VPWR VPWR sky130_fd_sc_hd__decap_6
XFILLER_94_1208 VPWR VGND VPWR VGND sky130_ef_sc_hd__decap_12
XFILLER_233_111 VPWR VGND VPWR VGND sky130_ef_sc_hd__decap_12
XFILLER_206_347 VPWR VGND VPWR VGND sky130_ef_sc_hd__decap_12
XFILLER_98_1399 VPWR VGND VPWR VGND sky130_ef_sc_hd__decap_12
XFILLER_234_667 VPWR VGND VPWR VGND sky130_ef_sc_hd__decap_12
XFILLER_185_1358 VPWR VGND VPWR VGND sky130_ef_sc_hd__decap_12
XFILLER_233_166 VGND VGND VPWR VPWR sky130_fd_sc_hd__decap_6
XFILLER_199_560 VPWR VGND VPWR VGND sky130_ef_sc_hd__decap_12
XTAP_TAPCELL_ROW_254_4650 VGND VPWR sky130_fd_sc_hd__tapvpwrvgnd_1
XTAP_TAPCELL_ROW_254_4661 VGND VPWR sky130_fd_sc_hd__tapvpwrvgnd_1
XTAP_TAPCELL_ROW_250_4503 VGND VPWR sky130_fd_sc_hd__tapvpwrvgnd_1
X_416_ net125 net130 net122 net157 _163_ VGND VGND VPWR VPWR _205_ sky130_fd_sc_hd__a311o_1
XFILLER_202_531 VGND VGND VPWR VPWR sky130_fd_sc_hd__decap_6
XFILLER_226_1355 VPWR VGND VPWR VGND sky130_ef_sc_hd__decap_12
XTAP_TAPCELL_ROW_250_4514 VGND VPWR sky130_fd_sc_hd__tapvpwrvgnd_1
XFILLER_230_851 VPWR VGND VPWR VGND sky130_ef_sc_hd__decap_12
XFILLER_187_744 VPWR VGND VPWR VGND sky130_ef_sc_hd__decap_12
XFILLER_222_1219 VGND VGND VPWR VPWR sky130_fd_sc_hd__decap_6
X_347_ net594 dout0_q\[15\] net541 VGND VGND VPWR VPWR _136_ sky130_fd_sc_hd__and3_1
XFILLER_175_928 VPWR VGND VPWR VGND sky130_ef_sc_hd__decap_12
XFILLER_168_980 VPWR VGND VPWR VGND sky130_ef_sc_hd__decap_12
XFILLER_187_799 VPWR VGND VPWR VGND sky130_ef_sc_hd__decap_12
XFILLER_70_1263 VGND VGND VPWR VPWR sky130_fd_sc_hd__decap_6
XFILLER_224_1090 VGND VGND VPWR VPWR sky130_fd_sc_hd__decap_6
XFILLER_196_1410 VPWR VGND VPWR VGND sky130_ef_sc_hd__decap_12
XTAP_TAPCELL_ROW_248_4421 VGND VPWR sky130_fd_sc_hd__tapvpwrvgnd_1
XTAP_TAPCELL_ROW_248_4432 VGND VPWR sky130_fd_sc_hd__tapvpwrvgnd_1
XFILLER_183_983 VGND VGND VPWR VPWR sky130_fd_sc_hd__decap_6
XFILLER_196_1465 VPWR VGND VPWR VGND sky130_ef_sc_hd__decap_12
XTAP_TAPCELL_ROW_248_4443 VGND VPWR sky130_fd_sc_hd__tapvpwrvgnd_1
XFILLER_5_161 VGND VGND VPWR VPWR sky130_fd_sc_hd__decap_8
XTAP_TAPCELL_ROW_244_4307 VGND VPWR sky130_fd_sc_hd__tapvpwrvgnd_1
XFILLER_233_1315 VPWR VGND VPWR VGND sky130_ef_sc_hd__decap_12
XFILLER_38_3 VPWR VGND VPWR VGND sky130_ef_sc_hd__decap_12
XFILLER_29_1165 VPWR VGND VPWR VGND sky130_ef_sc_hd__decap_12
XFILLER_190_1097 VPWR VGND VPWR VGND sky130_ef_sc_hd__decap_12
XTAP_TAPCELL_ROW_104_1_1386 VGND VPWR sky130_fd_sc_hd__tapvpwrvgnd_1
XFILLER_204_22 VPWR VGND VPWR VGND sky130_ef_sc_hd__decap_12
XFILLER_244_409 VPWR VGND VPWR VGND sky130_ef_sc_hd__decap_12
XFILLER_209_130 VPWR VGND VPWR VGND sky130_ef_sc_hd__decap_12
XFILLER_204_77 VPWR VGND VPWR VGND sky130_ef_sc_hd__decap_12
XTAP_TAPCELL_ROW_0_827 VGND VPWR sky130_fd_sc_hd__tapvpwrvgnd_1
XFILLER_209_185 VPWR VGND VPWR VGND sky130_ef_sc_hd__decap_12
XTAP_TAPCELL_ROW_0_838 VGND VPWR sky130_fd_sc_hd__tapvpwrvgnd_1
XTAP_TAPCELL_ROW_0_849 VGND VPWR sky130_fd_sc_hd__tapvpwrvgnd_1
XFILLER_129_1507 VGND VGND VPWR VPWR sky130_fd_sc_hd__decap_8
XFILLER_213_818 VPWR VGND VPWR VGND sky130_ef_sc_hd__decap_12
XFILLER_224_144 VGND VGND VPWR VPWR sky130_fd_sc_hd__decap_6
XFILLER_227_1119 VPWR VGND VPWR VGND sky130_ef_sc_hd__decap_12
XFILLER_252_464 VPWR VGND VPWR VGND sky130_ef_sc_hd__decap_12
XTAP_TAPCELL_ROW_125_2_5661 VGND VPWR sky130_fd_sc_hd__tapvpwrvgnd_1
XFILLER_225_689 VPWR VGND VPWR VGND sky130_ef_sc_hd__decap_12
XFILLER_244_1422 VPWR VGND VPWR VGND sky130_ef_sc_hd__decap_12
XFILLER_220_65 VPWR VGND VPWR VGND sky130_ef_sc_hd__decap_12
XFILLER_240_648 VPWR VGND VPWR VGND sky130_ef_sc_hd__decap_12
XFILLER_178_722 VPWR VGND VPWR VGND sky130_ef_sc_hd__decap_12
XFILLER_127_1242 VGND VGND VPWR VPWR sky130_fd_sc_hd__decap_6
XFILLER_244_1477 VGND VGND VPWR VPWR sky130_fd_sc_hd__decap_6
XFILLER_166_906 VPWR VGND VPWR VGND sky130_ef_sc_hd__decap_12
XFILLER_221_873 VPWR VGND VPWR VGND sky130_ef_sc_hd__decap_12
XFILLER_178_777 VPWR VGND VPWR VGND sky130_ef_sc_hd__decap_12
XFILLER_162_1177 VGND VGND VPWR VPWR sky130_fd_sc_hd__decap_6
XFILLER_193_725 VGND VGND VPWR VPWR sky130_fd_sc_hd__decap_6
XFILLER_14_1423 VPWR VGND VPWR VGND sky130_ef_sc_hd__decap_12
XFILLER_140_1442 VPWR VGND VPWR VGND sky130_ef_sc_hd__decap_12
XFILLER_197_1229 VPWR VGND VPWR VGND sky130_ef_sc_hd__decap_12
XFILLER_203_1174 VPWR VGND VPWR VGND sky130_ef_sc_hd__decap_12
XFILLER_14_1478 VGND VGND VPWR VPWR sky130_fd_sc_hd__decap_6
XFILLER_174_961 VGND VGND VPWR VPWR sky130_fd_sc_hd__decap_6
XFILLER_140_1497 VPWR VGND VPWR VGND sky130_ef_sc_hd__decap_12
XFILLER_238_1226 VPWR VGND VPWR VGND sky130_ef_sc_hd__decap_12
XPHY_EDGE_ROW_109_1_Right_765 VGND VGND VPWR VPWR sky130_fd_sc_hd__decap_3
XTAP_TAPCELL_ROW_41_2_4988 VGND VPWR sky130_fd_sc_hd__tapvpwrvgnd_1
XFILLER_86_1270 VPWR VGND VPWR VGND sky130_ef_sc_hd__decap_12
XFILLER_0_805 VPWR VGND VPWR VGND sky130_ef_sc_hd__decap_12
XTAP_TAPCELL_ROW_21_2_4831 VGND VPWR sky130_fd_sc_hd__tapvpwrvgnd_1
XFILLER_173_1284 VGND VGND VPWR VPWR sky130_fd_sc_hd__decap_6
XFILLER_181_39 VGND VGND VPWR VPWR sky130_fd_sc_hd__decap_4
XFILLER_229_940 VGND VGND VPWR VPWR sky130_fd_sc_hd__decap_6
XFILLER_114_22 VPWR VGND VPWR VGND sky130_ef_sc_hd__decap_12
XFILLER_60_1454 VPWR VGND VPWR VGND sky130_ef_sc_hd__decap_12
XFILLER_214_1281 VPWR VGND VPWR VGND sky130_ef_sc_hd__decap_12
XPHY_EDGE_ROW_45_2_Right_136 VGND VGND VPWR VPWR sky130_fd_sc_hd__decap_3
XFILLER_74_15 VGND VGND VPWR VPWR sky130_fd_sc_hd__decap_6
XPHY_EDGE_ROW_39_2_Left_541 VGND VGND VPWR VPWR sky130_fd_sc_hd__decap_3
XFILLER_215_111 VPWR VGND VPWR VGND sky130_ef_sc_hd__decap_12
XFILLER_243_431 VPWR VGND VPWR VGND sky130_ef_sc_hd__decap_12
XFILLER_3_1370 VGND VGND VPWR VPWR sky130_fd_sc_hd__decap_6
XFILLER_167_1033 VPWR VGND VPWR VGND sky130_ef_sc_hd__decap_12
XFILLER_249_1377 VPWR VGND VPWR VGND sky130_ef_sc_hd__decap_12
XFILLER_216_667 VPWR VGND VPWR VGND sky130_ef_sc_hd__decap_12
XFILLER_231_615 VPWR VGND VPWR VGND sky130_ef_sc_hd__decap_12
XFILLER_215_166 VGND VGND VPWR VPWR sky130_fd_sc_hd__decap_6
XFILLER_243_486 VPWR VGND VPWR VGND sky130_ef_sc_hd__decap_12
XFILLER_93_1230 VPWR VGND VPWR VGND sky130_ef_sc_hd__decap_12
XFILLER_188_519 VPWR VGND VPWR VGND sky130_ef_sc_hd__decap_12
XFILLER_167_1088 VPWR VGND VPWR VGND sky130_ef_sc_hd__decap_12
XFILLER_130_65 VGND VGND VPWR VPWR sky130_fd_sc_hd__decap_6
XFILLER_223_1506 VGND VGND VPWR VPWR sky130_fd_sc_hd__decap_8
XFILLER_169_744 VPWR VGND VPWR VGND sky130_ef_sc_hd__decap_12
XFILLER_184_1391 VGND VGND VPWR VPWR sky130_fd_sc_hd__decap_6
XFILLER_212_851 VPWR VGND VPWR VGND sky130_ef_sc_hd__decap_12
XFILLER_93_1285 VGND VGND VPWR VPWR sky130_fd_sc_hd__decap_6
XFILLER_142_3 VPWR VGND VPWR VGND sky130_ef_sc_hd__decap_12
XFILLER_90_58 VGND VGND VPWR VPWR sky130_fd_sc_hd__decap_6
XFILLER_19_1378 VPWR VGND VPWR VGND sky130_ef_sc_hd__decap_12
XFILLER_141_1206 VPWR VGND VPWR VGND sky130_ef_sc_hd__decap_12
XFILLER_184_703 VGND VGND VPWR VPWR sky130_fd_sc_hd__decap_6
XFILLER_106_1337 VPWR VGND VPWR VGND sky130_ef_sc_hd__decap_12
XTAP_TAPCELL_ROW_178_1977 VGND VPWR sky130_fd_sc_hd__tapvpwrvgnd_1
Xwire302 net303 VGND VGND VPWR VPWR net302 sky130_fd_sc_hd__clkbuf_1
XFILLER_169_799 VPWR VGND VPWR VGND sky130_ef_sc_hd__decap_12
XTAP_TAPCELL_ROW_178_1988 VGND VPWR sky130_fd_sc_hd__tapvpwrvgnd_1
XFILLER_196_574 VGND VGND VPWR VPWR sky130_fd_sc_hd__decap_6
Xwire313 net314 VGND VGND VPWR VPWR net313 sky130_fd_sc_hd__clkbuf_1
XTAP_TAPCELL_ROW_178_1999 VGND VPWR sky130_fd_sc_hd__tapvpwrvgnd_1
Xwire324 net325 VGND VGND VPWR VPWR net324 sky130_fd_sc_hd__clkbuf_1
XFILLER_8_949 VPWR VGND VPWR VGND sky130_ef_sc_hd__decap_12
XFILLER_221_1241 VGND VGND VPWR VPWR sky130_fd_sc_hd__decap_6
Xwire346 net347 VGND VGND VPWR VPWR net346 sky130_fd_sc_hd__clkbuf_1
Xwire357 net358 VGND VGND VPWR VPWR net357 sky130_fd_sc_hd__clkbuf_1
Xwire368 net369 VGND VGND VPWR VPWR net368 sky130_fd_sc_hd__clkbuf_1
Xwire379 net380 VGND VGND VPWR VPWR net379 sky130_fd_sc_hd__clkbuf_1
XFILLER_99_56 VPWR VGND VPWR VGND sky130_ef_sc_hd__decap_12
XFILLER_178_1140 VPWR VGND VPWR VGND sky130_ef_sc_hd__decap_12
XFILLER_174_1004 VGND VGND VPWR VPWR sky130_fd_sc_hd__decap_6
XFILLER_178_1195 VPWR VGND VPWR VGND sky130_ef_sc_hd__decap_12
XFILLER_2_120 VPWR VGND VPWR VGND sky130_ef_sc_hd__decap_12
XFILLER_2_175 VPWR VGND VPWR VGND sky130_ef_sc_hd__decap_12
XFILLER_117_1433 VPWR VGND VPWR VGND sky130_ef_sc_hd__decap_12
XFILLER_152_1313 VPWR VGND VPWR VGND sky130_ef_sc_hd__decap_12
XFILLER_61_1218 VPWR VGND VPWR VGND sky130_ef_sc_hd__decap_12
XPHY_EDGE_ROW_105_1_Left_360 VGND VGND VPWR VPWR sky130_fd_sc_hd__decap_3
XFILLER_215_1045 VPWR VGND VPWR VGND sky130_ef_sc_hd__decap_12
XFILLER_26_1349 VGND VGND VPWR VPWR sky130_fd_sc_hd__decap_6
XTAP_TAPCELL_ROW_162_2_5957 VGND VPWR sky130_fd_sc_hd__tapvpwrvgnd_1
XFILLER_117_1488 VPWR VGND VPWR VGND sky130_ef_sc_hd__decap_12
XFILLER_152_1368 VPWR VGND VPWR VGND sky130_ef_sc_hd__decap_12
XTAP_TAPCELL_ROW_98_2_5443 VGND VPWR sky130_fd_sc_hd__tapvpwrvgnd_1
XFILLER_8_1281 VPWR VGND VPWR VGND sky130_ef_sc_hd__decap_12
XFILLER_226_409 VPWR VGND VPWR VGND sky130_ef_sc_hd__decap_12
XTAP_TAPCELL_ROW_204_2900 VGND VPWR sky130_fd_sc_hd__tapvpwrvgnd_1
XTAP_TAPCELL_ROW_142_2_5800 VGND VPWR sky130_fd_sc_hd__tapvpwrvgnd_1
XTAP_TAPCELL_ROW_204_2911 VGND VPWR sky130_fd_sc_hd__tapvpwrvgnd_1
XFILLER_253_228 VPWR VGND VPWR VGND sky130_ef_sc_hd__decap_12
XFILLER_0_34 VGND VGND VPWR VPWR sky130_fd_sc_hd__decap_8
XFILLER_185_1100 VPWR VGND VPWR VGND sky130_ef_sc_hd__decap_12
XFILLER_246_280 VPWR VGND VPWR VGND sky130_ef_sc_hd__decap_12
XFILLER_0_1009 VPWR VGND VPWR VGND sky130_ef_sc_hd__decap_12
XFILLER_189_1291 VPWR VGND VPWR VGND sky130_ef_sc_hd__decap_12
XFILLER_206_144 VGND VGND VPWR VPWR sky130_fd_sc_hd__decap_6
XFILLER_98_1196 VPWR VGND VPWR VGND sky130_ef_sc_hd__decap_12
XFILLER_185_1155 VGND VGND VPWR VPWR sky130_fd_sc_hd__decap_6
XFILLER_207_689 VPWR VGND VPWR VGND sky130_ef_sc_hd__decap_12
XFILLER_234_464 VPWR VGND VPWR VGND sky130_ef_sc_hd__decap_12
XFILLER_222_648 VPWR VGND VPWR VGND sky130_ef_sc_hd__decap_12
XFILLER_250_968 VPWR VGND VPWR VGND sky130_ef_sc_hd__decap_12
XFILLER_72_1325 VPWR VGND VPWR VGND sky130_ef_sc_hd__decap_12
XFILLER_226_1152 VPWR VGND VPWR VGND sky130_ef_sc_hd__decap_12
XFILLER_37_1445 VPWR VGND VPWR VGND sky130_ef_sc_hd__decap_12
XFILLER_187_541 VPWR VGND VPWR VGND sky130_ef_sc_hd__decap_12
XTAP_TAPCELL_ROW_60_2_5144 VGND VPWR sky130_fd_sc_hd__tapvpwrvgnd_1
XFILLER_9_43 VPWR VGND VPWR VGND sky130_ef_sc_hd__decap_12
XFILLER_163_1464 VPWR VGND VPWR VGND sky130_ef_sc_hd__decap_12
XFILLER_203_873 VPWR VGND VPWR VGND sky130_ef_sc_hd__decap_12
XFILLER_9_76 VGND VGND VPWR VPWR sky130_fd_sc_hd__decap_8
XFILLER_175_725 VGND VGND VPWR VPWR sky130_fd_sc_hd__decap_6
XFILLER_187_596 VGND VGND VPWR VPWR sky130_fd_sc_hd__decap_6
XFILLER_200_1336 VPWR VGND VPWR VGND sky130_ef_sc_hd__decap_12
XTAP_TAPCELL_ROW_26_2_4868 VGND VPWR sky130_fd_sc_hd__tapvpwrvgnd_1
XFILLER_7_971 VPWR VGND VPWR VGND sky130_ef_sc_hd__decap_12
XTAP_TAPCELL_ROW_190_2399 VGND VPWR sky130_fd_sc_hd__tapvpwrvgnd_1
Xmax_cap613 rd_addr\[3\] VGND VGND VPWR VPWR net613 sky130_fd_sc_hd__clkbuf_1
Xmax_cap624 net625 VGND VGND VPWR VPWR net624 sky130_fd_sc_hd__clkbuf_2
XFILLER_196_1262 VGND VGND VPWR VPWR sky130_fd_sc_hd__decap_6
XFILLER_118_1208 VPWR VGND VPWR VGND sky130_ef_sc_hd__decap_12
XFILLER_170_452 VPWR VGND VPWR VGND sky130_ef_sc_hd__decap_12
XFILLER_83_1421 VPWR VGND VPWR VGND sky130_ef_sc_hd__decap_12
XFILLER_135_1500 VGND VGND VPWR VPWR sky130_fd_sc_hd__decap_6
XPHY_EDGE_ROW_37_1_Left_292 VGND VGND VPWR VPWR sky130_fd_sc_hd__decap_3
XFILLER_233_1112 VGND VGND VPWR VPWR sky130_fd_sc_hd__decap_6
XFILLER_83_1476 VPWR VGND VPWR VGND sky130_ef_sc_hd__decap_12
XFILLER_215_87 VPWR VGND VPWR VGND sky130_ef_sc_hd__decap_12
XFILLER_211_1432 VPWR VGND VPWR VGND sky130_ef_sc_hd__decap_12
XFILLER_244_206 VPWR VGND VPWR VGND sky130_ef_sc_hd__decap_12
XPHY_EDGE_ROW_206_Right_51 VGND VGND VPWR VPWR sky130_fd_sc_hd__decap_3
XFILLER_42_1184 VPWR VGND VPWR VGND sky130_ef_sc_hd__decap_12
XFILLER_211_1487 VPWR VGND VPWR VGND sky130_ef_sc_hd__decap_12
XFILLER_225_431 VPWR VGND VPWR VGND sky130_ef_sc_hd__decap_12
XFILLER_129_1304 VPWR VGND VPWR VGND sky130_ef_sc_hd__decap_12
XFILLER_213_615 VPWR VGND VPWR VGND sky130_ef_sc_hd__decap_12
XFILLER_252_261 VPWR VGND VPWR VGND sky130_ef_sc_hd__decap_12
XFILLER_225_486 VPWR VGND VPWR VGND sky130_ef_sc_hd__decap_12
XFILLER_198_839 VPWR VGND VPWR VGND sky130_ef_sc_hd__decap_12
XFILLER_129_1359 VPWR VGND VPWR VGND sky130_ef_sc_hd__decap_12
XFILLER_164_1239 VPWR VGND VPWR VGND sky130_ef_sc_hd__decap_12
XFILLER_197_338 VGND VGND VPWR VPWR sky130_fd_sc_hd__decap_6
XFILLER_240_445 VGND VGND VPWR VPWR sky130_fd_sc_hd__decap_6
XFILLER_100_46 VPWR VGND VPWR VGND sky130_ef_sc_hd__decap_12
XFILLER_166_703 VGND VGND VPWR VPWR sky130_fd_sc_hd__decap_6
XFILLER_221_670 VPWR VGND VPWR VGND sky130_ef_sc_hd__decap_12
XFILLER_178_574 VGND VGND VPWR VPWR sky130_fd_sc_hd__decap_6
XFILLER_165_202 VGND VGND VPWR VPWR sky130_fd_sc_hd__decap_8
XFILLER_14_1220 VGND VGND VPWR VPWR sky130_fd_sc_hd__decap_6
XPHY_EDGE_ROW_215_Right_60 VGND VGND VPWR VPWR sky130_fd_sc_hd__decap_3
XTAP_TAPCELL_ROW_214_3240 VGND VPWR sky130_fd_sc_hd__tapvpwrvgnd_1
XTAP_TAPCELL_ROW_214_3251 VGND VPWR sky130_fd_sc_hd__tapvpwrvgnd_1
XFILLER_101_1201 VGND VGND VPWR VPWR sky130_fd_sc_hd__decap_4
XFILLER_197_1026 VGND VGND VPWR VPWR sky130_fd_sc_hd__decap_6
XTAP_TAPCELL_ROW_214_3262 VGND VPWR sky130_fd_sc_hd__tapvpwrvgnd_1
XTAP_TAPCELL_ROW_210_3104 VGND VPWR sky130_fd_sc_hd__tapvpwrvgnd_1
XTAP_TAPCELL_ROW_233_3896 VGND VPWR sky130_fd_sc_hd__tapvpwrvgnd_1
XTAP_TAPCELL_ROW_210_3115 VGND VPWR sky130_fd_sc_hd__tapvpwrvgnd_1
XFILLER_109_44 VPWR VGND VPWR VGND sky130_ef_sc_hd__decap_12
XFILLER_140_1294 VPWR VGND VPWR VGND sky130_ef_sc_hd__decap_12
XFILLER_238_1023 VPWR VGND VPWR VGND sky130_ef_sc_hd__decap_12
XFILLER_49_1316 VPWR VGND VPWR VGND sky130_ef_sc_hd__decap_12
XFILLER_69_15 VPWR VGND VPWR VGND sky130_ef_sc_hd__decap_12
XFILLER_180_249 VPWR VGND VPWR VGND sky130_ef_sc_hd__decap_12
XFILLER_175_1346 VPWR VGND VPWR VGND sky130_ef_sc_hd__decap_12
XFILLER_238_1078 VPWR VGND VPWR VGND sky130_ef_sc_hd__decap_12
XTAP_TAPCELL_ROW_147_2_5837 VGND VPWR sky130_fd_sc_hd__tapvpwrvgnd_1
XTAP_TAPCELL_ROW_208_3022 VGND VPWR sky130_fd_sc_hd__tapvpwrvgnd_1
XTAP_TAPCELL_ROW_167_1601 VGND VPWR sky130_fd_sc_hd__tapvpwrvgnd_1
XTAP_TAPCELL_ROW_167_1612 VGND VPWR sky130_fd_sc_hd__tapvpwrvgnd_1
XTAP_TAPCELL_ROW_208_3033 VGND VPWR sky130_fd_sc_hd__tapvpwrvgnd_1
XTAP_TAPCELL_ROW_208_3044 VGND VPWR sky130_fd_sc_hd__tapvpwrvgnd_1
XFILLER_212_1207 VPWR VGND VPWR VGND sky130_ef_sc_hd__decap_12
XTAP_TAPCELL_ROW_227_3689 VGND VPWR sky130_fd_sc_hd__tapvpwrvgnd_1
XFILLER_216_1398 VPWR VGND VPWR VGND sky130_ef_sc_hd__decap_12
XFILLER_5_1432 VPWR VGND VPWR VGND sky130_ef_sc_hd__decap_12
XFILLER_208_409 VPWR VGND VPWR VGND sky130_ef_sc_hd__decap_12
XFILLER_60_1251 VPWR VGND VPWR VGND sky130_ef_sc_hd__decap_12
XFILLER_25_1371 VGND VGND VPWR VPWR sky130_fd_sc_hd__decap_6
XFILLER_151_1390 VPWR VGND VPWR VGND sky130_ef_sc_hd__decap_12
XFILLER_235_228 VPWR VGND VPWR VGND sky130_ef_sc_hd__decap_12
XFILLER_5_1487 VPWR VGND VPWR VGND sky130_ef_sc_hd__decap_12
XFILLER_228_280 VPWR VGND VPWR VGND sky130_ef_sc_hd__decap_12
XPHY_EDGE_ROW_46_2_Right_137 VGND VGND VPWR VPWR sky130_fd_sc_hd__decap_3
XFILLER_186_1453 VPWR VGND VPWR VGND sky130_ef_sc_hd__decap_12
XFILLER_216_464 VPWR VGND VPWR VGND sky130_ef_sc_hd__decap_12
XFILLER_249_1174 VPWR VGND VPWR VGND sky130_ef_sc_hd__decap_12
XFILLER_95_1347 VPWR VGND VPWR VGND sky130_ef_sc_hd__decap_12
XFILLER_231_412 VPWR VGND VPWR VGND sky130_ef_sc_hd__decap_12
XFILLER_243_283 VPWR VGND VPWR VGND sky130_ef_sc_hd__decap_12
XFILLER_188_316 VGND VGND VPWR VPWR sky130_fd_sc_hd__decap_6
XTAP_TAPCELL_ROW_45_2_5024 VGND VPWR sky130_fd_sc_hd__tapvpwrvgnd_1
XFILLER_204_648 VPWR VGND VPWR VGND sky130_ef_sc_hd__decap_12
XFILLER_232_968 VPWR VGND VPWR VGND sky130_ef_sc_hd__decap_12
XFILLER_223_1303 VPWR VGND VPWR VGND sky130_ef_sc_hd__decap_12
XFILLER_231_467 VGND VGND VPWR VPWR sky130_fd_sc_hd__decap_6
XFILLER_169_541 VPWR VGND VPWR VGND sky130_ef_sc_hd__decap_12
XFILLER_197_861 VPWR VGND VPWR VGND sky130_ef_sc_hd__decap_12
XFILLER_200_832 VGND VGND VPWR VPWR sky130_fd_sc_hd__decap_6
XFILLER_223_1358 VPWR VGND VPWR VGND sky130_ef_sc_hd__decap_12
XFILLER_169_596 VGND VGND VPWR VPWR sky130_fd_sc_hd__decap_6
XTAP_TAPCELL_ROW_12_2_4754 VGND VPWR sky130_fd_sc_hd__tapvpwrvgnd_1
Xwire143 net144 VGND VGND VPWR VPWR net143 sky130_fd_sc_hd__clkbuf_1
XFILLER_7_245 VGND VGND VPWR VPWR sky130_fd_sc_hd__fill_1
Xwire154 _174_ VGND VGND VPWR VPWR net154 sky130_fd_sc_hd__clkbuf_1
XFILLER_7_256 VGND VGND VPWR VPWR sky130_fd_sc_hd__fill_2
Xwire165 _143_ VGND VGND VPWR VPWR net165 sky130_fd_sc_hd__clkbuf_1
XFILLER_171_216 VPWR VGND VPWR VGND sky130_ef_sc_hd__decap_12
XFILLER_193_1413 VGND VGND VPWR VPWR sky130_fd_sc_hd__decap_6
XFILLER_3_451 VGND VGND VPWR VPWR sky130_fd_sc_hd__fill_1
XFILLER_234_1410 VPWR VGND VPWR VGND sky130_ef_sc_hd__decap_12
XFILLER_117_1230 VPWR VGND VPWR VGND sky130_ef_sc_hd__decap_12
XFILLER_234_1465 VPWR VGND VPWR VGND sky130_ef_sc_hd__decap_12
XFILLER_6_1207 VPWR VGND VPWR VGND sky130_ef_sc_hd__decap_12
XFILLER_117_1285 VGND VGND VPWR VPWR sky130_fd_sc_hd__decap_6
XFILLER_152_1165 VPWR VGND VPWR VGND sky130_ef_sc_hd__decap_12
XTAP_TAPCELL_ROW_183_2170 VGND VPWR sky130_fd_sc_hd__tapvpwrvgnd_1
XFILLER_226_206 VPWR VGND VPWR VGND sky130_ef_sc_hd__decap_12
XFILLER_187_1217 VPWR VGND VPWR VGND sky130_ef_sc_hd__decap_12
XFILLER_207_431 VPWR VGND VPWR VGND sky130_ef_sc_hd__decap_12
XFILLER_130_1485 VPWR VGND VPWR VGND sky130_ef_sc_hd__decap_12
XFILLER_241_209 VGND VGND VPWR VPWR sky130_fd_sc_hd__decap_6
XFILLER_39_1507 VGND VGND VPWR VPWR sky130_fd_sc_hd__decap_8
XFILLER_165_1504 VGND VGND VPWR VPWR sky130_fd_sc_hd__decap_8
XFILLER_250_710 VPWR VGND VPWR VGND sky130_ef_sc_hd__decap_12
XFILLER_234_261 VPWR VGND VPWR VGND sky130_ef_sc_hd__decap_12
XFILLER_207_486 VPWR VGND VPWR VGND sky130_ef_sc_hd__decap_12
XFILLER_228_1269 VPWR VGND VPWR VGND sky130_ef_sc_hd__decap_12
XFILLER_179_338 VGND VGND VPWR VPWR sky130_fd_sc_hd__decap_6
XFILLER_201_56 VPWR VGND VPWR VGND sky130_ef_sc_hd__decap_12
XFILLER_222_445 VGND VGND VPWR VPWR sky130_fd_sc_hd__decap_6
XFILLER_250_765 VPWR VGND VPWR VGND sky130_ef_sc_hd__decap_12
XFILLER_37_1242 VGND VGND VPWR VPWR sky130_fd_sc_hd__decap_6
XFILLER_203_670 VPWR VGND VPWR VGND sky130_ef_sc_hd__decap_12
XFILLER_163_1261 VPWR VGND VPWR VGND sky130_ef_sc_hd__decap_12
XFILLER_231_990 VPWR VGND VPWR VGND sky130_ef_sc_hd__decap_12
XFILLER_128_1392 VGND VGND VPWR VPWR sky130_fd_sc_hd__decap_6
XFILLER_188_894 VPWR VGND VPWR VGND sky130_ef_sc_hd__decap_12
XFILLER_72_1177 VGND VGND VPWR VPWR sky130_fd_sc_hd__decap_6
XFILLER_198_1324 VPWR VGND VPWR VGND sky130_ef_sc_hd__decap_12
XFILLER_50_1442 VPWR VGND VPWR VGND sky130_ef_sc_hd__decap_12
XFILLER_200_1133 VGND VGND VPWR VPWR sky130_fd_sc_hd__decap_6
XTAP_TAPCELL_ROW_90_2_5383 VGND VPWR sky130_fd_sc_hd__tapvpwrvgnd_1
XFILLER_198_1379 VPWR VGND VPWR VGND sky130_ef_sc_hd__decap_12
XTAP_TAPCELL_ROW_89_2_5377 VGND VPWR sky130_fd_sc_hd__tapvpwrvgnd_1
XFILLER_50_1497 VPWR VGND VPWR VGND sky130_ef_sc_hd__decap_12
XTAP_TAPCELL_ROW_133_2_5723 VGND VPWR sky130_fd_sc_hd__tapvpwrvgnd_1
XTAP_TAPCELL_ROW_102_2_5481 VGND VPWR sky130_fd_sc_hd__tapvpwrvgnd_1
XFILLER_172_1508 VGND VGND VPWR VPWR sky130_fd_sc_hd__decap_6
XFILLER_235_1229 VPWR VGND VPWR VGND sky130_ef_sc_hd__decap_12
Xmax_cap498 _121_ VGND VGND VPWR VPWR net498 sky130_fd_sc_hd__clkbuf_1
XFILLER_83_1273 VPWR VGND VPWR VGND sky130_ef_sc_hd__decap_12
XPHY_EDGE_ROW_34_1_Right_690 VGND VGND VPWR VPWR sky130_fd_sc_hd__decap_3
XTAP_TAPCELL_ROW_36_2_4950 VGND VPWR sky130_fd_sc_hd__tapvpwrvgnd_1
XTAP_TAPCELL_ROW_51_2_5067 VGND VPWR sky130_fd_sc_hd__tapvpwrvgnd_1
XTAP_TAPCELL_ROW_222_3520 VGND VPWR sky130_fd_sc_hd__tapvpwrvgnd_1
XFILLER_131_1249 VPWR VGND VPWR VGND sky130_ef_sc_hd__decap_12
XTAP_TAPCELL_ROW_222_3531 VGND VPWR sky130_fd_sc_hd__tapvpwrvgnd_1
XTAP_TAPCELL_ROW_1_900 VGND VPWR sky130_fd_sc_hd__tapvpwrvgnd_1
XFILLER_217_228 VPWR VGND VPWR VGND sky130_ef_sc_hd__decap_12
XTAP_TAPCELL_ROW_222_3542 VGND VPWR sky130_fd_sc_hd__tapvpwrvgnd_1
XTAP_TAPCELL_ROW_1_911 VGND VPWR sky130_fd_sc_hd__tapvpwrvgnd_1
XTAP_TAPCELL_ROW_1_922 VGND VPWR sky130_fd_sc_hd__tapvpwrvgnd_1
XFILLER_55_39 VGND VGND VPWR VPWR sky130_fd_sc_hd__decap_4
XFILLER_211_1284 VGND VGND VPWR VPWR sky130_fd_sc_hd__decap_6
XFILLER_213_412 VPWR VGND VPWR VGND sky130_ef_sc_hd__decap_12
XFILLER_246_1336 VPWR VGND VPWR VGND sky130_ef_sc_hd__decap_12
XFILLER_92_1509 VGND VGND VPWR VPWR sky130_fd_sc_hd__decap_6
XFILLER_241_732 VPWR VGND VPWR VGND sky130_ef_sc_hd__decap_12
XFILLER_168_1183 VPWR VGND VPWR VGND sky130_ef_sc_hd__decap_12
XFILLER_225_283 VPWR VGND VPWR VGND sky130_ef_sc_hd__decap_12
XFILLER_198_636 VPWR VGND VPWR VGND sky130_ef_sc_hd__decap_12
XFILLER_111_56 VPWR VGND VPWR VGND sky130_ef_sc_hd__decap_12
XFILLER_214_968 VPWR VGND VPWR VGND sky130_ef_sc_hd__decap_12
XFILLER_71_27 VPWR VGND VPWR VGND sky130_ef_sc_hd__decap_12
XFILLER_94_1380 VPWR VGND VPWR VGND sky130_ef_sc_hd__decap_12
XFILLER_213_467 VGND VGND VPWR VPWR sky130_fd_sc_hd__decap_6
XFILLER_241_787 VPWR VGND VPWR VGND sky130_ef_sc_hd__decap_12
XFILLER_129_1189 VPWR VGND VPWR VGND sky130_ef_sc_hd__decap_12
XTAP_TAPCELL_ROW_216_3302 VGND VPWR sky130_fd_sc_hd__tapvpwrvgnd_1
XFILLER_107_1421 VPWR VGND VPWR VGND sky130_ef_sc_hd__decap_12
XFILLER_179_861 VPWR VGND VPWR VGND sky130_ef_sc_hd__decap_12
XTAP_TAPCELL_ROW_216_3313 VGND VPWR sky130_fd_sc_hd__tapvpwrvgnd_1
XTAP_TAPCELL_ROW_216_3324 VGND VPWR sky130_fd_sc_hd__tapvpwrvgnd_1
XFILLER_51_1206 VPWR VGND VPWR VGND sky130_ef_sc_hd__decap_12
XFILLER_187_27 VPWR VGND VPWR VGND sky130_ef_sc_hd__decap_12
XFILLER_205_1033 VPWR VGND VPWR VGND sky130_ef_sc_hd__decap_12
XFILLER_16_1337 VPWR VGND VPWR VGND sky130_ef_sc_hd__decap_12
XFILLER_194_820 VPWR VGND VPWR VGND sky130_ef_sc_hd__decap_12
XTAP_TAPCELL_ROW_235_3969 VGND VPWR sky130_fd_sc_hd__tapvpwrvgnd_1
XFILLER_107_1476 VPWR VGND VPWR VGND sky130_ef_sc_hd__decap_12
XFILLER_142_1356 VPWR VGND VPWR VGND sky130_ef_sc_hd__decap_12
XFILLER_205_1088 VPWR VGND VPWR VGND sky130_ef_sc_hd__decap_12
XFILLER_194_875 VGND VGND VPWR VPWR sky130_fd_sc_hd__decap_6
XFILLER_222_1391 VGND VGND VPWR VPWR sky130_fd_sc_hd__decap_6
XFILLER_5_749 VGND VGND VPWR VPWR sky130_fd_sc_hd__decap_6
XFILLER_4_237 VGND VGND VPWR VPWR sky130_fd_sc_hd__decap_6
XFILLER_105_3 VPWR VGND VPWR VGND sky130_ef_sc_hd__decap_12
XFILLER_88_1184 VPWR VGND VPWR VGND sky130_ef_sc_hd__decap_12
XFILLER_175_1143 VPWR VGND VPWR VGND sky130_ef_sc_hd__decap_12
XFILLER_0_421 VGND VGND VPWR VPWR sky130_fd_sc_hd__fill_1
XFILLER_175_1198 VGND VGND VPWR VPWR sky130_fd_sc_hd__decap_6
XFILLER_62_1313 VPWR VGND VPWR VGND sky130_ef_sc_hd__decap_12
XFILLER_27_1433 VPWR VGND VPWR VGND sky130_ef_sc_hd__decap_12
XFILLER_96_46 VPWR VGND VPWR VGND sky130_ef_sc_hd__decap_12
XFILLER_216_1140 VPWR VGND VPWR VGND sky130_ef_sc_hd__decap_12
XFILLER_249_854 VGND VGND VPWR VPWR sky130_fd_sc_hd__decap_6
XFILLER_212_1004 VGND VGND VPWR VPWR sky130_fd_sc_hd__decap_6
XFILLER_62_1368 VPWR VGND VPWR VGND sky130_ef_sc_hd__decap_12
XFILLER_27_1488 VPWR VGND VPWR VGND sky130_ef_sc_hd__decap_12
XFILLER_216_1195 VPWR VGND VPWR VGND sky130_ef_sc_hd__decap_12
XFILLER_208_206 VPWR VGND VPWR VGND sky130_ef_sc_hd__decap_12
XFILLER_5_1284 VGND VGND VPWR VPWR sky130_fd_sc_hd__decap_6
X_664_ clknet_3_5__leaf_clk acc_core.adder.cla_blocks\[7\].block.sum\[2\] _072_ VGND
+ VGND VPWR VPWR net66 sky130_fd_sc_hd__dfrtp_1
XFILLER_223_209 VGND VGND VPWR VPWR sky130_fd_sc_hd__decap_6
XFILLER_251_529 VPWR VGND VPWR VGND sky130_ef_sc_hd__decap_12
XFILLER_147_1201 VGND VGND VPWR VPWR sky130_fd_sc_hd__decap_4
XFILLER_186_1250 VPWR VGND VPWR VGND sky130_ef_sc_hd__decap_12
XPHY_EDGE_ROW_47_2_Right_138 VGND VGND VPWR VPWR sky130_fd_sc_hd__decap_3
XFILLER_189_603 VPWR VGND VPWR VGND sky130_ef_sc_hd__decap_12
XFILLER_216_261 VPWR VGND VPWR VGND sky130_ef_sc_hd__decap_12
XFILLER_232_710 VPWR VGND VPWR VGND sky130_ef_sc_hd__decap_12
XFILLER_244_581 VPWR VGND VPWR VGND sky130_ef_sc_hd__decap_12
X_595_ clknet_3_2__leaf_clk _077_ _003_ VGND VGND VPWR VPWR rd_addr\[3\] sky130_fd_sc_hd__dfrtp_1
XFILLER_95_1177 VPWR VGND VPWR VGND sky130_ef_sc_hd__decap_12
XFILLER_204_445 VGND VGND VPWR VPWR sky130_fd_sc_hd__decap_6
XFILLER_189_658 VPWR VGND VPWR VGND sky130_ef_sc_hd__decap_12
XFILLER_232_765 VPWR VGND VPWR VGND sky130_ef_sc_hd__decap_12
XFILLER_223_1100 VPWR VGND VPWR VGND sky130_ef_sc_hd__decap_12
XFILLER_220_949 VPWR VGND VPWR VGND sky130_ef_sc_hd__decap_12
XFILLER_73_1464 VPWR VGND VPWR VGND sky130_ef_sc_hd__decap_12
XFILLER_213_990 VPWR VGND VPWR VGND sky130_ef_sc_hd__decap_12
XFILLER_227_1291 VPWR VGND VPWR VGND sky130_ef_sc_hd__decap_12
XFILLER_160_1423 VPWR VGND VPWR VGND sky130_ef_sc_hd__decap_12
XFILLER_185_842 VPWR VGND VPWR VGND sky130_ef_sc_hd__decap_12
XFILLER_223_1155 VGND VGND VPWR VPWR sky130_fd_sc_hd__decap_6
XTAP_TAPCELL_ROW_75_2_5263 VGND VPWR sky130_fd_sc_hd__tapvpwrvgnd_1
XTAP_TAPCELL_ROW_191_2450 VGND VPWR sky130_fd_sc_hd__tapvpwrvgnd_1
XFILLER_160_1478 VGND VGND VPWR VPWR sky130_fd_sc_hd__decap_6
XFILLER_201_1420 VPWR VGND VPWR VGND sky130_ef_sc_hd__decap_12
XTAP_TAPCELL_ROW_118_2_5603 VGND VPWR sky130_fd_sc_hd__tapvpwrvgnd_1
XFILLER_185_897 VGND VGND VPWR VPWR sky130_fd_sc_hd__decap_6
XFILLER_6_22 VPWR VGND VPWR VGND sky130_ef_sc_hd__decap_12
XANTENNA_4 dout0\[7\] VGND VGND VPWR VPWR sky130_fd_sc_hd__diode_2
XFILLER_201_1475 VPWR VGND VPWR VGND sky130_ef_sc_hd__decap_12
XFILLER_6_77 VPWR VGND VPWR VGND sky130_ef_sc_hd__decap_12
XFILLER_4_760 VGND VGND VPWR VPWR sky130_fd_sc_hd__fill_1
XFILLER_28_1208 VPWR VGND VPWR VGND sky130_ef_sc_hd__decap_12
XFILLER_45_1500 VGND VGND VPWR VPWR sky130_fd_sc_hd__decap_6
XFILLER_154_1227 VPWR VGND VPWR VGND sky130_ef_sc_hd__decap_12
XFILLER_119_1347 VPWR VGND VPWR VGND sky130_ef_sc_hd__decap_12
XTAP_TAPCELL_ROW_185_2221 VGND VPWR sky130_fd_sc_hd__tapvpwrvgnd_1
XTAP_TAPCELL_ROW_185_2232 VGND VPWR sky130_fd_sc_hd__tapvpwrvgnd_1
XTAP_TAPCELL_ROW_185_2243 VGND VPWR sky130_fd_sc_hd__tapvpwrvgnd_1
XFILLER_80_1435 VGND VGND VPWR VPWR sky130_fd_sc_hd__decap_6
XFILLER_234_1262 VGND VGND VPWR VPWR sky130_fd_sc_hd__decap_6
XFILLER_6_1004 VGND VGND VPWR VPWR sky130_fd_sc_hd__decap_6
XTAP_TAPCELL_ROW_181_2107 VGND VPWR sky130_fd_sc_hd__tapvpwrvgnd_1
XFILLER_20_3 VPWR VGND VPWR VGND sky130_ef_sc_hd__decap_12
XFILLER_254_323 VPWR VGND VPWR VGND sky130_ef_sc_hd__decap_12
XFILLER_187_1014 VPWR VGND VPWR VGND sky130_ef_sc_hd__decap_12
XFILLER_212_22 VPWR VGND VPWR VGND sky130_ef_sc_hd__decap_12
XFILLER_242_507 VPWR VGND VPWR VGND sky130_ef_sc_hd__decap_12
XFILLER_254_378 VPWR VGND VPWR VGND sky130_ef_sc_hd__decap_12
XFILLER_130_1282 VPWR VGND VPWR VGND sky130_ef_sc_hd__decap_12
XFILLER_187_1069 VGND VGND VPWR VPWR sky130_fd_sc_hd__decap_6
XFILLER_39_1304 VPWR VGND VPWR VGND sky130_ef_sc_hd__decap_12
XTAP_TAPCELL_ROW_179_2014 VGND VPWR sky130_fd_sc_hd__tapvpwrvgnd_1
XFILLER_228_1011 VPWR VGND VPWR VGND sky130_ef_sc_hd__decap_12
XTAP_TAPCELL_ROW_179_2025 VGND VPWR sky130_fd_sc_hd__tapvpwrvgnd_1
XFILLER_207_283 VPWR VGND VPWR VGND sky130_ef_sc_hd__decap_12
XFILLER_212_77 VPWR VGND VPWR VGND sky130_ef_sc_hd__decap_12
XFILLER_223_732 VPWR VGND VPWR VGND sky130_ef_sc_hd__decap_12
XTAP_TAPCELL_ROW_179_2036 VGND VPWR sky130_fd_sc_hd__tapvpwrvgnd_1
XFILLER_165_1345 VPWR VGND VPWR VGND sky130_ef_sc_hd__decap_12
XFILLER_39_1359 VPWR VGND VPWR VGND sky130_ef_sc_hd__decap_12
XFILLER_74_1239 VPWR VGND VPWR VGND sky130_ef_sc_hd__decap_12
XFILLER_228_1066 VPWR VGND VPWR VGND sky130_ef_sc_hd__decap_12
XFILLER_211_916 VPWR VGND VPWR VGND sky130_ef_sc_hd__decap_12
XFILLER_250_562 VPWR VGND VPWR VGND sky130_ef_sc_hd__decap_12
XFILLER_223_787 VPWR VGND VPWR VGND sky130_ef_sc_hd__decap_12
XFILLER_165_1378 VGND VGND VPWR VPWR sky130_fd_sc_hd__decap_8
XFILLER_176_820 VPWR VGND VPWR VGND sky130_ef_sc_hd__decap_12
XFILLER_195_639 VGND VGND VPWR VPWR sky130_fd_sc_hd__decap_6
XFILLER_188_691 VPWR VGND VPWR VGND sky130_ef_sc_hd__decap_12
XFILLER_198_1121 VPWR VGND VPWR VGND sky130_ef_sc_hd__decap_12
XTAP_TAPCELL_ROW_230_3800 VGND VPWR sky130_fd_sc_hd__tapvpwrvgnd_1
XFILLER_176_875 VGND VGND VPWR VPWR sky130_fd_sc_hd__decap_6
XTAP_TAPCELL_ROW_230_3811 VGND VPWR sky130_fd_sc_hd__tapvpwrvgnd_1
XTAP_TAPCELL_ROW_230_3822 VGND VPWR sky130_fd_sc_hd__tapvpwrvgnd_1
XFILLER_11_1201 VGND VGND VPWR VPWR sky130_fd_sc_hd__decap_4
XFILLER_198_1176 VGND VGND VPWR VPWR sky130_fd_sc_hd__decap_6
XFILLER_50_1294 VPWR VGND VPWR VGND sky130_ef_sc_hd__decap_12
XPHY_EDGE_ROW_48_2_Left_550 VGND VGND VPWR VPWR sky130_fd_sc_hd__decap_3
XFILLER_176_1441 VPWR VGND VPWR VGND sky130_ef_sc_hd__decap_12
XFILLER_190_366 VPWR VGND VPWR VGND sky130_ef_sc_hd__decap_12
XFILLER_239_1162 VPWR VGND VPWR VGND sky130_ef_sc_hd__decap_12
XFILLER_85_1335 VPWR VGND VPWR VGND sky130_ef_sc_hd__decap_12
XFILLER_137_1414 VGND VGND VPWR VPWR sky130_fd_sc_hd__decap_6
XFILLER_172_1305 VGND VGND VPWR VPWR sky130_fd_sc_hd__decap_6
XFILLER_235_1026 VGND VGND VPWR VPWR sky130_fd_sc_hd__decap_6
XFILLER_176_1496 VPWR VGND VPWR VGND sky130_ef_sc_hd__decap_12
XTAP_TAPCELL_ROW_228_3740 VGND VPWR sky130_fd_sc_hd__tapvpwrvgnd_1
XTAP_TAPCELL_ROW_228_3751 VGND VPWR sky130_fd_sc_hd__tapvpwrvgnd_1
XFILLER_106_34 VPWR VGND VPWR VGND sky130_ef_sc_hd__decap_12
XTAP_TAPCELL_ROW_163_2_5962 VGND VPWR sky130_fd_sc_hd__tapvpwrvgnd_1
XTAP_TAPCELL_ROW_224_3604 VGND VPWR sky130_fd_sc_hd__tapvpwrvgnd_1
XFILLER_213_1346 VPWR VGND VPWR VGND sky130_ef_sc_hd__decap_12
XPHY_EDGE_ROW_35_1_Right_691 VGND VGND VPWR VPWR sky130_fd_sc_hd__decap_3
XFILLER_245_345 VPWR VGND VPWR VGND sky130_ef_sc_hd__decap_12
XFILLER_61_1390 VPWR VGND VPWR VGND sky130_ef_sc_hd__decap_12
XFILLER_122_22 VPWR VGND VPWR VGND sky130_ef_sc_hd__decap_12
XFILLER_205_209 VGND VGND VPWR VPWR sky130_fd_sc_hd__decap_6
XFILLER_166_1109 VPWR VGND VPWR VGND sky130_ef_sc_hd__decap_12
XFILLER_96_1442 VPWR VGND VPWR VGND sky130_ef_sc_hd__decap_12
XFILLER_214_710 VPWR VGND VPWR VGND sky130_ef_sc_hd__decap_12
XFILLER_233_529 VPWR VGND VPWR VGND sky130_ef_sc_hd__decap_12
XFILLER_82_15 VGND VGND VPWR VPWR sky130_fd_sc_hd__decap_6
XFILLER_183_1401 VPWR VGND VPWR VGND sky130_ef_sc_hd__decap_12
XFILLER_226_581 VPWR VGND VPWR VGND sky130_ef_sc_hd__decap_12
XFILLER_246_1133 VGND VGND VPWR VPWR sky130_fd_sc_hd__decap_6
XFILLER_92_1306 VGND VGND VPWR VPWR sky130_fd_sc_hd__decap_6
XFILLER_198_15 VGND VGND VPWR VPWR sky130_fd_sc_hd__decap_6
XFILLER_96_1497 VPWR VGND VPWR VGND sky130_ef_sc_hd__decap_12
XFILLER_198_433 VPWR VGND VPWR VGND sky130_ef_sc_hd__decap_12
XFILLER_214_765 VPWR VGND VPWR VGND sky130_ef_sc_hd__decap_12
X_380_ net592 net581 net554 VGND VGND VPWR VPWR _169_ sky130_fd_sc_hd__a21o_1
XTAP_TAPCELL_ROW_124_2_5657 VGND VPWR sky130_fd_sc_hd__tapvpwrvgnd_1
XFILLER_183_1456 VGND VGND VPWR VPWR sky130_fd_sc_hd__decap_6
XFILLER_15_42 VGND VGND VPWR VPWR sky130_fd_sc_hd__fill_1
XFILLER_241_584 VPWR VGND VPWR VGND sky130_ef_sc_hd__decap_12
XFILLER_186_617 VGND VGND VPWR VPWR sky130_fd_sc_hd__decap_6
XFILLER_202_949 VPWR VGND VPWR VGND sky130_ef_sc_hd__decap_12
XFILLER_198_488 VGND VGND VPWR VPWR sky130_fd_sc_hd__decap_6
XFILLER_224_1453 VPWR VGND VPWR VGND sky130_ef_sc_hd__decap_12
XFILLER_167_842 VPWR VGND VPWR VGND sky130_ef_sc_hd__decap_12
XFILLER_107_1273 VPWR VGND VPWR VGND sky130_ef_sc_hd__decap_12
XFILLER_222_3 VPWR VGND VPWR VGND sky130_ef_sc_hd__decap_12
XFILLER_167_897 VGND VGND VPWR VPWR sky130_fd_sc_hd__decap_6
XFILLER_177_1205 VPWR VGND VPWR VGND sky130_ef_sc_hd__decap_12
XTAP_TAPCELL_ROW_61_1_1321 VGND VPWR sky130_fd_sc_hd__tapvpwrvgnd_1
XFILLER_5_557 VGND VGND VPWR VPWR sky130_fd_sc_hd__fill_2
XFILLER_181_388 VPWR VGND VPWR VGND sky130_ef_sc_hd__decap_12
Xoutput52 net538 VGND VGND VPWR VPWR acc_out[18] sky130_fd_sc_hd__buf_2
XFILLER_1_730 VGND VGND VPWR VPWR sky130_fd_sc_hd__fill_1
XFILLER_116_1509 VGND VGND VPWR VPWR sky130_fd_sc_hd__decap_6
Xoutput63 net63 VGND VGND VPWR VPWR acc_out[28] sky130_fd_sc_hd__buf_2
Xoutput74 net74 VGND VGND VPWR VPWR acc_out[9] sky130_fd_sc_hd__buf_2
XFILLER_27_1230 VPWR VGND VPWR VGND sky130_ef_sc_hd__decap_12
XFILLER_231_1413 VGND VGND VPWR VPWR sky130_fd_sc_hd__decap_6
XFILLER_118_1380 VPWR VGND VPWR VGND sky130_ef_sc_hd__decap_12
XFILLER_62_1165 VPWR VGND VPWR VGND sky130_ef_sc_hd__decap_12
XFILLER_7_1346 VPWR VGND VPWR VGND sky130_ef_sc_hd__decap_12
XFILLER_27_1285 VGND VGND VPWR VPWR sky130_fd_sc_hd__decap_6
XTAP_TAPCELL_ROW_240_4140 VGND VPWR sky130_fd_sc_hd__tapvpwrvgnd_1
XFILLER_0_295 VPWR VGND VPWR VGND sky130_ef_sc_hd__decap_12
XTAP_TAPCELL_ROW_240_4151 VGND VPWR sky130_fd_sc_hd__tapvpwrvgnd_1
XTAP_TAPCELL_ROW_240_4162 VGND VPWR sky130_fd_sc_hd__tapvpwrvgnd_1
XFILLER_188_1312 VPWR VGND VPWR VGND sky130_ef_sc_hd__decap_12
XTAP_TAPCELL_ROW_240_4173 VGND VPWR sky130_fd_sc_hd__tapvpwrvgnd_1
XFILLER_97_1206 VPWR VGND VPWR VGND sky130_ef_sc_hd__decap_12
XFILLER_236_323 VPWR VGND VPWR VGND sky130_ef_sc_hd__decap_12
XFILLER_248_194 VPWR VGND VPWR VGND sky130_ef_sc_hd__decap_12
XFILLER_224_507 VPWR VGND VPWR VGND sky130_ef_sc_hd__decap_12
XFILLER_188_1367 VPWR VGND VPWR VGND sky130_ef_sc_hd__decap_12
XFILLER_236_378 VPWR VGND VPWR VGND sky130_ef_sc_hd__decap_12
XFILLER_40_1485 VPWR VGND VPWR VGND sky130_ef_sc_hd__decap_12
XFILLER_251_326 VPWR VGND VPWR VGND sky130_ef_sc_hd__decap_12
X_647_ clknet_3_6__leaf_clk acc_core.adder.cla_blocks\[3\].block.sum\[1\] _055_ VGND
+ VGND VPWR VPWR net47 sky130_fd_sc_hd__dfrtp_1
XFILLER_189_400 VPWR VGND VPWR VGND sky130_ef_sc_hd__decap_12
XFILLER_205_732 VPWR VGND VPWR VGND sky130_ef_sc_hd__decap_12
XPHY_EDGE_ROW_48_2_Right_139 VGND VGND VPWR VPWR sky130_fd_sc_hd__decap_3
X_578_ net668 VGND VGND VPWR VPWR _060_ sky130_fd_sc_hd__inv_2
XFILLER_189_455 VPWR VGND VPWR VGND sky130_ef_sc_hd__decap_12
XFILLER_225_1217 VPWR VGND VPWR VGND sky130_ef_sc_hd__decap_12
XFILLER_232_562 VPWR VGND VPWR VGND sky130_ef_sc_hd__decap_12
XTAP_TAPCELL_ROW_238_4080 VGND VPWR sky130_fd_sc_hd__tapvpwrvgnd_1
XTAP_TAPCELL_ROW_193_2501 VGND VPWR sky130_fd_sc_hd__tapvpwrvgnd_1
XTAP_TAPCELL_ROW_201_2777 VGND VPWR sky130_fd_sc_hd__tapvpwrvgnd_1
XFILLER_205_787 VPWR VGND VPWR VGND sky130_ef_sc_hd__decap_12
XTAP_TAPCELL_ROW_238_4091 VGND VPWR sky130_fd_sc_hd__tapvpwrvgnd_1
XTAP_TAPCELL_ROW_193_2512 VGND VPWR sky130_fd_sc_hd__tapvpwrvgnd_1
XTAP_TAPCELL_ROW_201_2788 VGND VPWR sky130_fd_sc_hd__tapvpwrvgnd_1
XTAP_TAPCELL_ROW_201_2799 VGND VPWR sky130_fd_sc_hd__tapvpwrvgnd_1
XTAP_TAPCELL_ROW_193_2523 VGND VPWR sky130_fd_sc_hd__tapvpwrvgnd_1
XFILLER_177_639 VGND VGND VPWR VPWR sky130_fd_sc_hd__decap_6
XFILLER_220_746 VGND VGND VPWR VPWR sky130_fd_sc_hd__decap_6
XFILLER_73_1261 VPWR VGND VPWR VGND sky130_ef_sc_hd__decap_12
XFILLER_38_1392 VGND VGND VPWR VPWR sky130_fd_sc_hd__decap_6
XFILLER_160_1220 VGND VGND VPWR VPWR sky130_fd_sc_hd__decap_6
XFILLER_9_841 VPWR VGND VPWR VGND sky130_ef_sc_hd__decap_12
XFILLER_201_971 VPWR VGND VPWR VGND sky130_ef_sc_hd__decap_12
XFILLER_9_874 VGND VGND VPWR VPWR sky130_fd_sc_hd__decap_8
XFILLER_8_362 VGND VGND VPWR VPWR sky130_fd_sc_hd__decap_3
XFILLER_199_1463 VPWR VGND VPWR VGND sky130_ef_sc_hd__decap_12
XFILLER_68_3 VPWR VGND VPWR VGND sky130_ef_sc_hd__decap_12
XFILLER_195_1327 VGND VGND VPWR VPWR sky130_fd_sc_hd__decap_6
XFILLER_201_1272 VPWR VGND VPWR VGND sky130_ef_sc_hd__decap_12
XFILLER_172_366 VPWR VGND VPWR VGND sky130_ef_sc_hd__decap_12
XTAP_TAPCELL_ROW_187_2305 VGND VPWR sky130_fd_sc_hd__tapvpwrvgnd_1
XTAP_TAPCELL_ROW_187_2316 VGND VPWR sky130_fd_sc_hd__tapvpwrvgnd_1
XFILLER_236_1324 VPWR VGND VPWR VGND sky130_ef_sc_hd__decap_12
XTAP_TAPCELL_ROW_148_2_5842 VGND VPWR sky130_fd_sc_hd__tapvpwrvgnd_1
XFILLER_207_44 VPWR VGND VPWR VGND sky130_ef_sc_hd__decap_12
XFILLER_236_1379 VPWR VGND VPWR VGND sky130_ef_sc_hd__decap_12
XFILLER_119_1177 VPWR VGND VPWR VGND sky130_ef_sc_hd__decap_12
XFILLER_207_99 VPWR VGND VPWR VGND sky130_ef_sc_hd__decap_12
.ends
