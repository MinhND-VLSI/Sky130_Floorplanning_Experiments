* NGSPICE file created from acc32_sram.ext - technology: sky130A

* Black-box entry subcircuit for sky130_ef_sc_hd__decap_12 abstract view
.subckt sky130_ef_sc_hd__decap_12 VPWR VGND VPB VNB
.ends

* Black-box entry subcircuit for sky130_fd_sc_hd__tapvpwrvgnd_1 abstract view
.subckt sky130_fd_sc_hd__tapvpwrvgnd_1 VGND VPWR
.ends

* Black-box entry subcircuit for sky130_fd_sc_hd__fill_1 abstract view
.subckt sky130_fd_sc_hd__fill_1 VGND VNB VPB VPWR
.ends

* Black-box entry subcircuit for sky130_fd_sc_hd__decap_6 abstract view
.subckt sky130_fd_sc_hd__decap_6 VGND VNB VPB VPWR
.ends

* Black-box entry subcircuit for sky130_fd_sc_hd__conb_1 abstract view
.subckt sky130_fd_sc_hd__conb_1 VGND VNB VPB VPWR HI LO
.ends

* Black-box entry subcircuit for sky130_fd_sc_hd__decap_3 abstract view
.subckt sky130_fd_sc_hd__decap_3 VGND VNB VPB VPWR
.ends

* Black-box entry subcircuit for sky130_fd_sc_hd__o21ba_1 abstract view
.subckt sky130_fd_sc_hd__o21ba_1 A1 A2 B1_N VGND VNB VPB VPWR X
.ends

* Black-box entry subcircuit for sky130_fd_sc_hd__fill_2 abstract view
.subckt sky130_fd_sc_hd__fill_2 VGND VNB VPB VPWR
.ends

* Black-box entry subcircuit for sky130_fd_sc_hd__a21oi_1 abstract view
.subckt sky130_fd_sc_hd__a21oi_1 A1 A2 B1 VGND VNB VPB VPWR Y
.ends

* Black-box entry subcircuit for sky130_fd_sc_hd__a21o_1 abstract view
.subckt sky130_fd_sc_hd__a21o_1 A1 A2 B1 VGND VNB VPB VPWR X
.ends

* Black-box entry subcircuit for sky130_fd_sc_hd__nor2_1 abstract view
.subckt sky130_fd_sc_hd__nor2_1 A B VGND VNB VPB VPWR Y
.ends

* Black-box entry subcircuit for sky130_fd_sc_hd__clkbuf_1 abstract view
.subckt sky130_fd_sc_hd__clkbuf_1 A VGND VNB VPB VPWR X
.ends

* Black-box entry subcircuit for sky130_fd_sc_hd__decap_4 abstract view
.subckt sky130_fd_sc_hd__decap_4 VGND VNB VPB VPWR
.ends

* Black-box entry subcircuit for sky130_fd_sc_hd__decap_8 abstract view
.subckt sky130_fd_sc_hd__decap_8 VGND VNB VPB VPWR
.ends

* Black-box entry subcircuit for sky130_fd_sc_hd__or3b_1 abstract view
.subckt sky130_fd_sc_hd__or3b_1 A B C_N VGND VNB VPB VPWR X
.ends

* Black-box entry subcircuit for sky130_fd_sc_hd__or2_1 abstract view
.subckt sky130_fd_sc_hd__or2_1 A B VGND VNB VPB VPWR X
.ends

* Black-box entry subcircuit for sky130_fd_sc_hd__and3_1 abstract view
.subckt sky130_fd_sc_hd__and3_1 A B C VGND VNB VPB VPWR X
.ends

* Black-box entry subcircuit for sky130_fd_sc_hd__buf_1 abstract view
.subckt sky130_fd_sc_hd__buf_1 A VGND VNB VPB VPWR X
.ends

* Black-box entry subcircuit for sky130_fd_sc_hd__dfrtp_1 abstract view
.subckt sky130_fd_sc_hd__dfrtp_1 CLK D RESET_B VGND VNB VPB VPWR Q
.ends

* Black-box entry subcircuit for sky130_fd_sc_hd__diode_2 abstract view
.subckt sky130_fd_sc_hd__diode_2 DIODE VGND VNB VPB VPWR
.ends

* Black-box entry subcircuit for sky130_fd_sc_hd__buf_2 abstract view
.subckt sky130_fd_sc_hd__buf_2 A VGND VNB VPB VPWR X
.ends

* Black-box entry subcircuit for sky130_fd_sc_hd__inv_2 abstract view
.subckt sky130_fd_sc_hd__inv_2 A VGND VNB VPB VPWR Y
.ends

* Black-box entry subcircuit for sky130_fd_sc_hd__clkbuf_16 abstract view
.subckt sky130_fd_sc_hd__clkbuf_16 A VGND VNB VPB VPWR X
.ends

* Black-box entry subcircuit for sky130_fd_sc_hd__o21bai_1 abstract view
.subckt sky130_fd_sc_hd__o21bai_1 A1 A2 B1_N VGND VNB VPB VPWR Y
.ends

* Black-box entry subcircuit for sky130_fd_sc_hd__or3_1 abstract view
.subckt sky130_fd_sc_hd__or3_1 A B C VGND VNB VPB VPWR X
.ends

* Black-box entry subcircuit for sky130_fd_sc_hd__nand2_1 abstract view
.subckt sky130_fd_sc_hd__nand2_1 A B VGND VNB VPB VPWR Y
.ends

* Black-box entry subcircuit for sky130_fd_sc_hd__xor2_1 abstract view
.subckt sky130_fd_sc_hd__xor2_1 A B VGND VNB VPB VPWR X
.ends

* Black-box entry subcircuit for sky130_fd_sc_hd__buf_4 abstract view
.subckt sky130_fd_sc_hd__buf_4 A VGND VNB VPB VPWR X
.ends

* Black-box entry subcircuit for sky130_fd_sc_hd__and2b_1 abstract view
.subckt sky130_fd_sc_hd__and2b_1 A_N B VGND VNB VPB VPWR X
.ends

* Black-box entry subcircuit for sky130_fd_sc_hd__xnor2_1 abstract view
.subckt sky130_fd_sc_hd__xnor2_1 A B VGND VNB VPB VPWR Y
.ends

* Black-box entry subcircuit for sky130_fd_sc_hd__clkbuf_4 abstract view
.subckt sky130_fd_sc_hd__clkbuf_4 A VGND VNB VPB VPWR X
.ends

* Black-box entry subcircuit for sky130_fd_sc_hd__a2111o_1 abstract view
.subckt sky130_fd_sc_hd__a2111o_1 A1 A2 B1 C1 D1 VGND VNB VPB VPWR X
.ends

* Black-box entry subcircuit for sky130_fd_sc_hd__inv_8 abstract view
.subckt sky130_fd_sc_hd__inv_8 A VGND VNB VPB VPWR Y
.ends

* Black-box entry subcircuit for sky130_fd_sc_hd__nand3_1 abstract view
.subckt sky130_fd_sc_hd__nand3_1 A B C VGND VNB VPB VPWR Y
.ends

* Black-box entry subcircuit for sky130_fd_sc_hd__inv_6 abstract view
.subckt sky130_fd_sc_hd__inv_6 A VGND VNB VPB VPWR Y
.ends

* Black-box entry subcircuit for sky130_fd_sc_hd__clkinv_2 abstract view
.subckt sky130_fd_sc_hd__clkinv_2 A VGND VNB VPB VPWR Y
.ends

* Black-box entry subcircuit for sky130_fd_sc_hd__clkinv_4 abstract view
.subckt sky130_fd_sc_hd__clkinv_4 A VGND VNB VPB VPWR Y
.ends

* Black-box entry subcircuit for sky130_fd_sc_hd__a211o_1 abstract view
.subckt sky130_fd_sc_hd__a211o_1 A1 A2 B1 C1 VGND VNB VPB VPWR X
.ends

* Black-box entry subcircuit for sky130_fd_sc_hd__bufinv_16 abstract view
.subckt sky130_fd_sc_hd__bufinv_16 A VGND VNB VPB VPWR Y
.ends

* Black-box entry subcircuit for sky130_fd_sc_hd__o22ai_1 abstract view
.subckt sky130_fd_sc_hd__o22ai_1 A1 A2 B1 B2 VGND VNB VPB VPWR Y
.ends

* Black-box entry subcircuit for sky130_fd_sc_hd__nand2b_1 abstract view
.subckt sky130_fd_sc_hd__nand2b_1 A_N B VGND VNB VPB VPWR Y
.ends

* Black-box entry subcircuit for sky130_fd_sc_hd__o31a_1 abstract view
.subckt sky130_fd_sc_hd__o31a_1 A1 A2 A3 B1 VGND VNB VPB VPWR X
.ends

* Black-box entry subcircuit for sky130_fd_sc_hd__or4_1 abstract view
.subckt sky130_fd_sc_hd__or4_1 A B C D VGND VNB VPB VPWR X
.ends

* Black-box entry subcircuit for sky130_fd_sc_hd__o311a_1 abstract view
.subckt sky130_fd_sc_hd__o311a_1 A1 A2 A3 B1 C1 VGND VNB VPB VPWR X
.ends

* Black-box entry subcircuit for sky130_fd_sc_hd__o221a_1 abstract view
.subckt sky130_fd_sc_hd__o221a_1 A1 A2 B1 B2 C1 VGND VNB VPB VPWR X
.ends

* Black-box entry subcircuit for sky130_fd_sc_hd__mux2_1 abstract view
.subckt sky130_fd_sc_hd__mux2_1 A0 A1 S VGND VNB VPB VPWR X
.ends

* Black-box entry subcircuit for sky130_fd_sc_hd__o211a_1 abstract view
.subckt sky130_fd_sc_hd__o211a_1 A1 A2 B1 C1 VGND VNB VPB VPWR X
.ends

* Black-box entry subcircuit for sky130_fd_sc_hd__clkbuf_2 abstract view
.subckt sky130_fd_sc_hd__clkbuf_2 A VGND VNB VPB VPWR X
.ends

* Black-box entry subcircuit for sky130_fd_sc_hd__or4b_1 abstract view
.subckt sky130_fd_sc_hd__or4b_1 A B C D_N VGND VNB VPB VPWR X
.ends

* Black-box entry subcircuit for sky130_fd_sc_hd__and4_1 abstract view
.subckt sky130_fd_sc_hd__and4_1 A B C D VGND VNB VPB VPWR X
.ends

* Black-box entry subcircuit for sky130_fd_sc_hd__a21boi_1 abstract view
.subckt sky130_fd_sc_hd__a21boi_1 A1 A2 B1_N VGND VNB VPB VPWR Y
.ends

* Black-box entry subcircuit for sky130_fd_sc_hd__a211oi_1 abstract view
.subckt sky130_fd_sc_hd__a211oi_1 A1 A2 B1 C1 VGND VNB VPB VPWR Y
.ends

* Black-box entry subcircuit for sky130_fd_sc_hd__o21a_1 abstract view
.subckt sky130_fd_sc_hd__o21a_1 A1 A2 B1 VGND VNB VPB VPWR X
.ends

* Black-box entry subcircuit for sky130_fd_sc_hd__dlymetal6s2s_1 abstract view
.subckt sky130_fd_sc_hd__dlymetal6s2s_1 A VGND VNB VPB VPWR X
.ends

* Black-box entry subcircuit for sky130_fd_sc_hd__dlygate4sd3_1 abstract view
.subckt sky130_fd_sc_hd__dlygate4sd3_1 A VGND VNB VPB VPWR X
.ends

* Black-box entry subcircuit for sky130_fd_sc_hd__a21bo_1 abstract view
.subckt sky130_fd_sc_hd__a21bo_1 A1 A2 B1_N VGND VNB VPB VPWR X
.ends

* Black-box entry subcircuit for sky130_fd_sc_hd__nor3_1 abstract view
.subckt sky130_fd_sc_hd__nor3_1 A B C VGND VNB VPB VPWR Y
.ends

* Black-box entry subcircuit for sky130_fd_sc_hd__a31o_1 abstract view
.subckt sky130_fd_sc_hd__a31o_1 A1 A2 A3 B1 VGND VNB VPB VPWR X
.ends

* Black-box entry subcircuit for sky130_sram_1kbyte_1rw1r_32x256_8 abstract view
.subckt sky130_sram_1kbyte_1rw1r_32x256_8 din0[0] din0[1] din0[2] din0[3] din0[4]
+ din0[5] din0[6] din0[7] din0[8] din0[9] din0[10] din0[11] din0[12] din0[13] din0[14]
+ din0[15] din0[16] din0[17] din0[18] din0[19] din0[20] din0[21] din0[22] din0[23]
+ din0[24] din0[25] din0[26] din0[27] din0[28] din0[29] din0[30] din0[31] addr0[0]
+ addr0[1] addr0[2] addr0[3] addr0[4] addr0[5] addr0[6] addr0[7] addr1[0] addr1[1]
+ addr1[2] addr1[3] addr1[4] addr1[5] addr1[6] addr1[7] csb0 csb1 web0 clk0 clk1 wmask0[0]
+ wmask0[1] wmask0[2] wmask0[3] dout0[0] dout0[1] dout0[2] dout0[3] dout0[4] dout0[5]
+ dout0[6] dout0[7] dout0[8] dout0[9] dout0[10] dout0[11] dout0[12] dout0[13] dout0[14]
+ dout0[15] dout0[16] dout0[17] dout0[18] dout0[19] dout0[20] dout0[21] dout0[22]
+ dout0[23] dout0[24] dout0[25] dout0[26] dout0[27] dout0[28] dout0[29] dout0[30]
+ dout0[31] dout1[0] dout1[1] dout1[2] dout1[3] dout1[4] dout1[5] dout1[6] dout1[7]
+ dout1[8] dout1[9] dout1[10] dout1[11] dout1[12] dout1[13] dout1[14] dout1[15] dout1[16]
+ dout1[17] dout1[18] dout1[19] dout1[20] dout1[21] dout1[22] dout1[23] dout1[24]
+ dout1[25] dout1[26] dout1[27] dout1[28] dout1[29] dout1[30] dout1[31] vccd1 vssd1
.ends

* Black-box entry subcircuit for sky130_fd_sc_hd__a311o_1 abstract view
.subckt sky130_fd_sc_hd__a311o_1 A1 A2 A3 B1 C1 VGND VNB VPB VPWR X
.ends

.subckt acc32_sram VGND VPWR acc_out[0] acc_out[10] acc_out[11] acc_out[12] acc_out[13]
+ acc_out[14] acc_out[15] acc_out[16] acc_out[17] acc_out[18] acc_out[19] acc_out[1]
+ acc_out[20] acc_out[21] acc_out[22] acc_out[23] acc_out[24] acc_out[25] acc_out[26]
+ acc_out[27] acc_out[28] acc_out[29] acc_out[2] acc_out[30] acc_out[31] acc_out[3]
+ acc_out[4] acc_out[5] acc_out[6] acc_out[7] acc_out[8] acc_out[9] clk rst wr_addr[0]
+ wr_addr[1] wr_addr[2] wr_addr[3] wr_addr[4] wr_addr[5] wr_addr[6] wr_addr[7] wr_data[0]
+ wr_data[10] wr_data[11] wr_data[12] wr_data[13] wr_data[14] wr_data[15] wr_data[16]
+ wr_data[17] wr_data[18] wr_data[19] wr_data[1] wr_data[20] wr_data[21] wr_data[22]
+ wr_data[23] wr_data[24] wr_data[25] wr_data[26] wr_data[27] wr_data[28] wr_data[29]
+ wr_data[2] wr_data[30] wr_data[31] wr_data[3] wr_data[4] wr_data[5] wr_data[6] wr_data[7]
+ wr_data[8] wr_data[9] wr_en
XFILLER_246_109 VPWR VGND VPWR VGND sky130_ef_sc_hd__decap_12
XTAP_TAPCELL_ROW_9_1138 VGND VPWR sky130_fd_sc_hd__tapvpwrvgnd_1
XFILLER_228_813 VPWR VGND VPWR VGND sky130_ef_sc_hd__decap_12
XFILLER_45_1385 VGND VGND VPWR VPWR sky130_fd_sc_hd__fill_1
XFILLER_239_161 VGND VGND VPWR VPWR sky130_fd_sc_hd__decap_6
XFILLER_171_1393 VGND VGND VPWR VPWR sky130_fd_sc_hd__decap_6
XFILLER_254_153 VPWR VGND VPWR VGND sky130_ef_sc_hd__decap_12
XFILLER_215_529 VPWR VGND VPWR VGND sky130_ef_sc_hd__decap_12
XFILLER_208_581 VGND VGND VPWR VPWR sky130_fd_sc_hd__decap_6
XFILLER_254_197 VPWR VGND VPWR VGND sky130_ef_sc_hd__decap_12
XTAP_TAPCELL_ROW_204_2390 VGND VPWR sky130_fd_sc_hd__tapvpwrvgnd_1
XFILLER_223_573 VPWR VGND VPWR VGND sky130_ef_sc_hd__decap_12
XFILLER_52_29 VPWR VGND VPWR VGND sky130_ef_sc_hd__decap_12
XFILLER_196_937 VPWR VGND VPWR VGND sky130_ef_sc_hd__decap_12
XTAP_TAPCELL_ROW_200_2276 VGND VPWR sky130_fd_sc_hd__tapvpwrvgnd_1
XFILLER_52_1301 VGND VGND VPWR VPWR sky130_fd_sc_hd__fill_1
XFILLER_167_105 VGND VGND VPWR VPWR sky130_fd_sc_hd__decap_6
XTAP_TAPCELL_ROW_200_2287 VGND VPWR sky130_fd_sc_hd__tapvpwrvgnd_1
XTAP_TAPCELL_ROW_196_2180 VGND VPWR sky130_fd_sc_hd__tapvpwrvgnd_1
XTAP_TAPCELL_ROW_200_2298 VGND VPWR sky130_fd_sc_hd__tapvpwrvgnd_1
XFILLER_168_29 VPWR VGND VPWR VGND sky130_ef_sc_hd__decap_12
XFILLER_17_1443 VPWR VGND VPWR VGND sky130_ef_sc_hd__decap_12
XFILLER_195_447 VGND VGND VPWR VPWR sky130_fd_sc_hd__fill_1
XFILLER_210_245 VGND VGND VPWR VPWR sky130_fd_sc_hd__decap_6
XFILLER_167_149 VPWR VGND VPWR VGND sky130_ef_sc_hd__decap_12
XFILLER_206_1161 VPWR VGND VPWR VGND sky130_ef_sc_hd__decap_12
XFILLER_104_1413 VGND VGND VPWR VPWR sky130_fd_sc_hd__fill_1
XFILLER_183_609 VGND VGND VPWR VPWR sky130_fd_sc_hd__decap_6
XFILLER_241_1063 VGND VGND VPWR VPWR sky130_fd_sc_hd__fill_1
XTAP_TAPCELL_ROW_217_2740 VGND VPWR sky130_fd_sc_hd__tapvpwrvgnd_1
XTAP_TAPCELL_ROW_192_2066 VGND VPWR sky130_fd_sc_hd__tapvpwrvgnd_1
XTAP_TAPCELL_ROW_192_2077 VGND VPWR sky130_fd_sc_hd__tapvpwrvgnd_1
XFILLER_210_289 VPWR VGND VPWR VGND sky130_ef_sc_hd__decap_12
XTAP_TAPCELL_ROW_217_2751 VGND VPWR sky130_fd_sc_hd__tapvpwrvgnd_1
XFILLER_13_1329 VGND VGND VPWR VPWR sky130_fd_sc_hd__fill_1
XTAP_TAPCELL_ROW_213_2626 VGND VPWR sky130_fd_sc_hd__tapvpwrvgnd_1
XFILLER_175_193 VPWR VGND VPWR VGND sky130_ef_sc_hd__decap_12
XTAP_TAPCELL_ROW_213_2637 VGND VPWR sky130_fd_sc_hd__tapvpwrvgnd_1
XFILLER_191_653 VPWR VGND VPWR VGND sky130_ef_sc_hd__decap_12
XTAP_TAPCELL_ROW_213_2648 VGND VPWR sky130_fd_sc_hd__tapvpwrvgnd_1
XFILLER_190_141 VPWR VGND VPWR VGND sky130_ef_sc_hd__decap_12
XFILLER_219_1511 VGND VGND VPWR VPWR sky130_fd_sc_hd__fill_1
XFILLER_191_697 VPWR VGND VPWR VGND sky130_ef_sc_hd__decap_12
XTAP_TAPCELL_ROW_134_2_4559 VGND VPWR sky130_fd_sc_hd__tapvpwrvgnd_1
Xsram0_678 VGND VGND VPWR VPWR sram0_678/HI net678 sky130_fd_sc_hd__conb_1
XFILLER_85_1165 VPWR VGND VPWR VGND sky130_ef_sc_hd__decap_12
XFILLER_117_55 VGND VGND VPWR VPWR sky130_fd_sc_hd__fill_1
XFILLER_77_15 VPWR VGND VPWR VGND sky130_ef_sc_hd__decap_12
XFILLER_137_1255 VPWR VGND VPWR VGND sky130_ef_sc_hd__decap_12
XPHY_EDGE_ROW_165_Right_10 VGND VGND VPWR VPWR sky130_fd_sc_hd__decap_3
XFILLER_63_1441 VGND VGND VPWR VPWR sky130_fd_sc_hd__fill_1
XFILLER_137_1299 VPWR VGND VPWR VGND sky130_ef_sc_hd__decap_12
XFILLER_213_1121 VPWR VGND VPWR VGND sky130_ef_sc_hd__decap_12
XFILLER_218_301 VGND VGND VPWR VPWR sky130_fd_sc_hd__decap_6
XFILLER_246_643 VGND VGND VPWR VPWR sky130_fd_sc_hd__fill_1
XFILLER_24_1469 VGND VGND VPWR VPWR sky130_fd_sc_hd__fill_1
XPHY_EDGE_ROW_36_1_Right_692 VGND VGND VPWR VPWR sky130_fd_sc_hd__decap_3
XFILLER_218_345 VPWR VGND VPWR VGND sky130_ef_sc_hd__decap_12
XFILLER_234_805 VGND VGND VPWR VPWR sky130_fd_sc_hd__decap_6
XTAP_TAPCELL_ROW_82_2_4246 VGND VPWR sky130_fd_sc_hd__tapvpwrvgnd_1
XFILLER_248_1217 VPWR VGND VPWR VGND sky130_ef_sc_hd__decap_12
XFILLER_172_3 VPWR VGND VPWR VGND sky130_ef_sc_hd__decap_12
X_501_ net502 net89 _107_ VGND VGND VPWR VPWR _256_ sky130_fd_sc_hd__o21ba_1
XFILLER_218_389 VPWR VGND VPWR VGND sky130_ef_sc_hd__decap_12
XFILLER_234_849 VPWR VGND VPWR VGND sky130_ef_sc_hd__decap_12
XFILLER_93_69 VGND VGND VPWR VPWR sky130_fd_sc_hd__fill_2
XTAP_TAPCELL_ROW_181_1770 VGND VPWR sky130_fd_sc_hd__tapvpwrvgnd_1
XTAP_TAPCELL_ROW_181_1781 VGND VPWR sky130_fd_sc_hd__tapvpwrvgnd_1
XFILLER_233_337 VPWR VGND VPWR VGND sky130_ef_sc_hd__decap_12
XFILLER_57_1201 VPWR VGND VPWR VGND sky130_ef_sc_hd__decap_12
XFILLER_26_41 VGND VGND VPWR VPWR sky130_fd_sc_hd__decap_6
X_432_ net597 dout0_q\[21\] net534 VGND VGND VPWR VPWR _221_ sky130_fd_sc_hd__a21oi_1
XFILLER_96_1283 VPWR VGND VPWR VGND sky130_ef_sc_hd__decap_12
XFILLER_148_1351 VGND VGND VPWR VPWR sky130_fd_sc_hd__decap_6
XFILLER_183_1231 VGND VGND VPWR VPWR sky130_fd_sc_hd__fill_1
XFILLER_199_753 VPWR VGND VPWR VGND sky130_ef_sc_hd__decap_12
XFILLER_202_713 VPWR VGND VPWR VGND sky130_ef_sc_hd__decap_12
XFILLER_242_893 VPWR VGND VPWR VGND sky130_ef_sc_hd__decap_12
XFILLER_57_1267 VGND VGND VPWR VPWR sky130_fd_sc_hd__decap_6
XFILLER_144_1215 VPWR VGND VPWR VGND sky130_ef_sc_hd__decap_12
XFILLER_148_1395 VPWR VGND VPWR VGND sky130_ef_sc_hd__decap_12
X_363_ net592 net574 net546 VGND VGND VPWR VPWR _152_ sky130_fd_sc_hd__a21o_1
XFILLER_199_797 VPWR VGND VPWR VGND sky130_ef_sc_hd__decap_12
XFILLER_201_223 VGND VGND VPWR VPWR sky130_fd_sc_hd__fill_1
XFILLER_202_757 VPWR VGND VPWR VGND sky130_ef_sc_hd__decap_12
XFILLER_109_1379 VGND VGND VPWR VPWR sky130_fd_sc_hd__decap_6
XFILLER_144_1259 VPWR VGND VPWR VGND sky130_ef_sc_hd__decap_12
XFILLER_9_137 VGND VGND VPWR VPWR sky130_fd_sc_hd__decap_3
XFILLER_224_1261 VPWR VGND VPWR VGND sky130_ef_sc_hd__decap_12
X_294_ _084_ _087_ VGND VGND VPWR VPWR _078_ sky130_fd_sc_hd__nor2_1
XFILLER_186_469 VGND VGND VPWR VPWR sky130_fd_sc_hd__decap_6
XFILLER_220_1147 VGND VGND VPWR VPWR sky130_fd_sc_hd__fill_1
XFILLER_177_1057 VGND VGND VPWR VPWR sky130_fd_sc_hd__decap_6
XFILLER_170_837 VPWR VGND VPWR VGND sky130_ef_sc_hd__decap_12
XFILLER_155_1311 VPWR VGND VPWR VGND sky130_ef_sc_hd__decap_12
XFILLER_159_1491 VGND VGND VPWR VPWR sky130_fd_sc_hd__decap_6
XFILLER_194_1371 VGND VGND VPWR VPWR sky130_fd_sc_hd__fill_1
XFILLER_64_1227 VPWR VGND VPWR VGND sky130_ef_sc_hd__decap_12
XFILLER_155_1355 VPWR VGND VPWR VGND sky130_ef_sc_hd__decap_12
XFILLER_174_83 VGND VGND VPWR VPWR sky130_fd_sc_hd__fill_1
XTAP_TAPCELL_ROW_188_1957 VGND VPWR sky130_fd_sc_hd__tapvpwrvgnd_1
XTAP_TAPCELL_ROW_188_1968 VGND VPWR sky130_fd_sc_hd__tapvpwrvgnd_1
XFILLER_151_1219 VPWR VGND VPWR VGND sky130_ef_sc_hd__decap_12
XFILLER_116_1339 VPWR VGND VPWR VGND sky130_ef_sc_hd__decap_12
XFILLER_7_1121 VPWR VGND VPWR VGND sky130_ef_sc_hd__decap_12
XFILLER_155_1399 VPWR VGND VPWR VGND sky130_ef_sc_hd__decap_12
XFILLER_228_109 VPWR VGND VPWR VGND sky130_ef_sc_hd__decap_12
XTAP_TAPCELL_ROW_136_1_1271 VGND VPWR sky130_fd_sc_hd__tapvpwrvgnd_1
XFILLER_3_1007 VGND VGND VPWR VPWR sky130_fd_sc_hd__fill_1
XFILLER_237_665 VGND VGND VPWR VPWR sky130_fd_sc_hd__decap_6
XFILLER_231_1287 VGND VGND VPWR VPWR sky130_fd_sc_hd__fill_1
XFILLER_236_153 VPWR VGND VPWR VGND sky130_ef_sc_hd__decap_12
XFILLER_252_613 VPWR VGND VPWR VGND sky130_ef_sc_hd__decap_12
XTAP_TAPCELL_ROW_158_2_4700 VGND VPWR sky130_fd_sc_hd__tapvpwrvgnd_1
XFILLER_40_1271 VPWR VGND VPWR VGND sky130_ef_sc_hd__decap_12
XFILLER_184_1017 VPWR VGND VPWR VGND sky130_ef_sc_hd__decap_12
XFILLER_236_197 VPWR VGND VPWR VGND sky130_ef_sc_hd__decap_12
XFILLER_252_657 VPWR VGND VPWR VGND sky130_ef_sc_hd__decap_12
XFILLER_188_1197 VGND VGND VPWR VPWR sky130_fd_sc_hd__decap_6
XFILLER_75_1323 VGND VGND VPWR VPWR sky130_fd_sc_hd__decap_6
XFILLER_251_167 VGND VGND VPWR VPWR sky130_fd_sc_hd__fill_1
XFILLER_205_573 VPWR VGND VPWR VGND sky130_ef_sc_hd__decap_12
XFILLER_75_1367 VPWR VGND VPWR VGND sky130_ef_sc_hd__decap_12
XFILLER_127_1435 VGND VGND VPWR VPWR sky130_fd_sc_hd__decap_6
XFILLER_162_1315 VPWR VGND VPWR VGND sky130_ef_sc_hd__decap_12
XFILLER_178_937 VPWR VGND VPWR VGND sky130_ef_sc_hd__decap_12
XFILLER_162_1359 VPWR VGND VPWR VGND sky130_ef_sc_hd__decap_12
XFILLER_127_1479 VPWR VGND VPWR VGND sky130_ef_sc_hd__decap_12
XFILLER_177_447 VGND VGND VPWR VPWR sky130_fd_sc_hd__fill_1
XFILLER_203_1301 VPWR VGND VPWR VGND sky130_ef_sc_hd__decap_12
XFILLER_207_1481 VPWR VGND VPWR VGND sky130_ef_sc_hd__decap_12
XFILLER_220_587 VGND VGND VPWR VPWR sky130_fd_sc_hd__fill_1
XFILLER_186_981 VPWR VGND VPWR VGND sky130_ef_sc_hd__decap_12
XFILLER_203_1345 VPWR VGND VPWR VGND sky130_ef_sc_hd__decap_12
XFILLER_8_170 VGND VGND VPWR VPWR sky130_fd_sc_hd__fill_2
XFILLER_195_1113 VGND VGND VPWR VPWR sky130_fd_sc_hd__decap_6
XFILLER_12_1351 VGND VGND VPWR VPWR sky130_fd_sc_hd__decap_6
XFILLER_173_653 VPWR VGND VPWR VGND sky130_ef_sc_hd__decap_12
XFILLER_172_141 VPWR VGND VPWR VGND sky130_ef_sc_hd__decap_12
XFILLER_195_1157 VPWR VGND VPWR VGND sky130_ef_sc_hd__decap_12
XFILLER_173_697 VPWR VGND VPWR VGND sky130_ef_sc_hd__decap_12
XFILLER_218_65 VPWR VGND VPWR VGND sky130_ef_sc_hd__decap_12
XFILLER_12_1395 VPWR VGND VPWR VGND sky130_ef_sc_hd__decap_12
XFILLER_86_1463 VGND VGND VPWR VPWR sky130_fd_sc_hd__decap_6
XFILLER_82_1327 VPWR VGND VPWR VGND sky130_ef_sc_hd__decap_12
XFILLER_173_1455 VGND VGND VPWR VPWR sky130_fd_sc_hd__fill_1
XTAP_TAPCELL_ROW_100_2_4354 VGND VPWR sky130_fd_sc_hd__tapvpwrvgnd_1
XFILLER_134_1439 VPWR VGND VPWR VGND sky130_ef_sc_hd__decap_12
XFILLER_232_1029 VGND VGND VPWR VPWR sky130_fd_sc_hd__decap_6
XFILLER_234_53 VPWR VGND VPWR VGND sky130_ef_sc_hd__decap_12
XFILLER_214_1441 VPWR VGND VPWR VGND sky130_ef_sc_hd__decap_12
XFILLER_247_429 VPWR VGND VPWR VGND sky130_ef_sc_hd__decap_12
XFILLER_234_97 VPWR VGND VPWR VGND sky130_ef_sc_hd__decap_12
XFILLER_214_1485 VPWR VGND VPWR VGND sky130_ef_sc_hd__decap_12
XFILLER_228_643 VGND VGND VPWR VPWR sky130_fd_sc_hd__fill_1
XTAP_TAPCELL_ROW_67_2_4159 VGND VPWR sky130_fd_sc_hd__tapvpwrvgnd_1
XFILLER_216_805 VGND VGND VPWR VPWR sky130_fd_sc_hd__decap_6
XTAP_TAPCELL_ROW_206_2441 VGND VPWR sky130_fd_sc_hd__tapvpwrvgnd_1
XTAP_TAPCELL_ROW_206_2452 VGND VPWR sky130_fd_sc_hd__tapvpwrvgnd_1
XFILLER_255_473 VGND VGND VPWR VPWR sky130_fd_sc_hd__decap_3
XFILLER_250_41 VPWR VGND VPWR VGND sky130_ef_sc_hd__decap_12
XFILLER_216_849 VPWR VGND VPWR VGND sky130_ef_sc_hd__decap_12
XFILLER_23_1491 VGND VGND VPWR VPWR sky130_fd_sc_hd__decap_6
XFILLER_103_57 VPWR VGND VPWR VGND sky130_ef_sc_hd__decap_12
XTAP_TAPCELL_ROW_198_2220 VGND VPWR sky130_fd_sc_hd__tapvpwrvgnd_1
XTAP_TAPCELL_ROW_202_2327 VGND VPWR sky130_fd_sc_hd__tapvpwrvgnd_1
XFILLER_215_337 VPWR VGND VPWR VGND sky130_ef_sc_hd__decap_12
XTAP_TAPCELL_ROW_202_2338 VGND VPWR sky130_fd_sc_hd__tapvpwrvgnd_1
XTAP_TAPCELL_ROW_198_2231 VGND VPWR sky130_fd_sc_hd__tapvpwrvgnd_1
XTAP_TAPCELL_ROW_202_2349 VGND VPWR sky130_fd_sc_hd__tapvpwrvgnd_1
XFILLER_250_85 VPWR VGND VPWR VGND sky130_ef_sc_hd__decap_12
XFILLER_110_1483 VPWR VGND VPWR VGND sky130_ef_sc_hd__decap_12
XTAP_TAPCELL_ROW_198_2242 VGND VPWR sky130_fd_sc_hd__tapvpwrvgnd_1
XFILLER_63_39 VPWR VGND VPWR VGND sky130_ef_sc_hd__decap_12
XFILLER_93_1423 VPWR VGND VPWR VGND sky130_ef_sc_hd__decap_12
XTAP_TAPCELL_ROW_47_2_4035 VGND VPWR sky130_fd_sc_hd__tapvpwrvgnd_1
XFILLER_230_307 VGND VGND VPWR VPWR sky130_fd_sc_hd__fill_1
XFILLER_54_1407 VGND VGND VPWR VPWR sky130_fd_sc_hd__decap_6
XFILLER_179_39 VPWR VGND VPWR VGND sky130_ef_sc_hd__decap_12
XTAP_TAPCELL_ROW_194_2117 VGND VPWR sky130_fd_sc_hd__tapvpwrvgnd_1
XFILLER_196_701 VPWR VGND VPWR VGND sky130_ef_sc_hd__decap_12
XFILLER_242_189 VGND VGND VPWR VPWR sky130_fd_sc_hd__decap_6
XFILLER_93_1467 VPWR VGND VPWR VGND sky130_ef_sc_hd__decap_12
XFILLER_224_893 VPWR VGND VPWR VGND sky130_ef_sc_hd__decap_12
XTAP_TAPCELL_ROW_194_2128 VGND VPWR sky130_fd_sc_hd__tapvpwrvgnd_1
XTAP_TAPCELL_ROW_219_2802 VGND VPWR sky130_fd_sc_hd__tapvpwrvgnd_1
XFILLER_243_1169 VGND VGND VPWR VPWR sky130_fd_sc_hd__decap_6
XFILLER_221_1401 VPWR VGND VPWR VGND sky130_ef_sc_hd__decap_12
XFILLER_168_469 VGND VGND VPWR VPWR sky130_fd_sc_hd__decap_6
XFILLER_17_1273 VGND VGND VPWR VPWR sky130_fd_sc_hd__fill_1
XFILLER_183_417 VPWR VGND VPWR VGND sky130_ef_sc_hd__decap_12
Xwire539 net50 VGND VGND VPWR VPWR net539 sky130_fd_sc_hd__clkbuf_1
XFILLER_195_27 VPWR VGND VPWR VGND sky130_ef_sc_hd__decap_12
XFILLER_12_65 VGND VGND VPWR VPWR sky130_fd_sc_hd__decap_3
XFILLER_30_1451 VPWR VGND VPWR VGND sky130_ef_sc_hd__decap_12
XFILLER_192_973 VGND VGND VPWR VPWR sky130_fd_sc_hd__decap_6
XTAP_TAPCELL_ROW_25_2_3905 VGND VPWR sky130_fd_sc_hd__tapvpwrvgnd_1
XFILLER_191_461 VPWR VGND VPWR VGND sky130_ef_sc_hd__decap_12
XFILLER_128_65 VGND VGND VPWR VPWR sky130_fd_sc_hd__decap_6
XFILLER_30_1495 VPWR VGND VPWR VGND sky130_ef_sc_hd__decap_12
XTAP_TAPCELL_ROW_170_1471 VGND VPWR sky130_fd_sc_hd__tapvpwrvgnd_1
XFILLER_191_1511 VGND VGND VPWR VPWR sky130_fd_sc_hd__fill_1
XTAP_TAPCELL_ROW_170_1482 VGND VPWR sky130_fd_sc_hd__tapvpwrvgnd_1
XFILLER_250_1129 VPWR VGND VPWR VGND sky130_ef_sc_hd__decap_12
XFILLER_144_53 VPWR VGND VPWR VGND sky130_ef_sc_hd__decap_12
XFILLER_8_1441 VPWR VGND VPWR VGND sky130_ef_sc_hd__decap_12
XTAP_TAPCELL_ROW_183_1821 VGND VPWR sky130_fd_sc_hd__tapvpwrvgnd_1
XFILLER_98_1301 VGND VGND VPWR VPWR sky130_fd_sc_hd__fill_1
XTAP_TAPCELL_ROW_183_1832 VGND VPWR sky130_fd_sc_hd__tapvpwrvgnd_1
XFILLER_8_1485 VPWR VGND VPWR VGND sky130_ef_sc_hd__decap_12
XFILLER_219_665 VGND VGND VPWR VPWR sky130_fd_sc_hd__decap_6
XFILLER_37_51 VGND VGND VPWR VPWR sky130_fd_sc_hd__decap_4
XFILLER_218_153 VPWR VGND VPWR VGND sky130_ef_sc_hd__decap_12
XFILLER_234_613 VPWR VGND VPWR VGND sky130_ef_sc_hd__decap_12
XPHY_EDGE_ROW_37_1_Right_693 VGND VGND VPWR VPWR sky130_fd_sc_hd__decap_3
XFILLER_160_41 VPWR VGND VPWR VGND sky130_ef_sc_hd__decap_12
XFILLER_59_1329 VGND VGND VPWR VPWR sky130_fd_sc_hd__fill_1
XFILLER_218_197 VPWR VGND VPWR VGND sky130_ef_sc_hd__decap_12
XFILLER_234_657 VPWR VGND VPWR VGND sky130_ef_sc_hd__decap_12
XFILLER_185_1337 VGND VGND VPWR VPWR sky130_fd_sc_hd__decap_6
XFILLER_209_1009 VPWR VGND VPWR VGND sky130_ef_sc_hd__decap_12
XFILLER_2_1073 VPWR VGND VPWR VGND sky130_ef_sc_hd__decap_12
XFILLER_233_167 VGND VGND VPWR VPWR sky130_fd_sc_hd__fill_1
XFILLER_72_1507 VGND VGND VPWR VPWR sky130_fd_sc_hd__decap_8
XFILLER_199_561 VPWR VGND VPWR VGND sky130_ef_sc_hd__decap_12
XFILLER_221_329 VGND VGND VPWR VPWR sky130_fd_sc_hd__decap_6
X_415_ net132 _162_ _164_ VGND VGND VPWR VPWR _204_ sky130_fd_sc_hd__or3b_1
XFILLER_109_1165 VPWR VGND VPWR VGND sky130_ef_sc_hd__decap_12
XFILLER_186_233 VPWR VGND VPWR VGND sky130_ef_sc_hd__decap_12
X_346_ _133_ net335 VGND VGND VPWR VPWR _135_ sky130_fd_sc_hd__or2_1
XTAP_TAPCELL_ROW_177_1658 VGND VPWR sky130_fd_sc_hd__tapvpwrvgnd_1
XTAP_TAPCELL_ROW_177_1669 VGND VPWR sky130_fd_sc_hd__tapvpwrvgnd_1
XFILLER_202_587 VGND VGND VPWR VPWR sky130_fd_sc_hd__fill_1
XFILLER_168_981 VPWR VGND VPWR VGND sky130_ef_sc_hd__decap_12
XFILLER_186_277 VPWR VGND VPWR VGND sky130_ef_sc_hd__decap_12
XFILLER_224_1091 VGND VGND VPWR VPWR sky130_fd_sc_hd__fill_1
XFILLER_179_1119 VGND VGND VPWR VPWR sky130_fd_sc_hd__fill_1
XFILLER_6_630 VGND VGND VPWR VPWR sky130_fd_sc_hd__fill_2
XFILLER_183_951 VGND VGND VPWR VPWR sky130_fd_sc_hd__fill_1
XFILLER_6_652 VGND VGND VPWR VPWR sky130_fd_sc_hd__decap_8
XFILLER_170_601 VPWR VGND VPWR VGND sky130_ef_sc_hd__decap_12
XFILLER_196_1477 VGND VGND VPWR VPWR sky130_fd_sc_hd__decap_6
XFILLER_185_93 VPWR VGND VPWR VGND sky130_ef_sc_hd__decap_12
XFILLER_5_184 VGND VGND VPWR VPWR sky130_fd_sc_hd__decap_6
XFILLER_170_645 VPWR VGND VPWR VGND sky130_ef_sc_hd__decap_12
XFILLER_9_1205 VPWR VGND VPWR VGND sky130_ef_sc_hd__decap_12
XFILLER_29_1177 VPWR VGND VPWR VGND sky130_ef_sc_hd__decap_12
XFILLER_229_429 VPWR VGND VPWR VGND sky130_ef_sc_hd__decap_12
XTAP_TAPCELL_ROW_38_2_3983 VGND VPWR sky130_fd_sc_hd__tapvpwrvgnd_1
XFILLER_237_473 VPWR VGND VPWR VGND sky130_ef_sc_hd__decap_12
XFILLER_253_933 VPWR VGND VPWR VGND sky130_ef_sc_hd__decap_12
XFILLER_252_421 VPWR VGND VPWR VGND sky130_ef_sc_hd__decap_12
XTAP_TAPCELL_ROW_0_828 VGND VPWR sky130_fd_sc_hd__tapvpwrvgnd_1
XTAP_TAPCELL_ROW_0_839 VGND VPWR sky130_fd_sc_hd__tapvpwrvgnd_1
XFILLER_253_977 VPWR VGND VPWR VGND sky130_ef_sc_hd__decap_12
XFILLER_212_307 VGND VGND VPWR VPWR sky130_fd_sc_hd__fill_1
XFILLER_178_701 VPWR VGND VPWR VGND sky130_ef_sc_hd__decap_12
XFILLER_206_893 VPWR VGND VPWR VGND sky130_ef_sc_hd__decap_12
XFILLER_224_189 VGND VGND VPWR VPWR sky130_fd_sc_hd__decap_6
XFILLER_220_77 VGND VGND VPWR VPWR sky130_fd_sc_hd__decap_6
XFILLER_221_841 VPWR VGND VPWR VGND sky130_ef_sc_hd__decap_12
XTAP_TAPCELL_ROW_255_3758 VGND VPWR sky130_fd_sc_hd__tapvpwrvgnd_1
XFILLER_127_1243 VPWR VGND VPWR VGND sky130_ef_sc_hd__decap_12
XTAP_TAPCELL_ROW_255_3769 VGND VPWR sky130_fd_sc_hd__tapvpwrvgnd_1
XFILLER_240_1309 VGND VGND VPWR VPWR sky130_fd_sc_hd__decap_6
XFILLER_127_1287 VPWR VGND VPWR VGND sky130_ef_sc_hd__decap_12
XFILLER_14_1413 VGND VGND VPWR VPWR sky130_fd_sc_hd__fill_1
XFILLER_162_1189 VGND VGND VPWR VPWR sky130_fd_sc_hd__fill_1
XFILLER_165_417 VGND VGND VPWR VPWR sky130_fd_sc_hd__decap_3
XFILLER_203_1175 VGND VGND VPWR VPWR sky130_fd_sc_hd__fill_1
XFILLER_238_1205 VPWR VGND VPWR VGND sky130_ef_sc_hd__decap_12
XFILLER_174_973 VGND VGND VPWR VPWR sky130_fd_sc_hd__decap_6
XFILLER_173_461 VPWR VGND VPWR VGND sky130_ef_sc_hd__decap_12
XFILLER_86_1271 VPWR VGND VPWR VGND sky130_ef_sc_hd__decap_12
XFILLER_47_1255 VPWR VGND VPWR VGND sky130_ef_sc_hd__decap_12
XFILLER_134_1203 VPWR VGND VPWR VGND sky130_ef_sc_hd__decap_12
XFILLER_138_1383 VPWR VGND VPWR VGND sky130_ef_sc_hd__decap_12
XTAP_TAPCELL_ROW_43_1_1178 VGND VPWR sky130_fd_sc_hd__tapvpwrvgnd_1
XFILLER_251_1449 VGND VGND VPWR VPWR sky130_fd_sc_hd__decap_6
XTAP_TAPCELL_ROW_208_2503 VGND VPWR sky130_fd_sc_hd__tapvpwrvgnd_1
XFILLER_47_1299 VPWR VGND VPWR VGND sky130_ef_sc_hd__decap_12
XFILLER_134_1247 VPWR VGND VPWR VGND sky130_ef_sc_hd__decap_12
XTAP_TAPCELL_ROW_208_2514 VGND VPWR sky130_fd_sc_hd__tapvpwrvgnd_1
XFILLER_248_749 VGND VGND VPWR VPWR sky130_fd_sc_hd__decap_6
XFILLER_247_237 VPWR VGND VPWR VGND sky130_ef_sc_hd__decap_12
XFILLER_249_1301 VPWR VGND VPWR VGND sky130_ef_sc_hd__decap_12
XFILLER_74_27 VGND VGND VPWR VPWR sky130_fd_sc_hd__fill_1
XFILLER_216_613 VPWR VGND VPWR VGND sky130_ef_sc_hd__decap_12
XFILLER_167_1001 VGND VGND VPWR VPWR sky130_fd_sc_hd__decap_6
XFILLER_255_281 VPWR VGND VPWR VGND sky130_ef_sc_hd__decap_12
XFILLER_249_1345 VPWR VGND VPWR VGND sky130_ef_sc_hd__decap_12
XFILLER_216_657 VPWR VGND VPWR VGND sky130_ef_sc_hd__decap_12
XFILLER_167_1045 VPWR VGND VPWR VGND sky130_ef_sc_hd__decap_12
XFILLER_3_1393 VGND VGND VPWR VPWR sky130_fd_sc_hd__decap_6
XFILLER_215_167 VGND VGND VPWR VPWR sky130_fd_sc_hd__fill_1
XFILLER_93_1231 VPWR VGND VPWR VGND sky130_ef_sc_hd__decap_12
XFILLER_58_1351 VGND VGND VPWR VPWR sky130_fd_sc_hd__decap_6
XFILLER_203_329 VGND VGND VPWR VPWR sky130_fd_sc_hd__decap_6
XFILLER_167_1089 VPWR VGND VPWR VGND sky130_ef_sc_hd__decap_12
XFILLER_90_15 VPWR VGND VPWR VGND sky130_ef_sc_hd__decap_12
XFILLER_54_1215 VPWR VGND VPWR VGND sky130_ef_sc_hd__decap_12
XFILLER_58_1395 VPWR VGND VPWR VGND sky130_ef_sc_hd__decap_12
XFILLER_93_1275 VPWR VGND VPWR VGND sky130_ef_sc_hd__decap_12
XFILLER_145_1343 VPWR VGND VPWR VGND sky130_ef_sc_hd__decap_12
XFILLER_196_531 VGND VGND VPWR VPWR sky130_fd_sc_hd__fill_1
XFILLER_168_233 VPWR VGND VPWR VGND sky130_ef_sc_hd__decap_12
XFILLER_54_1259 VPWR VGND VPWR VGND sky130_ef_sc_hd__decap_12
XFILLER_19_1379 VGND VGND VPWR VPWR sky130_fd_sc_hd__decap_6
XFILLER_106_1327 VPWR VGND VPWR VGND sky130_ef_sc_hd__decap_12
XFILLER_145_1387 VPWR VGND VPWR VGND sky130_ef_sc_hd__decap_12
XFILLER_8_917 VGND VGND VPWR VPWR sky130_fd_sc_hd__decap_6
XFILLER_211_373 VPWR VGND VPWR VGND sky130_ef_sc_hd__decap_12
Xwire303 net304 VGND VGND VPWR VPWR net303 sky130_fd_sc_hd__clkbuf_1
XFILLER_135_3 VPWR VGND VPWR VGND sky130_ef_sc_hd__decap_12
XFILLER_168_277 VPWR VGND VPWR VGND sky130_ef_sc_hd__decap_12
Xwire314 net315 VGND VGND VPWR VPWR net314 sky130_fd_sc_hd__clkbuf_1
XFILLER_184_737 VPWR VGND VPWR VGND sky130_ef_sc_hd__decap_12
XFILLER_221_1231 VGND VGND VPWR VPWR sky130_fd_sc_hd__fill_1
Xwire325 _148_ VGND VGND VPWR VPWR net325 sky130_fd_sc_hd__clkbuf_1
Xwire336 net337 VGND VGND VPWR VPWR net336 sky130_fd_sc_hd__clkbuf_1
XFILLER_183_225 VPWR VGND VPWR VGND sky130_ef_sc_hd__decap_12
Xwire347 net348 VGND VGND VPWR VPWR net347 sky130_fd_sc_hd__clkbuf_1
XTAP_TAPCELL_ROW_172_1522 VGND VPWR sky130_fd_sc_hd__tapvpwrvgnd_1
Xwire358 net359 VGND VGND VPWR VPWR net358 sky130_fd_sc_hd__clkbuf_1
XTAP_TAPCELL_ROW_172_1533 VGND VPWR sky130_fd_sc_hd__tapvpwrvgnd_1
Xwire369 net370 VGND VGND VPWR VPWR net369 sky130_fd_sc_hd__clkbuf_1
XFILLER_178_1141 VGND VGND VPWR VPWR sky130_fd_sc_hd__decap_6
XFILLER_99_57 VPWR VGND VPWR VGND sky130_ef_sc_hd__decap_12
XFILLER_192_781 VPWR VGND VPWR VGND sky130_ef_sc_hd__decap_12
XFILLER_174_1005 VPWR VGND VPWR VGND sky130_ef_sc_hd__decap_12
XFILLER_178_1185 VPWR VGND VPWR VGND sky130_ef_sc_hd__decap_12
XFILLER_3_633 VGND VGND VPWR VPWR sky130_fd_sc_hd__fill_2
XFILLER_65_1311 VPWR VGND VPWR VGND sky130_ef_sc_hd__decap_12
XFILLER_2_121 VPWR VGND VPWR VGND sky130_ef_sc_hd__decap_12
XFILLER_69_1491 VGND VGND VPWR VPWR sky130_fd_sc_hd__decap_6
XFILLER_174_1049 VPWR VGND VPWR VGND sky130_ef_sc_hd__decap_12
XFILLER_65_1355 VPWR VGND VPWR VGND sky130_ef_sc_hd__decap_12
XFILLER_2_165 VPWR VGND VPWR VGND sky130_ef_sc_hd__decap_12
XFILLER_117_1423 VPWR VGND VPWR VGND sky130_ef_sc_hd__decap_12
XFILLER_152_1303 VPWR VGND VPWR VGND sky130_ef_sc_hd__decap_12
XFILLER_254_1073 VPWR VGND VPWR VGND sky130_ef_sc_hd__decap_12
XFILLER_156_1483 VPWR VGND VPWR VGND sky130_ef_sc_hd__decap_12
XFILLER_239_727 VGND VGND VPWR VPWR sky130_fd_sc_hd__fill_1
XFILLER_61_1219 VPWR VGND VPWR VGND sky130_ef_sc_hd__decap_12
XFILLER_26_1339 VPWR VGND VPWR VGND sky130_ef_sc_hd__decap_12
XFILLER_65_1399 VPWR VGND VPWR VGND sky130_ef_sc_hd__decap_12
XFILLER_117_1467 VPWR VGND VPWR VGND sky130_ef_sc_hd__decap_12
XFILLER_215_1057 VGND VGND VPWR VPWR sky130_fd_sc_hd__decap_6
XFILLER_232_1371 VGND VGND VPWR VPWR sky130_fd_sc_hd__fill_1
XPHY_EDGE_ROW_100_2_Right_191 VGND VGND VPWR VPWR sky130_fd_sc_hd__decap_3
XTAP_TAPCELL_ROW_166_1359 VGND VPWR sky130_fd_sc_hd__tapvpwrvgnd_1
XFILLER_171_51 VGND VGND VPWR VPWR sky130_fd_sc_hd__decap_4
XFILLER_219_473 VPWR VGND VPWR VGND sky130_ef_sc_hd__decap_12
XFILLER_235_933 VPWR VGND VPWR VGND sky130_ef_sc_hd__decap_12
XFILLER_234_421 VPWR VGND VPWR VGND sky130_ef_sc_hd__decap_12
XFILLER_185_1101 VPWR VGND VPWR VGND sky130_ef_sc_hd__decap_12
XFILLER_189_1281 VGND VGND VPWR VPWR sky130_fd_sc_hd__decap_6
XFILLER_0_57 VGND VGND VPWR VPWR sky130_fd_sc_hd__decap_8
XPHY_EDGE_ROW_38_1_Right_694 VGND VGND VPWR VPWR sky130_fd_sc_hd__decap_3
XFILLER_235_977 VPWR VGND VPWR VGND sky130_ef_sc_hd__decap_12
XFILLER_185_1145 VPWR VGND VPWR VGND sky130_ef_sc_hd__decap_12
XFILLER_228_1429 VPWR VGND VPWR VGND sky130_ef_sc_hd__decap_12
XFILLER_250_925 VPWR VGND VPWR VGND sky130_ef_sc_hd__decap_12
XTAP_TAPCELL_ROW_179_1709 VGND VPWR sky130_fd_sc_hd__tapvpwrvgnd_1
XFILLER_76_1451 VPWR VGND VPWR VGND sky130_ef_sc_hd__decap_12
XFILLER_181_1009 VPWR VGND VPWR VGND sky130_ef_sc_hd__decap_12
XFILLER_206_189 VGND VGND VPWR VPWR sky130_fd_sc_hd__decap_6
XFILLER_185_1189 VPWR VGND VPWR VGND sky130_ef_sc_hd__decap_12
XFILLER_221_137 VPWR VGND VPWR VGND sky130_ef_sc_hd__decap_12
XFILLER_37_1435 VGND VGND VPWR VPWR sky130_fd_sc_hd__decap_6
XFILLER_9_11 VPWR VGND VPWR VGND sky130_ef_sc_hd__decap_12
XFILLER_72_1315 VPWR VGND VPWR VGND sky130_ef_sc_hd__decap_12
XFILLER_203_841 VPWR VGND VPWR VGND sky130_ef_sc_hd__decap_12
XFILLER_76_1495 VPWR VGND VPWR VGND sky130_ef_sc_hd__decap_12
XFILLER_163_1443 VPWR VGND VPWR VGND sky130_ef_sc_hd__decap_12
XPHY_EDGE_ROW_74_1_Left_329 VGND VGND VPWR VPWR sky130_fd_sc_hd__decap_3
XFILLER_199_391 VGND VGND VPWR VPWR sky130_fd_sc_hd__fill_1
XFILLER_187_553 VGND VGND VPWR VPWR sky130_fd_sc_hd__decap_6
XFILLER_222_1017 VPWR VGND VPWR VGND sky130_ef_sc_hd__decap_12
XFILLER_37_1479 VPWR VGND VPWR VGND sky130_ef_sc_hd__decap_12
XFILLER_72_1359 VPWR VGND VPWR VGND sky130_ef_sc_hd__decap_12
XFILLER_124_1427 VPWR VGND VPWR VGND sky130_ef_sc_hd__decap_12
XFILLER_226_1197 VGND VGND VPWR VPWR sky130_fd_sc_hd__decap_6
XFILLER_230_693 VGND VGND VPWR VPWR sky130_fd_sc_hd__decap_6
XTAP_TAPCELL_ROW_250_3622 VGND VPWR sky130_fd_sc_hd__tapvpwrvgnd_1
XTAP_TAPCELL_ROW_250_3633 VGND VPWR sky130_fd_sc_hd__tapvpwrvgnd_1
X_329_ net594 dout0_q\[19\] net536 VGND VGND VPWR VPWR _118_ sky130_fd_sc_hd__and3_1
XFILLER_187_597 VPWR VGND VPWR VGND sky130_ef_sc_hd__decap_12
XTAP_TAPCELL_ROW_250_3644 VGND VPWR sky130_fd_sc_hd__tapvpwrvgnd_1
XFILLER_200_1315 VGND VGND VPWR VPWR sky130_fd_sc_hd__fill_1
Xmax_cap603 valid_d2 VGND VGND VPWR VPWR net603 sky130_fd_sc_hd__buf_1
XFILLER_196_1241 VPWR VGND VPWR VGND sky130_ef_sc_hd__decap_12
Xmax_cap614 net615 VGND VGND VPWR VPWR net614 sky130_fd_sc_hd__clkbuf_1
XFILLER_171_921 VPWR VGND VPWR VGND sky130_ef_sc_hd__decap_12
XFILLER_50_3 VPWR VGND VPWR VGND sky130_ef_sc_hd__decap_12
XTAP_TAPCELL_ROW_135_2_4564 VGND VPWR sky130_fd_sc_hd__tapvpwrvgnd_1
XFILLER_192_1105 VPWR VGND VPWR VGND sky130_ef_sc_hd__decap_12
XFILLER_196_1285 VPWR VGND VPWR VGND sky130_ef_sc_hd__decap_12
XFILLER_171_965 VPWR VGND VPWR VGND sky130_ef_sc_hd__decap_12
XFILLER_83_1411 VPWR VGND VPWR VGND sky130_ef_sc_hd__decap_12
XFILLER_100_1471 VPWR VGND VPWR VGND sky130_ef_sc_hd__decap_12
XFILLER_192_1149 VPWR VGND VPWR VGND sky130_ef_sc_hd__decap_12
XFILLER_170_475 VGND VGND VPWR VPWR sky130_fd_sc_hd__fill_1
XTAP_TAPCELL_ROW_248_3573 VGND VPWR sky130_fd_sc_hd__tapvpwrvgnd_1
XTAP_TAPCELL_ROW_248_3584 VGND VPWR sky130_fd_sc_hd__tapvpwrvgnd_1
XFILLER_233_1113 VGND VGND VPWR VPWR sky130_fd_sc_hd__decap_6
XFILLER_83_1455 VPWR VGND VPWR VGND sky130_ef_sc_hd__decap_12
XFILLER_233_1157 VPWR VGND VPWR VGND sky130_ef_sc_hd__decap_12
XFILLER_44_1439 VPWR VGND VPWR VGND sky130_ef_sc_hd__decap_12
XFILLER_83_1499 VPWR VGND VPWR VGND sky130_ef_sc_hd__decap_12
XFILLER_215_55 VGND VGND VPWR VPWR sky130_fd_sc_hd__fill_1
XFILLER_229_237 VPWR VGND VPWR VGND sky130_ef_sc_hd__decap_12
XTAP_TAPCELL_ROW_83_2_4251 VGND VPWR sky130_fd_sc_hd__tapvpwrvgnd_1
XFILLER_211_1455 VGND VGND VPWR VPWR sky130_fd_sc_hd__fill_1
XFILLER_238_793 VPWR VGND VPWR VGND sky130_ef_sc_hd__decap_12
XFILLER_237_281 VPWR VGND VPWR VGND sky130_ef_sc_hd__decap_12
XFILLER_253_741 VPWR VGND VPWR VGND sky130_ef_sc_hd__decap_12
XFILLER_252_251 VGND VGND VPWR VPWR sky130_fd_sc_hd__fill_1
XFILLER_168_1365 VGND VGND VPWR VPWR sky130_fd_sc_hd__decap_6
XFILLER_253_785 VPWR VGND VPWR VGND sky130_ef_sc_hd__decap_12
XFILLER_240_413 VGND VGND VPWR VPWR sky130_fd_sc_hd__decap_6
XFILLER_20_1483 VPWR VGND VPWR VGND sky130_ef_sc_hd__decap_12
XFILLER_197_317 VPWR VGND VPWR VGND sky130_ef_sc_hd__decap_12
XFILLER_240_457 VPWR VGND VPWR VGND sky130_ef_sc_hd__decap_12
XFILLER_90_1415 VPWR VGND VPWR VGND sky130_ef_sc_hd__decap_12
XFILLER_244_1253 VGND VGND VPWR VPWR sky130_fd_sc_hd__decap_6
XFILLER_178_531 VGND VGND VPWR VPWR sky130_fd_sc_hd__fill_1
XFILLER_240_1117 VPWR VGND VPWR VGND sky130_ef_sc_hd__decap_12
XFILLER_221_671 VGND VGND VPWR VPWR sky130_fd_sc_hd__fill_1
XFILLER_244_1297 VPWR VGND VPWR VGND sky130_ef_sc_hd__decap_12
XFILLER_60_18 VGND VGND VPWR VPWR sky130_fd_sc_hd__decap_8
XFILLER_60_29 VPWR VGND VPWR VGND sky130_ef_sc_hd__decap_12
XFILLER_166_737 VPWR VGND VPWR VGND sky130_ef_sc_hd__decap_12
XFILLER_165_225 VPWR VGND VPWR VGND sky130_ef_sc_hd__decap_12
XFILLER_176_29 VPWR VGND VPWR VGND sky130_ef_sc_hd__decap_12
XFILLER_5_909 VPWR VGND VPWR VGND sky130_ef_sc_hd__decap_12
XFILLER_101_1213 VGND VGND VPWR VPWR sky130_fd_sc_hd__decap_4
XFILLER_181_729 VPWR VGND VPWR VGND sky130_ef_sc_hd__decap_12
XFILLER_140_1295 VGND VGND VPWR VPWR sky130_fd_sc_hd__decap_6
XFILLER_174_781 VPWR VGND VPWR VGND sky130_ef_sc_hd__decap_12
XFILLER_238_1035 VGND VGND VPWR VPWR sky130_fd_sc_hd__fill_1
XPHY_EDGE_ROW_139_2_Right_230 VGND VGND VPWR VPWR sky130_fd_sc_hd__decap_3
XFILLER_175_1325 VPWR VGND VPWR VGND sky130_ef_sc_hd__decap_12
XFILLER_69_27 VPWR VGND VPWR VGND sky130_ef_sc_hd__decap_12
XFILLER_175_1369 VPWR VGND VPWR VGND sky130_ef_sc_hd__decap_12
XFILLER_251_1213 VPWR VGND VPWR VGND sky130_ef_sc_hd__decap_12
XFILLER_248_513 VPWR VGND VPWR VGND sky130_ef_sc_hd__decap_12
XFILLER_138_1191 VPWR VGND VPWR VGND sky130_ef_sc_hd__decap_12
XFILLER_0_658 VGND VGND VPWR VPWR sky130_fd_sc_hd__fill_2
XFILLER_251_1257 VPWR VGND VPWR VGND sky130_ef_sc_hd__decap_12
XFILLER_125_55 VGND VGND VPWR VPWR sky130_fd_sc_hd__fill_1
XFILLER_85_15 VPWR VGND VPWR VGND sky130_ef_sc_hd__decap_12
XFILLER_248_557 VPWR VGND VPWR VGND sky130_ef_sc_hd__decap_12
XTAP_TAPCELL_ROW_4_964 VGND VPWR sky130_fd_sc_hd__tapvpwrvgnd_1
XFILLER_5_1455 VGND VGND VPWR VPWR sky130_fd_sc_hd__fill_1
XTAP_TAPCELL_ROW_4_975 VGND VPWR sky130_fd_sc_hd__tapvpwrvgnd_1
XFILLER_217_933 VPWR VGND VPWR VGND sky130_ef_sc_hd__decap_12
XFILLER_18_53 VGND VGND VPWR VPWR sky130_fd_sc_hd__decap_8
XFILLER_216_421 VPWR VGND VPWR VGND sky130_ef_sc_hd__decap_12
XFILLER_186_1421 VGND VGND VPWR VPWR sky130_fd_sc_hd__decap_6
XFILLER_217_977 VPWR VGND VPWR VGND sky130_ef_sc_hd__decap_12
XFILLER_249_1175 VGND VGND VPWR VPWR sky130_fd_sc_hd__fill_1
XFILLER_186_1465 VPWR VGND VPWR VGND sky130_ef_sc_hd__decap_12
XFILLER_232_925 VPWR VGND VPWR VGND sky130_ef_sc_hd__decap_12
XFILLER_252_3 VPWR VGND VPWR VGND sky130_ef_sc_hd__decap_12
XFILLER_243_273 VGND VGND VPWR VPWR sky130_fd_sc_hd__decap_6
XFILLER_182_1329 VPWR VGND VPWR VGND sky130_ef_sc_hd__decap_12
XFILLER_203_137 VPWR VGND VPWR VGND sky130_ef_sc_hd__decap_12
XFILLER_34_41 VGND VGND VPWR VPWR sky130_fd_sc_hd__decap_8
XFILLER_34_63 VGND VGND VPWR VPWR sky130_fd_sc_hd__decap_8
XFILLER_19_1165 VPWR VGND VPWR VGND sky130_ef_sc_hd__decap_12
XFILLER_169_553 VGND VGND VPWR VPWR sky130_fd_sc_hd__decap_6
XFILLER_200_811 VGND VGND VPWR VPWR sky130_fd_sc_hd__fill_1
XFILLER_223_1337 VGND VGND VPWR VPWR sky130_fd_sc_hd__decap_6
XFILLER_184_501 VPWR VGND VPWR VGND sky130_ef_sc_hd__decap_12
XFILLER_197_895 VGND VGND VPWR VPWR sky130_fd_sc_hd__fill_1
XFILLER_212_693 VGND VGND VPWR VPWR sky130_fd_sc_hd__decap_6
Xwire100 net101 VGND VGND VPWR VPWR net100 sky130_fd_sc_hd__clkbuf_1
Xwire111 _203_ VGND VGND VPWR VPWR net111 sky130_fd_sc_hd__clkbuf_1
XFILLER_169_597 VPWR VGND VPWR VGND sky130_ef_sc_hd__decap_12
XFILLER_211_181 VPWR VGND VPWR VGND sky130_ef_sc_hd__decap_12
XFILLER_184_545 VPWR VGND VPWR VGND sky130_ef_sc_hd__decap_12
Xwire133 _157_ VGND VGND VPWR VPWR net133 sky130_fd_sc_hd__clkbuf_1
XFILLER_8_769 VGND VGND VPWR VPWR sky130_fd_sc_hd__decap_3
XFILLER_7_257 VGND VGND VPWR VPWR sky130_fd_sc_hd__fill_1
Xwire166 _139_ VGND VGND VPWR VPWR net166 sky130_fd_sc_hd__clkbuf_1
XFILLER_184_589 VPWR VGND VPWR VGND sky130_ef_sc_hd__decap_12
XFILLER_171_217 VGND VGND VPWR VPWR sky130_fd_sc_hd__decap_6
XTAP_TAPCELL_ROW_121_2_4483 VGND VPWR sky130_fd_sc_hd__tapvpwrvgnd_1
XFILLER_165_781 VGND VGND VPWR VPWR sky130_fd_sc_hd__decap_3
XFILLER_193_1425 VPWR VGND VPWR VGND sky130_ef_sc_hd__decap_12
XFILLER_217_1119 VGND VGND VPWR VPWR sky130_fd_sc_hd__fill_1
XFILLER_193_1469 VPWR VGND VPWR VGND sky130_ef_sc_hd__decap_12
XFILLER_117_1231 VPWR VGND VPWR VGND sky130_ef_sc_hd__decap_12
XFILLER_234_1477 VGND VGND VPWR VPWR sky130_fd_sc_hd__decap_6
XFILLER_117_1275 VPWR VGND VPWR VGND sky130_ef_sc_hd__decap_12
XFILLER_182_83 VGND VGND VPWR VPWR sky130_fd_sc_hd__fill_1
XFILLER_152_1177 VPWR VGND VPWR VGND sky130_ef_sc_hd__decap_12
XTAP_TAPCELL_ROW_68_2_4164 VGND VPWR sky130_fd_sc_hd__tapvpwrvgnd_1
XPHY_EDGE_ROW_101_2_Right_192 VGND VGND VPWR VPWR sky130_fd_sc_hd__decap_3
XFILLER_219_281 VPWR VGND VPWR VGND sky130_ef_sc_hd__decap_12
XFILLER_235_741 VPWR VGND VPWR VGND sky130_ef_sc_hd__decap_12
XFILLER_235_785 VPWR VGND VPWR VGND sky130_ef_sc_hd__decap_12
XFILLER_234_251 VGND VGND VPWR VPWR sky130_fd_sc_hd__fill_1
XTAP_TAPCELL_ROW_48_2_4040 VGND VPWR sky130_fd_sc_hd__tapvpwrvgnd_1
XPHY_EDGE_ROW_39_1_Right_695 VGND VGND VPWR VPWR sky130_fd_sc_hd__decap_3
XFILLER_222_413 VGND VGND VPWR VPWR sky130_fd_sc_hd__decap_6
XFILLER_179_317 VPWR VGND VPWR VGND sky130_ef_sc_hd__decap_12
XFILLER_228_1259 VGND VGND VPWR VPWR sky130_fd_sc_hd__fill_1
XFILLER_250_755 VGND VGND VPWR VPWR sky130_fd_sc_hd__fill_1
XFILLER_201_57 VPWR VGND VPWR VGND sky130_ef_sc_hd__decap_12
XFILLER_222_457 VPWR VGND VPWR VGND sky130_ef_sc_hd__decap_12
XTAP_TAPCELL_ROW_61_2_4118 VGND VPWR sky130_fd_sc_hd__tapvpwrvgnd_1
XFILLER_37_1243 VPWR VGND VPWR VGND sky130_ef_sc_hd__decap_12
XFILLER_98_3 VPWR VGND VPWR VGND sky130_ef_sc_hd__decap_12
XFILLER_128_1371 VPWR VGND VPWR VGND sky130_ef_sc_hd__decap_12
XTAP_TAPCELL_ROW_237_3274 VGND VPWR sky130_fd_sc_hd__tapvpwrvgnd_1
XFILLER_194_309 VPWR VGND VPWR VGND sky130_ef_sc_hd__decap_12
XFILLER_203_671 VGND VGND VPWR VPWR sky130_fd_sc_hd__fill_1
XFILLER_241_1437 VPWR VGND VPWR VGND sky130_ef_sc_hd__decap_12
XTAP_TAPCELL_ROW_237_3285 VGND VPWR sky130_fd_sc_hd__tapvpwrvgnd_1
XFILLER_163_1273 VGND VGND VPWR VPWR sky130_fd_sc_hd__fill_1
XFILLER_187_361 VPWR VGND VPWR VGND sky130_ef_sc_hd__decap_12
XTAP_TAPCELL_ROW_237_3296 VGND VPWR sky130_fd_sc_hd__tapvpwrvgnd_1
XFILLER_37_1287 VPWR VGND VPWR VGND sky130_ef_sc_hd__decap_12
XFILLER_72_1189 VGND VGND VPWR VPWR sky130_fd_sc_hd__fill_1
XPHY_EDGE_ROW_7_Left_263 VGND VGND VPWR VPWR sky130_fd_sc_hd__decap_3
XTAP_TAPCELL_ROW_26_2_3910 VGND VPWR sky130_fd_sc_hd__tapvpwrvgnd_1
XFILLER_196_1093 VPWR VGND VPWR VGND sky130_ef_sc_hd__decap_12
XFILLER_172_1509 VGND VGND VPWR VPWR sky130_fd_sc_hd__decap_6
XFILLER_239_1399 VGND VGND VPWR VPWR sky130_fd_sc_hd__fill_1
Xmax_cap499 _116_ VGND VGND VPWR VPWR net499 sky130_fd_sc_hd__clkbuf_1
XFILLER_226_65 VPWR VGND VPWR VGND sky130_ef_sc_hd__decap_12
XFILLER_44_1203 VPWR VGND VPWR VGND sky130_ef_sc_hd__decap_12
XFILLER_48_1383 VPWR VGND VPWR VGND sky130_ef_sc_hd__decap_12
XFILLER_135_1331 VPWR VGND VPWR VGND sky130_ef_sc_hd__decap_12
XFILLER_44_1247 VPWR VGND VPWR VGND sky130_ef_sc_hd__decap_12
XFILLER_131_1217 VGND VGND VPWR VPWR sky130_fd_sc_hd__fill_1
XFILLER_245_505 VPWR VGND VPWR VGND sky130_ef_sc_hd__decap_12
XFILLER_242_53 VPWR VGND VPWR VGND sky130_ef_sc_hd__decap_12
XTAP_TAPCELL_ROW_1_901 VGND VPWR sky130_fd_sc_hd__tapvpwrvgnd_1
XFILLER_242_97 VPWR VGND VPWR VGND sky130_ef_sc_hd__decap_12
XFILLER_246_1315 VGND VGND VPWR VPWR sky130_fd_sc_hd__fill_1
XTAP_TAPCELL_ROW_38_1_1173 VGND VPWR sky130_fd_sc_hd__tapvpwrvgnd_1
XFILLER_214_925 VPWR VGND VPWR VGND sky130_ef_sc_hd__decap_12
XTAP_TAPCELL_ROW_222_2875 VGND VPWR sky130_fd_sc_hd__tapvpwrvgnd_1
XFILLER_0_1341 VGND VGND VPWR VPWR sky130_fd_sc_hd__decap_3
XTAP_TAPCELL_ROW_222_2886 VGND VPWR sky130_fd_sc_hd__tapvpwrvgnd_1
XFILLER_225_273 VGND VGND VPWR VPWR sky130_fd_sc_hd__decap_6
XFILLER_168_1173 VPWR VGND VPWR VGND sky130_ef_sc_hd__decap_12
XFILLER_240_221 VPWR VGND VPWR VGND sky130_ef_sc_hd__decap_12
XFILLER_198_637 VGND VGND VPWR VPWR sky130_fd_sc_hd__decap_6
XFILLER_111_57 VPWR VGND VPWR VGND sky130_ef_sc_hd__decap_12
XFILLER_197_125 VPWR VGND VPWR VGND sky130_ef_sc_hd__decap_12
XFILLER_0_1385 VPWR VGND VPWR VGND sky130_ef_sc_hd__decap_12
XFILLER_241_777 VGND VGND VPWR VPWR sky130_fd_sc_hd__decap_6
XFILLER_205_1001 VGND VGND VPWR VPWR sky130_fd_sc_hd__decap_6
XFILLER_244_1061 VPWR VGND VPWR VGND sky130_ef_sc_hd__decap_12
XFILLER_240_265 VPWR VGND VPWR VGND sky130_ef_sc_hd__decap_12
XFILLER_55_1343 VPWR VGND VPWR VGND sky130_ef_sc_hd__decap_12
XFILLER_71_39 VPWR VGND VPWR VGND sky130_ef_sc_hd__decap_12
XFILLER_107_1411 VPWR VGND VPWR VGND sky130_ef_sc_hd__decap_12
XFILLER_146_1471 VPWR VGND VPWR VGND sky130_ef_sc_hd__decap_12
XFILLER_197_169 VPWR VGND VPWR VGND sky130_ef_sc_hd__decap_12
XFILLER_90_1245 VGND VGND VPWR VPWR sky130_fd_sc_hd__fill_1
XFILLER_16_1327 VPWR VGND VPWR VGND sky130_ef_sc_hd__decap_12
XFILLER_166_501 VPWR VGND VPWR VGND sky130_ef_sc_hd__decap_12
XFILLER_55_1387 VPWR VGND VPWR VGND sky130_ef_sc_hd__decap_12
XFILLER_179_895 VGND VGND VPWR VPWR sky130_fd_sc_hd__fill_1
XFILLER_187_39 VPWR VGND VPWR VGND sky130_ef_sc_hd__decap_12
XFILLER_205_1045 VPWR VGND VPWR VGND sky130_ef_sc_hd__decap_12
XFILLER_107_1455 VPWR VGND VPWR VGND sky130_ef_sc_hd__decap_12
XFILLER_142_1357 VGND VGND VPWR VPWR sky130_fd_sc_hd__fill_1
XFILLER_166_545 VPWR VGND VPWR VGND sky130_ef_sc_hd__decap_12
XFILLER_107_1499 VPWR VGND VPWR VGND sky130_ef_sc_hd__decap_12
XFILLER_205_1089 VPWR VGND VPWR VGND sky130_ef_sc_hd__decap_12
XFILLER_166_589 VPWR VGND VPWR VGND sky130_ef_sc_hd__decap_12
XFILLER_4_227 VPWR VGND VPWR VGND sky130_ef_sc_hd__decap_12
XFILLER_181_559 VGND VGND VPWR VPWR sky130_fd_sc_hd__fill_1
XTAP_TAPCELL_ROW_74_2_4196 VGND VPWR sky130_fd_sc_hd__tapvpwrvgnd_1
XFILLER_175_1133 VPWR VGND VPWR VGND sky130_ef_sc_hd__decap_12
XFILLER_20_65 VGND VGND VPWR VPWR sky130_fd_sc_hd__decap_6
XFILLER_1_912 VPWR VGND VPWR VGND sky130_ef_sc_hd__decap_12
XFILLER_0_400 VGND VGND VPWR VPWR sky130_fd_sc_hd__fill_1
XFILLER_136_65 VGND VGND VPWR VPWR sky130_fd_sc_hd__decap_6
XFILLER_175_1177 VPWR VGND VPWR VGND sky130_ef_sc_hd__decap_12
XFILLER_62_1303 VPWR VGND VPWR VGND sky130_ef_sc_hd__decap_12
XFILLER_27_1423 VPWR VGND VPWR VGND sky130_ef_sc_hd__decap_12
XFILLER_251_1021 VPWR VGND VPWR VGND sky130_ef_sc_hd__decap_12
XFILLER_216_1141 VGND VGND VPWR VPWR sky130_fd_sc_hd__decap_6
XFILLER_249_833 VGND VGND VPWR VPWR sky130_fd_sc_hd__decap_6
XFILLER_66_1483 VPWR VGND VPWR VGND sky130_ef_sc_hd__decap_12
XFILLER_248_321 VPWR VGND VPWR VGND sky130_ef_sc_hd__decap_12
XFILLER_27_1467 VPWR VGND VPWR VGND sky130_ef_sc_hd__decap_12
XFILLER_1_989 VPWR VGND VPWR VGND sky130_ef_sc_hd__decap_12
XFILLER_114_1415 VPWR VGND VPWR VGND sky130_ef_sc_hd__decap_12
XFILLER_212_1005 VPWR VGND VPWR VGND sky130_ef_sc_hd__decap_12
XFILLER_251_1065 VPWR VGND VPWR VGND sky130_ef_sc_hd__decap_12
XFILLER_0_477 VGND VGND VPWR VPWR sky130_fd_sc_hd__fill_2
XFILLER_216_1185 VPWR VGND VPWR VGND sky130_ef_sc_hd__decap_12
XFILLER_249_877 VPWR VGND VPWR VGND sky130_ef_sc_hd__decap_12
XFILLER_248_365 VPWR VGND VPWR VGND sky130_ef_sc_hd__decap_12
XFILLER_153_1497 VGND VGND VPWR VPWR sky130_fd_sc_hd__fill_1
XFILLER_212_1049 VPWR VGND VPWR VGND sky130_ef_sc_hd__decap_12
XFILLER_152_53 VPWR VGND VPWR VGND sky130_ef_sc_hd__decap_12
X_663_ clknet_3_5__leaf_clk acc_core.adder.cla_blocks\[7\].block.sum\[1\] _071_ VGND
+ VGND VPWR VPWR net64 sky130_fd_sc_hd__dfrtp_1
XFILLER_217_741 VPWR VGND VPWR VGND sky130_ef_sc_hd__decap_12
XFILLER_229_1513 VGND VGND VPWR VPWR sky130_fd_sc_hd__fill_2
XFILLER_216_251 VGND VGND VPWR VPWR sky130_fd_sc_hd__fill_1
XFILLER_217_785 VPWR VGND VPWR VGND sky130_ef_sc_hd__decap_12
XFILLER_45_51 VGND VGND VPWR VPWR sky130_fd_sc_hd__decap_4
X_594_ clknet_3_2__leaf_clk _076_ _002_ VGND VGND VPWR VPWR rd_addr\[2\] sky130_fd_sc_hd__dfrtp_1
XFILLER_147_1213 VGND VGND VPWR VPWR sky130_fd_sc_hd__decap_4
XFILLER_204_413 VGND VGND VPWR VPWR sky130_fd_sc_hd__decap_6
XFILLER_186_1273 VPWR VGND VPWR VGND sky130_ef_sc_hd__decap_12
XFILLER_189_615 VGND VGND VPWR VPWR sky130_fd_sc_hd__fill_1
XFILLER_232_755 VGND VGND VPWR VPWR sky130_fd_sc_hd__fill_1
XFILLER_95_1189 VPWR VGND VPWR VGND sky130_ef_sc_hd__decap_12
XFILLER_204_457 VPWR VGND VPWR VGND sky130_ef_sc_hd__decap_12
XFILLER_220_917 VGND VGND VPWR VPWR sky130_fd_sc_hd__decap_6
XFILLER_73_1443 VPWR VGND VPWR VGND sky130_ef_sc_hd__decap_12
XFILLER_223_1101 VPWR VGND VPWR VGND sky130_ef_sc_hd__decap_12
XFILLER_125_1511 VGND VGND VPWR VPWR sky130_fd_sc_hd__decap_4
XFILLER_176_309 VPWR VGND VPWR VGND sky130_ef_sc_hd__decap_12
XFILLER_227_1281 VGND VGND VPWR VPWR sky130_fd_sc_hd__decap_6
XFILLER_160_1413 VGND VGND VPWR VPWR sky130_fd_sc_hd__fill_1
XFILLER_169_361 VPWR VGND VPWR VGND sky130_ef_sc_hd__decap_12
XFILLER_34_1427 VPWR VGND VPWR VGND sky130_ef_sc_hd__decap_12
XFILLER_185_821 VPWR VGND VPWR VGND sky130_ef_sc_hd__decap_12
XFILLER_223_1145 VPWR VGND VPWR VGND sky130_ef_sc_hd__decap_12
XFILLER_185_865 VPWR VGND VPWR VGND sky130_ef_sc_hd__decap_12
XFILLER_223_1189 VPWR VGND VPWR VGND sky130_ef_sc_hd__decap_12
XTAP_TAPCELL_ROW_232_3160 VGND VPWR sky130_fd_sc_hd__tapvpwrvgnd_1
XANTENNA_5 dout0\[7\] VGND VGND VPWR VPWR sky130_fd_sc_hd__diode_2
XFILLER_193_1233 VPWR VGND VPWR VGND sky130_ef_sc_hd__decap_12
XPHY_EDGE_ROW_234_Right_79 VGND VGND VPWR VPWR sky130_fd_sc_hd__decap_3
XFILLER_10_1471 VPWR VGND VPWR VGND sky130_ef_sc_hd__decap_12
XFILLER_4_772 VGND VGND VPWR VPWR sky130_fd_sc_hd__fill_2
XFILLER_180_581 VGND VGND VPWR VPWR sky130_fd_sc_hd__decap_6
XTAP_TAPCELL_ROW_245_3510 VGND VPWR sky130_fd_sc_hd__tapvpwrvgnd_1
XFILLER_154_1239 VGND VGND VPWR VPWR sky130_fd_sc_hd__decap_6
XFILLER_193_93 VPWR VGND VPWR VGND sky130_ef_sc_hd__decap_12
XFILLER_234_1241 VPWR VGND VPWR VGND sky130_ef_sc_hd__decap_12
XFILLER_6_1005 VPWR VGND VPWR VGND sky130_ef_sc_hd__decap_12
XFILLER_230_1105 VPWR VGND VPWR VGND sky130_ef_sc_hd__decap_12
XFILLER_234_1285 VPWR VGND VPWR VGND sky130_ef_sc_hd__decap_12
XFILLER_80_1469 VGND VGND VPWR VPWR sky130_fd_sc_hd__fill_1
XFILLER_227_505 VPWR VGND VPWR VGND sky130_ef_sc_hd__decap_12
XFILLER_255_825 VPWR VGND VPWR VGND sky130_ef_sc_hd__decap_12
XFILLER_6_1049 VPWR VGND VPWR VGND sky130_ef_sc_hd__decap_12
XFILLER_230_1149 VPWR VGND VPWR VGND sky130_ef_sc_hd__decap_12
XFILLER_13_3 VPWR VGND VPWR VGND sky130_ef_sc_hd__decap_12
XTAP_TAPCELL_ROW_7_1044 VGND VPWR sky130_fd_sc_hd__tapvpwrvgnd_1
XTAP_TAPCELL_ROW_7_1055 VGND VPWR sky130_fd_sc_hd__tapvpwrvgnd_1
XFILLER_255_869 VPWR VGND VPWR VGND sky130_ef_sc_hd__decap_12
XFILLER_254_357 VGND VGND VPWR VPWR sky130_fd_sc_hd__decap_6
XTAP_TAPCELL_ROW_143_2_4615 VGND VPWR sky130_fd_sc_hd__tapvpwrvgnd_1
XPHY_EDGE_ROW_102_2_Right_193 VGND VGND VPWR VPWR sky130_fd_sc_hd__decap_3
XPHY_EDGE_ROW_18_1_Left_273 VGND VGND VPWR VPWR sky130_fd_sc_hd__decap_3
XFILLER_130_1283 VPWR VGND VPWR VGND sky130_ef_sc_hd__decap_12
XPHY_EDGE_ROW_243_Right_88 VGND VGND VPWR VPWR sky130_fd_sc_hd__decap_3
XTAP_TAPCELL_ROW_239_3325 VGND VPWR sky130_fd_sc_hd__tapvpwrvgnd_1
XFILLER_165_1313 VGND VGND VPWR VPWR sky130_fd_sc_hd__decap_3
XFILLER_207_273 VGND VGND VPWR VPWR sky130_fd_sc_hd__decap_6
XTAP_TAPCELL_ROW_239_3336 VGND VPWR sky130_fd_sc_hd__tapvpwrvgnd_1
XFILLER_169_1493 VPWR VGND VPWR VGND sky130_ef_sc_hd__decap_12
XTAP_TAPCELL_ROW_239_3347 VGND VPWR sky130_fd_sc_hd__tapvpwrvgnd_1
XFILLER_222_221 VPWR VGND VPWR VGND sky130_ef_sc_hd__decap_12
XFILLER_179_125 VPWR VGND VPWR VGND sky130_ef_sc_hd__decap_12
XFILLER_165_1357 VPWR VGND VPWR VGND sky130_ef_sc_hd__decap_12
XFILLER_223_777 VGND VGND VPWR VPWR sky130_fd_sc_hd__decap_6
XFILLER_222_265 VPWR VGND VPWR VGND sky130_ef_sc_hd__decap_12
XFILLER_241_1201 VPWR VGND VPWR VGND sky130_ef_sc_hd__decap_12
XFILLER_245_1381 VPWR VGND VPWR VGND sky130_ef_sc_hd__decap_12
XFILLER_179_169 VPWR VGND VPWR VGND sky130_ef_sc_hd__decap_12
XFILLER_195_629 VPWR VGND VPWR VGND sky130_ef_sc_hd__decap_12
XFILLER_188_681 VPWR VGND VPWR VGND sky130_ef_sc_hd__decap_12
XFILLER_241_1245 VPWR VGND VPWR VGND sky130_ef_sc_hd__decap_12
XFILLER_206_1365 VGND VGND VPWR VPWR sky130_fd_sc_hd__decap_6
XTAP_TAPCELL_ROW_91_2_4302 VGND VPWR sky130_fd_sc_hd__tapvpwrvgnd_1
XFILLER_194_139 VGND VGND VPWR VPWR sky130_fd_sc_hd__fill_1
XFILLER_202_1229 VPWR VGND VPWR VGND sky130_ef_sc_hd__decap_12
XFILLER_241_1289 VPWR VGND VPWR VGND sky130_ef_sc_hd__decap_12
XFILLER_11_1213 VGND VGND VPWR VPWR sky130_fd_sc_hd__decap_4
XFILLER_190_301 VGND VGND VPWR VPWR sky130_fd_sc_hd__decap_6
XPHY_EDGE_ROW_252_Right_97 VGND VGND VPWR VPWR sky130_fd_sc_hd__decap_3
XFILLER_50_1295 VGND VGND VPWR VPWR sky130_fd_sc_hd__decap_6
XFILLER_190_345 VPWR VGND VPWR VGND sky130_ef_sc_hd__decap_12
XTAP_TAPCELL_ROW_215_2690 VGND VPWR sky130_fd_sc_hd__tapvpwrvgnd_1
XFILLER_176_1453 VPWR VGND VPWR VGND sky130_ef_sc_hd__decap_12
XFILLER_190_389 VPWR VGND VPWR VGND sky130_ef_sc_hd__decap_12
XTAP_TAPCELL_ROW_211_2576 VGND VPWR sky130_fd_sc_hd__tapvpwrvgnd_1
XFILLER_172_1317 VPWR VGND VPWR VGND sky130_ef_sc_hd__decap_12
XTAP_TAPCELL_ROW_211_2587 VGND VPWR sky130_fd_sc_hd__tapvpwrvgnd_1
XFILLER_176_1497 VPWR VGND VPWR VGND sky130_ef_sc_hd__decap_12
XFILLER_252_1341 VPWR VGND VPWR VGND sky130_ef_sc_hd__decap_12
XFILLER_48_1191 VPWR VGND VPWR VGND sky130_ef_sc_hd__decap_12
XFILLER_213_1325 VPWR VGND VPWR VGND sky130_ef_sc_hd__decap_12
XFILLER_252_1385 VPWR VGND VPWR VGND sky130_ef_sc_hd__decap_12
XFILLER_246_825 VPWR VGND VPWR VGND sky130_ef_sc_hd__decap_12
XFILLER_213_1369 VPWR VGND VPWR VGND sky130_ef_sc_hd__decap_12
XPHY_EDGE_ROW_151_1_Left_406 VGND VGND VPWR VPWR sky130_fd_sc_hd__decap_3
XFILLER_170_1085 VGND VGND VPWR VPWR sky130_fd_sc_hd__decap_6
XTAP_TAPCELL_ROW_224_2926 VGND VPWR sky130_fd_sc_hd__tapvpwrvgnd_1
XTAP_TAPCELL_ROW_37_2_3979 VGND VPWR sky130_fd_sc_hd__tapvpwrvgnd_1
XTAP_TAPCELL_ROW_224_2937 VGND VPWR sky130_fd_sc_hd__tapvpwrvgnd_1
XFILLER_245_335 VGND VGND VPWR VPWR sky130_fd_sc_hd__fill_1
XFILLER_246_869 VPWR VGND VPWR VGND sky130_ef_sc_hd__decap_12
XFILLER_82_27 VGND VGND VPWR VPWR sky130_fd_sc_hd__fill_1
XFILLER_183_1413 VPWR VGND VPWR VGND sky130_ef_sc_hd__decap_12
XFILLER_198_401 VPWR VGND VPWR VGND sky130_ef_sc_hd__decap_12
XTAP_TAPCELL_ROW_17_2_3855 VGND VPWR sky130_fd_sc_hd__tapvpwrvgnd_1
XFILLER_241_541 VPWR VGND VPWR VGND sky130_ef_sc_hd__decap_12
XFILLER_198_27 VGND VGND VPWR VPWR sky130_fd_sc_hd__fill_1
XFILLER_214_755 VGND VGND VPWR VPWR sky130_fd_sc_hd__fill_1
XFILLER_183_1457 VPWR VGND VPWR VGND sky130_ef_sc_hd__decap_12
XFILLER_198_445 VPWR VGND VPWR VGND sky130_ef_sc_hd__decap_12
XFILLER_202_917 VGND VGND VPWR VPWR sky130_fd_sc_hd__decap_6
XFILLER_201_405 VPWR VGND VPWR VGND sky130_ef_sc_hd__decap_12
XFILLER_15_54 VGND VGND VPWR VPWR sky130_fd_sc_hd__fill_2
XFILLER_241_585 VPWR VGND VPWR VGND sky130_ef_sc_hd__decap_12
XFILLER_224_1421 VGND VGND VPWR VPWR sky130_fd_sc_hd__decap_6
XFILLER_198_489 VPWR VGND VPWR VGND sky130_ef_sc_hd__decap_12
XFILLER_9_319 VPWR VGND VPWR VGND sky130_ef_sc_hd__decap_12
XFILLER_167_821 VPWR VGND VPWR VGND sky130_ef_sc_hd__decap_12
XFILLER_201_449 VPWR VGND VPWR VGND sky130_ef_sc_hd__decap_12
XFILLER_224_1465 VPWR VGND VPWR VGND sky130_ef_sc_hd__decap_12
XTAP_TAPCELL_ROW_156_2_4693 VGND VPWR sky130_fd_sc_hd__tapvpwrvgnd_1
XFILLER_210_961 VPWR VGND VPWR VGND sky130_ef_sc_hd__decap_12
XFILLER_167_865 VPWR VGND VPWR VGND sky130_ef_sc_hd__decap_12
XFILLER_220_1329 VPWR VGND VPWR VGND sky130_ef_sc_hd__decap_12
XFILLER_142_1165 VPWR VGND VPWR VGND sky130_ef_sc_hd__decap_12
XFILLER_182_813 VPWR VGND VPWR VGND sky130_ef_sc_hd__decap_12
XFILLER_193_161 VGND VGND VPWR VPWR sky130_fd_sc_hd__decap_6
XFILLER_215_3 VPWR VGND VPWR VGND sky130_ef_sc_hd__decap_12
XFILLER_120_1463 VGND VGND VPWR VPWR sky130_fd_sc_hd__decap_6
XFILLER_218_1203 VGND VGND VPWR VPWR sky130_fd_sc_hd__fill_1
Xoutput53 net53 VGND VGND VPWR VPWR acc_out[19] sky130_fd_sc_hd__buf_2
Xoutput64 net64 VGND VGND VPWR VPWR acc_out[29] sky130_fd_sc_hd__buf_2
XFILLER_27_1231 VPWR VGND VPWR VGND sky130_ef_sc_hd__decap_12
XFILLER_249_641 VPWR VGND VPWR VGND sky130_ef_sc_hd__decap_12
XFILLER_7_1325 VPWR VGND VPWR VGND sky130_ef_sc_hd__decap_12
XFILLER_231_1425 VPWR VGND VPWR VGND sky130_ef_sc_hd__decap_12
XPHY_EDGE_ROW_83_1_Left_338 VGND VGND VPWR VPWR sky130_fd_sc_hd__decap_3
XFILLER_27_1275 VPWR VGND VPWR VGND sky130_ef_sc_hd__decap_12
XFILLER_209_505 VPWR VGND VPWR VGND sky130_ef_sc_hd__decap_12
XFILLER_249_685 VPWR VGND VPWR VGND sky130_ef_sc_hd__decap_12
XFILLER_62_1177 VPWR VGND VPWR VGND sky130_ef_sc_hd__decap_12
XFILLER_114_1245 VGND VGND VPWR VPWR sky130_fd_sc_hd__fill_1
XFILLER_7_1369 VPWR VGND VPWR VGND sky130_ef_sc_hd__decap_12
XFILLER_231_1469 VPWR VGND VPWR VGND sky130_ef_sc_hd__decap_12
XTAP_TAPCELL_ROW_186_1896 VGND VPWR sky130_fd_sc_hd__tapvpwrvgnd_1
XFILLER_248_195 VGND VGND VPWR VPWR sky130_fd_sc_hd__fill_1
XFILLER_236_357 VGND VGND VPWR VPWR sky130_fd_sc_hd__decap_6
XFILLER_251_305 VPWR VGND VPWR VGND sky130_ef_sc_hd__decap_12
X_646_ clknet_3_1__leaf_clk acc_core.adder.cla_blocks\[3\].block.sum\[0\] _054_ VGND
+ VGND VPWR VPWR net46 sky130_fd_sc_hd__dfrtp_1
XTAP_TAPCELL_ROW_96_2_4328 VGND VPWR sky130_fd_sc_hd__tapvpwrvgnd_1
XFILLER_229_1343 VGND VGND VPWR VPWR sky130_fd_sc_hd__fill_1
XFILLER_251_349 VPWR VGND VPWR VGND sky130_ef_sc_hd__decap_12
XFILLER_204_221 VPWR VGND VPWR VGND sky130_ef_sc_hd__decap_12
XTAP_TAPCELL_ROW_108_2_4404 VGND VPWR sky130_fd_sc_hd__tapvpwrvgnd_1
X_577_ net667 VGND VGND VPWR VPWR _059_ sky130_fd_sc_hd__inv_2
XFILLER_205_777 VGND VGND VPWR VPWR sky130_fd_sc_hd__decap_6
XFILLER_204_265 VPWR VGND VPWR VGND sky130_ef_sc_hd__decap_12
XFILLER_220_725 VPWR VGND VPWR VGND sky130_ef_sc_hd__decap_12
XTAP_TAPCELL_ROW_234_3200 VGND VPWR sky130_fd_sc_hd__tapvpwrvgnd_1
XTAP_TAPCELL_ROW_234_3211 VGND VPWR sky130_fd_sc_hd__tapvpwrvgnd_1
XFILLER_38_1371 VPWR VGND VPWR VGND sky130_ef_sc_hd__decap_12
XFILLER_177_629 VPWR VGND VPWR VGND sky130_ef_sc_hd__decap_12
XFILLER_203_1505 VGND VGND VPWR VPWR sky130_fd_sc_hd__decap_6
XFILLER_73_1273 VGND VGND VPWR VPWR sky130_fd_sc_hd__fill_1
XFILLER_220_769 VPWR VGND VPWR VGND sky130_ef_sc_hd__decap_12
XFILLER_176_139 VGND VGND VPWR VPWR sky130_fd_sc_hd__fill_1
XFILLER_9_853 VPWR VGND VPWR VGND sky130_ef_sc_hd__decap_12
XTAP_TAPCELL_ROW_230_3108 VGND VPWR sky130_fd_sc_hd__tapvpwrvgnd_1
XFILLER_125_1385 VGND VGND VPWR VPWR sky130_fd_sc_hd__fill_1
XFILLER_185_673 VPWR VGND VPWR VGND sky130_ef_sc_hd__decap_12
XPHY_EDGE_ROW_160_1_Right_816 VGND VGND VPWR VPWR sky130_fd_sc_hd__decap_3
XFILLER_172_301 VGND VGND VPWR VPWR sky130_fd_sc_hd__decap_6
XFILLER_9_897 VPWR VGND VPWR VGND sky130_ef_sc_hd__decap_12
XFILLER_172_345 VPWR VGND VPWR VGND sky130_ef_sc_hd__decap_12
XFILLER_172_389 VPWR VGND VPWR VGND sky130_ef_sc_hd__decap_12
XFILLER_193_1063 VGND VGND VPWR VPWR sky130_fd_sc_hd__fill_1
XTAP_TAPCELL_ROW_228_3037 VGND VPWR sky130_fd_sc_hd__tapvpwrvgnd_1
XTAP_TAPCELL_ROW_228_3048 VGND VPWR sky130_fd_sc_hd__tapvpwrvgnd_1
XFILLER_45_1331 VPWR VGND VPWR VGND sky130_ef_sc_hd__decap_12
XTAP_TAPCELL_ROW_9_1106 VGND VPWR sky130_fd_sc_hd__tapvpwrvgnd_1
XTAP_TAPCELL_ROW_9_1117 VGND VPWR sky130_fd_sc_hd__tapvpwrvgnd_1
XFILLER_119_1189 VPWR VGND VPWR VGND sky130_ef_sc_hd__decap_12
XFILLER_132_1301 VGND VGND VPWR VPWR sky130_fd_sc_hd__fill_1
XTAP_TAPCELL_ROW_9_1128 VGND VPWR sky130_fd_sc_hd__tapvpwrvgnd_1
XTAP_TAPCELL_ROW_9_1139 VGND VPWR sky130_fd_sc_hd__tapvpwrvgnd_1
XFILLER_234_1093 VPWR VGND VPWR VGND sky130_ef_sc_hd__decap_12
XFILLER_41_1217 VGND VGND VPWR VPWR sky130_fd_sc_hd__fill_1
XFILLER_228_825 VPWR VGND VPWR VGND sky130_ef_sc_hd__decap_12
XFILLER_210_1509 VGND VGND VPWR VPWR sky130_fd_sc_hd__decap_6
XFILLER_254_121 VPWR VGND VPWR VGND sky130_ef_sc_hd__decap_12
XFILLER_223_55 VGND VGND VPWR VPWR sky130_fd_sc_hd__fill_1
XFILLER_227_335 VGND VGND VPWR VPWR sky130_fd_sc_hd__fill_1
XFILLER_228_869 VPWR VGND VPWR VGND sky130_ef_sc_hd__decap_12
XFILLER_254_165 VPWR VGND VPWR VGND sky130_ef_sc_hd__decap_12
XFILLER_243_839 VGND VGND VPWR VPWR sky130_fd_sc_hd__fill_1
XPHY_EDGE_ROW_103_2_Right_194 VGND VGND VPWR VPWR sky130_fd_sc_hd__decap_3
XTAP_TAPCELL_ROW_204_2380 VGND VPWR sky130_fd_sc_hd__tapvpwrvgnd_1
XFILLER_165_1121 VPWR VGND VPWR VGND sky130_ef_sc_hd__decap_12
XTAP_TAPCELL_ROW_204_2391 VGND VPWR sky130_fd_sc_hd__tapvpwrvgnd_1
XFILLER_223_541 VPWR VGND VPWR VGND sky130_ef_sc_hd__decap_12
XFILLER_208_1427 VGND VGND VPWR VPWR sky130_fd_sc_hd__fill_1
XFILLER_196_905 VPWR VGND VPWR VGND sky130_ef_sc_hd__decap_12
XFILLER_39_1168 VPWR VGND VPWR VGND sky130_ef_sc_hd__decap_12
XTAP_TAPCELL_ROW_200_2277 VGND VPWR sky130_fd_sc_hd__tapvpwrvgnd_1
XFILLER_223_585 VPWR VGND VPWR VGND sky130_ef_sc_hd__decap_12
XFILLER_17_1411 VPWR VGND VPWR VGND sky130_ef_sc_hd__decap_12
XTAP_TAPCELL_ROW_196_2170 VGND VPWR sky130_fd_sc_hd__tapvpwrvgnd_1
XFILLER_56_1471 VPWR VGND VPWR VGND sky130_ef_sc_hd__decap_12
XFILLER_196_949 VPWR VGND VPWR VGND sky130_ef_sc_hd__decap_12
XTAP_TAPCELL_ROW_196_2181 VGND VPWR sky130_fd_sc_hd__tapvpwrvgnd_1
XTAP_TAPCELL_ROW_200_2288 VGND VPWR sky130_fd_sc_hd__tapvpwrvgnd_1
XFILLER_143_1441 VGND VGND VPWR VPWR sky130_fd_sc_hd__fill_1
XFILLER_17_1455 VPWR VGND VPWR VGND sky130_ef_sc_hd__decap_12
XTAP_TAPCELL_ROW_192_2056 VGND VPWR sky130_fd_sc_hd__tapvpwrvgnd_1
XFILLER_206_1173 VPWR VGND VPWR VGND sky130_ef_sc_hd__decap_12
XFILLER_52_1357 VGND VGND VPWR VPWR sky130_fd_sc_hd__fill_1
XTAP_TAPCELL_ROW_192_2067 VGND VPWR sky130_fd_sc_hd__tapvpwrvgnd_1
XTAP_TAPCELL_ROW_217_2741 VGND VPWR sky130_fd_sc_hd__tapvpwrvgnd_1
XTAP_TAPCELL_ROW_192_2078 VGND VPWR sky130_fd_sc_hd__tapvpwrvgnd_1
XTAP_TAPCELL_ROW_217_2752 VGND VPWR sky130_fd_sc_hd__tapvpwrvgnd_1
XFILLER_248_41 VPWR VGND VPWR VGND sky130_ef_sc_hd__decap_12
XFILLER_182_109 VPWR VGND VPWR VGND sky130_ef_sc_hd__decap_12
XFILLER_202_1037 VPWR VGND VPWR VGND sky130_ef_sc_hd__decap_12
XFILLER_17_1499 VPWR VGND VPWR VGND sky130_ef_sc_hd__decap_12
XFILLER_175_161 VGND VGND VPWR VPWR sky130_fd_sc_hd__decap_6
XFILLER_104_1469 VGND VGND VPWR VPWR sky130_fd_sc_hd__fill_1
XFILLER_248_85 VPWR VGND VPWR VGND sky130_ef_sc_hd__decap_12
XTAP_TAPCELL_ROW_213_2627 VGND VPWR sky130_fd_sc_hd__tapvpwrvgnd_1
XTAP_TAPCELL_ROW_213_2638 VGND VPWR sky130_fd_sc_hd__tapvpwrvgnd_1
XTAP_TAPCELL_ROW_213_2649 VGND VPWR sky130_fd_sc_hd__tapvpwrvgnd_1
XFILLER_184_29 VPWR VGND VPWR VGND sky130_ef_sc_hd__decap_12
XFILLER_191_665 VGND VGND VPWR VPWR sky130_fd_sc_hd__decap_6
XFILLER_190_153 VPWR VGND VPWR VGND sky130_ef_sc_hd__decap_12
XFILLER_137_1201 VPWR VGND VPWR VGND sky130_ef_sc_hd__decap_12
Xsram0_679 VGND VGND VPWR VPWR sram0_679/HI net679 sky130_fd_sc_hd__conb_1
XFILLER_176_1261 VPWR VGND VPWR VGND sky130_ef_sc_hd__decap_12
XFILLER_190_197 VPWR VGND VPWR VGND sky130_ef_sc_hd__decap_12
XFILLER_85_1177 VPWR VGND VPWR VGND sky130_ef_sc_hd__decap_12
XFILLER_77_27 VPWR VGND VPWR VGND sky130_ef_sc_hd__decap_12
XFILLER_137_1267 VGND VGND VPWR VPWR sky130_fd_sc_hd__decap_6
XFILLER_172_1147 VGND VGND VPWR VPWR sky130_fd_sc_hd__fill_1
XFILLER_24_1415 VPWR VGND VPWR VGND sky130_ef_sc_hd__decap_12
XFILLER_213_1133 VPWR VGND VPWR VGND sky130_ef_sc_hd__decap_12
XTAP_TAPCELL_ROW_114_2_4436 VGND VPWR sky130_fd_sc_hd__tapvpwrvgnd_1
XFILLER_4_1509 VGND VGND VPWR VPWR sky130_fd_sc_hd__decap_6
XFILLER_63_1497 VGND VGND VPWR VPWR sky130_fd_sc_hd__fill_1
XFILLER_133_55 VGND VGND VPWR VPWR sky130_fd_sc_hd__fill_1
XFILLER_213_1177 VPWR VGND VPWR VGND sky130_ef_sc_hd__decap_12
XFILLER_93_15 VPWR VGND VPWR VGND sky130_ef_sc_hd__decap_12
XFILLER_218_357 VGND VGND VPWR VPWR sky130_fd_sc_hd__decap_6
XTAP_TAPCELL_ROW_82_2_4247 VGND VPWR sky130_fd_sc_hd__tapvpwrvgnd_1
XFILLER_248_1229 VPWR VGND VPWR VGND sky130_ef_sc_hd__decap_12
X_500_ net503 net90 VGND VGND VPWR VPWR _255_ sky130_fd_sc_hd__nor2_1
XFILLER_233_305 VPWR VGND VPWR VGND sky130_ef_sc_hd__decap_12
XFILLER_246_699 VGND VGND VPWR VPWR sky130_fd_sc_hd__fill_1
XTAP_TAPCELL_ROW_181_1760 VGND VPWR sky130_fd_sc_hd__tapvpwrvgnd_1
XTAP_TAPCELL_ROW_181_1771 VGND VPWR sky130_fd_sc_hd__tapvpwrvgnd_1
XTAP_TAPCELL_ROW_181_1782 VGND VPWR sky130_fd_sc_hd__tapvpwrvgnd_1
XFILLER_57_1213 VGND VGND VPWR VPWR sky130_fd_sc_hd__decap_4
XFILLER_165_3 VPWR VGND VPWR VGND sky130_ef_sc_hd__decap_12
XFILLER_199_721 VGND VGND VPWR VPWR sky130_fd_sc_hd__decap_6
XFILLER_233_349 VPWR VGND VPWR VGND sky130_ef_sc_hd__decap_12
Xclkbuf_3_6__f_clk clknet_0_clk VGND VGND VPWR VPWR clknet_3_6__leaf_clk sky130_fd_sc_hd__clkbuf_16
X_431_ net128 VGND VGND VPWR VPWR _220_ sky130_fd_sc_hd__inv_2
XFILLER_242_861 VGND VGND VPWR VPWR sky130_fd_sc_hd__decap_6
XFILLER_96_1295 VGND VGND VPWR VPWR sky130_fd_sc_hd__decap_6
XFILLER_199_765 VPWR VGND VPWR VGND sky130_ef_sc_hd__decap_12
XFILLER_198_253 VPWR VGND VPWR VGND sky130_ef_sc_hd__decap_12
X_362_ net592 net574 net546 VGND VGND VPWR VPWR _151_ sky130_fd_sc_hd__and3_1
XFILLER_202_725 VPWR VGND VPWR VGND sky130_ef_sc_hd__decap_12
XFILLER_144_1227 VPWR VGND VPWR VGND sky130_ef_sc_hd__decap_12
XFILLER_35_1511 VGND VGND VPWR VPWR sky130_fd_sc_hd__decap_4
XFILLER_183_1287 VGND VGND VPWR VPWR sky130_fd_sc_hd__fill_1
XFILLER_241_393 VPWR VGND VPWR VGND sky130_ef_sc_hd__decap_12
XFILLER_70_1413 VGND VGND VPWR VPWR sky130_fd_sc_hd__fill_1
XFILLER_202_769 VPWR VGND VPWR VGND sky130_ef_sc_hd__decap_12
XFILLER_42_41 VGND VGND VPWR VPWR sky130_fd_sc_hd__decap_8
X_293_ net611 net519 net691 VGND VGND VPWR VPWR _087_ sky130_fd_sc_hd__a21oi_1
XFILLER_224_1273 VPWR VGND VPWR VGND sky130_ef_sc_hd__decap_12
XFILLER_201_279 VGND VGND VPWR VPWR sky130_fd_sc_hd__fill_1
XFILLER_158_41 VPWR VGND VPWR VGND sky130_ef_sc_hd__decap_12
XFILLER_167_673 VPWR VGND VPWR VGND sky130_ef_sc_hd__decap_12
XFILLER_5_300 VGND VGND VPWR VPWR sky130_fd_sc_hd__fill_2
XFILLER_5_311 VGND VGND VPWR VPWR sky130_fd_sc_hd__decap_6
XTAP_TAPCELL_ROW_175_1597 VGND VPWR sky130_fd_sc_hd__tapvpwrvgnd_1
XFILLER_6_845 VGND VGND VPWR VPWR sky130_fd_sc_hd__fill_2
XFILLER_182_643 VGND VGND VPWR VPWR sky130_fd_sc_hd__fill_1
XFILLER_170_805 VGND VGND VPWR VPWR sky130_fd_sc_hd__decap_6
XFILLER_120_1271 VPWR VGND VPWR VGND sky130_ef_sc_hd__decap_12
XFILLER_170_849 VPWR VGND VPWR VGND sky130_ef_sc_hd__decap_12
XFILLER_155_1323 VGND VGND VPWR VPWR sky130_fd_sc_hd__decap_6
XFILLER_190_1203 VGND VGND VPWR VPWR sky130_fd_sc_hd__fill_1
XTAP_TAPCELL_ROW_61_1_1196 VGND VPWR sky130_fd_sc_hd__tapvpwrvgnd_1
XFILLER_64_1239 VGND VGND VPWR VPWR sky130_fd_sc_hd__decap_6
XFILLER_155_1367 VPWR VGND VPWR VGND sky130_ef_sc_hd__decap_12
XTAP_TAPCELL_ROW_188_1958 VGND VPWR sky130_fd_sc_hd__tapvpwrvgnd_1
XTAP_TAPCELL_ROW_188_1969 VGND VPWR sky130_fd_sc_hd__tapvpwrvgnd_1
XFILLER_3_57 VPWR VGND VPWR VGND sky130_ef_sc_hd__decap_12
XFILLER_7_1133 VPWR VGND VPWR VGND sky130_ef_sc_hd__decap_12
XFILLER_1_594 VGND VGND VPWR VPWR sky130_fd_sc_hd__fill_2
XFILLER_231_1233 VPWR VGND VPWR VGND sky130_ef_sc_hd__decap_12
XFILLER_236_121 VPWR VGND VPWR VGND sky130_ef_sc_hd__decap_12
XFILLER_7_1177 VPWR VGND VPWR VGND sky130_ef_sc_hd__decap_12
XFILLER_209_335 VGND VGND VPWR VPWR sky130_fd_sc_hd__fill_1
XFILLER_190_83 VGND VGND VPWR VPWR sky130_fd_sc_hd__fill_1
XFILLER_236_165 VPWR VGND VPWR VGND sky130_ef_sc_hd__decap_12
XFILLER_225_839 VGND VGND VPWR VPWR sky130_fd_sc_hd__fill_1
XFILLER_252_625 VPWR VGND VPWR VGND sky130_ef_sc_hd__decap_12
XTAP_TAPCELL_ROW_158_2_4701 VGND VPWR sky130_fd_sc_hd__tapvpwrvgnd_1
XFILLER_251_113 VPWR VGND VPWR VGND sky130_ef_sc_hd__decap_12
XFILLER_40_1283 VPWR VGND VPWR VGND sky130_ef_sc_hd__decap_12
XFILLER_184_1029 VGND VGND VPWR VPWR sky130_fd_sc_hd__decap_6
XFILLER_252_669 VPWR VGND VPWR VGND sky130_ef_sc_hd__decap_12
XFILLER_205_541 VPWR VGND VPWR VGND sky130_ef_sc_hd__decap_12
X_629_ clknet_3_5__leaf_clk dout0\[27\] _037_ VGND VGND VPWR VPWR dout0_q\[27\] sky130_fd_sc_hd__dfrtp_1
XFILLER_166_1441 VPWR VGND VPWR VGND sky130_ef_sc_hd__decap_12
XFILLER_178_905 VPWR VGND VPWR VGND sky130_ef_sc_hd__decap_12
XFILLER_166_1485 VPWR VGND VPWR VGND sky130_ef_sc_hd__decap_12
XFILLER_199_81 VPWR VGND VPWR VGND sky130_ef_sc_hd__decap_12
XFILLER_205_585 VPWR VGND VPWR VGND sky130_ef_sc_hd__decap_12
XFILLER_75_1379 VGND VGND VPWR VPWR sky130_fd_sc_hd__decap_6
XFILLER_162_1327 VPWR VGND VPWR VGND sky130_ef_sc_hd__decap_12
XFILLER_178_949 VPWR VGND VPWR VGND sky130_ef_sc_hd__decap_12
XFILLER_220_533 VPWR VGND VPWR VGND sky130_ef_sc_hd__decap_12
XFILLER_80_3 VPWR VGND VPWR VGND sky130_ef_sc_hd__decap_12
XFILLER_203_1313 VPWR VGND VPWR VGND sky130_ef_sc_hd__decap_12
XFILLER_242_1373 VPWR VGND VPWR VGND sky130_ef_sc_hd__decap_12
XFILLER_207_1493 VPWR VGND VPWR VGND sky130_ef_sc_hd__decap_12
XFILLER_186_993 VPWR VGND VPWR VGND sky130_ef_sc_hd__decap_12
XFILLER_203_1357 VPWR VGND VPWR VGND sky130_ef_sc_hd__decap_12
XFILLER_238_1409 VPWR VGND VPWR VGND sky130_ef_sc_hd__decap_12
XPHY_EDGE_ROW_161_1_Right_817 VGND VGND VPWR VPWR sky130_fd_sc_hd__decap_3
XFILLER_173_665 VGND VGND VPWR VPWR sky130_fd_sc_hd__decap_6
XFILLER_172_153 VPWR VGND VPWR VGND sky130_ef_sc_hd__decap_12
XFILLER_103_1491 VGND VGND VPWR VPWR sky130_fd_sc_hd__decap_6
XFILLER_195_1169 VGND VGND VPWR VPWR sky130_fd_sc_hd__decap_6
XFILLER_218_77 VGND VGND VPWR VPWR sky130_fd_sc_hd__decap_6
XFILLER_173_1401 VPWR VGND VPWR VGND sky130_ef_sc_hd__decap_12
XFILLER_172_197 VPWR VGND VPWR VGND sky130_ef_sc_hd__decap_12
XFILLER_82_1339 VPWR VGND VPWR VGND sky130_ef_sc_hd__decap_12
XFILLER_134_1407 VGND VGND VPWR VPWR sky130_fd_sc_hd__decap_6
XTAP_TAPCELL_ROW_100_2_4355 VGND VPWR sky130_fd_sc_hd__tapvpwrvgnd_1
XFILLER_234_65 VPWR VGND VPWR VGND sky130_ef_sc_hd__decap_12
XFILLER_214_1453 VPWR VGND VPWR VGND sky130_ef_sc_hd__decap_12
XPHY_EDGE_ROW_29_2_Left_531 VGND VGND VPWR VPWR sky130_fd_sc_hd__decap_3
XFILLER_210_1317 VPWR VGND VPWR VGND sky130_ef_sc_hd__decap_12
XFILLER_249_1505 VGND VGND VPWR VPWR sky130_fd_sc_hd__decap_6
XFILLER_214_1497 VPWR VGND VPWR VGND sky130_ef_sc_hd__decap_12
XTAP_TAPCELL_ROW_206_2442 VGND VPWR sky130_fd_sc_hd__tapvpwrvgnd_1
XTAP_TAPCELL_ROW_206_2453 VGND VPWR sky130_fd_sc_hd__tapvpwrvgnd_1
XFILLER_215_305 VPWR VGND VPWR VGND sky130_ef_sc_hd__decap_12
XFILLER_228_699 VGND VGND VPWR VPWR sky130_fd_sc_hd__fill_1
XFILLER_250_53 VPWR VGND VPWR VGND sky130_ef_sc_hd__decap_12
XFILLER_110_1451 VPWR VGND VPWR VGND sky130_ef_sc_hd__decap_12
XTAP_TAPCELL_ROW_202_2328 VGND VPWR sky130_fd_sc_hd__tapvpwrvgnd_1
XTAP_TAPCELL_ROW_198_2221 VGND VPWR sky130_fd_sc_hd__tapvpwrvgnd_1
XTAP_TAPCELL_ROW_202_2339 VGND VPWR sky130_fd_sc_hd__tapvpwrvgnd_1
XFILLER_103_69 VGND VGND VPWR VPWR sky130_fd_sc_hd__fill_2
XTAP_TAPCELL_ROW_198_2232 VGND VPWR sky130_fd_sc_hd__tapvpwrvgnd_1
XFILLER_215_349 VPWR VGND VPWR VGND sky130_ef_sc_hd__decap_12
XTAP_TAPCELL_ROW_198_2243 VGND VPWR sky130_fd_sc_hd__tapvpwrvgnd_1
XFILLER_231_809 VPWR VGND VPWR VGND sky130_ef_sc_hd__decap_12
XFILLER_250_97 VPWR VGND VPWR VGND sky130_ef_sc_hd__decap_12
XTAP_TAPCELL_ROW_47_2_4036 VGND VPWR sky130_fd_sc_hd__tapvpwrvgnd_1
XFILLER_93_1435 VGND VGND VPWR VPWR sky130_fd_sc_hd__decap_6
XPHY_EDGE_ROW_104_2_Right_195 VGND VGND VPWR VPWR sky130_fd_sc_hd__decap_3
XFILLER_110_1495 VPWR VGND VPWR VGND sky130_ef_sc_hd__decap_12
XFILLER_224_861 VGND VGND VPWR VPWR sky130_fd_sc_hd__decap_6
XTAP_TAPCELL_ROW_194_2118 VGND VPWR sky130_fd_sc_hd__tapvpwrvgnd_1
XTAP_TAPCELL_ROW_194_2129 VGND VPWR sky130_fd_sc_hd__tapvpwrvgnd_1
XFILLER_196_713 VPWR VGND VPWR VGND sky130_ef_sc_hd__decap_12
XTAP_TAPCELL_ROW_219_2803 VGND VPWR sky130_fd_sc_hd__tapvpwrvgnd_1
XFILLER_93_1479 VPWR VGND VPWR VGND sky130_ef_sc_hd__decap_12
XFILLER_180_1427 VGND VGND VPWR VPWR sky130_fd_sc_hd__fill_1
XFILLER_223_393 VPWR VGND VPWR VGND sky130_ef_sc_hd__decap_12
XFILLER_195_223 VGND VGND VPWR VPWR sky130_fd_sc_hd__fill_1
XFILLER_196_757 VPWR VGND VPWR VGND sky130_ef_sc_hd__decap_12
XFILLER_221_1413 VPWR VGND VPWR VGND sky130_ef_sc_hd__decap_12
Xwire518 _089_ VGND VGND VPWR VPWR net518 sky130_fd_sc_hd__buf_1
XFILLER_52_1165 VPWR VGND VPWR VGND sky130_ef_sc_hd__decap_12
XFILLER_12_11 VGND VGND VPWR VPWR sky130_fd_sc_hd__fill_2
XFILLER_183_429 VPWR VGND VPWR VGND sky130_ef_sc_hd__decap_12
XFILLER_221_1457 VPWR VGND VPWR VGND sky130_ef_sc_hd__decap_12
XFILLER_195_39 VPWR VGND VPWR VGND sky130_ef_sc_hd__decap_12
XFILLER_87_1217 VGND VGND VPWR VPWR sky130_fd_sc_hd__fill_1
XPHY_EDGE_ROW_248_Left_503 VGND VGND VPWR VPWR sky130_fd_sc_hd__decap_3
XTAP_TAPCELL_ROW_25_2_3906 VGND VPWR sky130_fd_sc_hd__tapvpwrvgnd_1
XFILLER_30_1463 VGND VGND VPWR VPWR sky130_fd_sc_hd__decap_6
XFILLER_88_15 VPWR VGND VPWR VGND sky130_ef_sc_hd__decap_12
XFILLER_139_1329 VGND VGND VPWR VPWR sky130_fd_sc_hd__fill_1
XFILLER_191_473 VPWR VGND VPWR VGND sky130_ef_sc_hd__decap_12
XTAP_TAPCELL_ROW_170_1472 VGND VPWR sky130_fd_sc_hd__tapvpwrvgnd_1
XTAP_TAPCELL_ROW_170_1483 VGND VPWR sky130_fd_sc_hd__tapvpwrvgnd_1
XFILLER_176_1091 VGND VGND VPWR VPWR sky130_fd_sc_hd__fill_1
XFILLER_152_1507 VGND VGND VPWR VPWR sky130_fd_sc_hd__decap_8
XFILLER_239_909 VPWR VGND VPWR VGND sky130_ef_sc_hd__decap_12
XFILLER_238_419 VGND VGND VPWR VPWR sky130_fd_sc_hd__fill_1
XFILLER_144_65 VGND VGND VPWR VPWR sky130_fd_sc_hd__decap_6
XFILLER_8_1453 VPWR VGND VPWR VGND sky130_ef_sc_hd__decap_12
XTAP_TAPCELL_ROW_183_1822 VGND VPWR sky130_fd_sc_hd__tapvpwrvgnd_1
XFILLER_247_953 VPWR VGND VPWR VGND sky130_ef_sc_hd__decap_12
XFILLER_24_1245 VGND VGND VPWR VPWR sky130_fd_sc_hd__fill_1
XFILLER_4_1317 VPWR VGND VPWR VGND sky130_ef_sc_hd__decap_12
XTAP_TAPCELL_ROW_183_1833 VGND VPWR sky130_fd_sc_hd__tapvpwrvgnd_1
XFILLER_8_1497 VPWR VGND VPWR VGND sky130_ef_sc_hd__decap_12
XFILLER_218_121 VPWR VGND VPWR VGND sky130_ef_sc_hd__decap_12
XTAP_TAPCELL_ROW_144_2_4620 VGND VPWR sky130_fd_sc_hd__tapvpwrvgnd_1
XFILLER_218_165 VPWR VGND VPWR VGND sky130_ef_sc_hd__decap_12
XFILLER_234_625 VPWR VGND VPWR VGND sky130_ef_sc_hd__decap_12
XFILLER_98_1357 VGND VGND VPWR VPWR sky130_fd_sc_hd__fill_1
XFILLER_207_839 VGND VGND VPWR VPWR sky130_fd_sc_hd__fill_1
XFILLER_248_1037 VPWR VGND VPWR VGND sky130_ef_sc_hd__decap_12
XFILLER_160_53 VPWR VGND VPWR VGND sky130_ef_sc_hd__decap_12
XFILLER_233_113 VPWR VGND VPWR VGND sky130_ef_sc_hd__decap_12
XFILLER_234_669 VPWR VGND VPWR VGND sky130_ef_sc_hd__decap_12
XFILLER_2_1085 VGND VGND VPWR VPWR sky130_fd_sc_hd__decap_6
X_414_ net217 _202_ net218 VGND VGND VPWR VPWR _203_ sky130_fd_sc_hd__o21bai_1
XFILLER_199_573 VPWR VGND VPWR VGND sky130_ef_sc_hd__decap_12
XFILLER_202_533 VPWR VGND VPWR VGND sky130_ef_sc_hd__decap_12
X_345_ net592 net543 net572 VGND VGND VPWR VPWR _134_ sky130_fd_sc_hd__and3_1
XFILLER_169_51 VGND VGND VPWR VPWR sky130_fd_sc_hd__decap_4
XFILLER_109_1177 VPWR VGND VPWR VGND sky130_ef_sc_hd__decap_12
XTAP_TAPCELL_ROW_177_1659 VGND VPWR sky130_fd_sc_hd__tapvpwrvgnd_1
XFILLER_186_245 VGND VGND VPWR VPWR sky130_fd_sc_hd__decap_6
XFILLER_35_1385 VGND VGND VPWR VPWR sky130_fd_sc_hd__fill_1
XFILLER_168_993 VPWR VGND VPWR VGND sky130_ef_sc_hd__decap_12
XFILLER_186_289 VPWR VGND VPWR VGND sky130_ef_sc_hd__decap_12
XPHY_EDGE_ROW_157_2_Left_659 VGND VGND VPWR VPWR sky130_fd_sc_hd__decap_3
XFILLER_170_613 VPWR VGND VPWR VGND sky130_ef_sc_hd__decap_12
XFILLER_192_1309 VGND VGND VPWR VPWR sky130_fd_sc_hd__decap_6
XPHY_EDGE_ROW_27_1_Left_282 VGND VGND VPWR VPWR sky130_fd_sc_hd__decap_3
XFILLER_170_657 VPWR VGND VPWR VGND sky130_ef_sc_hd__decap_12
XFILLER_9_1217 VPWR VGND VPWR VGND sky130_ef_sc_hd__decap_12
XFILLER_29_1189 VPWR VGND VPWR VGND sky130_ef_sc_hd__decap_12
XFILLER_42_1301 VGND VGND VPWR VPWR sky130_fd_sc_hd__fill_1
XTAP_TAPCELL_ROW_38_2_3984 VGND VPWR sky130_fd_sc_hd__tapvpwrvgnd_1
XFILLER_231_1063 VGND VGND VPWR VPWR sky130_fd_sc_hd__fill_1
XFILLER_237_441 VGND VGND VPWR VPWR sky130_fd_sc_hd__decap_6
XPHY_EDGE_ROW_184_Right_29 VGND VGND VPWR VPWR sky130_fd_sc_hd__decap_3
XFILLER_237_485 VPWR VGND VPWR VGND sky130_ef_sc_hd__decap_12
XFILLER_253_945 VGND VGND VPWR VPWR sky130_fd_sc_hd__decap_6
XTAP_TAPCELL_ROW_0_829 VGND VPWR sky130_fd_sc_hd__tapvpwrvgnd_1
XFILLER_252_433 VPWR VGND VPWR VGND sky130_ef_sc_hd__decap_12
XFILLER_213_809 VPWR VGND VPWR VGND sky130_ef_sc_hd__decap_12
XTAP_TAPCELL_ROW_18_2_3860 VGND VPWR sky130_fd_sc_hd__tapvpwrvgnd_1
XFILLER_253_989 VPWR VGND VPWR VGND sky130_ef_sc_hd__decap_12
XFILLER_206_861 VGND VGND VPWR VPWR sky130_fd_sc_hd__decap_6
XFILLER_209_1511 VGND VGND VPWR VPWR sky130_fd_sc_hd__fill_1
XFILLER_252_477 VPWR VGND VPWR VGND sky130_ef_sc_hd__decap_12
XFILLER_178_713 VPWR VGND VPWR VGND sky130_ef_sc_hd__decap_12
XFILLER_75_1165 VPWR VGND VPWR VGND sky130_ef_sc_hd__decap_12
XTAP_TAPCELL_ROW_255_3759 VGND VPWR sky130_fd_sc_hd__tapvpwrvgnd_1
XTAP_TAPCELL_ROW_31_2_3938 VGND VPWR sky130_fd_sc_hd__tapvpwrvgnd_1
XFILLER_205_393 VPWR VGND VPWR VGND sky130_ef_sc_hd__decap_12
XFILLER_127_1255 VPWR VGND VPWR VGND sky130_ef_sc_hd__decap_12
XFILLER_221_853 VPWR VGND VPWR VGND sky130_ef_sc_hd__decap_12
XFILLER_177_223 VGND VGND VPWR VPWR sky130_fd_sc_hd__fill_1
XFILLER_178_757 VPWR VGND VPWR VGND sky130_ef_sc_hd__decap_12
XFILLER_53_1441 VGND VGND VPWR VPWR sky130_fd_sc_hd__fill_1
XFILLER_220_363 VGND VGND VPWR VPWR sky130_fd_sc_hd__fill_1
XFILLER_127_1299 VPWR VGND VPWR VGND sky130_ef_sc_hd__decap_12
XFILLER_221_897 VPWR VGND VPWR VGND sky130_ef_sc_hd__decap_12
XFILLER_193_727 VGND VGND VPWR VPWR sky130_fd_sc_hd__fill_1
XFILLER_203_1121 VPWR VGND VPWR VGND sky130_ef_sc_hd__decap_12
XPHY_EDGE_ROW_193_Right_38 VGND VGND VPWR VPWR sky130_fd_sc_hd__decap_3
XFILLER_14_1469 VGND VGND VPWR VPWR sky130_fd_sc_hd__fill_1
XPHY_EDGE_ROW_160_1_Left_415 VGND VGND VPWR VPWR sky130_fd_sc_hd__decap_3
XFILLER_238_1217 VPWR VGND VPWR VGND sky130_ef_sc_hd__decap_12
XFILLER_173_473 VPWR VGND VPWR VGND sky130_ef_sc_hd__decap_12
XPHY_EDGE_ROW_162_1_Right_818 VGND VGND VPWR VPWR sky130_fd_sc_hd__decap_3
XFILLER_47_1201 VPWR VGND VPWR VGND sky130_ef_sc_hd__decap_12
XTAP_TAPCELL_ROW_150_2_4652 VGND VPWR sky130_fd_sc_hd__tapvpwrvgnd_1
XFILLER_86_1283 VPWR VGND VPWR VGND sky130_ef_sc_hd__decap_12
XTAP_TAPCELL_ROW_149_2_4646 VGND VPWR sky130_fd_sc_hd__tapvpwrvgnd_1
XFILLER_173_1231 VGND VGND VPWR VPWR sky130_fd_sc_hd__fill_1
XFILLER_138_1351 VGND VGND VPWR VPWR sky130_fd_sc_hd__decap_6
XFILLER_58_29 VPWR VGND VPWR VGND sky130_ef_sc_hd__decap_12
XFILLER_47_1267 VGND VGND VPWR VPWR sky130_fd_sc_hd__decap_6
XFILLER_134_1215 VPWR VGND VPWR VGND sky130_ef_sc_hd__decap_12
XFILLER_138_1395 VPWR VGND VPWR VGND sky130_ef_sc_hd__decap_12
XTAP_TAPCELL_ROW_208_2504 VGND VPWR sky130_fd_sc_hd__tapvpwrvgnd_1
XFILLER_247_205 VPWR VGND VPWR VGND sky130_ef_sc_hd__decap_12
XFILLER_134_1259 VPWR VGND VPWR VGND sky130_ef_sc_hd__decap_12
XFILLER_214_1261 VPWR VGND VPWR VGND sky130_ef_sc_hd__decap_12
XFILLER_247_249 VPWR VGND VPWR VGND sky130_ef_sc_hd__decap_12
XFILLER_229_953 VPWR VGND VPWR VGND sky130_ef_sc_hd__decap_12
XFILLER_249_1313 VPWR VGND VPWR VGND sky130_ef_sc_hd__decap_12
XFILLER_244_923 VGND VGND VPWR VPWR sky130_fd_sc_hd__fill_1
XFILLER_210_1147 VGND VGND VPWR VPWR sky130_fd_sc_hd__fill_1
XFILLER_216_625 VPWR VGND VPWR VGND sky130_ef_sc_hd__decap_12
XFILLER_215_113 VPWR VGND VPWR VGND sky130_ef_sc_hd__decap_12
XFILLER_255_293 VPWR VGND VPWR VGND sky130_ef_sc_hd__decap_12
XFILLER_249_1357 VPWR VGND VPWR VGND sky130_ef_sc_hd__decap_12
XFILLER_216_669 VPWR VGND VPWR VGND sky130_ef_sc_hd__decap_12
XFILLER_167_1057 VGND VGND VPWR VPWR sky130_fd_sc_hd__decap_6
XFILLER_231_617 VPWR VGND VPWR VGND sky130_ef_sc_hd__decap_12
XFILLER_93_1243 VPWR VGND VPWR VGND sky130_ef_sc_hd__decap_12
XFILLER_145_1311 VPWR VGND VPWR VGND sky130_ef_sc_hd__decap_12
XPHY_EDGE_ROW_105_2_Right_196 VGND VGND VPWR VPWR sky130_fd_sc_hd__decap_3
XFILLER_149_1491 VGND VGND VPWR VPWR sky130_fd_sc_hd__decap_6
XFILLER_184_1371 VGND VGND VPWR VPWR sky130_fd_sc_hd__fill_1
XFILLER_90_27 VGND VGND VPWR VPWR sky130_fd_sc_hd__fill_1
XFILLER_54_1227 VPWR VGND VPWR VGND sky130_ef_sc_hd__decap_12
XFILLER_93_1287 VPWR VGND VPWR VGND sky130_ef_sc_hd__decap_12
XFILLER_145_1355 VPWR VGND VPWR VGND sky130_ef_sc_hd__decap_12
XFILLER_168_245 VGND VGND VPWR VPWR sky130_fd_sc_hd__decap_6
XFILLER_106_1339 VPWR VGND VPWR VGND sky130_ef_sc_hd__decap_12
XFILLER_141_1219 VPWR VGND VPWR VGND sky130_ef_sc_hd__decap_12
Xwire304 net305 VGND VGND VPWR VPWR net304 sky130_fd_sc_hd__clkbuf_1
XFILLER_145_1399 VPWR VGND VPWR VGND sky130_ef_sc_hd__decap_12
XFILLER_23_54 VGND VGND VPWR VPWR sky130_fd_sc_hd__fill_2
Xwire315 net316 VGND VGND VPWR VPWR net315 sky130_fd_sc_hd__clkbuf_1
XFILLER_196_587 VGND VGND VPWR VPWR sky130_fd_sc_hd__fill_1
XFILLER_211_385 VGND VGND VPWR VPWR sky130_fd_sc_hd__decap_6
XFILLER_168_289 VPWR VGND VPWR VGND sky130_ef_sc_hd__decap_12
XPHY_EDGE_ROW_92_1_Left_347 VGND VGND VPWR VPWR sky130_fd_sc_hd__decap_3
XFILLER_184_749 VGND VGND VPWR VPWR sky130_fd_sc_hd__decap_6
Xwire337 net338 VGND VGND VPWR VPWR net337 sky130_fd_sc_hd__clkbuf_1
Xwire348 net349 VGND VGND VPWR VPWR net348 sky130_fd_sc_hd__clkbuf_1
XFILLER_128_3 VPWR VGND VPWR VGND sky130_ef_sc_hd__decap_12
XFILLER_183_237 VPWR VGND VPWR VGND sky130_ef_sc_hd__decap_12
Xwire359 net360 VGND VGND VPWR VPWR net359 sky130_fd_sc_hd__clkbuf_1
XTAP_TAPCELL_ROW_172_1523 VGND VPWR sky130_fd_sc_hd__tapvpwrvgnd_1
XFILLER_165_963 VPWR VGND VPWR VGND sky130_ef_sc_hd__decap_12
XTAP_TAPCELL_ROW_172_1534 VGND VPWR sky130_fd_sc_hd__tapvpwrvgnd_1
XFILLER_221_1287 VGND VGND VPWR VPWR sky130_fd_sc_hd__fill_1
XFILLER_99_69 VGND VGND VPWR VPWR sky130_fd_sc_hd__fill_2
XFILLER_30_1271 VPWR VGND VPWR VGND sky130_ef_sc_hd__decap_12
XFILLER_192_793 VPWR VGND VPWR VGND sky130_ef_sc_hd__decap_12
XFILLER_191_281 VPWR VGND VPWR VGND sky130_ef_sc_hd__decap_12
XFILLER_174_1017 VPWR VGND VPWR VGND sky130_ef_sc_hd__decap_12
XFILLER_178_1197 VGND VGND VPWR VPWR sky130_fd_sc_hd__decap_6
XFILLER_65_1323 VGND VGND VPWR VPWR sky130_fd_sc_hd__decap_6
XFILLER_2_133 VGND VGND VPWR VPWR sky130_fd_sc_hd__decap_6
XFILLER_156_1451 VPWR VGND VPWR VGND sky130_ef_sc_hd__decap_12
XFILLER_3_689 VGND VGND VPWR VPWR sky130_fd_sc_hd__fill_1
XFILLER_65_1367 VPWR VGND VPWR VGND sky130_ef_sc_hd__decap_12
XFILLER_2_177 VPWR VGND VPWR VGND sky130_ef_sc_hd__decap_12
XFILLER_117_1435 VGND VGND VPWR VPWR sky130_fd_sc_hd__decap_6
XFILLER_152_1315 VPWR VGND VPWR VGND sky130_ef_sc_hd__decap_12
XFILLER_254_1085 VGND VGND VPWR VPWR sky130_fd_sc_hd__decap_6
XFILLER_156_1495 VPWR VGND VPWR VGND sky130_ef_sc_hd__decap_12
XFILLER_117_1479 VPWR VGND VPWR VGND sky130_ef_sc_hd__decap_12
XFILLER_152_1359 VPWR VGND VPWR VGND sky130_ef_sc_hd__decap_12
XFILLER_8_1261 VPWR VGND VPWR VGND sky130_ef_sc_hd__decap_12
XFILLER_219_441 VGND VGND VPWR VPWR sky130_fd_sc_hd__decap_6
XFILLER_247_783 VGND VGND VPWR VPWR sky130_fd_sc_hd__fill_1
XFILLER_4_1147 VGND VGND VPWR VPWR sky130_fd_sc_hd__fill_1
XFILLER_219_485 VPWR VGND VPWR VGND sky130_ef_sc_hd__decap_12
XFILLER_235_945 VGND VGND VPWR VPWR sky130_fd_sc_hd__decap_6
XTAP_TAPCELL_ROW_56_1_1191 VGND VPWR sky130_fd_sc_hd__tapvpwrvgnd_1
XFILLER_234_433 VPWR VGND VPWR VGND sky130_ef_sc_hd__decap_12
XFILLER_98_1165 VPWR VGND VPWR VGND sky130_ef_sc_hd__decap_12
XFILLER_185_1113 VGND VGND VPWR VPWR sky130_fd_sc_hd__decap_6
XFILLER_0_69 VPWR VGND VPWR VGND sky130_ef_sc_hd__decap_12
XFILLER_235_989 VPWR VGND VPWR VGND sky130_ef_sc_hd__decap_12
XFILLER_234_477 VPWR VGND VPWR VGND sky130_ef_sc_hd__decap_12
XFILLER_185_1157 VPWR VGND VPWR VGND sky130_ef_sc_hd__decap_12
XFILLER_250_937 VPWR VGND VPWR VGND sky130_ef_sc_hd__decap_12
XFILLER_221_105 VGND VGND VPWR VPWR sky130_fd_sc_hd__decap_6
XFILLER_76_1463 VGND VGND VPWR VPWR sky130_fd_sc_hd__decap_6
XFILLER_163_1411 VPWR VGND VPWR VGND sky130_ef_sc_hd__decap_12
XFILLER_221_149 VPWR VGND VPWR VGND sky130_ef_sc_hd__decap_12
XFILLER_9_23 VGND VGND VPWR VPWR sky130_fd_sc_hd__decap_4
XFILLER_72_1327 VPWR VGND VPWR VGND sky130_ef_sc_hd__decap_12
XFILLER_203_853 VPWR VGND VPWR VGND sky130_ef_sc_hd__decap_12
XFILLER_163_1455 VPWR VGND VPWR VGND sky130_ef_sc_hd__decap_12
XFILLER_202_363 VGND VGND VPWR VPWR sky130_fd_sc_hd__fill_1
XFILLER_203_897 VPWR VGND VPWR VGND sky130_ef_sc_hd__decap_12
XFILLER_222_1029 VGND VGND VPWR VPWR sky130_fd_sc_hd__decap_6
XFILLER_124_1439 VPWR VGND VPWR VGND sky130_ef_sc_hd__decap_12
XFILLER_163_1499 VPWR VGND VPWR VGND sky130_ef_sc_hd__decap_12
XFILLER_175_727 VGND VGND VPWR VPWR sky130_fd_sc_hd__fill_1
XTAP_TAPCELL_ROW_250_3623 VGND VPWR sky130_fd_sc_hd__tapvpwrvgnd_1
X_328_ _115_ net499 VGND VGND VPWR VPWR _117_ sky130_fd_sc_hd__or2_1
XFILLER_204_1441 VPWR VGND VPWR VGND sky130_ef_sc_hd__decap_12
XTAP_TAPCELL_ROW_250_3634 VGND VPWR sky130_fd_sc_hd__tapvpwrvgnd_1
XTAP_TAPCELL_ROW_250_3645 VGND VPWR sky130_fd_sc_hd__tapvpwrvgnd_1
XFILLER_204_1485 VPWR VGND VPWR VGND sky130_ef_sc_hd__decap_12
XFILLER_7_951 VGND VGND VPWR VPWR sky130_fd_sc_hd__fill_1
Xmax_cap604 net605 VGND VGND VPWR VPWR net604 sky130_fd_sc_hd__clkbuf_1
Xmax_cap615 rd_addr\[1\] VGND VGND VPWR VPWR net615 sky130_fd_sc_hd__clkbuf_1
XFILLER_196_1253 VGND VGND VPWR VPWR sky130_fd_sc_hd__decap_6
XFILLER_171_933 VPWR VGND VPWR VGND sky130_ef_sc_hd__decap_12
XFILLER_13_1491 VGND VGND VPWR VPWR sky130_fd_sc_hd__decap_6
XFILLER_170_421 VPWR VGND VPWR VGND sky130_ef_sc_hd__decap_12
XTAP_TAPCELL_ROW_135_2_4565 VGND VPWR sky130_fd_sc_hd__tapvpwrvgnd_1
XFILLER_192_1117 VPWR VGND VPWR VGND sky130_ef_sc_hd__decap_12
XFILLER_196_1297 VPWR VGND VPWR VGND sky130_ef_sc_hd__decap_12
XFILLER_171_977 VPWR VGND VPWR VGND sky130_ef_sc_hd__decap_12
XFILLER_43_3 VPWR VGND VPWR VGND sky130_ef_sc_hd__decap_12
XFILLER_83_1423 VPWR VGND VPWR VGND sky130_ef_sc_hd__decap_12
XFILLER_100_1483 VPWR VGND VPWR VGND sky130_ef_sc_hd__decap_12
XTAP_TAPCELL_ROW_248_3574 VGND VPWR sky130_fd_sc_hd__tapvpwrvgnd_1
XTAP_TAPCELL_ROW_248_3585 VGND VPWR sky130_fd_sc_hd__tapvpwrvgnd_1
XFILLER_44_1407 VGND VGND VPWR VPWR sky130_fd_sc_hd__decap_6
XFILLER_83_1467 VPWR VGND VPWR VGND sky130_ef_sc_hd__decap_12
XFILLER_229_205 VPWR VGND VPWR VGND sky130_ef_sc_hd__decap_12
XFILLER_233_1169 VGND VGND VPWR VPWR sky130_fd_sc_hd__decap_6
XFILLER_211_1401 VPWR VGND VPWR VGND sky130_ef_sc_hd__decap_12
XFILLER_229_249 VPWR VGND VPWR VGND sky130_ef_sc_hd__decap_12
XFILLER_245_709 VPWR VGND VPWR VGND sky130_ef_sc_hd__decap_12
XFILLER_250_1483 VGND VGND VPWR VPWR sky130_fd_sc_hd__fill_1
XTAP_TAPCELL_ROW_83_2_4252 VGND VPWR sky130_fd_sc_hd__tapvpwrvgnd_1
XFILLER_226_923 VGND VGND VPWR VPWR sky130_fd_sc_hd__fill_1
XFILLER_237_293 VPWR VGND VPWR VGND sky130_ef_sc_hd__decap_12
XFILLER_253_753 VPWR VGND VPWR VGND sky130_ef_sc_hd__decap_12
XFILLER_231_55 VGND VGND VPWR VPWR sky130_fd_sc_hd__fill_1
XFILLER_20_1451 VPWR VGND VPWR VGND sky130_ef_sc_hd__decap_12
XFILLER_213_617 VPWR VGND VPWR VGND sky130_ef_sc_hd__decap_12
XFILLER_253_797 VPWR VGND VPWR VGND sky130_ef_sc_hd__decap_12
XFILLER_20_1495 VPWR VGND VPWR VGND sky130_ef_sc_hd__decap_12
XFILLER_181_1511 VGND VGND VPWR VPWR sky130_fd_sc_hd__fill_1
XFILLER_197_329 VGND VGND VPWR VPWR sky130_fd_sc_hd__decap_6
XFILLER_90_1427 VPWR VGND VPWR VGND sky130_ef_sc_hd__decap_12
XFILLER_100_15 VPWR VGND VPWR VGND sky130_ef_sc_hd__decap_12
XFILLER_240_469 VGND VGND VPWR VPWR sky130_fd_sc_hd__decap_6
XFILLER_240_1129 VPWR VGND VPWR VGND sky130_ef_sc_hd__decap_12
XFILLER_178_587 VGND VGND VPWR VPWR sky130_fd_sc_hd__fill_1
XFILLER_166_749 VGND VGND VPWR VPWR sky130_fd_sc_hd__decap_6
XFILLER_165_237 VPWR VGND VPWR VGND sky130_ef_sc_hd__decap_12
XFILLER_88_1301 VGND VGND VPWR VPWR sky130_fd_sc_hd__fill_1
XFILLER_174_793 VPWR VGND VPWR VGND sky130_ef_sc_hd__decap_12
XFILLER_109_57 VPWR VGND VPWR VGND sky130_ef_sc_hd__decap_12
XFILLER_49_1329 VGND VGND VPWR VPWR sky130_fd_sc_hd__fill_1
XFILLER_173_281 VPWR VGND VPWR VGND sky130_ef_sc_hd__decap_12
XFILLER_175_1337 VGND VGND VPWR VPWR sky130_fd_sc_hd__decap_6
XFILLER_69_39 VPWR VGND VPWR VGND sky130_ef_sc_hd__decap_12
XPHY_EDGE_ROW_163_1_Right_819 VGND VGND VPWR VPWR sky130_fd_sc_hd__decap_3
XFILLER_192_29 VPWR VGND VPWR VGND sky130_ef_sc_hd__decap_12
XFILLER_62_1507 VGND VGND VPWR VPWR sky130_fd_sc_hd__decap_8
XFILLER_251_1225 VGND VGND VPWR VPWR sky130_fd_sc_hd__decap_6
XFILLER_248_525 VGND VGND VPWR VPWR sky130_fd_sc_hd__decap_6
XFILLER_251_1269 VPWR VGND VPWR VGND sky130_ef_sc_hd__decap_12
XFILLER_5_1401 VPWR VGND VPWR VGND sky130_ef_sc_hd__decap_12
XFILLER_85_27 VPWR VGND VPWR VGND sky130_ef_sc_hd__decap_12
XFILLER_248_569 VPWR VGND VPWR VGND sky130_ef_sc_hd__decap_12
XTAP_TAPCELL_ROW_4_965 VGND VPWR sky130_fd_sc_hd__tapvpwrvgnd_1
XFILLER_214_1091 VGND VGND VPWR VPWR sky130_fd_sc_hd__fill_1
XTAP_TAPCELL_ROW_4_976 VGND VPWR sky130_fd_sc_hd__tapvpwrvgnd_1
XFILLER_99_1441 VGND VGND VPWR VPWR sky130_fd_sc_hd__fill_1
XFILLER_169_1119 VGND VGND VPWR VPWR sky130_fd_sc_hd__fill_1
XFILLER_229_783 VGND VGND VPWR VPWR sky130_fd_sc_hd__fill_1
XFILLER_249_1121 VPWR VGND VPWR VGND sky130_ef_sc_hd__decap_12
XFILLER_217_945 VGND VGND VPWR VPWR sky130_fd_sc_hd__decap_6
XFILLER_216_433 VPWR VGND VPWR VGND sky130_ef_sc_hd__decap_12
XFILLER_141_55 VGND VGND VPWR VPWR sky130_fd_sc_hd__fill_1
XFILLER_217_989 VPWR VGND VPWR VGND sky130_ef_sc_hd__decap_12
XFILLER_245_1007 VGND VGND VPWR VPWR sky130_fd_sc_hd__fill_1
XFILLER_186_1477 VGND VGND VPWR VPWR sky130_fd_sc_hd__decap_6
XFILLER_216_477 VPWR VGND VPWR VGND sky130_ef_sc_hd__decap_12
XFILLER_188_307 VGND VGND VPWR VPWR sky130_fd_sc_hd__fill_1
XFILLER_203_105 VGND VGND VPWR VPWR sky130_fd_sc_hd__decap_6
XFILLER_232_937 VPWR VGND VPWR VGND sky130_ef_sc_hd__decap_12
XFILLER_231_447 VGND VGND VPWR VPWR sky130_fd_sc_hd__fill_1
XFILLER_245_3 VPWR VGND VPWR VGND sky130_ef_sc_hd__decap_12
XFILLER_203_149 VPWR VGND VPWR VGND sky130_ef_sc_hd__decap_12
XFILLER_197_841 VPWR VGND VPWR VGND sky130_ef_sc_hd__decap_12
XPHY_EDGE_ROW_106_2_Right_197 VGND VGND VPWR VPWR sky130_fd_sc_hd__decap_3
XFILLER_240_981 VPWR VGND VPWR VGND sky130_ef_sc_hd__decap_12
XFILLER_19_1177 VPWR VGND VPWR VGND sky130_ef_sc_hd__decap_12
XFILLER_184_513 VPWR VGND VPWR VGND sky130_ef_sc_hd__decap_12
XFILLER_211_193 VPWR VGND VPWR VGND sky130_ef_sc_hd__decap_12
XFILLER_200_867 VGND VGND VPWR VPWR sky130_fd_sc_hd__fill_1
XFILLER_184_557 VPWR VGND VPWR VGND sky130_ef_sc_hd__decap_12
XFILLER_50_41 VPWR VGND VPWR VGND sky130_ef_sc_hd__decap_12
Xwire145 _215_ VGND VGND VPWR VPWR net145 sky130_fd_sc_hd__clkbuf_1
XPHY_EDGE_ROW_199_Left_454 VGND VGND VPWR VPWR sky130_fd_sc_hd__decap_3
Xwire156 _166_ VGND VGND VPWR VPWR net156 sky130_fd_sc_hd__clkbuf_1
Xwire167 _135_ VGND VGND VPWR VPWR net167 sky130_fd_sc_hd__clkbuf_1
Xwire178 _099_ VGND VGND VPWR VPWR net178 sky130_fd_sc_hd__clkbuf_1
XFILLER_166_41 VPWR VGND VPWR VGND sky130_ef_sc_hd__decap_12
XFILLER_166_85 VPWR VGND VPWR VGND sky130_ef_sc_hd__decap_12
XFILLER_193_1437 VPWR VGND VPWR VGND sky130_ef_sc_hd__decap_12
XTAP_TAPCELL_ROW_101_2_4360 VGND VPWR sky130_fd_sc_hd__tapvpwrvgnd_1
XFILLER_239_503 VGND VGND VPWR VPWR sky130_fd_sc_hd__fill_1
XFILLER_117_1243 VPWR VGND VPWR VGND sky130_ef_sc_hd__decap_12
XFILLER_230_1309 VGND VGND VPWR VPWR sky130_fd_sc_hd__decap_6
XFILLER_117_1287 VPWR VGND VPWR VGND sky130_ef_sc_hd__decap_12
XFILLER_227_709 VPWR VGND VPWR VGND sky130_ef_sc_hd__decap_12
XTAP_TAPCELL_ROW_68_2_4165 VGND VPWR sky130_fd_sc_hd__tapvpwrvgnd_1
XFILLER_152_1189 VGND VGND VPWR VPWR sky130_fd_sc_hd__fill_1
XFILLER_8_1091 VGND VGND VPWR VPWR sky130_fd_sc_hd__fill_1
XFILLER_208_923 VGND VGND VPWR VPWR sky130_fd_sc_hd__fill_1
XFILLER_219_293 VPWR VGND VPWR VGND sky130_ef_sc_hd__decap_12
XFILLER_235_753 VPWR VGND VPWR VGND sky130_ef_sc_hd__decap_12
XFILLER_228_1205 VPWR VGND VPWR VGND sky130_ef_sc_hd__decap_12
XFILLER_250_701 VPWR VGND VPWR VGND sky130_ef_sc_hd__decap_12
XFILLER_235_797 VPWR VGND VPWR VGND sky130_ef_sc_hd__decap_12
XTAP_TAPCELL_ROW_48_2_4041 VGND VPWR sky130_fd_sc_hd__tapvpwrvgnd_1
XTAP_TAPCELL_ROW_164_1_1299 VGND VPWR sky130_fd_sc_hd__tapvpwrvgnd_1
XFILLER_179_329 VGND VGND VPWR VPWR sky130_fd_sc_hd__decap_6
XFILLER_76_1271 VPWR VGND VPWR VGND sky130_ef_sc_hd__decap_12
XFILLER_201_69 VPWR VGND VPWR VGND sky130_ef_sc_hd__decap_12
XFILLER_222_469 VGND VGND VPWR VPWR sky130_fd_sc_hd__decap_6
XTAP_TAPCELL_ROW_61_2_4119 VGND VPWR sky130_fd_sc_hd__tapvpwrvgnd_1
XFILLER_37_1255 VPWR VGND VPWR VGND sky130_ef_sc_hd__decap_12
XFILLER_124_1203 VPWR VGND VPWR VGND sky130_ef_sc_hd__decap_12
XTAP_TAPCELL_ROW_237_3275 VGND VPWR sky130_fd_sc_hd__tapvpwrvgnd_1
XFILLER_128_1383 VPWR VGND VPWR VGND sky130_ef_sc_hd__decap_12
XTAP_TAPCELL_ROW_237_3286 VGND VPWR sky130_fd_sc_hd__tapvpwrvgnd_1
XFILLER_241_1449 VGND VGND VPWR VPWR sky130_fd_sc_hd__decap_6
XTAP_TAPCELL_ROW_237_3297 VGND VPWR sky130_fd_sc_hd__tapvpwrvgnd_1
XFILLER_37_1299 VPWR VGND VPWR VGND sky130_ef_sc_hd__decap_12
XFILLER_124_1247 VPWR VGND VPWR VGND sky130_ef_sc_hd__decap_12
XFILLER_187_373 VPWR VGND VPWR VGND sky130_ef_sc_hd__decap_12
XFILLER_198_1315 VGND VGND VPWR VPWR sky130_fd_sc_hd__fill_1
XPHY_EDGE_ROW_38_2_Left_540 VGND VGND VPWR VPWR sky130_fd_sc_hd__decap_3
XFILLER_239_1301 VPWR VGND VPWR VGND sky130_ef_sc_hd__decap_12
XTAP_TAPCELL_ROW_26_2_3911 VGND VPWR sky130_fd_sc_hd__tapvpwrvgnd_1
XFILLER_239_1345 VPWR VGND VPWR VGND sky130_ef_sc_hd__decap_12
XFILLER_196_1061 VPWR VGND VPWR VGND sky130_ef_sc_hd__decap_12
XFILLER_6_280 VGND VGND VPWR VPWR sky130_fd_sc_hd__fill_1
XFILLER_171_741 VPWR VGND VPWR VGND sky130_ef_sc_hd__decap_12
XFILLER_170_251 VGND VGND VPWR VPWR sky130_fd_sc_hd__fill_1
XFILLER_171_785 VPWR VGND VPWR VGND sky130_ef_sc_hd__decap_12
XPHY_EDGE_ROW_203_Left_458 VGND VGND VPWR VPWR sky130_fd_sc_hd__decap_3
XFILLER_48_1351 VGND VGND VPWR VPWR sky130_fd_sc_hd__decap_6
XFILLER_83_1231 VPWR VGND VPWR VGND sky130_ef_sc_hd__decap_12
XFILLER_226_77 VGND VGND VPWR VPWR sky130_fd_sc_hd__decap_6
XFILLER_44_1215 VPWR VGND VPWR VGND sky130_ef_sc_hd__decap_12
XFILLER_83_1275 VPWR VGND VPWR VGND sky130_ef_sc_hd__decap_12
XFILLER_48_1395 VPWR VGND VPWR VGND sky130_ef_sc_hd__decap_12
XFILLER_135_1343 VPWR VGND VPWR VGND sky130_ef_sc_hd__decap_12
XFILLER_44_1259 VPWR VGND VPWR VGND sky130_ef_sc_hd__decap_12
XFILLER_135_1387 VPWR VGND VPWR VGND sky130_ef_sc_hd__decap_12
XFILLER_245_517 VPWR VGND VPWR VGND sky130_ef_sc_hd__decap_12
XFILLER_211_1231 VGND VGND VPWR VPWR sky130_fd_sc_hd__fill_1
XFILLER_242_65 VPWR VGND VPWR VGND sky130_ef_sc_hd__decap_12
XTAP_TAPCELL_ROW_1_902 VGND VPWR sky130_fd_sc_hd__tapvpwrvgnd_1
XTAP_TAPCELL_ROW_226_2990 VGND VPWR sky130_fd_sc_hd__tapvpwrvgnd_1
XFILLER_253_561 VPWR VGND VPWR VGND sky130_ef_sc_hd__decap_12
XFILLER_168_1141 VGND VGND VPWR VPWR sky130_fd_sc_hd__decap_6
XTAP_TAPCELL_ROW_222_2876 VGND VPWR sky130_fd_sc_hd__tapvpwrvgnd_1
XPHY_EDGE_ROW_212_Left_467 VGND VGND VPWR VPWR sky130_fd_sc_hd__decap_3
XFILLER_214_937 VPWR VGND VPWR VGND sky130_ef_sc_hd__decap_12
XTAP_TAPCELL_ROW_222_2887 VGND VPWR sky130_fd_sc_hd__tapvpwrvgnd_1
XFILLER_168_1185 VPWR VGND VPWR VGND sky130_ef_sc_hd__decap_12
XFILLER_213_447 VGND VGND VPWR VPWR sky130_fd_sc_hd__fill_1
XFILLER_240_233 VPWR VGND VPWR VGND sky130_ef_sc_hd__decap_12
XFILLER_55_1311 VPWR VGND VPWR VGND sky130_ef_sc_hd__decap_12
XFILLER_59_1491 VGND VGND VPWR VPWR sky130_fd_sc_hd__decap_6
XFILLER_94_1371 VPWR VGND VPWR VGND sky130_ef_sc_hd__decap_12
XFILLER_111_69 VGND VGND VPWR VPWR sky130_fd_sc_hd__fill_2
XFILLER_179_841 VPWR VGND VPWR VGND sky130_ef_sc_hd__decap_12
XFILLER_197_137 VPWR VGND VPWR VGND sky130_ef_sc_hd__decap_12
XFILLER_0_1397 VGND VGND VPWR VPWR sky130_fd_sc_hd__decap_3
XFILLER_201_609 VGND VGND VPWR VPWR sky130_fd_sc_hd__decap_6
XFILLER_55_1355 VPWR VGND VPWR VGND sky130_ef_sc_hd__decap_12
XFILLER_142_1303 VPWR VGND VPWR VGND sky130_ef_sc_hd__decap_12
XFILLER_244_1073 VPWR VGND VPWR VGND sky130_ef_sc_hd__decap_12
XFILLER_240_277 VPWR VGND VPWR VGND sky130_ef_sc_hd__decap_12
XFILLER_107_1423 VPWR VGND VPWR VGND sky130_ef_sc_hd__decap_12
XFILLER_222_981 VPWR VGND VPWR VGND sky130_ef_sc_hd__decap_12
XFILLER_146_1483 VPWR VGND VPWR VGND sky130_ef_sc_hd__decap_12
XFILLER_194_811 VGND VGND VPWR VPWR sky130_fd_sc_hd__fill_1
XFILLER_51_1219 VPWR VGND VPWR VGND sky130_ef_sc_hd__decap_12
XFILLER_16_1339 VPWR VGND VPWR VGND sky130_ef_sc_hd__decap_12
XFILLER_166_513 VPWR VGND VPWR VGND sky130_ef_sc_hd__decap_12
XFILLER_55_1399 VPWR VGND VPWR VGND sky130_ef_sc_hd__decap_12
XFILLER_107_1467 VPWR VGND VPWR VGND sky130_ef_sc_hd__decap_12
XFILLER_205_1057 VGND VGND VPWR VPWR sky130_fd_sc_hd__decap_6
XFILLER_166_557 VPWR VGND VPWR VGND sky130_ef_sc_hd__decap_12
XFILLER_222_1371 VGND VGND VPWR VPWR sky130_fd_sc_hd__fill_1
XFILLER_5_707 VGND VGND VPWR VPWR sky130_fd_sc_hd__fill_2
XFILLER_181_505 VPWR VGND VPWR VGND sky130_ef_sc_hd__decap_12
XFILLER_5_729 VGND VGND VPWR VPWR sky130_fd_sc_hd__decap_6
XFILLER_4_217 VGND VGND VPWR VPWR sky130_fd_sc_hd__decap_3
XFILLER_175_1101 VPWR VGND VPWR VGND sky130_ef_sc_hd__decap_12
XPHY_EDGE_ROW_221_Left_476 VGND VGND VPWR VPWR sky130_fd_sc_hd__decap_3
XFILLER_179_1281 VGND VGND VPWR VPWR sky130_fd_sc_hd__decap_6
XTAP_TAPCELL_ROW_74_2_4197 VGND VPWR sky130_fd_sc_hd__tapvpwrvgnd_1
XFILLER_175_1145 VPWR VGND VPWR VGND sky130_ef_sc_hd__decap_12
XFILLER_218_1429 VPWR VGND VPWR VGND sky130_ef_sc_hd__decap_12
XFILLER_1_924 VPWR VGND VPWR VGND sky130_ef_sc_hd__decap_12
XFILLER_66_1451 VPWR VGND VPWR VGND sky130_ef_sc_hd__decap_12
XFILLER_96_15 VPWR VGND VPWR VGND sky130_ef_sc_hd__decap_12
XFILLER_171_1009 VPWR VGND VPWR VGND sky130_ef_sc_hd__decap_12
XFILLER_175_1189 VPWR VGND VPWR VGND sky130_ef_sc_hd__decap_12
XFILLER_62_1315 VPWR VGND VPWR VGND sky130_ef_sc_hd__decap_12
XFILLER_27_1435 VGND VGND VPWR VPWR sky130_fd_sc_hd__decap_6
XTAP_TAPCELL_ROW_167_1400 VGND VPWR sky130_fd_sc_hd__tapvpwrvgnd_1
XFILLER_251_1033 VPWR VGND VPWR VGND sky130_ef_sc_hd__decap_12
XFILLER_153_1443 VPWR VGND VPWR VGND sky130_ef_sc_hd__decap_12
XFILLER_66_1495 VPWR VGND VPWR VGND sky130_ef_sc_hd__decap_12
XFILLER_248_333 VPWR VGND VPWR VGND sky130_ef_sc_hd__decap_12
XFILLER_62_1359 VPWR VGND VPWR VGND sky130_ef_sc_hd__decap_12
XFILLER_27_1479 VPWR VGND VPWR VGND sky130_ef_sc_hd__decap_12
XFILLER_114_1427 VPWR VGND VPWR VGND sky130_ef_sc_hd__decap_12
XFILLER_209_709 VPWR VGND VPWR VGND sky130_ef_sc_hd__decap_12
XFILLER_212_1017 VPWR VGND VPWR VGND sky130_ef_sc_hd__decap_12
XFILLER_251_1077 VPWR VGND VPWR VGND sky130_ef_sc_hd__decap_12
XFILLER_195_3 VPWR VGND VPWR VGND sky130_ef_sc_hd__decap_12
XFILLER_216_1197 VGND VGND VPWR VPWR sky130_fd_sc_hd__decap_6
XFILLER_249_889 VGND VGND VPWR VPWR sky130_fd_sc_hd__decap_6
XFILLER_248_377 VPWR VGND VPWR VGND sky130_ef_sc_hd__decap_12
XFILLER_5_1231 VGND VGND VPWR VPWR sky130_fd_sc_hd__fill_1
XFILLER_152_65 VGND VGND VPWR VPWR sky130_fd_sc_hd__decap_6
X_662_ clknet_3_5__leaf_clk acc_core.adder.cla_blocks\[7\].block.sum\[0\] _070_ VGND
+ VGND VPWR VPWR net63 sky130_fd_sc_hd__dfrtp_1
XFILLER_217_753 VPWR VGND VPWR VGND sky130_ef_sc_hd__decap_12
XPHY_EDGE_ROW_230_Left_485 VGND VGND VPWR VPWR sky130_fd_sc_hd__decap_3
XFILLER_186_1241 VPWR VGND VPWR VGND sky130_ef_sc_hd__decap_12
XFILLER_232_701 VPWR VGND VPWR VGND sky130_ef_sc_hd__decap_12
X_593_ clknet_3_2__leaf_clk _075_ _001_ VGND VGND VPWR VPWR rd_addr\[1\] sky130_fd_sc_hd__dfrtp_1
XFILLER_217_797 VPWR VGND VPWR VGND sky130_ef_sc_hd__decap_12
XFILLER_182_1105 VPWR VGND VPWR VGND sky130_ef_sc_hd__decap_12
XFILLER_186_1285 VPWR VGND VPWR VGND sky130_ef_sc_hd__decap_12
XFILLER_73_1411 VPWR VGND VPWR VGND sky130_ef_sc_hd__decap_12
XPHY_EDGE_ROW_36_1_Left_291 VGND VGND VPWR VPWR sky130_fd_sc_hd__decap_3
XFILLER_182_1149 VPWR VGND VPWR VGND sky130_ef_sc_hd__decap_12
XFILLER_204_469 VGND VGND VPWR VPWR sky130_fd_sc_hd__decap_6
XFILLER_73_1455 VPWR VGND VPWR VGND sky130_ef_sc_hd__decap_12
XFILLER_223_1113 VGND VGND VPWR VPWR sky130_fd_sc_hd__decap_6
XFILLER_197_671 VGND VGND VPWR VPWR sky130_fd_sc_hd__fill_1
XFILLER_169_373 VPWR VGND VPWR VGND sky130_ef_sc_hd__decap_12
XFILLER_34_1439 VPWR VGND VPWR VGND sky130_ef_sc_hd__decap_12
XPHY_EDGE_ROW_107_2_Right_198 VGND VGND VPWR VPWR sky130_fd_sc_hd__decap_3
XFILLER_185_833 VGND VGND VPWR VPWR sky130_fd_sc_hd__decap_6
XFILLER_61_51 VGND VGND VPWR VPWR sky130_fd_sc_hd__fill_1
XFILLER_73_1499 VPWR VGND VPWR VGND sky130_ef_sc_hd__decap_12
XFILLER_223_1157 VPWR VGND VPWR VGND sky130_ef_sc_hd__decap_12
XFILLER_184_321 VPWR VGND VPWR VGND sky130_ef_sc_hd__decap_12
XFILLER_160_1469 VGND VGND VPWR VPWR sky130_fd_sc_hd__fill_1
XFILLER_177_51 VGND VGND VPWR VPWR sky130_fd_sc_hd__decap_4
XFILLER_185_877 VPWR VGND VPWR VGND sky130_ef_sc_hd__decap_12
XTAP_TAPCELL_ROW_232_3150 VGND VPWR sky130_fd_sc_hd__tapvpwrvgnd_1
XFILLER_184_365 VPWR VGND VPWR VGND sky130_ef_sc_hd__decap_12
XTAP_TAPCELL_ROW_232_3161 VGND VPWR sky130_fd_sc_hd__tapvpwrvgnd_1
XFILLER_201_1455 VGND VGND VPWR VPWR sky130_fd_sc_hd__fill_1
XANTENNA_6 dout0\[10\] VGND VGND VPWR VPWR sky130_fd_sc_hd__diode_2
XFILLER_193_1201 VPWR VGND VPWR VGND sky130_ef_sc_hd__decap_12
XFILLER_197_1381 VPWR VGND VPWR VGND sky130_ef_sc_hd__decap_12
XFILLER_4_762 VGND VGND VPWR VPWR sky130_fd_sc_hd__fill_2
XFILLER_193_1245 VPWR VGND VPWR VGND sky130_ef_sc_hd__decap_12
XTAP_TAPCELL_ROW_245_3500 VGND VPWR sky130_fd_sc_hd__tapvpwrvgnd_1
XFILLER_10_1483 VPWR VGND VPWR VGND sky130_ef_sc_hd__decap_12
XTAP_TAPCELL_ROW_245_3511 VGND VPWR sky130_fd_sc_hd__tapvpwrvgnd_1
XFILLER_193_1289 VPWR VGND VPWR VGND sky130_ef_sc_hd__decap_12
XFILLER_80_1415 VPWR VGND VPWR VGND sky130_ef_sc_hd__decap_12
XFILLER_234_1253 VGND VGND VPWR VPWR sky130_fd_sc_hd__decap_6
XFILLER_6_1017 VPWR VGND VPWR VGND sky130_ef_sc_hd__decap_12
XFILLER_230_1117 VPWR VGND VPWR VGND sky130_ef_sc_hd__decap_12
XFILLER_234_1297 VPWR VGND VPWR VGND sky130_ef_sc_hd__decap_12
XFILLER_227_517 VPWR VGND VPWR VGND sky130_ef_sc_hd__decap_12
XFILLER_255_837 VGND VGND VPWR VPWR sky130_fd_sc_hd__decap_3
XTAP_TAPCELL_ROW_7_1045 VGND VPWR sky130_fd_sc_hd__tapvpwrvgnd_1
XTAP_TAPCELL_ROW_7_1056 VGND VPWR sky130_fd_sc_hd__tapvpwrvgnd_1
XFILLER_235_561 VPWR VGND VPWR VGND sky130_ef_sc_hd__decap_12
XFILLER_130_1295 VGND VGND VPWR VPWR sky130_fd_sc_hd__decap_6
XTAP_TAPCELL_ROW_239_3326 VGND VPWR sky130_fd_sc_hd__tapvpwrvgnd_1
XTAP_TAPCELL_ROW_239_3337 VGND VPWR sky130_fd_sc_hd__tapvpwrvgnd_1
XPHY_EDGE_ROW_69_2_Right_160 VGND VGND VPWR VPWR sky130_fd_sc_hd__decap_3
XFILLER_228_1035 VGND VGND VPWR VPWR sky130_fd_sc_hd__fill_1
XFILLER_250_531 VGND VGND VPWR VPWR sky130_fd_sc_hd__fill_1
XTAP_TAPCELL_ROW_239_3348 VGND VPWR sky130_fd_sc_hd__tapvpwrvgnd_1
XFILLER_222_233 VPWR VGND VPWR VGND sky130_ef_sc_hd__decap_12
XFILLER_91_1511 VGND VGND VPWR VPWR sky130_fd_sc_hd__decap_4
XFILLER_179_137 VPWR VGND VPWR VGND sky130_ef_sc_hd__decap_12
XFILLER_165_1369 VGND VGND VPWR VPWR sky130_fd_sc_hd__decap_3
XTAP_TAPCELL_ROW_98_1_1233 VGND VPWR sky130_fd_sc_hd__tapvpwrvgnd_1
XFILLER_204_981 VPWR VGND VPWR VGND sky130_ef_sc_hd__decap_12
XFILLER_222_277 VPWR VGND VPWR VGND sky130_ef_sc_hd__decap_12
XFILLER_241_1213 VPWR VGND VPWR VGND sky130_ef_sc_hd__decap_12
XFILLER_245_1393 VGND VGND VPWR VPWR sky130_fd_sc_hd__decap_6
XTAP_TAPCELL_ROW_112_1_1247 VGND VPWR sky130_fd_sc_hd__tapvpwrvgnd_1
XFILLER_176_811 VGND VGND VPWR VPWR sky130_fd_sc_hd__fill_1
XFILLER_128_1191 VPWR VGND VPWR VGND sky130_ef_sc_hd__decap_12
XFILLER_188_693 VGND VGND VPWR VPWR sky130_fd_sc_hd__decap_6
XFILLER_241_1257 VPWR VGND VPWR VGND sky130_ef_sc_hd__decap_12
XTAP_TAPCELL_ROW_91_2_4303 VGND VPWR sky130_fd_sc_hd__tapvpwrvgnd_1
XFILLER_187_181 VPWR VGND VPWR VGND sky130_ef_sc_hd__decap_12
XPHY_EDGE_ROW_6_Right_6 VGND VGND VPWR VPWR sky130_fd_sc_hd__decap_3
XFILLER_176_1421 VGND VGND VPWR VPWR sky130_fd_sc_hd__decap_6
XTAP_TAPCELL_ROW_215_2680 VGND VPWR sky130_fd_sc_hd__tapvpwrvgnd_1
XFILLER_190_357 VGND VGND VPWR VPWR sky130_fd_sc_hd__decap_6
XTAP_TAPCELL_ROW_215_2691 VGND VPWR sky130_fd_sc_hd__tapvpwrvgnd_1
XFILLER_239_1175 VGND VGND VPWR VPWR sky130_fd_sc_hd__fill_1
XFILLER_176_1465 VPWR VGND VPWR VGND sky130_ef_sc_hd__decap_12
XTAP_TAPCELL_ROW_211_2577 VGND VPWR sky130_fd_sc_hd__tapvpwrvgnd_1
XFILLER_172_1329 VPWR VGND VPWR VGND sky130_ef_sc_hd__decap_12
XTAP_TAPCELL_ROW_211_2588 VGND VPWR sky130_fd_sc_hd__tapvpwrvgnd_1
XFILLER_252_1353 VPWR VGND VPWR VGND sky130_ef_sc_hd__decap_12
XFILLER_66_18 VGND VGND VPWR VPWR sky130_fd_sc_hd__decap_8
XFILLER_213_1337 VGND VGND VPWR VPWR sky130_fd_sc_hd__decap_6
XFILLER_66_29 VPWR VGND VPWR VGND sky130_ef_sc_hd__decap_12
XFILLER_252_1397 VPWR VGND VPWR VGND sky130_ef_sc_hd__decap_12
XFILLER_246_837 VPWR VGND VPWR VGND sky130_ef_sc_hd__decap_12
XTAP_TAPCELL_ROW_224_2927 VGND VPWR sky130_fd_sc_hd__tapvpwrvgnd_1
XTAP_TAPCELL_ROW_224_2938 VGND VPWR sky130_fd_sc_hd__tapvpwrvgnd_1
XFILLER_214_701 VPWR VGND VPWR VGND sky130_ef_sc_hd__decap_12
XFILLER_254_881 VPWR VGND VPWR VGND sky130_ef_sc_hd__decap_12
XFILLER_183_1425 VPWR VGND VPWR VGND sky130_ef_sc_hd__decap_12
XFILLER_198_413 VGND VGND VPWR VPWR sky130_fd_sc_hd__decap_6
XFILLER_253_391 VGND VGND VPWR VPWR sky130_fd_sc_hd__fill_1
XTAP_TAPCELL_ROW_17_2_3856 VGND VPWR sky130_fd_sc_hd__tapvpwrvgnd_1
XFILLER_0_1161 VPWR VGND VPWR VGND sky130_ef_sc_hd__decap_12
XFILLER_241_553 VGND VGND VPWR VPWR sky130_fd_sc_hd__decap_6
XFILLER_207_1119 VGND VGND VPWR VPWR sky130_fd_sc_hd__fill_1
XFILLER_198_457 VPWR VGND VPWR VGND sky130_ef_sc_hd__decap_12
XFILLER_183_1469 VPWR VGND VPWR VGND sky130_ef_sc_hd__decap_12
XFILLER_201_417 VPWR VGND VPWR VGND sky130_ef_sc_hd__decap_12
XFILLER_241_597 VPWR VGND VPWR VGND sky130_ef_sc_hd__decap_12
XFILLER_107_1231 VPWR VGND VPWR VGND sky130_ef_sc_hd__decap_12
XFILLER_179_671 VGND VGND VPWR VPWR sky130_fd_sc_hd__fill_1
XFILLER_167_833 VGND VGND VPWR VPWR sky130_fd_sc_hd__decap_6
XFILLER_166_321 VPWR VGND VPWR VGND sky130_ef_sc_hd__decap_12
XFILLER_224_1477 VGND VGND VPWR VPWR sky130_fd_sc_hd__decap_6
XFILLER_107_1275 VPWR VGND VPWR VGND sky130_ef_sc_hd__decap_12
XFILLER_210_973 VGND VGND VPWR VPWR sky130_fd_sc_hd__decap_6
XFILLER_142_1177 VPWR VGND VPWR VGND sky130_ef_sc_hd__decap_12
XFILLER_167_877 VPWR VGND VPWR VGND sky130_ef_sc_hd__decap_12
XFILLER_166_365 VPWR VGND VPWR VGND sky130_ef_sc_hd__decap_12
XFILLER_182_825 VPWR VGND VPWR VGND sky130_ef_sc_hd__decap_12
XFILLER_110_3 VPWR VGND VPWR VGND sky130_ef_sc_hd__decap_12
XFILLER_181_335 VGND VGND VPWR VPWR sky130_fd_sc_hd__fill_1
XFILLER_182_869 VPWR VGND VPWR VGND sky130_ef_sc_hd__decap_12
XTAP_TAPCELL_ROW_136_2_4570 VGND VPWR sky130_fd_sc_hd__tapvpwrvgnd_1
XFILLER_208_3 VPWR VGND VPWR VGND sky130_ef_sc_hd__decap_12
Xoutput43 net568 VGND VGND VPWR VPWR acc_out[0] sky130_fd_sc_hd__buf_2
XFILLER_190_1429 VPWR VGND VPWR VGND sky130_ef_sc_hd__decap_12
XFILLER_218_1259 VGND VGND VPWR VPWR sky130_fd_sc_hd__fill_1
Xoutput54 net565 VGND VGND VPWR VPWR acc_out[1] sky130_fd_sc_hd__buf_2
Xoutput65 net562 VGND VGND VPWR VPWR acc_out[2] sky130_fd_sc_hd__buf_2
XFILLER_27_1243 VPWR VGND VPWR VGND sky130_ef_sc_hd__decap_12
XFILLER_0_253 VPWR VGND VPWR VGND sky130_ef_sc_hd__decap_12
XFILLER_118_1371 VPWR VGND VPWR VGND sky130_ef_sc_hd__decap_12
XFILLER_249_653 VPWR VGND VPWR VGND sky130_ef_sc_hd__decap_12
XFILLER_248_141 VPWR VGND VPWR VGND sky130_ef_sc_hd__decap_12
XFILLER_7_1337 VGND VGND VPWR VPWR sky130_fd_sc_hd__decap_6
XFILLER_231_1437 VPWR VGND VPWR VGND sky130_ef_sc_hd__decap_12
XFILLER_153_1273 VGND VGND VPWR VPWR sky130_fd_sc_hd__fill_1
XFILLER_27_1287 VPWR VGND VPWR VGND sky130_ef_sc_hd__decap_12
XFILLER_209_517 VPWR VGND VPWR VGND sky130_ef_sc_hd__decap_12
XFILLER_249_697 VPWR VGND VPWR VGND sky130_ef_sc_hd__decap_12
XFILLER_62_1189 VGND VGND VPWR VPWR sky130_fd_sc_hd__fill_1
XTAP_TAPCELL_ROW_186_1897 VGND VPWR sky130_fd_sc_hd__tapvpwrvgnd_1
XFILLER_97_1219 VPWR VGND VPWR VGND sky130_ef_sc_hd__decap_12
X_645_ clknet_3_1__leaf_clk acc_core.adder.cla_blocks\[2\].block.sum\[3\] _053_ VGND
+ VGND VPWR VPWR net45 sky130_fd_sc_hd__dfrtp_1
XFILLER_217_561 VPWR VGND VPWR VGND sky130_ef_sc_hd__decap_12
XFILLER_251_317 VPWR VGND VPWR VGND sky130_ef_sc_hd__decap_12
XTAP_TAPCELL_ROW_96_2_4329 VGND VPWR sky130_fd_sc_hd__tapvpwrvgnd_1
XFILLER_232_531 VGND VGND VPWR VPWR sky130_fd_sc_hd__fill_1
X_576_ net667 VGND VGND VPWR VPWR _058_ sky130_fd_sc_hd__inv_2
XTAP_TAPCELL_ROW_108_2_4405 VGND VPWR sky130_fd_sc_hd__tapvpwrvgnd_1
XFILLER_204_233 VPWR VGND VPWR VGND sky130_ef_sc_hd__decap_12
XFILLER_186_1093 VPWR VGND VPWR VGND sky130_ef_sc_hd__decap_12
XFILLER_229_1399 VGND VGND VPWR VPWR sky130_fd_sc_hd__fill_1
XFILLER_204_277 VPWR VGND VPWR VGND sky130_ef_sc_hd__decap_12
XTAP_TAPCELL_ROW_234_3201 VGND VPWR sky130_fd_sc_hd__tapvpwrvgnd_1
XFILLER_220_737 VPWR VGND VPWR VGND sky130_ef_sc_hd__decap_12
XTAP_TAPCELL_ROW_234_3212 VGND VPWR sky130_fd_sc_hd__tapvpwrvgnd_1
XFILLER_34_1203 VPWR VGND VPWR VGND sky130_ef_sc_hd__decap_12
XFILLER_38_1383 VPWR VGND VPWR VGND sky130_ef_sc_hd__decap_12
XFILLER_125_1331 VPWR VGND VPWR VGND sky130_ef_sc_hd__decap_12
XFILLER_201_951 VGND VGND VPWR VPWR sky130_fd_sc_hd__fill_1
XFILLER_169_181 VPWR VGND VPWR VGND sky130_ef_sc_hd__decap_12
XFILLER_188_83 VGND VGND VPWR VPWR sky130_fd_sc_hd__fill_1
XFILLER_34_1247 VPWR VGND VPWR VGND sky130_ef_sc_hd__decap_12
XFILLER_185_641 VPWR VGND VPWR VGND sky130_ef_sc_hd__decap_12
XFILLER_9_865 VGND VGND VPWR VPWR sky130_fd_sc_hd__decap_3
XPHY_EDGE_ROW_108_2_Right_199 VGND VGND VPWR VPWR sky130_fd_sc_hd__decap_3
XFILLER_121_1217 VGND VGND VPWR VPWR sky130_fd_sc_hd__fill_1
XTAP_TAPCELL_ROW_159_1_1294 VGND VPWR sky130_fd_sc_hd__tapvpwrvgnd_1
XFILLER_185_685 VPWR VGND VPWR VGND sky130_ef_sc_hd__decap_12
XFILLER_184_195 VGND VGND VPWR VPWR sky130_fd_sc_hd__fill_1
XFILLER_172_357 VGND VGND VPWR VPWR sky130_fd_sc_hd__decap_6
XFILLER_236_1315 VGND VGND VPWR VPWR sky130_fd_sc_hd__fill_1
XFILLER_207_57 VPWR VGND VPWR VGND sky130_ef_sc_hd__decap_12
XTAP_TAPCELL_ROW_228_3038 VGND VPWR sky130_fd_sc_hd__tapvpwrvgnd_1
XTAP_TAPCELL_ROW_228_3049 VGND VPWR sky130_fd_sc_hd__tapvpwrvgnd_1
XTAP_TAPCELL_ROW_9_1107 VGND VPWR sky130_fd_sc_hd__tapvpwrvgnd_1
XFILLER_45_1343 VPWR VGND VPWR VGND sky130_ef_sc_hd__decap_12
XFILLER_234_1061 VPWR VGND VPWR VGND sky130_ef_sc_hd__decap_12
XTAP_TAPCELL_ROW_9_1118 VGND VPWR sky130_fd_sc_hd__tapvpwrvgnd_1
XFILLER_136_1471 VPWR VGND VPWR VGND sky130_ef_sc_hd__decap_12
XTAP_TAPCELL_ROW_9_1129 VGND VPWR sky130_fd_sc_hd__tapvpwrvgnd_1
XFILLER_80_1245 VGND VGND VPWR VPWR sky130_fd_sc_hd__fill_1
XFILLER_255_601 VPWR VGND VPWR VGND sky130_ef_sc_hd__decap_12
XFILLER_45_1387 VPWR VGND VPWR VGND sky130_ef_sc_hd__decap_12
XFILLER_228_837 VPWR VGND VPWR VGND sky130_ef_sc_hd__decap_12
XFILLER_132_1357 VGND VGND VPWR VPWR sky130_fd_sc_hd__fill_1
XFILLER_255_645 VPWR VGND VPWR VGND sky130_ef_sc_hd__decap_12
XFILLER_254_133 VGND VGND VPWR VPWR sky130_fd_sc_hd__decap_6
XFILLER_254_177 VPWR VGND VPWR VGND sky130_ef_sc_hd__decap_12
XFILLER_236_881 VPWR VGND VPWR VGND sky130_ef_sc_hd__decap_12
XFILLER_247_1455 VGND VGND VPWR VPWR sky130_fd_sc_hd__fill_1
XFILLER_235_391 VGND VGND VPWR VPWR sky130_fd_sc_hd__fill_1
XTAP_TAPCELL_ROW_204_2381 VGND VPWR sky130_fd_sc_hd__tapvpwrvgnd_1
XTAP_TAPCELL_ROW_204_2392 VGND VPWR sky130_fd_sc_hd__tapvpwrvgnd_1
XFILLER_165_1133 VPWR VGND VPWR VGND sky130_ef_sc_hd__decap_12
XFILLER_223_553 VGND VGND VPWR VPWR sky130_fd_sc_hd__decap_6
XFILLER_1_1481 VPWR VGND VPWR VGND sky130_ef_sc_hd__decap_12
XFILLER_196_917 VGND VGND VPWR VPWR sky130_fd_sc_hd__decap_6
XFILLER_251_895 VGND VGND VPWR VPWR sky130_fd_sc_hd__fill_1
XFILLER_165_1177 VPWR VGND VPWR VGND sky130_ef_sc_hd__decap_12
XFILLER_195_405 VPWR VGND VPWR VGND sky130_ef_sc_hd__decap_12
XTAP_TAPCELL_ROW_200_2278 VGND VPWR sky130_fd_sc_hd__tapvpwrvgnd_1
XFILLER_223_597 VPWR VGND VPWR VGND sky130_ef_sc_hd__decap_12
XTAP_TAPCELL_ROW_196_2171 VGND VPWR sky130_fd_sc_hd__tapvpwrvgnd_1
XTAP_TAPCELL_ROW_200_2289 VGND VPWR sky130_fd_sc_hd__tapvpwrvgnd_1
XFILLER_241_1021 VPWR VGND VPWR VGND sky130_ef_sc_hd__decap_12
XFILLER_52_1303 VPWR VGND VPWR VGND sky130_ef_sc_hd__decap_12
XFILLER_17_1423 VPWR VGND VPWR VGND sky130_ef_sc_hd__decap_12
XTAP_TAPCELL_ROW_196_2182 VGND VPWR sky130_fd_sc_hd__tapvpwrvgnd_1
XFILLER_56_1483 VPWR VGND VPWR VGND sky130_ef_sc_hd__decap_12
XFILLER_206_1141 VGND VGND VPWR VPWR sky130_fd_sc_hd__decap_6
XFILLER_195_449 VPWR VGND VPWR VGND sky130_ef_sc_hd__decap_12
XFILLER_91_1385 VGND VGND VPWR VPWR sky130_fd_sc_hd__fill_1
XFILLER_202_1005 VPWR VGND VPWR VGND sky130_ef_sc_hd__decap_12
XTAP_TAPCELL_ROW_217_2731 VGND VPWR sky130_fd_sc_hd__tapvpwrvgnd_1
XFILLER_241_1065 VPWR VGND VPWR VGND sky130_ef_sc_hd__decap_12
XFILLER_17_1467 VPWR VGND VPWR VGND sky130_ef_sc_hd__decap_12
XFILLER_104_1415 VPWR VGND VPWR VGND sky130_ef_sc_hd__decap_12
XTAP_TAPCELL_ROW_192_2057 VGND VPWR sky130_fd_sc_hd__tapvpwrvgnd_1
XFILLER_206_1185 VPWR VGND VPWR VGND sky130_ef_sc_hd__decap_12
XTAP_TAPCELL_ROW_192_2068 VGND VPWR sky130_fd_sc_hd__tapvpwrvgnd_1
XTAP_TAPCELL_ROW_217_2742 VGND VPWR sky130_fd_sc_hd__tapvpwrvgnd_1
XTAP_TAPCELL_ROW_192_2079 VGND VPWR sky130_fd_sc_hd__tapvpwrvgnd_1
XTAP_TAPCELL_ROW_217_2753 VGND VPWR sky130_fd_sc_hd__tapvpwrvgnd_1
XFILLER_248_53 VPWR VGND VPWR VGND sky130_ef_sc_hd__decap_12
XFILLER_143_1497 VGND VGND VPWR VPWR sky130_fd_sc_hd__fill_1
XFILLER_202_1049 VPWR VGND VPWR VGND sky130_ef_sc_hd__decap_12
XTAP_TAPCELL_ROW_213_2628 VGND VPWR sky130_fd_sc_hd__tapvpwrvgnd_1
XFILLER_248_97 VPWR VGND VPWR VGND sky130_ef_sc_hd__decap_12
XFILLER_190_121 VPWR VGND VPWR VGND sky130_ef_sc_hd__decap_12
XTAP_TAPCELL_ROW_213_2639 VGND VPWR sky130_fd_sc_hd__tapvpwrvgnd_1
XFILLER_219_1513 VGND VGND VPWR VPWR sky130_fd_sc_hd__fill_2
XFILLER_190_165 VPWR VGND VPWR VGND sky130_ef_sc_hd__decap_12
XFILLER_137_1213 VGND VGND VPWR VPWR sky130_fd_sc_hd__decap_4
XFILLER_176_1273 VPWR VGND VPWR VGND sky130_ef_sc_hd__decap_12
XFILLER_117_57 VPWR VGND VPWR VGND sky130_ef_sc_hd__decap_12
XFILLER_85_1189 VPWR VGND VPWR VGND sky130_ef_sc_hd__decap_12
XFILLER_77_39 VPWR VGND VPWR VGND sky130_ef_sc_hd__decap_12
XFILLER_213_1101 VPWR VGND VPWR VGND sky130_ef_sc_hd__decap_12
XFILLER_63_1443 VPWR VGND VPWR VGND sky130_ef_sc_hd__decap_12
XFILLER_115_1511 VGND VGND VPWR VPWR sky130_fd_sc_hd__decap_4
XFILLER_252_1161 VPWR VGND VPWR VGND sky130_ef_sc_hd__decap_12
XFILLER_217_1281 VGND VGND VPWR VPWR sky130_fd_sc_hd__decap_6
XFILLER_150_1413 VGND VGND VPWR VPWR sky130_fd_sc_hd__fill_1
XFILLER_246_601 VPWR VGND VPWR VGND sky130_ef_sc_hd__decap_12
XFILLER_24_1427 VPWR VGND VPWR VGND sky130_ef_sc_hd__decap_12
XTAP_TAPCELL_ROW_114_2_4437 VGND VPWR sky130_fd_sc_hd__tapvpwrvgnd_1
XTAP_TAPCELL_ROW_69_2_4170 VGND VPWR sky130_fd_sc_hd__tapvpwrvgnd_1
XFILLER_213_1145 VPWR VGND VPWR VGND sky130_ef_sc_hd__decap_12
XFILLER_245_111 VGND VGND VPWR VPWR sky130_fd_sc_hd__fill_1
XFILLER_246_645 VPWR VGND VPWR VGND sky130_ef_sc_hd__decap_12
XFILLER_213_1189 VPWR VGND VPWR VGND sky130_ef_sc_hd__decap_12
XFILLER_93_27 VPWR VGND VPWR VGND sky130_ef_sc_hd__decap_12
XTAP_TAPCELL_ROW_82_2_4248 VGND VPWR sky130_fd_sc_hd__tapvpwrvgnd_1
XTAP_TAPCELL_ROW_181_1761 VGND VPWR sky130_fd_sc_hd__tapvpwrvgnd_1
XFILLER_233_317 VPWR VGND VPWR VGND sky130_ef_sc_hd__decap_12
XTAP_TAPCELL_ROW_181_1772 VGND VPWR sky130_fd_sc_hd__tapvpwrvgnd_1
XTAP_TAPCELL_ROW_181_1783 VGND VPWR sky130_fd_sc_hd__tapvpwrvgnd_1
X_430_ _215_ _216_ net192 VGND VGND VPWR VPWR _219_ sky130_fd_sc_hd__or3_1
XFILLER_214_531 VGND VGND VPWR VPWR sky130_fd_sc_hd__fill_1
XFILLER_183_1233 VPWR VGND VPWR VGND sky130_ef_sc_hd__decap_12
XFILLER_198_221 VPWR VGND VPWR VGND sky130_ef_sc_hd__decap_12
XFILLER_158_3 VPWR VGND VPWR VGND sky130_ef_sc_hd__decap_12
XTAP_TAPCELL_ROW_62_2_4124 VGND VPWR sky130_fd_sc_hd__tapvpwrvgnd_1
XFILLER_241_361 VPWR VGND VPWR VGND sky130_ef_sc_hd__decap_12
X_361_ net326 _149_ VGND VGND VPWR VPWR _150_ sky130_fd_sc_hd__nand2_1
XFILLER_199_777 VGND VGND VPWR VPWR sky130_fd_sc_hd__decap_6
XFILLER_198_265 VPWR VGND VPWR VGND sky130_ef_sc_hd__decap_12
XFILLER_202_737 VPWR VGND VPWR VGND sky130_ef_sc_hd__decap_12
XFILLER_144_1239 VGND VGND VPWR VPWR sky130_fd_sc_hd__decap_6
XFILLER_201_225 VPWR VGND VPWR VGND sky130_ef_sc_hd__decap_12
XFILLER_224_1241 VPWR VGND VPWR VGND sky130_ef_sc_hd__decap_12
X_292_ net690 net182 VGND VGND VPWR VPWR _079_ sky130_fd_sc_hd__xor2_1
XFILLER_167_641 VPWR VGND VPWR VGND sky130_ef_sc_hd__decap_12
XFILLER_220_1105 VPWR VGND VPWR VGND sky130_ef_sc_hd__decap_12
XFILLER_224_1285 VPWR VGND VPWR VGND sky130_ef_sc_hd__decap_12
XFILLER_70_1469 VGND VGND VPWR VPWR sky130_fd_sc_hd__fill_1
XFILLER_210_781 VPWR VGND VPWR VGND sky130_ef_sc_hd__decap_12
XFILLER_158_53 VPWR VGND VPWR VGND sky130_ef_sc_hd__decap_12
XFILLER_167_685 VPWR VGND VPWR VGND sky130_ef_sc_hd__decap_12
XFILLER_6_813 VPWR VGND VPWR VGND sky130_ef_sc_hd__decap_12
XFILLER_220_1149 VPWR VGND VPWR VGND sky130_ef_sc_hd__decap_12
XTAP_TAPCELL_ROW_175_1598 VGND VPWR sky130_fd_sc_hd__tapvpwrvgnd_1
XFILLER_166_195 VGND VGND VPWR VPWR sky130_fd_sc_hd__fill_1
XFILLER_120_1283 VPWR VGND VPWR VGND sky130_ef_sc_hd__decap_12
XFILLER_182_699 VGND VGND VPWR VPWR sky130_fd_sc_hd__fill_1
XFILLER_174_41 VPWR VGND VPWR VGND sky130_ef_sc_hd__decap_12
XFILLER_194_1373 VPWR VGND VPWR VGND sky130_ef_sc_hd__decap_12
XFILLER_174_85 VPWR VGND VPWR VGND sky130_ef_sc_hd__decap_12
XTAP_TAPCELL_ROW_188_1948 VGND VPWR sky130_fd_sc_hd__tapvpwrvgnd_1
XTAP_TAPCELL_ROW_188_1959 VGND VPWR sky130_fd_sc_hd__tapvpwrvgnd_1
XFILLER_190_1259 VGND VGND VPWR VPWR sky130_fd_sc_hd__fill_1
XFILLER_7_1101 VPWR VGND VPWR VGND sky130_ef_sc_hd__decap_12
XFILLER_155_1379 VGND VGND VPWR VPWR sky130_fd_sc_hd__decap_6
XFILLER_231_1201 VPWR VGND VPWR VGND sky130_ef_sc_hd__decap_12
XFILLER_235_1381 VPWR VGND VPWR VGND sky130_ef_sc_hd__decap_12
XFILLER_3_69 VPWR VGND VPWR VGND sky130_ef_sc_hd__decap_12
XFILLER_249_461 VPWR VGND VPWR VGND sky130_ef_sc_hd__decap_12
XFILLER_7_1145 VPWR VGND VPWR VGND sky130_ef_sc_hd__decap_12
XFILLER_231_1245 VPWR VGND VPWR VGND sky130_ef_sc_hd__decap_12
XFILLER_3_1009 VPWR VGND VPWR VGND sky130_ef_sc_hd__decap_12
XFILLER_7_1189 VPWR VGND VPWR VGND sky130_ef_sc_hd__decap_12
XFILLER_236_133 VGND VGND VPWR VPWR sky130_fd_sc_hd__decap_6
XFILLER_231_1289 VPWR VGND VPWR VGND sky130_ef_sc_hd__decap_12
XTAP_TAPCELL_ROW_158_2_4702 VGND VPWR sky130_fd_sc_hd__tapvpwrvgnd_1
XFILLER_236_177 VPWR VGND VPWR VGND sky130_ef_sc_hd__decap_12
XFILLER_218_881 VPWR VGND VPWR VGND sky130_ef_sc_hd__decap_12
XFILLER_252_637 VGND VGND VPWR VPWR sky130_fd_sc_hd__decap_6
XFILLER_251_125 VPWR VGND VPWR VGND sky130_ef_sc_hd__decap_12
XFILLER_40_1295 VGND VGND VPWR VPWR sky130_fd_sc_hd__decap_6
X_628_ clknet_3_5__leaf_clk dout0\[26\] _036_ VGND VGND VPWR VPWR dout0_q\[26\] sky130_fd_sc_hd__dfrtp_1
XFILLER_217_391 VGND VGND VPWR VPWR sky130_fd_sc_hd__fill_1
XFILLER_166_1453 VPWR VGND VPWR VGND sky130_ef_sc_hd__decap_12
XFILLER_205_553 VGND VGND VPWR VPWR sky130_fd_sc_hd__decap_6
XFILLER_251_169 VPWR VGND VPWR VGND sky130_ef_sc_hd__decap_12
XFILLER_178_917 VGND VGND VPWR VPWR sky130_fd_sc_hd__decap_6
XFILLER_220_501 VPWR VGND VPWR VGND sky130_ef_sc_hd__decap_12
XFILLER_233_895 VGND VGND VPWR VPWR sky130_fd_sc_hd__fill_1
X_559_ net670 VGND VGND VPWR VPWR _041_ sky130_fd_sc_hd__inv_2
XFILLER_177_405 VPWR VGND VPWR VGND sky130_ef_sc_hd__decap_12
XFILLER_166_1497 VPWR VGND VPWR VGND sky130_ef_sc_hd__decap_12
XFILLER_199_93 VPWR VGND VPWR VGND sky130_ef_sc_hd__decap_12
XFILLER_205_597 VPWR VGND VPWR VGND sky130_ef_sc_hd__decap_12
XFILLER_162_1339 VPWR VGND VPWR VGND sky130_ef_sc_hd__decap_12
XFILLER_242_1341 VPWR VGND VPWR VGND sky130_ef_sc_hd__decap_12
XFILLER_220_545 VPWR VGND VPWR VGND sky130_ef_sc_hd__decap_12
XFILLER_177_449 VPWR VGND VPWR VGND sky130_ef_sc_hd__decap_12
XFILLER_38_1191 VPWR VGND VPWR VGND sky130_ef_sc_hd__decap_12
XFILLER_193_909 VPWR VGND VPWR VGND sky130_ef_sc_hd__decap_12
XFILLER_186_961 VPWR VGND VPWR VGND sky130_ef_sc_hd__decap_12
XFILLER_203_1325 VPWR VGND VPWR VGND sky130_ef_sc_hd__decap_12
XFILLER_220_589 VPWR VGND VPWR VGND sky130_ef_sc_hd__decap_12
XFILLER_242_1385 VPWR VGND VPWR VGND sky130_ef_sc_hd__decap_12
XFILLER_192_419 VGND VGND VPWR VPWR sky130_fd_sc_hd__fill_1
XFILLER_9_673 VPWR VGND VPWR VGND sky130_ef_sc_hd__decap_12
XFILLER_73_3 VPWR VGND VPWR VGND sky130_ef_sc_hd__decap_12
XFILLER_203_1369 VPWR VGND VPWR VGND sky130_ef_sc_hd__decap_12
XFILLER_8_183 VPWR VGND VPWR VGND sky130_ef_sc_hd__decap_12
XFILLER_172_121 VPWR VGND VPWR VGND sky130_ef_sc_hd__decap_12
XTAP_TAPCELL_ROW_107_1_1242 VGND VPWR sky130_fd_sc_hd__tapvpwrvgnd_1
XFILLER_172_165 VPWR VGND VPWR VGND sky130_ef_sc_hd__decap_12
XFILLER_173_1413 VPWR VGND VPWR VGND sky130_ef_sc_hd__decap_12
XFILLER_173_1457 VPWR VGND VPWR VGND sky130_ef_sc_hd__decap_12
XTAP_TAPCELL_ROW_100_2_4356 VGND VPWR sky130_fd_sc_hd__tapvpwrvgnd_1
XFILLER_214_1421 VGND VGND VPWR VPWR sky130_fd_sc_hd__decap_6
XFILLER_253_1481 VPWR VGND VPWR VGND sky130_ef_sc_hd__decap_12
XFILLER_228_601 VPWR VGND VPWR VGND sky130_ef_sc_hd__decap_12
XFILLER_234_77 VGND VGND VPWR VPWR sky130_fd_sc_hd__decap_6
XFILLER_214_1465 VPWR VGND VPWR VGND sky130_ef_sc_hd__decap_12
XFILLER_227_111 VGND VGND VPWR VPWR sky130_fd_sc_hd__fill_1
XFILLER_228_645 VPWR VGND VPWR VGND sky130_ef_sc_hd__decap_12
XFILLER_210_1329 VPWR VGND VPWR VGND sky130_ef_sc_hd__decap_12
XFILLER_132_1165 VPWR VGND VPWR VGND sky130_ef_sc_hd__decap_12
XTAP_TAPCELL_ROW_206_2443 VGND VPWR sky130_fd_sc_hd__tapvpwrvgnd_1
XFILLER_103_15 VPWR VGND VPWR VGND sky130_ef_sc_hd__decap_12
XTAP_TAPCELL_ROW_206_2454 VGND VPWR sky130_fd_sc_hd__tapvpwrvgnd_1
XFILLER_243_615 VGND VGND VPWR VPWR sky130_fd_sc_hd__fill_1
XFILLER_215_317 VPWR VGND VPWR VGND sky130_ef_sc_hd__decap_12
XFILLER_250_65 VPWR VGND VPWR VGND sky130_ef_sc_hd__decap_12
XTAP_TAPCELL_ROW_202_2329 VGND VPWR sky130_fd_sc_hd__tapvpwrvgnd_1
XFILLER_110_1463 VGND VGND VPWR VPWR sky130_fd_sc_hd__decap_6
XTAP_TAPCELL_ROW_198_2222 VGND VPWR sky130_fd_sc_hd__tapvpwrvgnd_1
XTAP_TAPCELL_ROW_198_2233 VGND VPWR sky130_fd_sc_hd__tapvpwrvgnd_1
XTAP_TAPCELL_ROW_198_2244 VGND VPWR sky130_fd_sc_hd__tapvpwrvgnd_1
XFILLER_208_1203 VGND VGND VPWR VPWR sky130_fd_sc_hd__fill_1
XTAP_TAPCELL_ROW_47_2_4037 VGND VPWR sky130_fd_sc_hd__tapvpwrvgnd_1
XFILLER_230_309 VPWR VGND VPWR VGND sky130_ef_sc_hd__decap_12
XFILLER_223_361 VPWR VGND VPWR VGND sky130_ef_sc_hd__decap_12
XTAP_TAPCELL_ROW_194_2119 VGND VPWR sky130_fd_sc_hd__tapvpwrvgnd_1
XTAP_TAPCELL_ROW_219_2804 VGND VPWR sky130_fd_sc_hd__tapvpwrvgnd_1
XFILLER_196_725 VPWR VGND VPWR VGND sky130_ef_sc_hd__decap_12
XFILLER_17_1231 VPWR VGND VPWR VGND sky130_ef_sc_hd__decap_12
XFILLER_196_769 VPWR VGND VPWR VGND sky130_ef_sc_hd__decap_12
XFILLER_221_1425 VPWR VGND VPWR VGND sky130_ef_sc_hd__decap_12
XFILLER_17_1275 VPWR VGND VPWR VGND sky130_ef_sc_hd__decap_12
XFILLER_195_279 VGND VGND VPWR VPWR sky130_fd_sc_hd__fill_1
XFILLER_6_109 VPWR VGND VPWR VGND sky130_ef_sc_hd__decap_12
XFILLER_52_1177 VPWR VGND VPWR VGND sky130_ef_sc_hd__decap_12
XFILLER_104_1245 VGND VGND VPWR VPWR sky130_fd_sc_hd__fill_1
XFILLER_221_1469 VPWR VGND VPWR VGND sky130_ef_sc_hd__decap_12
XFILLER_191_441 VGND VGND VPWR VPWR sky130_fd_sc_hd__decap_6
XTAP_TAPCELL_ROW_25_2_3907 VGND VPWR sky130_fd_sc_hd__tapvpwrvgnd_1
XFILLER_191_485 VPWR VGND VPWR VGND sky130_ef_sc_hd__decap_12
XFILLER_88_27 VGND VGND VPWR VPWR sky130_fd_sc_hd__fill_1
XTAP_TAPCELL_ROW_170_1462 VGND VPWR sky130_fd_sc_hd__tapvpwrvgnd_1
XTAP_TAPCELL_ROW_170_1473 VGND VPWR sky130_fd_sc_hd__tapvpwrvgnd_1
XFILLER_191_1513 VGND VGND VPWR VPWR sky130_fd_sc_hd__fill_2
XFILLER_219_1343 VGND VGND VPWR VPWR sky130_fd_sc_hd__fill_1
XFILLER_5_6 VPWR VGND VPWR VGND sky130_ef_sc_hd__decap_12
XTAP_TAPCELL_ROW_170_1484 VGND VPWR sky130_fd_sc_hd__tapvpwrvgnd_1
XFILLER_8_1421 VGND VGND VPWR VPWR sky130_fd_sc_hd__decap_6
XFILLER_28_1371 VPWR VGND VPWR VGND sky130_ef_sc_hd__decap_12
XFILLER_247_921 VPWR VGND VPWR VGND sky130_ef_sc_hd__decap_12
XFILLER_63_1273 VGND VGND VPWR VPWR sky130_fd_sc_hd__fill_1
Xfanout663 net671 VGND VGND VPWR VPWR net663 sky130_fd_sc_hd__buf_4
XFILLER_8_1465 VPWR VGND VPWR VGND sky130_ef_sc_hd__decap_12
XTAP_TAPCELL_ROW_183_1823 VGND VPWR sky130_fd_sc_hd__tapvpwrvgnd_1
XTAP_TAPCELL_ROW_183_1834 VGND VPWR sky130_fd_sc_hd__tapvpwrvgnd_1
XFILLER_98_1303 VPWR VGND VPWR VGND sky130_ef_sc_hd__decap_12
XPHY_EDGE_ROW_171_Left_426 VGND VGND VPWR VPWR sky130_fd_sc_hd__decap_3
XFILLER_247_965 VPWR VGND VPWR VGND sky130_ef_sc_hd__decap_12
XFILLER_4_1329 VPWR VGND VPWR VGND sky130_ef_sc_hd__decap_12
XFILLER_218_133 VGND VGND VPWR VPWR sky130_fd_sc_hd__decap_6
XFILLER_115_1385 VGND VGND VPWR VPWR sky130_fd_sc_hd__fill_1
XTAP_TAPCELL_ROW_144_2_4621 VGND VPWR sky130_fd_sc_hd__tapvpwrvgnd_1
XFILLER_248_1005 VPWR VGND VPWR VGND sky130_ef_sc_hd__decap_12
XPHY_EDGE_ROW_90_1_Right_746 VGND VGND VPWR VPWR sky130_fd_sc_hd__decap_3
XFILLER_246_475 VGND VGND VPWR VPWR sky130_fd_sc_hd__fill_1
XFILLER_218_177 VPWR VGND VPWR VGND sky130_ef_sc_hd__decap_12
XFILLER_234_637 VGND VGND VPWR VPWR sky130_fd_sc_hd__decap_6
XFILLER_248_1049 VPWR VGND VPWR VGND sky130_ef_sc_hd__decap_12
XFILLER_160_65 VGND VGND VPWR VPWR sky130_fd_sc_hd__decap_6
XFILLER_233_125 VPWR VGND VPWR VGND sky130_ef_sc_hd__decap_12
XFILLER_199_541 VPWR VGND VPWR VGND sky130_ef_sc_hd__decap_12
XFILLER_233_169 VPWR VGND VPWR VGND sky130_ef_sc_hd__decap_12
XPHY_EDGE_ROW_64_1_Left_319 VGND VGND VPWR VPWR sky130_fd_sc_hd__decap_3
X_413_ net125 _200_ _201_ VGND VGND VPWR VPWR _202_ sky130_fd_sc_hd__and3_1
XFILLER_202_501 VPWR VGND VPWR VGND sky130_ef_sc_hd__decap_12
XFILLER_215_895 VGND VGND VPWR VPWR sky130_fd_sc_hd__fill_1
XFILLER_242_681 VPWR VGND VPWR VGND sky130_ef_sc_hd__decap_12
XFILLER_183_1063 VGND VGND VPWR VPWR sky130_fd_sc_hd__fill_1
XFILLER_199_585 VPWR VGND VPWR VGND sky130_ef_sc_hd__decap_12
XFILLER_53_63 VGND VGND VPWR VPWR sky130_fd_sc_hd__decap_8
XFILLER_202_545 VPWR VGND VPWR VGND sky130_ef_sc_hd__decap_12
X_344_ net592 net572 net544 VGND VGND VPWR VPWR _133_ sky130_fd_sc_hd__a21oi_1
XFILLER_35_1331 VPWR VGND VPWR VGND sky130_ef_sc_hd__decap_12
XFILLER_175_909 VPWR VGND VPWR VGND sky130_ef_sc_hd__decap_12
XFILLER_109_1189 VPWR VGND VPWR VGND sky130_ef_sc_hd__decap_12
XFILLER_122_1301 VGND VGND VPWR VPWR sky130_fd_sc_hd__fill_1
XFILLER_168_961 VPWR VGND VPWR VGND sky130_ef_sc_hd__decap_12
XFILLER_202_589 VPWR VGND VPWR VGND sky130_ef_sc_hd__decap_12
XPHY_EDGE_ROW_180_Left_435 VGND VGND VPWR VPWR sky130_fd_sc_hd__decap_3
XFILLER_174_419 VGND VGND VPWR VPWR sky130_fd_sc_hd__fill_1
XFILLER_31_1217 VGND VGND VPWR VPWR sky130_fd_sc_hd__fill_1
XFILLER_224_1093 VPWR VGND VPWR VGND sky130_ef_sc_hd__decap_12
XFILLER_200_1509 VGND VGND VPWR VPWR sky130_fd_sc_hd__decap_6
XFILLER_183_953 VPWR VGND VPWR VGND sky130_ef_sc_hd__decap_12
XFILLER_6_643 VGND VGND VPWR VPWR sky130_fd_sc_hd__fill_1
XFILLER_185_51 VGND VGND VPWR VPWR sky130_fd_sc_hd__decap_4
XFILLER_255_1009 VPWR VGND VPWR VGND sky130_ef_sc_hd__decap_12
XFILLER_170_625 VPWR VGND VPWR VGND sky130_ef_sc_hd__decap_12
XFILLER_6_687 VGND VGND VPWR VPWR sky130_fd_sc_hd__fill_1
XFILLER_170_669 VPWR VGND VPWR VGND sky130_ef_sc_hd__decap_12
XFILLER_9_1229 VGND VGND VPWR VPWR sky130_fd_sc_hd__decap_3
XFILLER_46_1471 VPWR VGND VPWR VGND sky130_ef_sc_hd__decap_12
XFILLER_133_1441 VGND VGND VPWR VPWR sky130_fd_sc_hd__fill_1
XFILLER_209_111 VGND VGND VPWR VPWR sky130_fd_sc_hd__fill_1
XTAP_TAPCELL_ROW_38_2_3985 VGND VPWR sky130_fd_sc_hd__tapvpwrvgnd_1
XFILLER_42_1357 VGND VGND VPWR VPWR sky130_fd_sc_hd__fill_1
XFILLER_225_615 VGND VGND VPWR VPWR sky130_fd_sc_hd__fill_1
XFILLER_252_401 VPWR VGND VPWR VGND sky130_ef_sc_hd__decap_12
XFILLER_237_497 VGND VGND VPWR VPWR sky130_fd_sc_hd__decap_6
XFILLER_252_445 VPWR VGND VPWR VGND sky130_ef_sc_hd__decap_12
XTAP_TAPCELL_ROW_18_2_3861 VGND VPWR sky130_fd_sc_hd__tapvpwrvgnd_1
XFILLER_212_309 VPWR VGND VPWR VGND sky130_ef_sc_hd__decap_12
XFILLER_252_489 VPWR VGND VPWR VGND sky130_ef_sc_hd__decap_12
XFILLER_127_1201 VPWR VGND VPWR VGND sky130_ef_sc_hd__decap_12
XFILLER_166_1261 VPWR VGND VPWR VGND sky130_ef_sc_hd__decap_12
XFILLER_205_361 VPWR VGND VPWR VGND sky130_ef_sc_hd__decap_12
XFILLER_221_821 VPWR VGND VPWR VGND sky130_ef_sc_hd__decap_12
XFILLER_178_725 VPWR VGND VPWR VGND sky130_ef_sc_hd__decap_12
XTAP_TAPCELL_ROW_31_2_3939 VGND VPWR sky130_fd_sc_hd__tapvpwrvgnd_1
XFILLER_75_1177 VPWR VGND VPWR VGND sky130_ef_sc_hd__decap_12
XFILLER_127_1267 VGND VGND VPWR VPWR sky130_fd_sc_hd__decap_6
XFILLER_221_865 VPWR VGND VPWR VGND sky130_ef_sc_hd__decap_12
XFILLER_178_769 VPWR VGND VPWR VGND sky130_ef_sc_hd__decap_12
XFILLER_14_1415 VPWR VGND VPWR VGND sky130_ef_sc_hd__decap_12
XFILLER_177_279 VGND VGND VPWR VPWR sky130_fd_sc_hd__fill_1
XFILLER_203_1133 VPWR VGND VPWR VGND sky130_ef_sc_hd__decap_12
XFILLER_53_1497 VGND VGND VPWR VPWR sky130_fd_sc_hd__fill_1
XFILLER_229_55 VGND VGND VPWR VPWR sky130_fd_sc_hd__fill_1
XFILLER_203_1177 VPWR VGND VPWR VGND sky130_ef_sc_hd__decap_12
XFILLER_173_441 VGND VGND VPWR VPWR sky130_fd_sc_hd__decap_6
XFILLER_238_1229 VPWR VGND VPWR VGND sky130_ef_sc_hd__decap_12
XFILLER_173_485 VPWR VGND VPWR VGND sky130_ef_sc_hd__decap_12
XFILLER_47_1213 VGND VGND VPWR VPWR sky130_fd_sc_hd__decap_4
XTAP_TAPCELL_ROW_150_2_4653 VGND VPWR sky130_fd_sc_hd__tapvpwrvgnd_1
XTAP_TAPCELL_ROW_149_2_4647 VGND VPWR sky130_fd_sc_hd__tapvpwrvgnd_1
XFILLER_86_1295 VGND VGND VPWR VPWR sky130_fd_sc_hd__decap_6
XFILLER_134_1227 VPWR VGND VPWR VGND sky130_ef_sc_hd__decap_12
XFILLER_25_1511 VGND VGND VPWR VPWR sky130_fd_sc_hd__decap_4
XFILLER_173_1287 VGND VGND VPWR VPWR sky130_fd_sc_hd__fill_1
XTAP_TAPCELL_ROW_208_2505 VGND VPWR sky130_fd_sc_hd__tapvpwrvgnd_1
XFILLER_247_217 VGND VGND VPWR VPWR sky130_fd_sc_hd__decap_6
XFILLER_60_1413 VGND VGND VPWR VPWR sky130_fd_sc_hd__fill_1
XFILLER_229_921 VPWR VGND VPWR VGND sky130_ef_sc_hd__decap_12
XFILLER_214_1273 VPWR VGND VPWR VGND sky130_ef_sc_hd__decap_12
XFILLER_229_965 VPWR VGND VPWR VGND sky130_ef_sc_hd__decap_12
XFILLER_249_1325 VPWR VGND VPWR VGND sky130_ef_sc_hd__decap_12
XFILLER_74_29 VPWR VGND VPWR VGND sky130_ef_sc_hd__decap_12
XFILLER_228_475 VGND VGND VPWR VPWR sky130_fd_sc_hd__fill_1
XTAP_TAPCELL_ROW_97_2_4334 VGND VPWR sky130_fd_sc_hd__tapvpwrvgnd_1
XFILLER_216_637 VGND VGND VPWR VPWR sky130_fd_sc_hd__decap_6
XFILLER_215_125 VPWR VGND VPWR VGND sky130_ef_sc_hd__decap_12
XFILLER_249_1369 VPWR VGND VPWR VGND sky130_ef_sc_hd__decap_12
XFILLER_244_979 VGND VGND VPWR VPWR sky130_fd_sc_hd__fill_1
XTAP_TAPCELL_ROW_109_2_4410 VGND VPWR sky130_fd_sc_hd__tapvpwrvgnd_1
XFILLER_110_1271 VPWR VGND VPWR VGND sky130_ef_sc_hd__decap_12
XFILLER_215_169 VPWR VGND VPWR VGND sky130_ef_sc_hd__decap_12
XFILLER_231_629 VPWR VGND VPWR VGND sky130_ef_sc_hd__decap_12
XFILLER_224_681 VPWR VGND VPWR VGND sky130_ef_sc_hd__decap_12
XFILLER_93_1255 VPWR VGND VPWR VGND sky130_ef_sc_hd__decap_12
XFILLER_145_1323 VGND VGND VPWR VPWR sky130_fd_sc_hd__decap_6
XFILLER_180_1203 VGND VGND VPWR VPWR sky130_fd_sc_hd__fill_1
XFILLER_230_139 VGND VGND VPWR VPWR sky130_fd_sc_hd__fill_1
XFILLER_54_1239 VGND VGND VPWR VPWR sky130_fd_sc_hd__decap_6
XFILLER_196_533 VPWR VGND VPWR VGND sky130_ef_sc_hd__decap_12
XFILLER_93_1299 VPWR VGND VPWR VGND sky130_ef_sc_hd__decap_12
XFILLER_145_1367 VPWR VGND VPWR VGND sky130_ef_sc_hd__decap_12
Xwire305 net306 VGND VGND VPWR VPWR net305 sky130_fd_sc_hd__clkbuf_1
Xwire316 net317 VGND VGND VPWR VPWR net316 sky130_fd_sc_hd__clkbuf_1
XFILLER_183_205 VPWR VGND VPWR VGND sky130_ef_sc_hd__decap_12
XFILLER_221_1233 VPWR VGND VPWR VGND sky130_ef_sc_hd__decap_12
Xwire338 net339 VGND VGND VPWR VPWR net338 sky130_fd_sc_hd__clkbuf_1
XFILLER_139_55 VGND VGND VPWR VPWR sky130_fd_sc_hd__fill_1
Xwire349 net350 VGND VGND VPWR VPWR net349 sky130_fd_sc_hd__clkbuf_1
XFILLER_99_15 VPWR VGND VPWR VGND sky130_ef_sc_hd__decap_12
XTAP_TAPCELL_ROW_172_1524 VGND VPWR sky130_fd_sc_hd__tapvpwrvgnd_1
XFILLER_165_953 VGND VGND VPWR VPWR sky130_fd_sc_hd__decap_6
XFILLER_183_249 VPWR VGND VPWR VGND sky130_ef_sc_hd__decap_12
XTAP_TAPCELL_ROW_172_1535 VGND VPWR sky130_fd_sc_hd__tapvpwrvgnd_1
XFILLER_165_975 VGND VGND VPWR VPWR sky130_fd_sc_hd__decap_4
XTAP_TAPCELL_ROW_14_1_1149 VGND VPWR sky130_fd_sc_hd__tapvpwrvgnd_1
XFILLER_180_923 VGND VGND VPWR VPWR sky130_fd_sc_hd__fill_1
XFILLER_30_1283 VPWR VGND VPWR VGND sky130_ef_sc_hd__decap_12
XFILLER_174_1029 VGND VGND VPWR VPWR sky130_fd_sc_hd__decap_6
XFILLER_191_293 VPWR VGND VPWR VGND sky130_ef_sc_hd__decap_12
XFILLER_3_3 VPWR VGND VPWR VGND sky130_ef_sc_hd__decap_12
XFILLER_156_1463 VGND VGND VPWR VPWR sky130_fd_sc_hd__decap_6
XFILLER_191_1343 VGND VGND VPWR VPWR sky130_fd_sc_hd__fill_1
XFILLER_239_729 VPWR VGND VPWR VGND sky130_ef_sc_hd__decap_12
XFILLER_65_1379 VGND VGND VPWR VPWR sky130_fd_sc_hd__decap_6
XFILLER_2_189 VGND VGND VPWR VPWR sky130_fd_sc_hd__decap_6
XFILLER_152_1327 VPWR VGND VPWR VGND sky130_ef_sc_hd__decap_12
XFILLER_8_1273 VPWR VGND VPWR VGND sky130_ef_sc_hd__decap_12
XFILLER_232_1373 VPWR VGND VPWR VGND sky130_ef_sc_hd__decap_12
XFILLER_234_401 VPWR VGND VPWR VGND sky130_ef_sc_hd__decap_12
XFILLER_0_15 VPWR VGND VPWR VGND sky130_ef_sc_hd__decap_12
XFILLER_207_615 VGND VGND VPWR VPWR sky130_fd_sc_hd__fill_1
XFILLER_219_497 VGND VGND VPWR VPWR sky130_fd_sc_hd__decap_6
XPHY_EDGE_ROW_91_1_Right_747 VGND VGND VPWR VPWR sky130_fd_sc_hd__decap_3
XFILLER_228_1409 VPWR VGND VPWR VGND sky130_ef_sc_hd__decap_12
XFILLER_234_445 VPWR VGND VPWR VGND sky130_ef_sc_hd__decap_12
XFILLER_98_1177 VPWR VGND VPWR VGND sky130_ef_sc_hd__decap_12
XFILLER_250_905 VPWR VGND VPWR VGND sky130_ef_sc_hd__decap_12
XFILLER_185_1169 VGND VGND VPWR VPWR sky130_fd_sc_hd__decap_6
XFILLER_234_489 VPWR VGND VPWR VGND sky130_ef_sc_hd__decap_12
XFILLER_250_949 VPWR VGND VPWR VGND sky130_ef_sc_hd__decap_12
XFILLER_203_821 VPWR VGND VPWR VGND sky130_ef_sc_hd__decap_12
XFILLER_163_1423 VPWR VGND VPWR VGND sky130_ef_sc_hd__decap_12
XFILLER_72_1339 VPWR VGND VPWR VGND sky130_ef_sc_hd__decap_12
XFILLER_199_393 VPWR VGND VPWR VGND sky130_ef_sc_hd__decap_12
XFILLER_203_865 VPWR VGND VPWR VGND sky130_ef_sc_hd__decap_12
XFILLER_124_1407 VGND VGND VPWR VPWR sky130_fd_sc_hd__decap_6
XFILLER_163_1467 VPWR VGND VPWR VGND sky130_ef_sc_hd__decap_12
XFILLER_9_57 VPWR VGND VPWR VGND sky130_ef_sc_hd__decap_12
X_327_ net594 net538 dout0_q\[17\] VGND VGND VPWR VPWR _116_ sky130_fd_sc_hd__and3_1
XTAP_TAPCELL_ROW_250_3624 VGND VPWR sky130_fd_sc_hd__tapvpwrvgnd_1
XFILLER_204_1453 VPWR VGND VPWR VGND sky130_ef_sc_hd__decap_12
XTAP_TAPCELL_ROW_250_3635 VGND VPWR sky130_fd_sc_hd__tapvpwrvgnd_1
XTAP_TAPCELL_ROW_250_3646 VGND VPWR sky130_fd_sc_hd__tapvpwrvgnd_1
XFILLER_200_1317 VPWR VGND VPWR VGND sky130_ef_sc_hd__decap_12
XFILLER_196_83 VGND VGND VPWR VPWR sky130_fd_sc_hd__fill_1
XFILLER_204_1497 VPWR VGND VPWR VGND sky130_ef_sc_hd__decap_12
XFILLER_239_1505 VGND VGND VPWR VPWR sky130_fd_sc_hd__decap_6
Xmax_cap616 net617 VGND VGND VPWR VPWR net616 sky130_fd_sc_hd__clkbuf_1
XFILLER_183_783 VGND VGND VPWR VPWR sky130_fd_sc_hd__fill_1
XFILLER_6_462 VGND VGND VPWR VPWR sky130_fd_sc_hd__fill_2
XFILLER_171_945 VGND VGND VPWR VPWR sky130_fd_sc_hd__decap_6
XFILLER_100_1451 VPWR VGND VPWR VGND sky130_ef_sc_hd__decap_12
XTAP_TAPCELL_ROW_135_2_4566 VGND VPWR sky130_fd_sc_hd__tapvpwrvgnd_1
XFILLER_170_433 VPWR VGND VPWR VGND sky130_ef_sc_hd__decap_12
XFILLER_192_1129 VPWR VGND VPWR VGND sky130_ef_sc_hd__decap_12
XFILLER_171_989 VPWR VGND VPWR VGND sky130_ef_sc_hd__decap_12
XFILLER_83_1435 VGND VGND VPWR VPWR sky130_fd_sc_hd__decap_6
XFILLER_100_1495 VPWR VGND VPWR VGND sky130_ef_sc_hd__decap_12
XFILLER_170_477 VPWR VGND VPWR VGND sky130_ef_sc_hd__decap_12
XTAP_TAPCELL_ROW_248_3575 VGND VPWR sky130_fd_sc_hd__tapvpwrvgnd_1
XTAP_TAPCELL_ROW_248_3586 VGND VPWR sky130_fd_sc_hd__tapvpwrvgnd_1
XFILLER_36_3 VPWR VGND VPWR VGND sky130_ef_sc_hd__decap_12
XFILLER_9_1037 VPWR VGND VPWR VGND sky130_ef_sc_hd__decap_12
XFILLER_83_1479 VPWR VGND VPWR VGND sky130_ef_sc_hd__decap_12
XFILLER_170_1427 VGND VGND VPWR VPWR sky130_fd_sc_hd__fill_1
XTAP_TAPCELL_ROW_115_2_4442 VGND VPWR sky130_fd_sc_hd__tapvpwrvgnd_1
XFILLER_229_217 VGND VGND VPWR VPWR sky130_fd_sc_hd__decap_6
XFILLER_215_57 VPWR VGND VPWR VGND sky130_ef_sc_hd__decap_12
XFILLER_211_1413 VPWR VGND VPWR VGND sky130_ef_sc_hd__decap_12
XFILLER_244_209 VPWR VGND VPWR VGND sky130_ef_sc_hd__decap_12
XTAP_TAPCELL_ROW_83_2_4253 VGND VPWR sky130_fd_sc_hd__tapvpwrvgnd_1
XFILLER_211_1457 VPWR VGND VPWR VGND sky130_ef_sc_hd__decap_12
XFILLER_237_261 VPWR VGND VPWR VGND sky130_ef_sc_hd__decap_12
XFILLER_253_721 VGND VGND VPWR VPWR sky130_fd_sc_hd__decap_6
XFILLER_77_1217 VGND VGND VPWR VPWR sky130_fd_sc_hd__fill_1
XFILLER_246_1509 VGND VGND VPWR VPWR sky130_fd_sc_hd__decap_6
XFILLER_0_1513 VGND VGND VPWR VPWR sky130_fd_sc_hd__fill_2
XFILLER_226_979 VGND VGND VPWR VPWR sky130_fd_sc_hd__fill_1
XFILLER_253_765 VPWR VGND VPWR VGND sky130_ef_sc_hd__decap_12
XFILLER_20_1463 VGND VGND VPWR VPWR sky130_fd_sc_hd__decap_6
XFILLER_252_253 VPWR VGND VPWR VGND sky130_ef_sc_hd__decap_12
XFILLER_129_1329 VGND VGND VPWR VPWR sky130_fd_sc_hd__fill_1
XFILLER_213_629 VPWR VGND VPWR VGND sky130_ef_sc_hd__decap_12
XFILLER_206_681 VPWR VGND VPWR VGND sky130_ef_sc_hd__decap_12
XFILLER_212_139 VGND VGND VPWR VPWR sky130_fd_sc_hd__fill_1
XFILLER_166_1091 VGND VGND VPWR VPWR sky130_fd_sc_hd__fill_1
XFILLER_178_533 VPWR VGND VPWR VGND sky130_ef_sc_hd__decap_12
XFILLER_90_1439 VPWR VGND VPWR VGND sky130_ef_sc_hd__decap_12
XFILLER_100_27 VGND VGND VPWR VPWR sky130_fd_sc_hd__fill_1
XFILLER_142_1507 VGND VGND VPWR VPWR sky130_fd_sc_hd__decap_8
XFILLER_221_673 VPWR VGND VPWR VGND sky130_ef_sc_hd__decap_12
XFILLER_193_503 VGND VGND VPWR VPWR sky130_fd_sc_hd__fill_1
XFILLER_197_1007 VGND VGND VPWR VPWR sky130_fd_sc_hd__fill_1
XFILLER_14_1245 VGND VGND VPWR VPWR sky130_fd_sc_hd__fill_1
XFILLER_165_249 VGND VGND VPWR VPWR sky130_fd_sc_hd__decap_3
XFILLER_181_709 VPWR VGND VPWR VGND sky130_ef_sc_hd__decap_12
XFILLER_88_1357 VGND VGND VPWR VPWR sky130_fd_sc_hd__fill_1
XFILLER_238_1037 VPWR VGND VPWR VGND sky130_ef_sc_hd__decap_12
XFILLER_109_69 VGND VGND VPWR VPWR sky130_fd_sc_hd__fill_2
XFILLER_173_293 VPWR VGND VPWR VGND sky130_ef_sc_hd__decap_12
XFILLER_255_1373 VPWR VGND VPWR VGND sky130_ef_sc_hd__decap_12
XFILLER_125_57 VPWR VGND VPWR VGND sky130_ef_sc_hd__decap_12
XFILLER_5_1413 VPWR VGND VPWR VGND sky130_ef_sc_hd__decap_12
XFILLER_85_39 VPWR VGND VPWR VGND sky130_ef_sc_hd__decap_12
XFILLER_25_1385 VGND VGND VPWR VPWR sky130_fd_sc_hd__fill_1
XFILLER_5_1457 VPWR VGND VPWR VGND sky130_ef_sc_hd__decap_12
XTAP_TAPCELL_ROW_4_966 VGND VPWR sky130_fd_sc_hd__tapvpwrvgnd_1
XTAP_TAPCELL_ROW_165_1350 VGND VPWR sky130_fd_sc_hd__tapvpwrvgnd_1
XTAP_TAPCELL_ROW_4_977 VGND VPWR sky130_fd_sc_hd__tapvpwrvgnd_1
XFILLER_216_401 VPWR VGND VPWR VGND sky130_ef_sc_hd__decap_12
XFILLER_249_1133 VPWR VGND VPWR VGND sky130_ef_sc_hd__decap_12
XFILLER_99_1497 VGND VGND VPWR VPWR sky130_fd_sc_hd__fill_1
XFILLER_216_445 VPWR VGND VPWR VGND sky130_ef_sc_hd__decap_12
XFILLER_232_905 VPWR VGND VPWR VGND sky130_ef_sc_hd__decap_12
XFILLER_189_809 VPWR VGND VPWR VGND sky130_ef_sc_hd__decap_12
XFILLER_249_1177 VPWR VGND VPWR VGND sky130_ef_sc_hd__decap_12
XFILLER_182_1309 VGND VGND VPWR VPWR sky130_fd_sc_hd__decap_6
XFILLER_216_489 VPWR VGND VPWR VGND sky130_ef_sc_hd__decap_12
XFILLER_232_949 VPWR VGND VPWR VGND sky130_ef_sc_hd__decap_12
XTAP_TAPCELL_ROW_178_1700 VGND VPWR sky130_fd_sc_hd__tapvpwrvgnd_1
XTAP_TAPCELL_ROW_130_1_1265 VGND VPWR sky130_fd_sc_hd__tapvpwrvgnd_1
XFILLER_197_853 VPWR VGND VPWR VGND sky130_ef_sc_hd__decap_12
XFILLER_140_3 VPWR VGND VPWR VGND sky130_ef_sc_hd__decap_12
XTAP_TAPCELL_ROW_141_2_4598 VGND VPWR sky130_fd_sc_hd__tapvpwrvgnd_1
XFILLER_200_813 VPWR VGND VPWR VGND sky130_ef_sc_hd__decap_12
XFILLER_240_993 VPWR VGND VPWR VGND sky130_ef_sc_hd__decap_12
XFILLER_238_3 VPWR VGND VPWR VGND sky130_ef_sc_hd__decap_12
XFILLER_211_161 VGND VGND VPWR VPWR sky130_fd_sc_hd__decap_6
XFILLER_19_1189 VPWR VGND VPWR VGND sky130_ef_sc_hd__decap_12
XFILLER_196_363 VGND VGND VPWR VPWR sky130_fd_sc_hd__fill_1
XFILLER_32_1301 VGND VGND VPWR VPWR sky130_fd_sc_hd__fill_1
Xwire102 _210_ VGND VGND VPWR VPWR net102 sky130_fd_sc_hd__clkbuf_1
XFILLER_197_897 VPWR VGND VPWR VGND sky130_ef_sc_hd__decap_12
XFILLER_184_525 VGND VGND VPWR VPWR sky130_fd_sc_hd__decap_6
XFILLER_184_569 VPWR VGND VPWR VGND sky130_ef_sc_hd__decap_12
XFILLER_221_1063 VGND VGND VPWR VPWR sky130_fd_sc_hd__fill_1
XFILLER_50_53 VPWR VGND VPWR VGND sky130_ef_sc_hd__decap_12
XFILLER_4_922 VGND VGND VPWR VPWR sky130_fd_sc_hd__fill_2
XFILLER_166_53 VPWR VGND VPWR VGND sky130_ef_sc_hd__decap_12
XFILLER_166_97 VPWR VGND VPWR VGND sky130_ef_sc_hd__decap_12
XFILLER_193_1449 VGND VGND VPWR VPWR sky130_fd_sc_hd__decap_6
XFILLER_3_454 VGND VGND VPWR VPWR sky130_fd_sc_hd__fill_2
XFILLER_59_51 VGND VGND VPWR VPWR sky130_fd_sc_hd__decap_4
XTAP_TAPCELL_ROW_101_2_4361 VGND VPWR sky130_fd_sc_hd__tapvpwrvgnd_1
XFILLER_156_1271 VPWR VGND VPWR VGND sky130_ef_sc_hd__decap_12
XFILLER_65_1165 VPWR VGND VPWR VGND sky130_ef_sc_hd__decap_12
XFILLER_182_41 VPWR VGND VPWR VGND sky130_ef_sc_hd__decap_12
XFILLER_117_1255 VPWR VGND VPWR VGND sky130_ef_sc_hd__decap_12
XFILLER_239_559 VGND VGND VPWR VPWR sky130_fd_sc_hd__fill_1
XFILLER_182_85 VPWR VGND VPWR VGND sky130_ef_sc_hd__decap_12
XTAP_TAPCELL_ROW_243_3450 VGND VPWR sky130_fd_sc_hd__tapvpwrvgnd_1
XFILLER_43_1441 VGND VGND VPWR VPWR sky130_fd_sc_hd__fill_1
XFILLER_117_1299 VPWR VGND VPWR VGND sky130_ef_sc_hd__decap_12
XFILLER_226_209 VPWR VGND VPWR VGND sky130_ef_sc_hd__decap_12
XFILLER_219_261 VPWR VGND VPWR VGND sky130_ef_sc_hd__decap_12
XFILLER_235_721 VGND VGND VPWR VPWR sky130_fd_sc_hd__decap_6
XFILLER_235_765 VPWR VGND VPWR VGND sky130_ef_sc_hd__decap_12
XFILLER_208_979 VGND VGND VPWR VPWR sky130_fd_sc_hd__fill_1
XFILLER_228_1217 VPWR VGND VPWR VGND sky130_ef_sc_hd__decap_12
XFILLER_234_253 VPWR VGND VPWR VGND sky130_ef_sc_hd__decap_12
XFILLER_250_713 VPWR VGND VPWR VGND sky130_ef_sc_hd__decap_12
XTAP_TAPCELL_ROW_48_2_4042 VGND VPWR sky130_fd_sc_hd__tapvpwrvgnd_1
XPHY_EDGE_ROW_92_1_Right_748 VGND VGND VPWR VPWR sky130_fd_sc_hd__decap_3
XFILLER_201_15 VPWR VGND VPWR VGND sky130_ef_sc_hd__decap_12
XFILLER_37_1201 VPWR VGND VPWR VGND sky130_ef_sc_hd__decap_12
XFILLER_250_757 VPWR VGND VPWR VGND sky130_ef_sc_hd__decap_12
XFILLER_76_1283 VPWR VGND VPWR VGND sky130_ef_sc_hd__decap_12
XFILLER_128_1351 VGND VGND VPWR VPWR sky130_fd_sc_hd__decap_6
XFILLER_163_1231 VPWR VGND VPWR VGND sky130_ef_sc_hd__decap_12
XTAP_TAPCELL_ROW_237_3276 VGND VPWR sky130_fd_sc_hd__tapvpwrvgnd_1
XFILLER_37_1267 VGND VGND VPWR VPWR sky130_fd_sc_hd__decap_6
XFILLER_124_1215 VPWR VGND VPWR VGND sky130_ef_sc_hd__decap_12
XFILLER_203_673 VPWR VGND VPWR VGND sky130_ef_sc_hd__decap_12
XTAP_TAPCELL_ROW_237_3287 VGND VPWR sky130_fd_sc_hd__tapvpwrvgnd_1
XFILLER_128_1395 VPWR VGND VPWR VGND sky130_ef_sc_hd__decap_12
XFILLER_163_1275 VPWR VGND VPWR VGND sky130_ef_sc_hd__decap_12
XFILLER_175_503 VGND VGND VPWR VPWR sky130_fd_sc_hd__fill_1
XFILLER_187_385 VGND VGND VPWR VPWR sky130_fd_sc_hd__decap_6
XFILLER_124_1259 VPWR VGND VPWR VGND sky130_ef_sc_hd__decap_12
XFILLER_204_1261 VPWR VGND VPWR VGND sky130_ef_sc_hd__decap_12
XFILLER_239_1313 VPWR VGND VPWR VGND sky130_ef_sc_hd__decap_12
XTAP_TAPCELL_ROW_26_2_3912 VGND VPWR sky130_fd_sc_hd__tapvpwrvgnd_1
XFILLER_200_1147 VGND VGND VPWR VPWR sky130_fd_sc_hd__fill_1
XFILLER_239_1357 VPWR VGND VPWR VGND sky130_ef_sc_hd__decap_12
XFILLER_6_270 VGND VGND VPWR VPWR sky130_fd_sc_hd__fill_1
XFILLER_196_1073 VPWR VGND VPWR VGND sky130_ef_sc_hd__decap_12
XFILLER_171_753 VPWR VGND VPWR VGND sky130_ef_sc_hd__decap_12
XFILLER_171_797 VPWR VGND VPWR VGND sky130_ef_sc_hd__decap_12
XFILLER_83_1243 VPWR VGND VPWR VGND sky130_ef_sc_hd__decap_12
XFILLER_135_1311 VPWR VGND VPWR VGND sky130_ef_sc_hd__decap_12
XFILLER_139_1491 VGND VGND VPWR VPWR sky130_fd_sc_hd__decap_6
XFILLER_174_1371 VGND VGND VPWR VPWR sky130_fd_sc_hd__fill_1
XFILLER_44_1227 VPWR VGND VPWR VGND sky130_ef_sc_hd__decap_12
XFILLER_83_1287 VPWR VGND VPWR VGND sky130_ef_sc_hd__decap_12
XFILLER_135_1355 VPWR VGND VPWR VGND sky130_ef_sc_hd__decap_12
XFILLER_131_1219 VPWR VGND VPWR VGND sky130_ef_sc_hd__decap_12
XFILLER_135_1399 VPWR VGND VPWR VGND sky130_ef_sc_hd__decap_12
XFILLER_245_529 VPWR VGND VPWR VGND sky130_ef_sc_hd__decap_12
XFILLER_242_77 VGND VGND VPWR VPWR sky130_fd_sc_hd__decap_6
XFILLER_238_581 VGND VGND VPWR VPWR sky130_fd_sc_hd__decap_6
XTAP_TAPCELL_ROW_226_2980 VGND VPWR sky130_fd_sc_hd__tapvpwrvgnd_1
XTAP_TAPCELL_ROW_226_2991 VGND VPWR sky130_fd_sc_hd__tapvpwrvgnd_1
XFILLER_211_1287 VGND VGND VPWR VPWR sky130_fd_sc_hd__fill_1
XFILLER_214_905 VPWR VGND VPWR VGND sky130_ef_sc_hd__decap_12
XFILLER_246_1317 VPWR VGND VPWR VGND sky130_ef_sc_hd__decap_12
XTAP_TAPCELL_ROW_222_2866 VGND VPWR sky130_fd_sc_hd__tapvpwrvgnd_1
XFILLER_253_573 VPWR VGND VPWR VGND sky130_ef_sc_hd__decap_12
XFILLER_111_15 VPWR VGND VPWR VGND sky130_ef_sc_hd__decap_12
XTAP_TAPCELL_ROW_222_2877 VGND VPWR sky130_fd_sc_hd__tapvpwrvgnd_1
XFILLER_20_1271 VPWR VGND VPWR VGND sky130_ef_sc_hd__decap_12
XTAP_TAPCELL_ROW_222_2888 VGND VPWR sky130_fd_sc_hd__tapvpwrvgnd_1
XFILLER_214_949 VPWR VGND VPWR VGND sky130_ef_sc_hd__decap_12
XFILLER_197_105 VGND VGND VPWR VPWR sky130_fd_sc_hd__decap_6
XFILLER_168_1197 VGND VGND VPWR VPWR sky130_fd_sc_hd__decap_6
XFILLER_55_1323 VGND VGND VPWR VPWR sky130_fd_sc_hd__decap_6
XFILLER_90_1203 VPWR VGND VPWR VGND sky130_ef_sc_hd__decap_12
XFILLER_240_245 VGND VGND VPWR VPWR sky130_fd_sc_hd__decap_6
XFILLER_94_1383 VPWR VGND VPWR VGND sky130_ef_sc_hd__decap_12
XFILLER_146_1451 VPWR VGND VPWR VGND sky130_ef_sc_hd__decap_12
XFILLER_179_853 VPWR VGND VPWR VGND sky130_ef_sc_hd__decap_12
XFILLER_197_149 VPWR VGND VPWR VGND sky130_ef_sc_hd__decap_12
XFILLER_200_109 VPWR VGND VPWR VGND sky130_ef_sc_hd__decap_12
XFILLER_240_289 VPWR VGND VPWR VGND sky130_ef_sc_hd__decap_12
XFILLER_55_1367 VPWR VGND VPWR VGND sky130_ef_sc_hd__decap_12
XFILLER_90_1247 VPWR VGND VPWR VGND sky130_ef_sc_hd__decap_12
XFILLER_107_1435 VGND VGND VPWR VPWR sky130_fd_sc_hd__decap_6
XFILLER_142_1315 VPWR VGND VPWR VGND sky130_ef_sc_hd__decap_12
XFILLER_244_1085 VGND VGND VPWR VPWR sky130_fd_sc_hd__decap_6
XFILLER_178_363 VGND VGND VPWR VPWR sky130_fd_sc_hd__fill_1
XFILLER_222_993 VPWR VGND VPWR VGND sky130_ef_sc_hd__decap_12
XFILLER_146_1495 VPWR VGND VPWR VGND sky130_ef_sc_hd__decap_12
XFILLER_179_897 VPWR VGND VPWR VGND sky130_ef_sc_hd__decap_12
XFILLER_166_525 VGND VGND VPWR VPWR sky130_fd_sc_hd__decap_6
XFILLER_107_1479 VPWR VGND VPWR VGND sky130_ef_sc_hd__decap_12
XFILLER_142_1359 VPWR VGND VPWR VGND sky130_ef_sc_hd__decap_12
XFILLER_194_867 VGND VGND VPWR VPWR sky130_fd_sc_hd__fill_1
XFILLER_166_569 VPWR VGND VPWR VGND sky130_ef_sc_hd__decap_12
XFILLER_181_517 VPWR VGND VPWR VGND sky130_ef_sc_hd__decap_12
XPHY_EDGE_ROW_54_1_Right_710 VGND VGND VPWR VPWR sky130_fd_sc_hd__decap_3
XFILLER_88_1165 VPWR VGND VPWR VGND sky130_ef_sc_hd__decap_12
XFILLER_175_1113 VGND VGND VPWR VPWR sky130_fd_sc_hd__decap_6
XTAP_TAPCELL_ROW_74_2_4198 VGND VPWR sky130_fd_sc_hd__tapvpwrvgnd_1
XFILLER_175_1157 VPWR VGND VPWR VGND sky130_ef_sc_hd__decap_12
XFILLER_251_1001 VGND VGND VPWR VPWR sky130_fd_sc_hd__decap_6
XFILLER_66_1463 VGND VGND VPWR VPWR sky130_fd_sc_hd__decap_6
XFILLER_1_936 VPWR VGND VPWR VGND sky130_ef_sc_hd__decap_12
XFILLER_153_1411 VPWR VGND VPWR VGND sky130_ef_sc_hd__decap_12
XFILLER_96_27 VGND VGND VPWR VPWR sky130_fd_sc_hd__fill_1
XPHY_EDGE_ROW_73_1_Left_328 VGND VGND VPWR VPWR sky130_fd_sc_hd__decap_3
XFILLER_248_301 VGND VGND VPWR VPWR sky130_fd_sc_hd__decap_6
XTAP_TAPCELL_ROW_167_1401 VGND VPWR sky130_fd_sc_hd__tapvpwrvgnd_1
XFILLER_62_1327 VPWR VGND VPWR VGND sky130_ef_sc_hd__decap_12
XFILLER_251_1045 VPWR VGND VPWR VGND sky130_ef_sc_hd__decap_12
XFILLER_153_1455 VPWR VGND VPWR VGND sky130_ef_sc_hd__decap_12
XFILLER_248_345 VPWR VGND VPWR VGND sky130_ef_sc_hd__decap_12
XTAP_TAPCELL_ROW_39_2_3990 VGND VPWR sky130_fd_sc_hd__tapvpwrvgnd_1
XFILLER_212_1029 VGND VGND VPWR VPWR sky130_fd_sc_hd__decap_6
XFILLER_114_1439 VPWR VGND VPWR VGND sky130_ef_sc_hd__decap_12
XFILLER_251_1089 VPWR VGND VPWR VGND sky130_ef_sc_hd__decap_12
XFILLER_153_1499 VPWR VGND VPWR VGND sky130_ef_sc_hd__decap_12
XFILLER_208_209 VPWR VGND VPWR VGND sky130_ef_sc_hd__decap_12
XFILLER_248_389 VPWR VGND VPWR VGND sky130_ef_sc_hd__decap_12
XFILLER_188_3 VPWR VGND VPWR VGND sky130_ef_sc_hd__decap_12
X_661_ clknet_3_5__leaf_clk acc_core.adder.cla_blocks\[6\].block.sum\[3\] _069_ VGND
+ VGND VPWR VPWR net62 sky130_fd_sc_hd__dfrtp_1
XFILLER_217_721 VGND VGND VPWR VPWR sky130_fd_sc_hd__decap_6
XFILLER_5_1287 VGND VGND VPWR VPWR sky130_fd_sc_hd__fill_1
XFILLER_217_765 VPWR VGND VPWR VGND sky130_ef_sc_hd__decap_12
X_592_ clknet_3_2__leaf_clk _074_ _000_ VGND VGND VPWR VPWR rd_addr\[0\] sky130_fd_sc_hd__dfrtp_1
XFILLER_216_253 VPWR VGND VPWR VGND sky130_ef_sc_hd__decap_12
XFILLER_186_1253 VGND VGND VPWR VPWR sky130_fd_sc_hd__decap_6
XFILLER_232_713 VPWR VGND VPWR VGND sky130_ef_sc_hd__decap_12
XFILLER_189_617 VPWR VGND VPWR VGND sky130_ef_sc_hd__decap_12
XFILLER_182_1117 VPWR VGND VPWR VGND sky130_ef_sc_hd__decap_12
XFILLER_231_223 VGND VGND VPWR VPWR sky130_fd_sc_hd__fill_1
XFILLER_186_1297 VPWR VGND VPWR VGND sky130_ef_sc_hd__decap_12
XFILLER_232_757 VPWR VGND VPWR VGND sky130_ef_sc_hd__decap_12
XTAP_TAPCELL_ROW_32_2_3944 VGND VPWR sky130_fd_sc_hd__tapvpwrvgnd_1
XFILLER_73_1423 VPWR VGND VPWR VGND sky130_ef_sc_hd__decap_12
XFILLER_34_1407 VGND VGND VPWR VPWR sky130_fd_sc_hd__decap_6
XFILLER_73_1467 VPWR VGND VPWR VGND sky130_ef_sc_hd__decap_12
XFILLER_160_1415 VPWR VGND VPWR VGND sky130_ef_sc_hd__decap_12
XFILLER_169_385 VGND VGND VPWR VPWR sky130_fd_sc_hd__decap_6
XFILLER_200_643 VGND VGND VPWR VPWR sky130_fd_sc_hd__fill_1
XFILLER_223_1169 VGND VGND VPWR VPWR sky130_fd_sc_hd__decap_6
XFILLER_184_333 VPWR VGND VPWR VGND sky130_ef_sc_hd__decap_12
XFILLER_201_1401 VPWR VGND VPWR VGND sky130_ef_sc_hd__decap_12
XTAP_TAPCELL_ROW_232_3140 VGND VPWR sky130_fd_sc_hd__tapvpwrvgnd_1
XTAP_TAPCELL_ROW_232_3151 VGND VPWR sky130_fd_sc_hd__tapvpwrvgnd_1
XFILLER_240_1483 VGND VGND VPWR VPWR sky130_fd_sc_hd__fill_1
XFILLER_185_889 VGND VGND VPWR VPWR sky130_fd_sc_hd__decap_6
XTAP_TAPCELL_ROW_232_3162 VGND VPWR sky130_fd_sc_hd__tapvpwrvgnd_1
XFILLER_184_377 VPWR VGND VPWR VGND sky130_ef_sc_hd__decap_12
XANTENNA_7 dout0\[8\] VGND VGND VPWR VPWR sky130_fd_sc_hd__diode_2
XFILLER_193_1213 VPWR VGND VPWR VGND sky130_ef_sc_hd__decap_12
XFILLER_197_1393 VGND VGND VPWR VPWR sky130_fd_sc_hd__decap_6
XFILLER_10_1451 VPWR VGND VPWR VGND sky130_ef_sc_hd__decap_12
XFILLER_193_51 VGND VGND VPWR VPWR sky130_fd_sc_hd__decap_4
XFILLER_193_1257 VPWR VGND VPWR VGND sky130_ef_sc_hd__decap_12
XTAP_TAPCELL_ROW_245_3501 VGND VPWR sky130_fd_sc_hd__tapvpwrvgnd_1
XFILLER_4_785 VGND VGND VPWR VPWR sky130_fd_sc_hd__decap_4
XTAP_TAPCELL_ROW_245_3512 VGND VPWR sky130_fd_sc_hd__tapvpwrvgnd_1
XFILLER_10_1495 VPWR VGND VPWR VGND sky130_ef_sc_hd__decap_12
XFILLER_171_1511 VGND VGND VPWR VPWR sky130_fd_sc_hd__fill_1
XFILLER_80_1427 VPWR VGND VPWR VGND sky130_ef_sc_hd__decap_12
XFILLER_6_1029 VGND VGND VPWR VPWR sky130_fd_sc_hd__decap_6
XFILLER_230_1129 VPWR VGND VPWR VGND sky130_ef_sc_hd__decap_12
XFILLER_227_529 VPWR VGND VPWR VGND sky130_ef_sc_hd__decap_12
XTAP_TAPCELL_ROW_7_1046 VGND VPWR sky130_fd_sc_hd__tapvpwrvgnd_1
XTAP_TAPCELL_ROW_7_1057 VGND VPWR sky130_fd_sc_hd__tapvpwrvgnd_1
XFILLER_78_1301 VGND VGND VPWR VPWR sky130_fd_sc_hd__fill_1
XFILLER_235_573 VPWR VGND VPWR VGND sky130_ef_sc_hd__decap_12
XTAP_TAPCELL_ROW_239_3327 VGND VPWR sky130_fd_sc_hd__tapvpwrvgnd_1
XFILLER_39_1329 VGND VGND VPWR VPWR sky130_fd_sc_hd__fill_1
XTAP_TAPCELL_ROW_239_3338 VGND VPWR sky130_fd_sc_hd__tapvpwrvgnd_1
XFILLER_179_105 VGND VGND VPWR VPWR sky130_fd_sc_hd__decap_6
XTAP_TAPCELL_ROW_239_3349 VGND VPWR sky130_fd_sc_hd__tapvpwrvgnd_1
XPHY_EDGE_ROW_93_1_Right_749 VGND VGND VPWR VPWR sky130_fd_sc_hd__decap_3
XFILLER_222_245 VGND VGND VPWR VPWR sky130_fd_sc_hd__decap_6
XFILLER_179_149 VPWR VGND VPWR VGND sky130_ef_sc_hd__decap_12
XFILLER_195_609 VGND VGND VPWR VPWR sky130_fd_sc_hd__decap_6
XFILLER_250_587 VGND VGND VPWR VPWR sky130_fd_sc_hd__fill_1
XFILLER_52_1507 VGND VGND VPWR VPWR sky130_fd_sc_hd__decap_8
XFILLER_204_993 VPWR VGND VPWR VGND sky130_ef_sc_hd__decap_12
XFILLER_222_289 VPWR VGND VPWR VGND sky130_ef_sc_hd__decap_12
XFILLER_241_1225 VGND VGND VPWR VPWR sky130_fd_sc_hd__decap_6
XFILLER_241_1269 VPWR VGND VPWR VGND sky130_ef_sc_hd__decap_12
XFILLER_187_193 VPWR VGND VPWR VGND sky130_ef_sc_hd__decap_12
XFILLER_176_867 VGND VGND VPWR VPWR sky130_fd_sc_hd__fill_1
XFILLER_204_1091 VGND VGND VPWR VPWR sky130_fd_sc_hd__fill_1
XFILLER_89_1441 VGND VGND VPWR VPWR sky130_fd_sc_hd__fill_1
XFILLER_239_1121 VPWR VGND VPWR VGND sky130_ef_sc_hd__decap_12
Xmax_cap210 net211 VGND VGND VPWR VPWR net210 sky130_fd_sc_hd__clkbuf_1
XTAP_TAPCELL_ROW_215_2681 VGND VPWR sky130_fd_sc_hd__tapvpwrvgnd_1
XFILLER_237_55 VGND VGND VPWR VPWR sky130_fd_sc_hd__fill_1
XTAP_TAPCELL_ROW_215_2692 VGND VPWR sky130_fd_sc_hd__tapvpwrvgnd_1
XFILLER_235_1007 VGND VGND VPWR VPWR sky130_fd_sc_hd__fill_1
XFILLER_171_561 VPWR VGND VPWR VGND sky130_ef_sc_hd__decap_12
XFILLER_176_1477 VGND VGND VPWR VPWR sky130_fd_sc_hd__decap_6
XTAP_TAPCELL_ROW_211_2578 VGND VPWR sky130_fd_sc_hd__tapvpwrvgnd_1
XTAP_TAPCELL_ROW_211_2589 VGND VPWR sky130_fd_sc_hd__tapvpwrvgnd_1
XFILLER_106_15 VPWR VGND VPWR VGND sky130_ef_sc_hd__decap_12
XFILLER_252_1365 VGND VGND VPWR VPWR sky130_fd_sc_hd__decap_6
XFILLER_246_805 VGND VGND VPWR VPWR sky130_fd_sc_hd__decap_6
XTAP_TAPCELL_ROW_224_2928 VGND VPWR sky130_fd_sc_hd__tapvpwrvgnd_1
XFILLER_246_849 VPWR VGND VPWR VGND sky130_ef_sc_hd__decap_12
XTAP_TAPCELL_ROW_224_2939 VGND VPWR sky130_fd_sc_hd__tapvpwrvgnd_1
XFILLER_245_337 VPWR VGND VPWR VGND sky130_ef_sc_hd__decap_12
XFILLER_2_1427 VGND VGND VPWR VPWR sky130_fd_sc_hd__fill_1
XFILLER_214_713 VPWR VGND VPWR VGND sky130_ef_sc_hd__decap_12
XFILLER_254_893 VPWR VGND VPWR VGND sky130_ef_sc_hd__decap_12
XFILLER_82_29 VPWR VGND VPWR VGND sky130_ef_sc_hd__decap_12
XFILLER_246_1147 VGND VGND VPWR VPWR sky130_fd_sc_hd__fill_1
XTAP_TAPCELL_ROW_17_2_3857 VGND VPWR sky130_fd_sc_hd__tapvpwrvgnd_1
XFILLER_183_1437 VPWR VGND VPWR VGND sky130_ef_sc_hd__decap_12
XFILLER_213_223 VGND VGND VPWR VPWR sky130_fd_sc_hd__fill_1
XFILLER_214_757 VPWR VGND VPWR VGND sky130_ef_sc_hd__decap_12
XFILLER_198_29 VPWR VGND VPWR VGND sky130_ef_sc_hd__decap_12
XFILLER_0_1173 VGND VGND VPWR VPWR sky130_fd_sc_hd__decap_3
XFILLER_198_469 VGND VGND VPWR VPWR sky130_fd_sc_hd__decap_6
XFILLER_94_1191 VPWR VGND VPWR VGND sky130_ef_sc_hd__decap_12
XFILLER_201_429 VPWR VGND VPWR VGND sky130_ef_sc_hd__decap_12
XFILLER_107_1243 VPWR VGND VPWR VGND sky130_ef_sc_hd__decap_12
XFILLER_220_1309 VGND VGND VPWR VPWR sky130_fd_sc_hd__decap_6
XFILLER_166_333 VPWR VGND VPWR VGND sky130_ef_sc_hd__decap_12
XFILLER_107_1287 VPWR VGND VPWR VGND sky130_ef_sc_hd__decap_12
XFILLER_142_1189 VGND VGND VPWR VPWR sky130_fd_sc_hd__fill_1
XFILLER_167_889 VGND VGND VPWR VPWR sky130_fd_sc_hd__decap_6
XFILLER_166_377 VPWR VGND VPWR VGND sky130_ef_sc_hd__decap_12
XFILLER_182_837 VPWR VGND VPWR VGND sky130_ef_sc_hd__decap_12
XTAP_TAPCELL_ROW_125_1_1260 VGND VPWR sky130_fd_sc_hd__tapvpwrvgnd_1
XFILLER_147_55 VGND VGND VPWR VPWR sky130_fd_sc_hd__fill_1
XPHY_EDGE_ROW_55_1_Right_711 VGND VGND VPWR VPWR sky130_fd_sc_hd__decap_3
XTAP_TAPCELL_ROW_136_2_4571 VGND VPWR sky130_fd_sc_hd__tapvpwrvgnd_1
XFILLER_218_1205 VPWR VGND VPWR VGND sky130_ef_sc_hd__decap_12
XFILLER_103_3 VPWR VGND VPWR VGND sky130_ef_sc_hd__decap_12
XFILLER_190_881 VPWR VGND VPWR VGND sky130_ef_sc_hd__decap_12
Xoutput44 net547 VGND VGND VPWR VPWR acc_out[10] sky130_fd_sc_hd__buf_2
Xoutput55 net55 VGND VGND VPWR VPWR acc_out[20] sky130_fd_sc_hd__buf_2
XFILLER_1_733 VGND VGND VPWR VPWR sky130_fd_sc_hd__fill_1
XFILLER_66_1271 VPWR VGND VPWR VGND sky130_ef_sc_hd__decap_12
Xoutput66 net66 VGND VGND VPWR VPWR acc_out[30] sky130_fd_sc_hd__buf_2
XFILLER_0_221 VGND VGND VPWR VPWR sky130_fd_sc_hd__decap_3
XFILLER_27_1255 VPWR VGND VPWR VGND sky130_ef_sc_hd__decap_12
XFILLER_114_1203 VPWR VGND VPWR VGND sky130_ef_sc_hd__decap_12
XFILLER_1_788 VGND VGND VPWR VPWR sky130_fd_sc_hd__decap_3
XFILLER_0_265 VPWR VGND VPWR VGND sky130_ef_sc_hd__decap_12
XFILLER_118_1383 VPWR VGND VPWR VGND sky130_ef_sc_hd__decap_12
XFILLER_249_665 VGND VGND VPWR VPWR sky130_fd_sc_hd__decap_6
XFILLER_248_153 VPWR VGND VPWR VGND sky130_ef_sc_hd__decap_12
XFILLER_231_1449 VGND VGND VPWR VPWR sky130_fd_sc_hd__decap_6
XFILLER_27_1299 VPWR VGND VPWR VGND sky130_ef_sc_hd__decap_12
XFILLER_114_1247 VPWR VGND VPWR VGND sky130_ef_sc_hd__decap_12
XFILLER_209_529 VPWR VGND VPWR VGND sky130_ef_sc_hd__decap_12
XTAP_TAPCELL_ROW_186_1898 VGND VPWR sky130_fd_sc_hd__tapvpwrvgnd_1
XFILLER_188_1315 VGND VGND VPWR VPWR sky130_fd_sc_hd__fill_1
XFILLER_248_197 VPWR VGND VPWR VGND sky130_ef_sc_hd__decap_12
XFILLER_56_41 VPWR VGND VPWR VGND sky130_ef_sc_hd__decap_12
X_644_ clknet_3_1__leaf_clk acc_core.adder.cla_blocks\[2\].block.sum\[2\] _052_ VGND
+ VGND VPWR VPWR net44 sky130_fd_sc_hd__dfrtp_1
XFILLER_229_1301 VPWR VGND VPWR VGND sky130_ef_sc_hd__decap_12
XFILLER_251_329 VGND VGND VPWR VPWR sky130_fd_sc_hd__decap_6
XFILLER_217_573 VPWR VGND VPWR VGND sky130_ef_sc_hd__decap_12
XFILLER_186_1061 VPWR VGND VPWR VGND sky130_ef_sc_hd__decap_12
XFILLER_229_1345 VPWR VGND VPWR VGND sky130_ef_sc_hd__decap_12
X_575_ net667 VGND VGND VPWR VPWR _057_ sky130_fd_sc_hd__inv_2
XFILLER_189_447 VGND VGND VPWR VPWR sky130_fd_sc_hd__fill_1
XFILLER_204_245 VGND VGND VPWR VPWR sky130_fd_sc_hd__decap_6
XFILLER_177_609 VGND VGND VPWR VPWR sky130_fd_sc_hd__decap_6
XFILLER_38_1351 VGND VGND VPWR VPWR sky130_fd_sc_hd__decap_6
XFILLER_73_1231 VPWR VGND VPWR VGND sky130_ef_sc_hd__decap_12
XFILLER_232_587 VGND VGND VPWR VPWR sky130_fd_sc_hd__fill_1
XTAP_TAPCELL_ROW_234_3202 VGND VPWR sky130_fd_sc_hd__tapvpwrvgnd_1
XTAP_TAPCELL_ROW_234_3213 VGND VPWR sky130_fd_sc_hd__tapvpwrvgnd_1
XFILLER_204_289 VPWR VGND VPWR VGND sky130_ef_sc_hd__decap_12
XFILLER_198_981 VPWR VGND VPWR VGND sky130_ef_sc_hd__decap_12
XFILLER_220_749 VGND VGND VPWR VPWR sky130_fd_sc_hd__decap_6
XFILLER_34_1215 VPWR VGND VPWR VGND sky130_ef_sc_hd__decap_12
XFILLER_38_1395 VPWR VGND VPWR VGND sky130_ef_sc_hd__decap_12
XFILLER_73_1275 VPWR VGND VPWR VGND sky130_ef_sc_hd__decap_12
XFILLER_125_1343 VPWR VGND VPWR VGND sky130_ef_sc_hd__decap_12
XFILLER_160_1245 VGND VGND VPWR VPWR sky130_fd_sc_hd__fill_1
XFILLER_34_1259 VPWR VGND VPWR VGND sky130_ef_sc_hd__decap_12
XFILLER_169_193 VPWR VGND VPWR VGND sky130_ef_sc_hd__decap_12
XFILLER_185_653 VPWR VGND VPWR VGND sky130_ef_sc_hd__decap_12
XFILLER_125_1387 VPWR VGND VPWR VGND sky130_ef_sc_hd__decap_12
XFILLER_184_141 VPWR VGND VPWR VGND sky130_ef_sc_hd__decap_12
XFILLER_199_1455 VGND VGND VPWR VPWR sky130_fd_sc_hd__fill_1
XFILLER_8_365 VPWR VGND VPWR VGND sky130_ef_sc_hd__decap_12
XFILLER_201_1231 VGND VGND VPWR VPWR sky130_fd_sc_hd__fill_1
XFILLER_185_697 VPWR VGND VPWR VGND sky130_ef_sc_hd__decap_12
XFILLER_193_1021 VPWR VGND VPWR VGND sky130_ef_sc_hd__decap_12
XFILLER_193_1065 VPWR VGND VPWR VGND sky130_ef_sc_hd__decap_12
XTAP_TAPCELL_ROW_228_3028 VGND VPWR sky130_fd_sc_hd__tapvpwrvgnd_1
XFILLER_207_69 VPWR VGND VPWR VGND sky130_ef_sc_hd__decap_12
XTAP_TAPCELL_ROW_228_3039 VGND VPWR sky130_fd_sc_hd__tapvpwrvgnd_1
XFILLER_45_1311 VPWR VGND VPWR VGND sky130_ef_sc_hd__decap_12
XFILLER_49_1491 VGND VGND VPWR VPWR sky130_fd_sc_hd__decap_6
XFILLER_84_1371 VPWR VGND VPWR VGND sky130_ef_sc_hd__decap_12
XTAP_TAPCELL_ROW_9_1108 VGND VPWR sky130_fd_sc_hd__tapvpwrvgnd_1
XTAP_TAPCELL_ROW_9_1119 VGND VPWR sky130_fd_sc_hd__tapvpwrvgnd_1
XFILLER_45_1355 VPWR VGND VPWR VGND sky130_ef_sc_hd__decap_12
XFILLER_132_1303 VPWR VGND VPWR VGND sky130_ef_sc_hd__decap_12
XFILLER_234_1073 VPWR VGND VPWR VGND sky130_ef_sc_hd__decap_12
XPHY_EDGE_ROW_19_2_Left_521 VGND VGND VPWR VPWR sky130_fd_sc_hd__decap_3
XFILLER_136_1483 VPWR VGND VPWR VGND sky130_ef_sc_hd__decap_12
XFILLER_228_805 VGND VGND VPWR VPWR sky130_fd_sc_hd__decap_6
XFILLER_41_1219 VPWR VGND VPWR VGND sky130_ef_sc_hd__decap_12
XFILLER_255_613 VGND VGND VPWR VPWR sky130_fd_sc_hd__decap_3
XFILLER_45_1399 VPWR VGND VPWR VGND sky130_ef_sc_hd__decap_12
XFILLER_228_849 VPWR VGND VPWR VGND sky130_ef_sc_hd__decap_12
XFILLER_223_57 VPWR VGND VPWR VGND sky130_ef_sc_hd__decap_12
XFILLER_227_337 VPWR VGND VPWR VGND sky130_ef_sc_hd__decap_12
XFILLER_255_657 VPWR VGND VPWR VGND sky130_ef_sc_hd__decap_12
XFILLER_212_1371 VGND VGND VPWR VPWR sky130_fd_sc_hd__fill_1
XFILLER_247_1401 VPWR VGND VPWR VGND sky130_ef_sc_hd__decap_12
XFILLER_242_307 VGND VGND VPWR VPWR sky130_fd_sc_hd__fill_1
XFILLER_254_189 VGND VGND VPWR VPWR sky130_fd_sc_hd__decap_6
XFILLER_236_893 VPWR VGND VPWR VGND sky130_ef_sc_hd__decap_12
XFILLER_169_1281 VGND VGND VPWR VPWR sky130_fd_sc_hd__decap_6
XFILLER_251_841 VPWR VGND VPWR VGND sky130_ef_sc_hd__decap_12
XTAP_TAPCELL_ROW_204_2382 VGND VPWR sky130_fd_sc_hd__tapvpwrvgnd_1
XTAP_TAPCELL_ROW_204_2393 VGND VPWR sky130_fd_sc_hd__tapvpwrvgnd_1
XFILLER_165_1145 VGND VGND VPWR VPWR sky130_fd_sc_hd__decap_3
XFILLER_208_1429 VPWR VGND VPWR VGND sky130_ef_sc_hd__decap_12
XFILLER_1_1493 VPWR VGND VPWR VGND sky130_ef_sc_hd__decap_12
XFILLER_56_1451 VPWR VGND VPWR VGND sky130_ef_sc_hd__decap_12
XFILLER_91_1331 VPWR VGND VPWR VGND sky130_ef_sc_hd__decap_12
XFILLER_211_727 VGND VGND VPWR VPWR sky130_fd_sc_hd__fill_1
XFILLER_165_1189 VPWR VGND VPWR VGND sky130_ef_sc_hd__decap_12
XFILLER_195_417 VPWR VGND VPWR VGND sky130_ef_sc_hd__decap_12
XTAP_TAPCELL_ROW_196_2172 VGND VPWR sky130_fd_sc_hd__tapvpwrvgnd_1
XTAP_TAPCELL_ROW_200_2279 VGND VPWR sky130_fd_sc_hd__tapvpwrvgnd_1
XFILLER_52_1315 VPWR VGND VPWR VGND sky130_ef_sc_hd__decap_12
XTAP_TAPCELL_ROW_196_2183 VGND VPWR sky130_fd_sc_hd__tapvpwrvgnd_1
XFILLER_241_1033 VPWR VGND VPWR VGND sky130_ef_sc_hd__decap_12
XFILLER_17_1435 VGND VGND VPWR VPWR sky130_fd_sc_hd__decap_6
XFILLER_56_1495 VPWR VGND VPWR VGND sky130_ef_sc_hd__decap_12
XFILLER_143_1443 VPWR VGND VPWR VGND sky130_ef_sc_hd__decap_12
XTAP_TAPCELL_ROW_192_2058 VGND VPWR sky130_fd_sc_hd__tapvpwrvgnd_1
XTAP_TAPCELL_ROW_217_2732 VGND VPWR sky130_fd_sc_hd__tapvpwrvgnd_1
XFILLER_52_1359 VPWR VGND VPWR VGND sky130_ef_sc_hd__decap_12
XFILLER_17_1479 VPWR VGND VPWR VGND sky130_ef_sc_hd__decap_12
XFILLER_104_1427 VPWR VGND VPWR VGND sky130_ef_sc_hd__decap_12
XTAP_TAPCELL_ROW_192_2069 VGND VPWR sky130_fd_sc_hd__tapvpwrvgnd_1
XFILLER_202_1017 VPWR VGND VPWR VGND sky130_ef_sc_hd__decap_12
XTAP_TAPCELL_ROW_217_2743 VGND VPWR sky130_fd_sc_hd__tapvpwrvgnd_1
XFILLER_241_1077 VPWR VGND VPWR VGND sky130_ef_sc_hd__decap_12
XFILLER_206_1197 VGND VGND VPWR VPWR sky130_fd_sc_hd__decap_6
XTAP_TAPCELL_ROW_217_2754 VGND VPWR sky130_fd_sc_hd__tapvpwrvgnd_1
XFILLER_248_65 VPWR VGND VPWR VGND sky130_ef_sc_hd__decap_12
XTAP_TAPCELL_ROW_213_2629 VGND VPWR sky130_fd_sc_hd__tapvpwrvgnd_1
XFILLER_190_133 VGND VGND VPWR VPWR sky130_fd_sc_hd__decap_6
XTAP_TAPCELL_ROW_10_1_3811 VGND VPWR sky130_fd_sc_hd__tapvpwrvgnd_1
XFILLER_176_1241 VPWR VGND VPWR VGND sky130_ef_sc_hd__decap_12
XFILLER_172_881 VPWR VGND VPWR VGND sky130_ef_sc_hd__decap_12
XFILLER_190_177 VPWR VGND VPWR VGND sky130_ef_sc_hd__decap_12
XFILLER_254_1427 VGND VGND VPWR VPWR sky130_fd_sc_hd__fill_1
XFILLER_172_1105 VPWR VGND VPWR VGND sky130_ef_sc_hd__decap_12
XFILLER_171_391 VGND VGND VPWR VPWR sky130_fd_sc_hd__fill_1
XFILLER_176_1285 VPWR VGND VPWR VGND sky130_ef_sc_hd__decap_12
XFILLER_117_69 VGND VGND VPWR VPWR sky130_fd_sc_hd__fill_2
XFILLER_63_1411 VPWR VGND VPWR VGND sky130_ef_sc_hd__decap_12
XFILLER_172_1149 VPWR VGND VPWR VGND sky130_ef_sc_hd__decap_12
XFILLER_63_1455 VPWR VGND VPWR VGND sky130_ef_sc_hd__decap_12
XFILLER_213_1113 VGND VGND VPWR VPWR sky130_fd_sc_hd__decap_6
XFILLER_252_1173 VPWR VGND VPWR VGND sky130_ef_sc_hd__decap_12
XTAP_TAPCELL_ROW_114_2_4438 VGND VPWR sky130_fd_sc_hd__tapvpwrvgnd_1
XFILLER_246_613 VPWR VGND VPWR VGND sky130_ef_sc_hd__decap_12
XTAP_TAPCELL_ROW_69_2_4171 VGND VPWR sky130_fd_sc_hd__tapvpwrvgnd_1
XFILLER_24_1439 VPWR VGND VPWR VGND sky130_ef_sc_hd__decap_12
XFILLER_63_1499 VPWR VGND VPWR VGND sky130_ef_sc_hd__decap_12
XFILLER_213_1157 VPWR VGND VPWR VGND sky130_ef_sc_hd__decap_12
XFILLER_98_1507 VGND VGND VPWR VPWR sky130_fd_sc_hd__decap_8
XFILLER_133_57 VPWR VGND VPWR VGND sky130_ef_sc_hd__decap_12
XFILLER_150_1469 VGND VGND VPWR VPWR sky130_fd_sc_hd__fill_1
XFILLER_246_657 VPWR VGND VPWR VGND sky130_ef_sc_hd__decap_12
XFILLER_6_1371 VGND VGND VPWR VPWR sky130_fd_sc_hd__fill_1
XTAP_TAPCELL_ROW_82_2_4249 VGND VPWR sky130_fd_sc_hd__tapvpwrvgnd_1
XFILLER_93_39 VPWR VGND VPWR VGND sky130_ef_sc_hd__decap_12
XFILLER_245_167 VGND VGND VPWR VPWR sky130_fd_sc_hd__fill_1
XTAP_TAPCELL_ROW_181_1762 VGND VPWR sky130_fd_sc_hd__tapvpwrvgnd_1
XTAP_TAPCELL_ROW_181_1773 VGND VPWR sky130_fd_sc_hd__tapvpwrvgnd_1
XFILLER_233_329 VGND VGND VPWR VPWR sky130_fd_sc_hd__decap_6
XTAP_TAPCELL_ROW_181_1784 VGND VPWR sky130_fd_sc_hd__tapvpwrvgnd_1
XFILLER_183_1201 VPWR VGND VPWR VGND sky130_ef_sc_hd__decap_12
XFILLER_187_1381 VPWR VGND VPWR VGND sky130_ef_sc_hd__decap_12
XFILLER_183_1245 VPWR VGND VPWR VGND sky130_ef_sc_hd__decap_12
XFILLER_198_233 VPWR VGND VPWR VGND sky130_ef_sc_hd__decap_12
X_360_ net593 net573 net46 VGND VGND VPWR VPWR _149_ sky130_fd_sc_hd__a21o_1
XTAP_TAPCELL_ROW_62_2_4125 VGND VPWR sky130_fd_sc_hd__tapvpwrvgnd_1
XFILLER_241_373 VPWR VGND VPWR VGND sky130_ef_sc_hd__decap_12
XFILLER_214_587 VGND VGND VPWR VPWR sky130_fd_sc_hd__fill_1
XFILLER_183_1289 VPWR VGND VPWR VGND sky130_ef_sc_hd__decap_12
XFILLER_198_277 VPWR VGND VPWR VGND sky130_ef_sc_hd__decap_12
XFILLER_202_749 VGND VGND VPWR VPWR sky130_fd_sc_hd__decap_6
X_291_ _085_ _086_ VGND VGND VPWR VPWR _080_ sky130_fd_sc_hd__and2b_1
XFILLER_70_1415 VPWR VGND VPWR VGND sky130_ef_sc_hd__decap_12
XFILLER_201_237 VPWR VGND VPWR VGND sky130_ef_sc_hd__decap_12
XFILLER_224_1253 VGND VGND VPWR VPWR sky130_fd_sc_hd__decap_6
XFILLER_195_951 VGND VGND VPWR VPWR sky130_fd_sc_hd__fill_1
XFILLER_167_653 VPWR VGND VPWR VGND sky130_ef_sc_hd__decap_12
XFILLER_220_1117 VPWR VGND VPWR VGND sky130_ef_sc_hd__decap_12
XPHY_EDGE_ROW_147_2_Left_649 VGND VGND VPWR VPWR sky130_fd_sc_hd__decap_3
XFILLER_166_141 VPWR VGND VPWR VGND sky130_ef_sc_hd__decap_12
XFILLER_220_3 VPWR VGND VPWR VGND sky130_ef_sc_hd__decap_12
XFILLER_224_1297 VPWR VGND VPWR VGND sky130_ef_sc_hd__decap_12
XFILLER_182_601 VPWR VGND VPWR VGND sky130_ef_sc_hd__decap_12
XFILLER_210_793 VPWR VGND VPWR VGND sky130_ef_sc_hd__decap_12
XFILLER_158_65 VGND VGND VPWR VPWR sky130_fd_sc_hd__decap_6
XFILLER_167_697 VPWR VGND VPWR VGND sky130_ef_sc_hd__decap_12
XTAP_TAPCELL_ROW_175_1599 VGND VPWR sky130_fd_sc_hd__tapvpwrvgnd_1
XFILLER_181_111 VGND VGND VPWR VPWR sky130_fd_sc_hd__fill_1
XFILLER_182_645 VPWR VGND VPWR VGND sky130_ef_sc_hd__decap_12
XPHY_EDGE_ROW_17_1_Left_272 VGND VGND VPWR VPWR sky130_fd_sc_hd__decap_3
XFILLER_194_1341 VPWR VGND VPWR VGND sky130_ef_sc_hd__decap_12
XPHY_EDGE_ROW_56_1_Right_712 VGND VGND VPWR VPWR sky130_fd_sc_hd__decap_3
XFILLER_120_1295 VGND VGND VPWR VPWR sky130_fd_sc_hd__decap_6
XFILLER_174_53 VPWR VGND VPWR VGND sky130_ef_sc_hd__decap_12
XFILLER_190_1205 VPWR VGND VPWR VGND sky130_ef_sc_hd__decap_12
XFILLER_218_1035 VGND VGND VPWR VPWR sky130_fd_sc_hd__fill_1
XFILLER_194_1385 VPWR VGND VPWR VGND sky130_ef_sc_hd__decap_12
XFILLER_3_15 VPWR VGND VPWR VGND sky130_ef_sc_hd__decap_12
XFILLER_81_1511 VGND VGND VPWR VPWR sky130_fd_sc_hd__decap_4
XTAP_TAPCELL_ROW_188_1949 VGND VPWR sky130_fd_sc_hd__tapvpwrvgnd_1
XFILLER_174_97 VPWR VGND VPWR VGND sky130_ef_sc_hd__decap_12
XFILLER_7_1113 VGND VGND VPWR VPWR sky130_fd_sc_hd__decap_6
XFILLER_231_1213 VPWR VGND VPWR VGND sky130_ef_sc_hd__decap_12
XFILLER_235_1393 VGND VGND VPWR VPWR sky130_fd_sc_hd__decap_6
XFILLER_67_51 VGND VGND VPWR VPWR sky130_fd_sc_hd__decap_4
XFILLER_249_473 VPWR VGND VPWR VGND sky130_ef_sc_hd__decap_12
XFILLER_118_1191 VPWR VGND VPWR VGND sky130_ef_sc_hd__decap_12
XFILLER_7_1157 VPWR VGND VPWR VGND sky130_ef_sc_hd__decap_12
XFILLER_190_41 VPWR VGND VPWR VGND sky130_ef_sc_hd__decap_12
XFILLER_231_1257 VPWR VGND VPWR VGND sky130_ef_sc_hd__decap_12
XFILLER_209_337 VPWR VGND VPWR VGND sky130_ef_sc_hd__decap_12
XFILLER_190_85 VPWR VGND VPWR VGND sky130_ef_sc_hd__decap_12
XFILLER_224_307 VGND VGND VPWR VPWR sky130_fd_sc_hd__fill_1
XTAP_TAPCELL_ROW_158_2_4703 VGND VPWR sky130_fd_sc_hd__tapvpwrvgnd_1
XFILLER_236_189 VGND VGND VPWR VPWR sky130_fd_sc_hd__decap_6
XFILLER_218_893 VPWR VGND VPWR VGND sky130_ef_sc_hd__decap_12
X_627_ clknet_3_5__leaf_clk dout0\[25\] _035_ VGND VGND VPWR VPWR dout0_q\[25\] sky130_fd_sc_hd__dfrtp_1
XFILLER_166_1421 VGND VGND VPWR VPWR sky130_fd_sc_hd__decap_6
XFILLER_251_137 VPWR VGND VPWR VGND sky130_ef_sc_hd__decap_12
XFILLER_233_841 VPWR VGND VPWR VGND sky130_ef_sc_hd__decap_12
XFILLER_166_1465 VPWR VGND VPWR VGND sky130_ef_sc_hd__decap_12
XFILLER_229_1175 VGND VGND VPWR VPWR sky130_fd_sc_hd__fill_1
X_558_ net670 VGND VGND VPWR VPWR _040_ sky130_fd_sc_hd__inv_2
XFILLER_220_513 VPWR VGND VPWR VGND sky130_ef_sc_hd__decap_12
XFILLER_177_417 VPWR VGND VPWR VGND sky130_ef_sc_hd__decap_12
X_489_ net171 net86 VGND VGND VPWR VPWR acc_core.adder.cla_blocks\[4\].block.sum\[2\]
+ sky130_fd_sc_hd__xnor2_1
XFILLER_220_557 VPWR VGND VPWR VGND sky130_ef_sc_hd__decap_12
XFILLER_242_1353 VPWR VGND VPWR VGND sky130_ef_sc_hd__decap_12
XFILLER_9_641 VGND VGND VPWR VPWR sky130_fd_sc_hd__decap_3
XFILLER_186_973 VGND VGND VPWR VPWR sky130_fd_sc_hd__decap_6
XFILLER_203_1337 VGND VGND VPWR VPWR sky130_fd_sc_hd__decap_6
XFILLER_242_1397 VPWR VGND VPWR VGND sky130_ef_sc_hd__decap_12
XPHY_EDGE_ROW_150_1_Left_405 VGND VGND VPWR VPWR sky130_fd_sc_hd__decap_3
XFILLER_185_461 VPWR VGND VPWR VGND sky130_ef_sc_hd__decap_12
XTAP_TAPCELL_ROW_32_1_1167 VGND VPWR sky130_fd_sc_hd__tapvpwrvgnd_1
XFILLER_9_685 VPWR VGND VPWR VGND sky130_ef_sc_hd__decap_12
XFILLER_8_195 VGND VGND VPWR VPWR sky130_fd_sc_hd__fill_1
XFILLER_172_133 VGND VGND VPWR VPWR sky130_fd_sc_hd__decap_6
XFILLER_172_177 VPWR VGND VPWR VGND sky130_ef_sc_hd__decap_12
XFILLER_173_1425 VPWR VGND VPWR VGND sky130_ef_sc_hd__decap_12
XFILLER_173_1469 VPWR VGND VPWR VGND sky130_ef_sc_hd__decap_12
XTAP_TAPCELL_ROW_100_2_4357 VGND VPWR sky130_fd_sc_hd__tapvpwrvgnd_1
XFILLER_253_1493 VPWR VGND VPWR VGND sky130_ef_sc_hd__decap_12
XFILLER_228_613 VPWR VGND VPWR VGND sky130_ef_sc_hd__decap_12
XFILLER_255_421 VPWR VGND VPWR VGND sky130_ef_sc_hd__decap_12
XFILLER_214_1477 VGND VGND VPWR VPWR sky130_fd_sc_hd__decap_6
XFILLER_228_657 VPWR VGND VPWR VGND sky130_ef_sc_hd__decap_12
XFILLER_3_1511 VGND VGND VPWR VPWR sky130_fd_sc_hd__fill_1
XFILLER_132_1177 VPWR VGND VPWR VGND sky130_ef_sc_hd__decap_12
XTAP_TAPCELL_ROW_206_2444 VGND VPWR sky130_fd_sc_hd__tapvpwrvgnd_1
XTAP_TAPCELL_ROW_206_2455 VGND VPWR sky130_fd_sc_hd__tapvpwrvgnd_1
XFILLER_103_27 VPWR VGND VPWR VGND sky130_ef_sc_hd__decap_12
XFILLER_227_167 VGND VGND VPWR VPWR sky130_fd_sc_hd__fill_1
XFILLER_215_329 VGND VGND VPWR VPWR sky130_fd_sc_hd__decap_6
XTAP_TAPCELL_ROW_198_2223 VGND VPWR sky130_fd_sc_hd__tapvpwrvgnd_1
XFILLER_250_77 VGND VGND VPWR VPWR sky130_fd_sc_hd__decap_6
XFILLER_247_1231 VGND VGND VPWR VPWR sky130_fd_sc_hd__fill_1
XTAP_TAPCELL_ROW_198_2234 VGND VPWR sky130_fd_sc_hd__tapvpwrvgnd_1
XTAP_TAPCELL_ROW_47_2_4038 VGND VPWR sky130_fd_sc_hd__tapvpwrvgnd_1
XFILLER_251_671 VGND VGND VPWR VPWR sky130_fd_sc_hd__fill_1
XTAP_TAPCELL_ROW_219_2805 VGND VPWR sky130_fd_sc_hd__tapvpwrvgnd_1
XFILLER_223_373 VPWR VGND VPWR VGND sky130_ef_sc_hd__decap_12
XFILLER_180_1429 VPWR VGND VPWR VGND sky130_ef_sc_hd__decap_12
XFILLER_208_1259 VGND VGND VPWR VPWR sky130_fd_sc_hd__fill_1
XFILLER_196_737 VPWR VGND VPWR VGND sky130_ef_sc_hd__decap_12
XPHY_EDGE_ROW_249_Right_94 VGND VGND VPWR VPWR sky130_fd_sc_hd__decap_3
XFILLER_195_225 VPWR VGND VPWR VGND sky130_ef_sc_hd__decap_12
XFILLER_17_1243 VPWR VGND VPWR VGND sky130_ef_sc_hd__decap_12
XPHY_EDGE_ROW_82_1_Left_337 VGND VGND VPWR VPWR sky130_fd_sc_hd__decap_3
XFILLER_177_951 VGND VGND VPWR VPWR sky130_fd_sc_hd__fill_1
XFILLER_108_1371 VPWR VGND VPWR VGND sky130_ef_sc_hd__decap_12
XFILLER_143_1273 VGND VGND VPWR VPWR sky130_fd_sc_hd__fill_1
XFILLER_221_1437 VPWR VGND VPWR VGND sky130_ef_sc_hd__decap_12
XFILLER_17_1287 VPWR VGND VPWR VGND sky130_ef_sc_hd__decap_12
XFILLER_52_1189 VGND VGND VPWR VPWR sky130_fd_sc_hd__fill_1
XFILLER_87_1219 VPWR VGND VPWR VGND sky130_ef_sc_hd__decap_12
XTAP_TAPCELL_ROW_170_1463 VGND VPWR sky130_fd_sc_hd__tapvpwrvgnd_1
XFILLER_191_497 VGND VGND VPWR VPWR sky130_fd_sc_hd__decap_6
XTAP_TAPCELL_ROW_170_1474 VGND VPWR sky130_fd_sc_hd__tapvpwrvgnd_1
XFILLER_2_327 VGND VGND VPWR VPWR sky130_fd_sc_hd__fill_1
XTAP_TAPCELL_ROW_170_1485 VGND VPWR sky130_fd_sc_hd__tapvpwrvgnd_1
XFILLER_176_1093 VPWR VGND VPWR VGND sky130_ef_sc_hd__decap_12
XFILLER_219_1399 VGND VGND VPWR VPWR sky130_fd_sc_hd__fill_1
XFILLER_24_1203 VPWR VGND VPWR VGND sky130_ef_sc_hd__decap_12
XFILLER_28_1383 VPWR VGND VPWR VGND sky130_ef_sc_hd__decap_12
XFILLER_115_1331 VPWR VGND VPWR VGND sky130_ef_sc_hd__decap_12
XFILLER_247_933 VPWR VGND VPWR VGND sky130_ef_sc_hd__decap_12
Xfanout664 net671 VGND VGND VPWR VPWR net664 sky130_fd_sc_hd__clkbuf_4
XTAP_TAPCELL_ROW_183_1813 VGND VPWR sky130_fd_sc_hd__tapvpwrvgnd_1
XFILLER_8_1477 VGND VGND VPWR VPWR sky130_fd_sc_hd__decap_6
XTAP_TAPCELL_ROW_183_1824 VGND VPWR sky130_fd_sc_hd__tapvpwrvgnd_1
XFILLER_246_421 VPWR VGND VPWR VGND sky130_ef_sc_hd__decap_12
XFILLER_24_1247 VPWR VGND VPWR VGND sky130_ef_sc_hd__decap_12
XTAP_TAPCELL_ROW_183_1835 VGND VPWR sky130_fd_sc_hd__tapvpwrvgnd_1
XFILLER_98_1315 VPWR VGND VPWR VGND sky130_ef_sc_hd__decap_12
XFILLER_111_1217 VGND VGND VPWR VPWR sky130_fd_sc_hd__fill_1
XFILLER_247_977 VPWR VGND VPWR VGND sky130_ef_sc_hd__decap_12
XFILLER_206_307 VGND VGND VPWR VPWR sky130_fd_sc_hd__fill_1
XFILLER_248_1017 VPWR VGND VPWR VGND sky130_ef_sc_hd__decap_12
XFILLER_98_1359 VPWR VGND VPWR VGND sky130_ef_sc_hd__decap_12
XFILLER_170_3 VPWR VGND VPWR VGND sky130_ef_sc_hd__decap_12
XFILLER_218_189 VGND VGND VPWR VPWR sky130_fd_sc_hd__decap_6
XFILLER_215_841 VPWR VGND VPWR VGND sky130_ef_sc_hd__decap_12
XFILLER_233_137 VPWR VGND VPWR VGND sky130_ef_sc_hd__decap_12
X_412_ net201 net130 _182_ _185_ net203 VGND VGND VPWR VPWR _201_ sky130_fd_sc_hd__a2111o_1
XFILLER_226_1315 VGND VGND VPWR VPWR sky130_fd_sc_hd__fill_1
XFILLER_199_553 VGND VGND VPWR VPWR sky130_fd_sc_hd__decap_6
XFILLER_230_811 VGND VGND VPWR VPWR sky130_fd_sc_hd__fill_1
XFILLER_202_513 VPWR VGND VPWR VGND sky130_ef_sc_hd__decap_12
XFILLER_242_693 VGND VGND VPWR VPWR sky130_fd_sc_hd__decap_6
XFILLER_241_181 VPWR VGND VPWR VGND sky130_ef_sc_hd__decap_12
X_343_ _130_ _131_ VGND VGND VPWR VPWR _132_ sky130_fd_sc_hd__nand2_1
XFILLER_199_597 VPWR VGND VPWR VGND sky130_ef_sc_hd__decap_12
XFILLER_202_557 VPWR VGND VPWR VGND sky130_ef_sc_hd__decap_12
XFILLER_35_1343 VPWR VGND VPWR VGND sky130_ef_sc_hd__decap_12
XFILLER_224_1061 VPWR VGND VPWR VGND sky130_ef_sc_hd__decap_12
XFILLER_70_1245 VGND VGND VPWR VPWR sky130_fd_sc_hd__fill_1
XFILLER_126_1471 VPWR VGND VPWR VGND sky130_ef_sc_hd__decap_12
XFILLER_168_973 VGND VGND VPWR VPWR sky130_fd_sc_hd__decap_6
XFILLER_167_461 VPWR VGND VPWR VGND sky130_ef_sc_hd__decap_12
XFILLER_35_1387 VPWR VGND VPWR VGND sky130_ef_sc_hd__decap_12
XFILLER_183_921 VPWR VGND VPWR VGND sky130_ef_sc_hd__decap_12
XFILLER_122_1357 VGND VGND VPWR VPWR sky130_fd_sc_hd__fill_1
XFILLER_5_110 VGND VGND VPWR VPWR sky130_fd_sc_hd__fill_2
XFILLER_183_965 VPWR VGND VPWR VGND sky130_ef_sc_hd__decap_12
XFILLER_182_475 VGND VGND VPWR VPWR sky130_fd_sc_hd__fill_1
XFILLER_170_637 VGND VGND VPWR VPWR sky130_fd_sc_hd__decap_6
XFILLER_6_699 VGND VGND VPWR VPWR sky130_fd_sc_hd__fill_1
XFILLER_237_1455 VGND VGND VPWR VPWR sky130_fd_sc_hd__fill_1
XPHY_EDGE_ROW_57_1_Right_713 VGND VGND VPWR VPWR sky130_fd_sc_hd__decap_3
XFILLER_190_1035 VGND VGND VPWR VPWR sky130_fd_sc_hd__fill_1
XFILLER_2_872 VGND VGND VPWR VPWR sky130_fd_sc_hd__decap_3
XFILLER_42_1303 VPWR VGND VPWR VGND sky130_ef_sc_hd__decap_12
XFILLER_46_1483 VPWR VGND VPWR VGND sky130_ef_sc_hd__decap_12
XFILLER_231_1021 VPWR VGND VPWR VGND sky130_ef_sc_hd__decap_12
XFILLER_204_15 VPWR VGND VPWR VGND sky130_ef_sc_hd__decap_12
XFILLER_249_281 VPWR VGND VPWR VGND sky130_ef_sc_hd__decap_12
XFILLER_81_1385 VGND VGND VPWR VPWR sky130_fd_sc_hd__fill_1
XFILLER_231_1065 VPWR VGND VPWR VGND sky130_ef_sc_hd__decap_12
XFILLER_133_1497 VGND VGND VPWR VPWR sky130_fd_sc_hd__fill_1
XFILLER_209_167 VGND VGND VPWR VPWR sky130_fd_sc_hd__fill_1
XFILLER_252_413 VGND VGND VPWR VPWR sky130_fd_sc_hd__decap_6
XFILLER_252_457 VPWR VGND VPWR VGND sky130_ef_sc_hd__decap_12
XTAP_TAPCELL_ROW_18_2_3862 VGND VPWR sky130_fd_sc_hd__tapvpwrvgnd_1
XFILLER_209_1513 VGND VGND VPWR VPWR sky130_fd_sc_hd__fill_2
XFILLER_233_671 VGND VGND VPWR VPWR sky130_fd_sc_hd__fill_1
XFILLER_127_1213 VGND VGND VPWR VPWR sky130_fd_sc_hd__decap_4
XFILLER_166_1273 VPWR VGND VPWR VGND sky130_ef_sc_hd__decap_12
XFILLER_205_373 VPWR VGND VPWR VGND sky130_ef_sc_hd__decap_12
XFILLER_221_833 VGND VGND VPWR VPWR sky130_fd_sc_hd__decap_6
XFILLER_178_737 VPWR VGND VPWR VGND sky130_ef_sc_hd__decap_12
XFILLER_220_321 VPWR VGND VPWR VGND sky130_ef_sc_hd__decap_12
XFILLER_75_1189 VPWR VGND VPWR VGND sky130_ef_sc_hd__decap_12
XFILLER_177_225 VPWR VGND VPWR VGND sky130_ef_sc_hd__decap_12
XFILLER_221_877 VPWR VGND VPWR VGND sky130_ef_sc_hd__decap_12
XFILLER_53_1443 VPWR VGND VPWR VGND sky130_ef_sc_hd__decap_12
XFILLER_105_1511 VGND VGND VPWR VPWR sky130_fd_sc_hd__decap_4
XFILLER_203_1101 VPWR VGND VPWR VGND sky130_ef_sc_hd__decap_12
XFILLER_220_365 VPWR VGND VPWR VGND sky130_ef_sc_hd__decap_12
XFILLER_242_1161 VPWR VGND VPWR VGND sky130_ef_sc_hd__decap_12
XFILLER_207_1281 VGND VGND VPWR VPWR sky130_fd_sc_hd__decap_6
XFILLER_140_1413 VGND VGND VPWR VPWR sky130_fd_sc_hd__fill_1
XFILLER_193_729 VPWR VGND VPWR VGND sky130_ef_sc_hd__decap_12
XFILLER_14_1427 VPWR VGND VPWR VGND sky130_ef_sc_hd__decap_12
XFILLER_203_1145 VPWR VGND VPWR VGND sky130_ef_sc_hd__decap_12
XFILLER_186_781 VPWR VGND VPWR VGND sky130_ef_sc_hd__decap_12
XFILLER_203_1189 VPWR VGND VPWR VGND sky130_ef_sc_hd__decap_12
XFILLER_173_497 VGND VGND VPWR VPWR sky130_fd_sc_hd__decap_6
XTAP_TAPCELL_ROW_150_2_4654 VGND VPWR sky130_fd_sc_hd__tapvpwrvgnd_1
XFILLER_245_55 VGND VGND VPWR VPWR sky130_fd_sc_hd__fill_1
XTAP_TAPCELL_ROW_149_2_4648 VGND VPWR sky130_fd_sc_hd__tapvpwrvgnd_1
XFILLER_173_1233 VPWR VGND VPWR VGND sky130_ef_sc_hd__decap_12
XFILLER_134_1239 VGND VGND VPWR VPWR sky130_fd_sc_hd__decap_6
XTAP_TAPCELL_ROW_208_2506 VGND VPWR sky130_fd_sc_hd__tapvpwrvgnd_1
XFILLER_214_1241 VPWR VGND VPWR VGND sky130_ef_sc_hd__decap_12
XFILLER_114_15 VPWR VGND VPWR VGND sky130_ef_sc_hd__decap_12
XFILLER_229_933 VPWR VGND VPWR VGND sky130_ef_sc_hd__decap_12
XFILLER_228_421 VPWR VGND VPWR VGND sky130_ef_sc_hd__decap_12
XFILLER_210_1105 VPWR VGND VPWR VGND sky130_ef_sc_hd__decap_12
XFILLER_214_1285 VPWR VGND VPWR VGND sky130_ef_sc_hd__decap_12
XFILLER_229_977 VPWR VGND VPWR VGND sky130_ef_sc_hd__decap_12
XFILLER_60_1469 VGND VGND VPWR VPWR sky130_fd_sc_hd__fill_1
XFILLER_244_925 VPWR VGND VPWR VGND sky130_ef_sc_hd__decap_12
XFILLER_210_1149 VPWR VGND VPWR VGND sky130_ef_sc_hd__decap_12
XFILLER_249_1337 VGND VGND VPWR VPWR sky130_fd_sc_hd__decap_6
XTAP_TAPCELL_ROW_97_2_4335 VGND VPWR sky130_fd_sc_hd__tapvpwrvgnd_1
XFILLER_215_137 VPWR VGND VPWR VGND sky130_ef_sc_hd__decap_12
XFILLER_93_1201 VPWR VGND VPWR VGND sky130_ef_sc_hd__decap_12
XTAP_TAPCELL_ROW_109_2_4411 VGND VPWR sky130_fd_sc_hd__tapvpwrvgnd_1
XFILLER_110_1283 VPWR VGND VPWR VGND sky130_ef_sc_hd__decap_12
XFILLER_212_811 VGND VGND VPWR VPWR sky130_fd_sc_hd__fill_1
XFILLER_184_1373 VPWR VGND VPWR VGND sky130_ef_sc_hd__decap_12
XFILLER_196_501 VPWR VGND VPWR VGND sky130_ef_sc_hd__decap_12
XFILLER_224_693 VGND VGND VPWR VPWR sky130_fd_sc_hd__decap_6
XFILLER_90_29 VPWR VGND VPWR VGND sky130_ef_sc_hd__decap_12
XFILLER_93_1267 VGND VGND VPWR VPWR sky130_fd_sc_hd__decap_6
XFILLER_223_181 VPWR VGND VPWR VGND sky130_ef_sc_hd__decap_12
XFILLER_196_545 VPWR VGND VPWR VGND sky130_ef_sc_hd__decap_12
XFILLER_23_34 VPWR VGND VPWR VGND sky130_ef_sc_hd__decap_12
XFILLER_145_1379 VGND VGND VPWR VPWR sky130_fd_sc_hd__decap_6
XFILLER_180_1259 VGND VGND VPWR VPWR sky130_fd_sc_hd__fill_1
XFILLER_221_1201 VPWR VGND VPWR VGND sky130_ef_sc_hd__decap_12
Xwire306 net307 VGND VGND VPWR VPWR net306 sky130_fd_sc_hd__clkbuf_1
XFILLER_225_1381 VPWR VGND VPWR VGND sky130_ef_sc_hd__decap_12
XTAP_TAPCELL_ROW_176_1650 VGND VPWR sky130_fd_sc_hd__tapvpwrvgnd_1
XFILLER_196_589 VPWR VGND VPWR VGND sky130_ef_sc_hd__decap_12
Xwire317 net318 VGND VGND VPWR VPWR net317 sky130_fd_sc_hd__clkbuf_1
XFILLER_165_921 VGND VGND VPWR VPWR sky130_fd_sc_hd__decap_3
XFILLER_183_217 VGND VGND VPWR VPWR sky130_fd_sc_hd__decap_6
XFILLER_221_1245 VPWR VGND VPWR VGND sky130_ef_sc_hd__decap_12
Xwire339 net340 VGND VGND VPWR VPWR net339 sky130_fd_sc_hd__clkbuf_1
XTAP_TAPCELL_ROW_172_1525 VGND VPWR sky130_fd_sc_hd__tapvpwrvgnd_1
XFILLER_99_27 VPWR VGND VPWR VGND sky130_ef_sc_hd__decap_12
XTAP_TAPCELL_ROW_172_1536 VGND VPWR sky130_fd_sc_hd__tapvpwrvgnd_1
XFILLER_221_1289 VPWR VGND VPWR VGND sky130_ef_sc_hd__decap_12
XFILLER_191_261 VPWR VGND VPWR VGND sky130_ef_sc_hd__decap_12
XFILLER_30_1295 VGND VGND VPWR VPWR sky130_fd_sc_hd__decap_6
XFILLER_155_55 VGND VGND VPWR VPWR sky130_fd_sc_hd__fill_1
XFILLER_180_979 VGND VGND VPWR VPWR sky130_fd_sc_hd__fill_1
XFILLER_152_1339 VPWR VGND VPWR VGND sky130_ef_sc_hd__decap_12
XFILLER_8_1241 VPWR VGND VPWR VGND sky130_ef_sc_hd__decap_12
XFILLER_191_1399 VGND VGND VPWR VPWR sky130_fd_sc_hd__fill_1
XFILLER_232_1341 VPWR VGND VPWR VGND sky130_ef_sc_hd__decap_12
XFILLER_28_1191 VPWR VGND VPWR VGND sky130_ef_sc_hd__decap_12
XFILLER_247_741 VPWR VGND VPWR VGND sky130_ef_sc_hd__decap_12
XFILLER_4_1105 VPWR VGND VPWR VGND sky130_ef_sc_hd__decap_12
XFILLER_8_1285 VPWR VGND VPWR VGND sky130_ef_sc_hd__decap_12
XFILLER_232_1385 VPWR VGND VPWR VGND sky130_ef_sc_hd__decap_12
XFILLER_246_251 VGND VGND VPWR VPWR sky130_fd_sc_hd__fill_1
XFILLER_4_1149 VPWR VGND VPWR VGND sky130_ef_sc_hd__decap_12
XFILLER_247_785 VPWR VGND VPWR VGND sky130_ef_sc_hd__decap_12
XFILLER_234_413 VGND VGND VPWR VPWR sky130_fd_sc_hd__decap_6
XFILLER_0_27 VGND VGND VPWR VPWR sky130_fd_sc_hd__fill_1
XFILLER_64_41 VGND VGND VPWR VPWR sky130_fd_sc_hd__decap_6
XFILLER_98_1189 VGND VGND VPWR VPWR sky130_fd_sc_hd__fill_1
XFILLER_234_457 VPWR VGND VPWR VGND sky130_ef_sc_hd__decap_12
XFILLER_250_917 VGND VGND VPWR VPWR sky130_fd_sc_hd__decap_6
XFILLER_215_671 VGND VGND VPWR VPWR sky130_fd_sc_hd__fill_1
XFILLER_199_361 VPWR VGND VPWR VGND sky130_ef_sc_hd__decap_12
XFILLER_203_833 VGND VGND VPWR VPWR sky130_fd_sc_hd__decap_6
XFILLER_163_1435 VGND VGND VPWR VPWR sky130_fd_sc_hd__decap_6
XFILLER_202_321 VPWR VGND VPWR VGND sky130_ef_sc_hd__decap_12
XTAP_TAPCELL_ROW_254_3750 VGND VPWR sky130_fd_sc_hd__tapvpwrvgnd_1
XFILLER_203_877 VPWR VGND VPWR VGND sky130_ef_sc_hd__decap_12
X_326_ net594 dout0_q\[17\] net51 VGND VGND VPWR VPWR _115_ sky130_fd_sc_hd__a21oi_1
XFILLER_163_1479 VPWR VGND VPWR VGND sky130_ef_sc_hd__decap_12
XFILLER_202_365 VPWR VGND VPWR VGND sky130_ef_sc_hd__decap_12
XFILLER_204_1421 VGND VGND VPWR VPWR sky130_fd_sc_hd__decap_6
XFILLER_9_69 VPWR VGND VPWR VGND sky130_ef_sc_hd__decap_12
XFILLER_243_1481 VPWR VGND VPWR VGND sky130_ef_sc_hd__decap_12
XFILLER_175_729 VPWR VGND VPWR VGND sky130_ef_sc_hd__decap_12
XFILLER_198_1509 VGND VGND VPWR VPWR sky130_fd_sc_hd__decap_6
XTAP_TAPCELL_ROW_250_3625 VGND VPWR sky130_fd_sc_hd__tapvpwrvgnd_1
XTAP_TAPCELL_ROW_250_3636 VGND VPWR sky130_fd_sc_hd__tapvpwrvgnd_1
XFILLER_168_781 VPWR VGND VPWR VGND sky130_ef_sc_hd__decap_12
XPHY_EDGE_ROW_28_2_Left_530 VGND VGND VPWR VPWR sky130_fd_sc_hd__decap_3
XFILLER_204_1465 VPWR VGND VPWR VGND sky130_ef_sc_hd__decap_12
XTAP_TAPCELL_ROW_250_3647 VGND VPWR sky130_fd_sc_hd__tapvpwrvgnd_1
XFILLER_7_953 VPWR VGND VPWR VGND sky130_ef_sc_hd__decap_12
XFILLER_122_1165 VPWR VGND VPWR VGND sky130_ef_sc_hd__decap_12
XFILLER_200_1329 VPWR VGND VPWR VGND sky130_ef_sc_hd__decap_12
Xmax_cap606 rd_addr\[6\] VGND VGND VPWR VPWR net606 sky130_fd_sc_hd__clkbuf_1
Xmax_cap617 net618 VGND VGND VPWR VPWR net617 sky130_fd_sc_hd__clkbuf_1
XFILLER_170_401 VPWR VGND VPWR VGND sky130_ef_sc_hd__decap_12
XPHY_EDGE_ROW_120_2_Right_211 VGND VGND VPWR VPWR sky130_fd_sc_hd__decap_3
XFILLER_157_1217 VGND VGND VPWR VPWR sky130_fd_sc_hd__fill_1
XTAP_TAPCELL_ROW_135_2_4567 VGND VPWR sky130_fd_sc_hd__tapvpwrvgnd_1
XFILLER_100_1463 VGND VGND VPWR VPWR sky130_fd_sc_hd__decap_6
XFILLER_170_445 VPWR VGND VPWR VGND sky130_ef_sc_hd__decap_12
XTAP_TAPCELL_ROW_248_3576 VGND VPWR sky130_fd_sc_hd__tapvpwrvgnd_1
XFILLER_170_489 VPWR VGND VPWR VGND sky130_ef_sc_hd__decap_12
XTAP_TAPCELL_ROW_248_3587 VGND VPWR sky130_fd_sc_hd__tapvpwrvgnd_1
XPHY_EDGE_ROW_58_1_Right_714 VGND VGND VPWR VPWR sky130_fd_sc_hd__decap_3
XTAP_TAPCELL_ROW_27_1_1162 VGND VPWR sky130_fd_sc_hd__tapvpwrvgnd_1
XFILLER_9_1049 VPWR VGND VPWR VGND sky130_ef_sc_hd__decap_12
XTAP_TAPCELL_ROW_115_2_4443 VGND VPWR sky130_fd_sc_hd__tapvpwrvgnd_1
XFILLER_250_1441 VPWR VGND VPWR VGND sky130_ef_sc_hd__decap_12
XFILLER_29_3 VPWR VGND VPWR VGND sky130_ef_sc_hd__decap_12
XFILLER_215_69 VPWR VGND VPWR VGND sky130_ef_sc_hd__decap_12
XFILLER_211_1425 VPWR VGND VPWR VGND sky130_ef_sc_hd__decap_12
XFILLER_250_1485 VPWR VGND VPWR VGND sky130_ef_sc_hd__decap_12
XTAP_TAPCELL_ROW_83_2_4254 VGND VPWR sky130_fd_sc_hd__tapvpwrvgnd_1
XFILLER_226_925 VPWR VGND VPWR VGND sky130_ef_sc_hd__decap_12
XFILLER_42_1188 VGND VGND VPWR VPWR sky130_fd_sc_hd__fill_2
XFILLER_211_1469 VPWR VGND VPWR VGND sky130_ef_sc_hd__decap_12
XFILLER_237_273 VGND VGND VPWR VPWR sky130_fd_sc_hd__decap_6
XFILLER_252_221 VPWR VGND VPWR VGND sky130_ef_sc_hd__decap_12
XFILLER_231_57 VPWR VGND VPWR VGND sky130_ef_sc_hd__decap_12
XFILLER_253_777 VGND VGND VPWR VPWR sky130_fd_sc_hd__decap_6
XFILLER_252_265 VPWR VGND VPWR VGND sky130_ef_sc_hd__decap_12
XTAP_TAPCELL_ROW_63_2_4130 VGND VPWR sky130_fd_sc_hd__tapvpwrvgnd_1
XFILLER_178_501 VPWR VGND VPWR VGND sky130_ef_sc_hd__decap_12
XFILLER_181_1513 VGND VGND VPWR VPWR sky130_fd_sc_hd__fill_2
XFILLER_209_1343 VGND VGND VPWR VPWR sky130_fd_sc_hd__fill_1
XFILLER_90_1407 VGND VGND VPWR VPWR sky130_fd_sc_hd__decap_6
XFILLER_206_693 VGND VGND VPWR VPWR sky130_fd_sc_hd__decap_6
XFILLER_205_181 VPWR VGND VPWR VGND sky130_ef_sc_hd__decap_12
XFILLER_221_641 VPWR VGND VPWR VGND sky130_ef_sc_hd__decap_12
XFILLER_178_545 VPWR VGND VPWR VGND sky130_ef_sc_hd__decap_12
XFILLER_221_685 VPWR VGND VPWR VGND sky130_ef_sc_hd__decap_12
XFILLER_18_1371 VPWR VGND VPWR VGND sky130_ef_sc_hd__decap_12
XFILLER_178_589 VPWR VGND VPWR VGND sky130_ef_sc_hd__decap_12
XFILLER_53_1273 VGND VGND VPWR VPWR sky130_fd_sc_hd__fill_1
XFILLER_220_195 VGND VGND VPWR VPWR sky130_fd_sc_hd__fill_1
XFILLER_88_1303 VPWR VGND VPWR VGND sky130_ef_sc_hd__decap_12
XFILLER_193_559 VGND VGND VPWR VPWR sky130_fd_sc_hd__fill_1
XFILLER_9_290 VGND VGND VPWR VPWR sky130_fd_sc_hd__fill_1
XFILLER_105_1385 VGND VGND VPWR VPWR sky130_fd_sc_hd__fill_1
XFILLER_109_15 VPWR VGND VPWR VGND sky130_ef_sc_hd__decap_12
XFILLER_238_1005 VPWR VGND VPWR VGND sky130_ef_sc_hd__decap_12
XFILLER_180_209 VPWR VGND VPWR VGND sky130_ef_sc_hd__decap_12
XFILLER_173_261 VPWR VGND VPWR VGND sky130_ef_sc_hd__decap_12
XFILLER_238_1049 VPWR VGND VPWR VGND sky130_ef_sc_hd__decap_12
XFILLER_255_1341 VGND VGND VPWR VPWR sky130_fd_sc_hd__decap_3
XTAP_TAPCELL_ROW_74_1_1209 VGND VPWR sky130_fd_sc_hd__tapvpwrvgnd_1
XFILLER_0_617 VGND VGND VPWR VPWR sky130_fd_sc_hd__fill_1
XFILLER_255_1385 VPWR VGND VPWR VGND sky130_ef_sc_hd__decap_12
XFILLER_173_1063 VGND VGND VPWR VPWR sky130_fd_sc_hd__fill_1
XFILLER_125_69 VGND VGND VPWR VPWR sky130_fd_sc_hd__fill_2
XFILLER_25_1331 VPWR VGND VPWR VGND sky130_ef_sc_hd__decap_12
XFILLER_229_741 VPWR VGND VPWR VGND sky130_ef_sc_hd__decap_12
XFILLER_5_1425 VPWR VGND VPWR VGND sky130_ef_sc_hd__decap_12
XFILLER_112_1301 VGND VGND VPWR VPWR sky130_fd_sc_hd__fill_1
XTAP_TAPCELL_ROW_165_1340 VGND VPWR sky130_fd_sc_hd__tapvpwrvgnd_1
XFILLER_21_1217 VGND VGND VPWR VPWR sky130_fd_sc_hd__fill_1
XTAP_TAPCELL_ROW_4_967 VGND VPWR sky130_fd_sc_hd__tapvpwrvgnd_1
XFILLER_214_1093 VPWR VGND VPWR VGND sky130_ef_sc_hd__decap_12
XFILLER_228_251 VGND VGND VPWR VPWR sky130_fd_sc_hd__fill_1
XFILLER_249_1101 VPWR VGND VPWR VGND sky130_ef_sc_hd__decap_12
XTAP_TAPCELL_ROW_4_978 VGND VPWR sky130_fd_sc_hd__tapvpwrvgnd_1
XFILLER_99_1443 VPWR VGND VPWR VGND sky130_ef_sc_hd__decap_12
XTAP_TAPCELL_ROW_165_1351 VGND VPWR sky130_fd_sc_hd__tapvpwrvgnd_1
XFILLER_229_785 VPWR VGND VPWR VGND sky130_ef_sc_hd__decap_12
XFILLER_5_1469 VPWR VGND VPWR VGND sky130_ef_sc_hd__decap_12
XPHY_EDGE_ROW_156_2_Left_658 VGND VGND VPWR VPWR sky130_fd_sc_hd__decap_3
XFILLER_216_413 VGND VGND VPWR VPWR sky130_fd_sc_hd__decap_6
XFILLER_249_1145 VPWR VGND VPWR VGND sky130_ef_sc_hd__decap_12
XFILLER_244_755 VGND VGND VPWR VPWR sky130_fd_sc_hd__fill_1
XFILLER_95_1329 VGND VGND VPWR VPWR sky130_fd_sc_hd__fill_1
XFILLER_141_57 VPWR VGND VPWR VGND sky130_ef_sc_hd__decap_12
XFILLER_216_457 VPWR VGND VPWR VGND sky130_ef_sc_hd__decap_12
XFILLER_232_917 VGND VGND VPWR VPWR sky130_fd_sc_hd__decap_6
XFILLER_245_1009 VPWR VGND VPWR VGND sky130_ef_sc_hd__decap_12
XFILLER_249_1189 VPWR VGND VPWR VGND sky130_ef_sc_hd__decap_12
XPHY_EDGE_ROW_26_1_Left_281 VGND VGND VPWR VPWR sky130_fd_sc_hd__decap_3
XPHY_EDGE_ROW_20_1_Right_676 VGND VGND VPWR VPWR sky130_fd_sc_hd__decap_3
XFILLER_231_405 VPWR VGND VPWR VGND sky130_ef_sc_hd__decap_12
XFILLER_188_309 VPWR VGND VPWR VGND sky130_ef_sc_hd__decap_12
XTAP_TAPCELL_ROW_178_1701 VGND VPWR sky130_fd_sc_hd__tapvpwrvgnd_1
XFILLER_197_821 VPWR VGND VPWR VGND sky130_ef_sc_hd__decap_12
XFILLER_231_449 VPWR VGND VPWR VGND sky130_ef_sc_hd__decap_12
XFILLER_240_961 VPWR VGND VPWR VGND sky130_ef_sc_hd__decap_12
XFILLER_145_1165 VPWR VGND VPWR VGND sky130_ef_sc_hd__decap_12
XFILLER_197_865 VPWR VGND VPWR VGND sky130_ef_sc_hd__decap_12
XTAP_TAPCELL_ROW_141_2_4599 VGND VPWR sky130_fd_sc_hd__tapvpwrvgnd_1
XFILLER_200_825 VPWR VGND VPWR VGND sky130_ef_sc_hd__decap_12
XFILLER_36_1471 VPWR VGND VPWR VGND sky130_ef_sc_hd__decap_12
Xwire103 _209_ VGND VGND VPWR VPWR net103 sky130_fd_sc_hd__clkbuf_1
XFILLER_133_3 VPWR VGND VPWR VGND sky130_ef_sc_hd__decap_12
Xwire114 _205_ VGND VGND VPWR VPWR net114 sky130_fd_sc_hd__clkbuf_1
XFILLER_8_739 VPWR VGND VPWR VGND sky130_ef_sc_hd__decap_12
XFILLER_7_216 VGND VGND VPWR VPWR sky130_fd_sc_hd__fill_1
Xwire125 _178_ VGND VGND VPWR VPWR net125 sky130_fd_sc_hd__clkbuf_1
XFILLER_123_1441 VGND VGND VPWR VPWR sky130_fd_sc_hd__fill_1
XFILLER_200_869 VPWR VGND VPWR VGND sky130_ef_sc_hd__decap_12
Xwire147 _190_ VGND VGND VPWR VPWR net147 sky130_fd_sc_hd__clkbuf_1
XFILLER_32_1357 VGND VGND VPWR VPWR sky130_fd_sc_hd__fill_1
XFILLER_50_65 VGND VGND VPWR VPWR sky130_fd_sc_hd__decap_3
XFILLER_192_581 VGND VGND VPWR VPWR sky130_fd_sc_hd__decap_6
XFILLER_166_65 VPWR VGND VPWR VGND sky130_ef_sc_hd__decap_12
XTAP_TAPCELL_ROW_230_3090 VGND VPWR sky130_fd_sc_hd__tapvpwrvgnd_1
XFILLER_117_1201 VPWR VGND VPWR VGND sky130_ef_sc_hd__decap_12
XTAP_TAPCELL_ROW_101_2_4362 VGND VPWR sky130_fd_sc_hd__tapvpwrvgnd_1
XFILLER_239_505 VPWR VGND VPWR VGND sky130_ef_sc_hd__decap_12
XFILLER_156_1283 VPWR VGND VPWR VGND sky130_ef_sc_hd__decap_12
XFILLER_65_1177 VPWR VGND VPWR VGND sky130_ef_sc_hd__decap_12
XFILLER_182_53 VPWR VGND VPWR VGND sky130_ef_sc_hd__decap_12
XFILLER_117_1267 VGND VGND VPWR VPWR sky130_fd_sc_hd__decap_6
XTAP_TAPCELL_ROW_243_3440 VGND VPWR sky130_fd_sc_hd__tapvpwrvgnd_1
XTAP_TAPCELL_ROW_243_3451 VGND VPWR sky130_fd_sc_hd__tapvpwrvgnd_1
XFILLER_182_97 VPWR VGND VPWR VGND sky130_ef_sc_hd__decap_12
XFILLER_8_1093 VPWR VGND VPWR VGND sky130_ef_sc_hd__decap_12
XFILLER_208_925 VPWR VGND VPWR VGND sky130_ef_sc_hd__decap_12
XFILLER_43_1497 VGND VGND VPWR VPWR sky130_fd_sc_hd__fill_1
XFILLER_75_51 VGND VGND VPWR VPWR sky130_fd_sc_hd__decap_4
XFILLER_219_273 VGND VGND VPWR VPWR sky130_fd_sc_hd__decap_6
XFILLER_234_221 VPWR VGND VPWR VGND sky130_ef_sc_hd__decap_12
XFILLER_235_777 VGND VGND VPWR VPWR sky130_fd_sc_hd__decap_6
XFILLER_228_1229 VPWR VGND VPWR VGND sky130_ef_sc_hd__decap_12
XTAP_TAPCELL_ROW_48_2_4043 VGND VPWR sky130_fd_sc_hd__tapvpwrvgnd_1
XFILLER_234_265 VPWR VGND VPWR VGND sky130_ef_sc_hd__decap_12
XFILLER_250_725 VPWR VGND VPWR VGND sky130_ef_sc_hd__decap_12
XFILLER_201_27 VPWR VGND VPWR VGND sky130_ef_sc_hd__decap_12
XFILLER_37_1213 VGND VGND VPWR VPWR sky130_fd_sc_hd__decap_4
XFILLER_250_769 VPWR VGND VPWR VGND sky130_ef_sc_hd__decap_12
XFILLER_203_641 VPWR VGND VPWR VGND sky130_ef_sc_hd__decap_12
XFILLER_76_1295 VGND VGND VPWR VPWR sky130_fd_sc_hd__decap_6
XFILLER_163_1243 VPWR VGND VPWR VGND sky130_ef_sc_hd__decap_12
XTAP_TAPCELL_ROW_237_3277 VGND VPWR sky130_fd_sc_hd__tapvpwrvgnd_1
XTAP_TAPCELL_ROW_237_3288 VGND VPWR sky130_fd_sc_hd__tapvpwrvgnd_1
XFILLER_124_1227 VPWR VGND VPWR VGND sky130_ef_sc_hd__decap_12
XFILLER_203_685 VPWR VGND VPWR VGND sky130_ef_sc_hd__decap_12
XFILLER_15_1511 VGND VGND VPWR VPWR sky130_fd_sc_hd__decap_4
XFILLER_163_1287 VPWR VGND VPWR VGND sky130_ef_sc_hd__decap_12
XFILLER_50_1413 VGND VGND VPWR VPWR sky130_fd_sc_hd__fill_1
XFILLER_198_1317 VPWR VGND VPWR VGND sky130_ef_sc_hd__decap_12
XFILLER_202_195 VGND VGND VPWR VPWR sky130_fd_sc_hd__fill_1
X_309_ net595 dout0_q\[25\] net530 VGND VGND VPWR VPWR _098_ sky130_fd_sc_hd__a21oi_1
XFILLER_175_559 VGND VGND VPWR VPWR sky130_fd_sc_hd__fill_1
XFILLER_204_1273 VPWR VGND VPWR VGND sky130_ef_sc_hd__decap_12
XTAP_TAPCELL_ROW_26_2_3913 VGND VPWR sky130_fd_sc_hd__tapvpwrvgnd_1
XFILLER_239_1325 VPWR VGND VPWR VGND sky130_ef_sc_hd__decap_12
XFILLER_171_721 VGND VGND VPWR VPWR sky130_fd_sc_hd__decap_6
XFILLER_239_1369 VPWR VGND VPWR VGND sky130_ef_sc_hd__decap_12
XFILLER_196_1085 VGND VGND VPWR VPWR sky130_fd_sc_hd__decap_6
XPHY_EDGE_ROW_121_2_Right_212 VGND VGND VPWR VPWR sky130_fd_sc_hd__decap_3
XFILLER_171_765 VPWR VGND VPWR VGND sky130_ef_sc_hd__decap_12
XFILLER_100_1271 VPWR VGND VPWR VGND sky130_ef_sc_hd__decap_12
XFILLER_170_253 VPWR VGND VPWR VGND sky130_ef_sc_hd__decap_12
XFILLER_83_1255 VPWR VGND VPWR VGND sky130_ef_sc_hd__decap_12
XFILLER_135_1323 VGND VGND VPWR VPWR sky130_fd_sc_hd__decap_6
XFILLER_170_1203 VGND VGND VPWR VPWR sky130_fd_sc_hd__fill_1
XPHY_EDGE_ROW_59_1_Right_715 VGND VGND VPWR VPWR sky130_fd_sc_hd__decap_3
XFILLER_44_1239 VGND VGND VPWR VPWR sky130_fd_sc_hd__decap_6
XFILLER_83_1299 VPWR VGND VPWR VGND sky130_ef_sc_hd__decap_12
XFILLER_135_1367 VPWR VGND VPWR VGND sky130_ef_sc_hd__decap_12
XPHY_EDGE_ROW_91_1_Left_346 VGND VGND VPWR VPWR sky130_fd_sc_hd__decap_3
XFILLER_211_1233 VPWR VGND VPWR VGND sky130_ef_sc_hd__decap_12
XTAP_TAPCELL_ROW_226_2981 VGND VPWR sky130_fd_sc_hd__tapvpwrvgnd_1
XTAP_TAPCELL_ROW_226_2992 VGND VPWR sky130_fd_sc_hd__tapvpwrvgnd_1
XFILLER_253_541 VPWR VGND VPWR VGND sky130_ef_sc_hd__decap_12
XFILLER_226_755 VGND VGND VPWR VPWR sky130_fd_sc_hd__fill_1
XFILLER_1_81 VPWR VGND VPWR VGND sky130_ef_sc_hd__decap_12
XFILLER_214_917 VGND VGND VPWR VPWR sky130_fd_sc_hd__decap_6
XTAP_TAPCELL_ROW_222_2867 VGND VPWR sky130_fd_sc_hd__tapvpwrvgnd_1
XFILLER_246_1329 VPWR VGND VPWR VGND sky130_ef_sc_hd__decap_12
XFILLER_213_405 VPWR VGND VPWR VGND sky130_ef_sc_hd__decap_12
XTAP_TAPCELL_ROW_222_2878 VGND VPWR sky130_fd_sc_hd__tapvpwrvgnd_1
XFILLER_253_585 VPWR VGND VPWR VGND sky130_ef_sc_hd__decap_12
XFILLER_111_27 VPWR VGND VPWR VGND sky130_ef_sc_hd__decap_12
XTAP_TAPCELL_ROW_222_2889 VGND VPWR sky130_fd_sc_hd__tapvpwrvgnd_1
XFILLER_20_1283 VPWR VGND VPWR VGND sky130_ef_sc_hd__decap_12
XFILLER_94_1351 VGND VGND VPWR VPWR sky130_fd_sc_hd__decap_6
XFILLER_179_821 VPWR VGND VPWR VGND sky130_ef_sc_hd__decap_12
XFILLER_213_449 VPWR VGND VPWR VGND sky130_ef_sc_hd__decap_12
XFILLER_90_1215 VPWR VGND VPWR VGND sky130_ef_sc_hd__decap_12
XFILLER_94_1395 VPWR VGND VPWR VGND sky130_ef_sc_hd__decap_12
XFILLER_181_1343 VGND VGND VPWR VPWR sky130_fd_sc_hd__fill_1
XFILLER_222_961 VPWR VGND VPWR VGND sky130_ef_sc_hd__decap_12
XFILLER_146_1463 VGND VGND VPWR VPWR sky130_fd_sc_hd__decap_6
XFILLER_179_865 VPWR VGND VPWR VGND sky130_ef_sc_hd__decap_12
XFILLER_55_1379 VGND VGND VPWR VPWR sky130_fd_sc_hd__decap_6
XFILLER_90_1259 VPWR VGND VPWR VGND sky130_ef_sc_hd__decap_12
XFILLER_142_1327 VPWR VGND VPWR VGND sky130_ef_sc_hd__decap_12
XFILLER_194_813 VPWR VGND VPWR VGND sky130_ef_sc_hd__decap_12
XFILLER_222_1373 VPWR VGND VPWR VGND sky130_ef_sc_hd__decap_12
XTAP_TAPCELL_ROW_106_2_4388 VGND VPWR sky130_fd_sc_hd__tapvpwrvgnd_1
XFILLER_181_529 VPWR VGND VPWR VGND sky130_ef_sc_hd__decap_12
XFILLER_174_581 VGND VGND VPWR VPWR sky130_fd_sc_hd__decap_6
XTAP_TAPCELL_ROW_74_2_4199 VGND VPWR sky130_fd_sc_hd__tapvpwrvgnd_1
XFILLER_88_1177 VPWR VGND VPWR VGND sky130_ef_sc_hd__decap_12
XFILLER_218_1409 VPWR VGND VPWR VGND sky130_ef_sc_hd__decap_12
XPHY_EDGE_ROW_199_Right_44 VGND VGND VPWR VPWR sky130_fd_sc_hd__decap_3
XFILLER_175_1169 VGND VGND VPWR VPWR sky130_fd_sc_hd__decap_6
XFILLER_1_948 VGND VGND VPWR VPWR sky130_fd_sc_hd__decap_4
XFILLER_153_1423 VPWR VGND VPWR VGND sky130_ef_sc_hd__decap_12
XTAP_TAPCELL_ROW_167_1402 VGND VPWR sky130_fd_sc_hd__tapvpwrvgnd_1
XFILLER_192_1483 VGND VGND VPWR VPWR sky130_fd_sc_hd__fill_1
XFILLER_62_1339 VPWR VGND VPWR VGND sky130_ef_sc_hd__decap_12
XFILLER_114_1407 VGND VGND VPWR VPWR sky130_fd_sc_hd__decap_6
XFILLER_251_1057 VGND VGND VPWR VPWR sky130_fd_sc_hd__decap_6
XFILLER_0_469 VGND VGND VPWR VPWR sky130_fd_sc_hd__fill_1
XFILLER_153_1467 VPWR VGND VPWR VGND sky130_ef_sc_hd__decap_12
XFILLER_248_357 VGND VGND VPWR VPWR sky130_fd_sc_hd__decap_6
XTAP_TAPCELL_ROW_39_2_3991 VGND VPWR sky130_fd_sc_hd__tapvpwrvgnd_1
XFILLER_5_1233 VPWR VGND VPWR VGND sky130_ef_sc_hd__decap_12
X_660_ clknet_3_5__leaf_clk acc_core.adder.cla_blocks\[6\].block.sum\[2\] _068_ VGND
+ VGND VPWR VPWR net61 sky130_fd_sc_hd__dfrtp_1
XFILLER_216_221 VPWR VGND VPWR VGND sky130_ef_sc_hd__decap_12
XFILLER_1_1119 VGND VGND VPWR VPWR sky130_fd_sc_hd__fill_1
XFILLER_99_1273 VGND VGND VPWR VPWR sky130_fd_sc_hd__fill_1
XFILLER_229_1505 VGND VGND VPWR VPWR sky130_fd_sc_hd__decap_6
X_591_ net670 VGND VGND VPWR VPWR _073_ sky130_fd_sc_hd__inv_2
XFILLER_217_777 VGND VGND VPWR VPWR sky130_fd_sc_hd__decap_6
XFILLER_216_265 VPWR VGND VPWR VGND sky130_ef_sc_hd__decap_12
XFILLER_232_725 VPWR VGND VPWR VGND sky130_ef_sc_hd__decap_12
XFILLER_250_3 VPWR VGND VPWR VGND sky130_ef_sc_hd__decap_12
XFILLER_189_629 VPWR VGND VPWR VGND sky130_ef_sc_hd__decap_12
XFILLER_182_1129 VPWR VGND VPWR VGND sky130_ef_sc_hd__decap_12
XPHY_EDGE_ROW_21_1_Right_677 VGND VGND VPWR VPWR sky130_fd_sc_hd__decap_3
XTAP_TAPCELL_ROW_32_2_3945 VGND VPWR sky130_fd_sc_hd__tapvpwrvgnd_1
XFILLER_232_769 VPWR VGND VPWR VGND sky130_ef_sc_hd__decap_12
XFILLER_188_139 VGND VGND VPWR VPWR sky130_fd_sc_hd__fill_1
XFILLER_73_1435 VGND VGND VPWR VPWR sky130_fd_sc_hd__decap_6
XFILLER_231_279 VGND VGND VPWR VPWR sky130_fd_sc_hd__fill_1
XFILLER_197_673 VPWR VGND VPWR VGND sky130_ef_sc_hd__decap_12
XFILLER_73_1479 VPWR VGND VPWR VGND sky130_ef_sc_hd__decap_12
XFILLER_160_1427 VPWR VGND VPWR VGND sky130_ef_sc_hd__decap_12
XFILLER_184_301 VGND VGND VPWR VPWR sky130_fd_sc_hd__decap_6
XFILLER_201_1413 VPWR VGND VPWR VGND sky130_ef_sc_hd__decap_12
XFILLER_184_345 VPWR VGND VPWR VGND sky130_ef_sc_hd__decap_12
XTAP_TAPCELL_ROW_232_3141 VGND VPWR sky130_fd_sc_hd__tapvpwrvgnd_1
XTAP_TAPCELL_ROW_232_3152 VGND VPWR sky130_fd_sc_hd__tapvpwrvgnd_1
XFILLER_200_699 VGND VGND VPWR VPWR sky130_fd_sc_hd__fill_1
XFILLER_32_1165 VPWR VGND VPWR VGND sky130_ef_sc_hd__decap_12
XFILLER_184_389 VPWR VGND VPWR VGND sky130_ef_sc_hd__decap_12
XFILLER_201_1457 VPWR VGND VPWR VGND sky130_ef_sc_hd__decap_12
XFILLER_158_1301 VGND VGND VPWR VPWR sky130_fd_sc_hd__fill_1
XFILLER_67_1217 VGND VGND VPWR VPWR sky130_fd_sc_hd__fill_1
XFILLER_236_1509 VGND VGND VPWR VPWR sky130_fd_sc_hd__decap_6
XFILLER_193_1225 VGND VGND VPWR VPWR sky130_fd_sc_hd__decap_6
XFILLER_10_1463 VGND VGND VPWR VPWR sky130_fd_sc_hd__decap_6
XFILLER_3_241 VGND VGND VPWR VPWR sky130_fd_sc_hd__decap_6
XFILLER_119_1329 VGND VGND VPWR VPWR sky130_fd_sc_hd__fill_1
XTAP_TAPCELL_ROW_245_3502 VGND VPWR sky130_fd_sc_hd__tapvpwrvgnd_1
XFILLER_193_1269 VPWR VGND VPWR VGND sky130_ef_sc_hd__decap_12
XTAP_TAPCELL_ROW_245_3513 VGND VPWR sky130_fd_sc_hd__tapvpwrvgnd_1
XFILLER_239_335 VGND VGND VPWR VPWR sky130_fd_sc_hd__fill_1
XFILLER_80_1439 VPWR VGND VPWR VGND sky130_ef_sc_hd__decap_12
XFILLER_132_1507 VGND VGND VPWR VPWR sky130_fd_sc_hd__decap_8
XPHY_EDGE_ROW_203_Right_48 VGND VGND VPWR VPWR sky130_fd_sc_hd__decap_3
XFILLER_0_981 VPWR VGND VPWR VGND sky130_ef_sc_hd__decap_12
XTAP_TAPCELL_ROW_7_1047 VGND VPWR sky130_fd_sc_hd__tapvpwrvgnd_1
XFILLER_187_1007 VGND VGND VPWR VPWR sky130_fd_sc_hd__fill_1
XTAP_TAPCELL_ROW_7_1058 VGND VPWR sky130_fd_sc_hd__tapvpwrvgnd_1
XTAP_TAPCELL_ROW_98_2_4340 VGND VPWR sky130_fd_sc_hd__tapvpwrvgnd_1
XFILLER_212_15 VPWR VGND VPWR VGND sky130_ef_sc_hd__decap_12
XFILLER_208_755 VGND VGND VPWR VPWR sky130_fd_sc_hd__fill_1
XFILLER_235_541 VPWR VGND VPWR VGND sky130_ef_sc_hd__decap_12
XFILLER_78_1357 VGND VGND VPWR VPWR sky130_fd_sc_hd__fill_1
XTAP_TAPCELL_ROW_239_3328 VGND VPWR sky130_fd_sc_hd__tapvpwrvgnd_1
XFILLER_235_585 VPWR VGND VPWR VGND sky130_ef_sc_hd__decap_12
XTAP_TAPCELL_ROW_239_3339 VGND VPWR sky130_fd_sc_hd__tapvpwrvgnd_1
XFILLER_228_1037 VPWR VGND VPWR VGND sky130_ef_sc_hd__decap_12
XFILLER_250_533 VPWR VGND VPWR VGND sky130_ef_sc_hd__decap_12
XFILLER_211_909 VPWR VGND VPWR VGND sky130_ef_sc_hd__decap_12
XFILLER_204_961 VPWR VGND VPWR VGND sky130_ef_sc_hd__decap_12
XFILLER_96_3 VPWR VGND VPWR VGND sky130_ef_sc_hd__decap_12
XFILLER_210_419 VGND VGND VPWR VPWR sky130_fd_sc_hd__fill_1
XFILLER_176_813 VPWR VGND VPWR VGND sky130_ef_sc_hd__decap_12
XFILLER_194_109 VPWR VGND VPWR VGND sky130_ef_sc_hd__decap_12
XPHY_EDGE_ROW_212_Right_57 VGND VGND VPWR VPWR sky130_fd_sc_hd__decap_3
XFILLER_187_161 VGND VGND VPWR VPWR sky130_fd_sc_hd__decap_6
XFILLER_198_1147 VGND VGND VPWR VPWR sky130_fd_sc_hd__fill_1
XFILLER_15_1385 VGND VGND VPWR VPWR sky130_fd_sc_hd__fill_1
Xmax_cap200 _188_ VGND VGND VPWR VPWR net200 sky130_fd_sc_hd__clkbuf_1
Xmax_cap211 _172_ VGND VGND VPWR VPWR net211 sky130_fd_sc_hd__clkbuf_1
XFILLER_239_1133 VPWR VGND VPWR VGND sky130_ef_sc_hd__decap_12
XTAP_TAPCELL_ROW_215_2682 VGND VPWR sky130_fd_sc_hd__tapvpwrvgnd_1
XTAP_TAPCELL_ROW_215_2693 VGND VPWR sky130_fd_sc_hd__tapvpwrvgnd_1
Xmax_cap244 net245 VGND VGND VPWR VPWR net244 sky130_fd_sc_hd__clkbuf_1
XFILLER_89_1497 VGND VGND VPWR VPWR sky130_fd_sc_hd__fill_1
XFILLER_239_1177 VPWR VGND VPWR VGND sky130_ef_sc_hd__decap_12
XFILLER_171_573 VPWR VGND VPWR VGND sky130_ef_sc_hd__decap_12
XFILLER_172_1309 VGND VGND VPWR VPWR sky130_fd_sc_hd__decap_6
XTAP_TAPCELL_ROW_211_2579 VGND VPWR sky130_fd_sc_hd__tapvpwrvgnd_1
XPHY_EDGE_ROW_122_2_Right_213 VGND VGND VPWR VPWR sky130_fd_sc_hd__decap_3
XFILLER_106_27 VGND VGND VPWR VPWR sky130_fd_sc_hd__fill_1
XPHY_EDGE_ROW_221_Right_66 VGND VGND VPWR VPWR sky130_fd_sc_hd__decap_3
XFILLER_253_55 VGND VGND VPWR VPWR sky130_fd_sc_hd__fill_1
XFILLER_22_1301 VGND VGND VPWR VPWR sky130_fd_sc_hd__fill_1
XFILLER_245_305 VPWR VGND VPWR VGND sky130_ef_sc_hd__decap_12
XTAP_TAPCELL_ROW_224_2929 VGND VPWR sky130_fd_sc_hd__tapvpwrvgnd_1
XFILLER_245_349 VPWR VGND VPWR VGND sky130_ef_sc_hd__decap_12
XFILLER_122_15 VPWR VGND VPWR VGND sky130_ef_sc_hd__decap_12
XTAP_TAPCELL_ROW_69_1_1204 VGND VPWR sky130_fd_sc_hd__tapvpwrvgnd_1
XFILLER_211_1063 VGND VGND VPWR VPWR sky130_fd_sc_hd__fill_1
XFILLER_96_1413 VGND VGND VPWR VPWR sky130_fd_sc_hd__fill_1
XFILLER_254_861 VGND VGND VPWR VPWR sky130_fd_sc_hd__decap_6
XFILLER_214_725 VPWR VGND VPWR VGND sky130_ef_sc_hd__decap_12
XFILLER_253_393 VPWR VGND VPWR VGND sky130_ef_sc_hd__decap_12
XTAP_TAPCELL_ROW_17_2_3858 VGND VPWR sky130_fd_sc_hd__tapvpwrvgnd_1
XFILLER_183_1449 VGND VGND VPWR VPWR sky130_fd_sc_hd__decap_6
XFILLER_214_769 VPWR VGND VPWR VGND sky130_ef_sc_hd__decap_12
XPHY_EDGE_ROW_230_Right_75 VGND VGND VPWR VPWR sky130_fd_sc_hd__decap_3
XFILLER_213_279 VGND VGND VPWR VPWR sky130_fd_sc_hd__fill_1
XFILLER_15_68 VGND VGND VPWR VPWR sky130_fd_sc_hd__decap_3
XFILLER_146_1271 VPWR VGND VPWR VGND sky130_ef_sc_hd__decap_12
XFILLER_55_1165 VPWR VGND VPWR VGND sky130_ef_sc_hd__decap_12
XFILLER_179_673 VPWR VGND VPWR VGND sky130_ef_sc_hd__decap_12
XFILLER_166_301 VGND VGND VPWR VPWR sky130_fd_sc_hd__decap_6
XFILLER_107_1255 VPWR VGND VPWR VGND sky130_ef_sc_hd__decap_12
XTAP_TAPCELL_ROW_50_1_1185 VGND VPWR sky130_fd_sc_hd__tapvpwrvgnd_1
XFILLER_194_643 VGND VGND VPWR VPWR sky130_fd_sc_hd__fill_1
XFILLER_33_1441 VGND VGND VPWR VPWR sky130_fd_sc_hd__fill_1
XFILLER_166_345 VPWR VGND VPWR VGND sky130_ef_sc_hd__decap_12
XFILLER_182_805 VGND VGND VPWR VPWR sky130_fd_sc_hd__decap_6
XFILLER_107_1299 VPWR VGND VPWR VGND sky130_ef_sc_hd__decap_12
XFILLER_166_389 VPWR VGND VPWR VGND sky130_ef_sc_hd__decap_12
XFILLER_182_849 VPWR VGND VPWR VGND sky130_ef_sc_hd__decap_12
XFILLER_181_337 VPWR VGND VPWR VGND sky130_ef_sc_hd__decap_12
XTAP_TAPCELL_ROW_136_2_4572 VGND VPWR sky130_fd_sc_hd__tapvpwrvgnd_1
XFILLER_218_1217 VPWR VGND VPWR VGND sky130_ef_sc_hd__decap_12
XFILLER_253_1119 VGND VGND VPWR VPWR sky130_fd_sc_hd__fill_1
XFILLER_190_893 VPWR VGND VPWR VGND sky130_ef_sc_hd__decap_12
XFILLER_190_1409 VPWR VGND VPWR VGND sky130_ef_sc_hd__decap_12
XFILLER_27_1201 VPWR VGND VPWR VGND sky130_ef_sc_hd__decap_12
Xoutput45 net45 VGND VGND VPWR VPWR acc_out[11] sky130_fd_sc_hd__buf_2
Xoutput56 net56 VGND VGND VPWR VPWR acc_out[21] sky130_fd_sc_hd__buf_2
Xoutput67 net67 VGND VGND VPWR VPWR acc_out[31] sky130_fd_sc_hd__buf_2
XFILLER_66_1283 VPWR VGND VPWR VGND sky130_ef_sc_hd__decap_12
XFILLER_118_1351 VGND VGND VPWR VPWR sky130_fd_sc_hd__decap_6
XFILLER_153_1231 VPWR VGND VPWR VGND sky130_ef_sc_hd__decap_12
XFILLER_248_121 VPWR VGND VPWR VGND sky130_ef_sc_hd__decap_12
XFILLER_163_55 VGND VGND VPWR VPWR sky130_fd_sc_hd__fill_1
XFILLER_27_1267 VGND VGND VPWR VPWR sky130_fd_sc_hd__decap_6
XFILLER_114_1215 VPWR VGND VPWR VGND sky130_ef_sc_hd__decap_12
XFILLER_0_277 VGND VGND VPWR VPWR sky130_fd_sc_hd__decap_3
XFILLER_118_1395 VPWR VGND VPWR VGND sky130_ef_sc_hd__decap_12
XFILLER_153_1275 VPWR VGND VPWR VGND sky130_ef_sc_hd__decap_12
XFILLER_248_165 VPWR VGND VPWR VGND sky130_ef_sc_hd__decap_12
XFILLER_0_299 VGND VGND VPWR VPWR sky130_fd_sc_hd__decap_8
XFILLER_237_839 VGND VGND VPWR VPWR sky130_fd_sc_hd__fill_1
XFILLER_114_1259 VPWR VGND VPWR VGND sky130_ef_sc_hd__decap_12
XTAP_TAPCELL_ROW_186_1899 VGND VPWR sky130_fd_sc_hd__tapvpwrvgnd_1
XFILLER_56_53 VPWR VGND VPWR VGND sky130_ef_sc_hd__decap_12
XFILLER_5_1063 VGND VGND VPWR VPWR sky130_fd_sc_hd__fill_1
X_643_ clknet_3_0__leaf_clk acc_core.adder.cla_blocks\[2\].block.sum\[1\] _051_ VGND
+ VGND VPWR VPWR net74 sky130_fd_sc_hd__dfrtp_1
XFILLER_217_541 VPWR VGND VPWR VGND sky130_ef_sc_hd__decap_12
XFILLER_229_1313 VPWR VGND VPWR VGND sky130_ef_sc_hd__decap_12
XFILLER_217_585 VPWR VGND VPWR VGND sky130_ef_sc_hd__decap_12
X_574_ net666 VGND VGND VPWR VPWR _056_ sky130_fd_sc_hd__inv_2
XFILLER_186_1073 VPWR VGND VPWR VGND sky130_ef_sc_hd__decap_12
XFILLER_229_1357 VPWR VGND VPWR VGND sky130_ef_sc_hd__decap_12
XFILLER_232_533 VPWR VGND VPWR VGND sky130_ef_sc_hd__decap_12
XFILLER_72_41 VPWR VGND VPWR VGND sky130_ef_sc_hd__decap_12
XPHY_EDGE_ROW_22_1_Right_678 VGND VGND VPWR VPWR sky130_fd_sc_hd__decap_3
XTAP_TAPCELL_ROW_234_3203 VGND VPWR sky130_fd_sc_hd__tapvpwrvgnd_1
XFILLER_73_1243 VPWR VGND VPWR VGND sky130_ef_sc_hd__decap_12
XFILLER_125_1311 VPWR VGND VPWR VGND sky130_ef_sc_hd__decap_12
XFILLER_188_41 VPWR VGND VPWR VGND sky130_ef_sc_hd__decap_12
XTAP_TAPCELL_ROW_234_3214 VGND VPWR sky130_fd_sc_hd__tapvpwrvgnd_1
XFILLER_129_1491 VGND VGND VPWR VPWR sky130_fd_sc_hd__decap_6
XFILLER_164_1371 VPWR VGND VPWR VGND sky130_ef_sc_hd__decap_12
XFILLER_176_109 VPWR VGND VPWR VGND sky130_ef_sc_hd__decap_12
XFILLER_198_993 VPWR VGND VPWR VGND sky130_ef_sc_hd__decap_12
XFILLER_34_1227 VPWR VGND VPWR VGND sky130_ef_sc_hd__decap_12
XFILLER_169_161 VGND VGND VPWR VPWR sky130_fd_sc_hd__decap_6
XFILLER_199_1401 VPWR VGND VPWR VGND sky130_ef_sc_hd__decap_12
XFILLER_201_953 VPWR VGND VPWR VGND sky130_ef_sc_hd__decap_12
XFILLER_73_1287 VPWR VGND VPWR VGND sky130_ef_sc_hd__decap_12
XFILLER_125_1355 VPWR VGND VPWR VGND sky130_ef_sc_hd__decap_12
XFILLER_188_85 VPWR VGND VPWR VGND sky130_ef_sc_hd__decap_12
XFILLER_121_1219 VPWR VGND VPWR VGND sky130_ef_sc_hd__decap_12
XFILLER_185_665 VGND VGND VPWR VPWR sky130_fd_sc_hd__decap_6
XFILLER_125_1399 VPWR VGND VPWR VGND sky130_ef_sc_hd__decap_12
XFILLER_184_153 VPWR VGND VPWR VGND sky130_ef_sc_hd__decap_12
XFILLER_8_377 VGND VGND VPWR VPWR sky130_fd_sc_hd__fill_2
XFILLER_184_197 VPWR VGND VPWR VGND sky130_ef_sc_hd__decap_12
XFILLER_201_1287 VGND VGND VPWR VPWR sky130_fd_sc_hd__fill_1
XFILLER_236_1317 VPWR VGND VPWR VGND sky130_ef_sc_hd__decap_12
XFILLER_193_1033 VPWR VGND VPWR VGND sky130_ef_sc_hd__decap_12
XFILLER_207_15 VPWR VGND VPWR VGND sky130_ef_sc_hd__decap_12
XFILLER_10_1271 VPWR VGND VPWR VGND sky130_ef_sc_hd__decap_12
XTAP_TAPCELL_ROW_228_3029 VGND VPWR sky130_fd_sc_hd__tapvpwrvgnd_1
XFILLER_193_1077 VPWR VGND VPWR VGND sky130_ef_sc_hd__decap_12
XFILLER_80_1203 VPWR VGND VPWR VGND sky130_ef_sc_hd__decap_12
XFILLER_45_1323 VGND VGND VPWR VPWR sky130_fd_sc_hd__decap_6
XFILLER_84_1383 VPWR VGND VPWR VGND sky130_ef_sc_hd__decap_12
XFILLER_136_1451 VPWR VGND VPWR VGND sky130_ef_sc_hd__decap_12
XTAP_TAPCELL_ROW_9_1109 VGND VPWR sky130_fd_sc_hd__tapvpwrvgnd_1
XFILLER_45_1367 VPWR VGND VPWR VGND sky130_ef_sc_hd__decap_12
XFILLER_80_1247 VPWR VGND VPWR VGND sky130_ef_sc_hd__decap_12
XFILLER_132_1315 VPWR VGND VPWR VGND sky130_ef_sc_hd__decap_12
XFILLER_234_1085 VGND VGND VPWR VPWR sky130_fd_sc_hd__decap_6
XFILLER_136_1495 VPWR VGND VPWR VGND sky130_ef_sc_hd__decap_12
XFILLER_227_305 VPWR VGND VPWR VGND sky130_ef_sc_hd__decap_12
XFILLER_132_1359 VPWR VGND VPWR VGND sky130_ef_sc_hd__decap_12
XFILLER_11_3 VPWR VGND VPWR VGND sky130_ef_sc_hd__decap_12
XFILLER_223_69 VPWR VGND VPWR VGND sky130_ef_sc_hd__decap_12
XFILLER_227_349 VPWR VGND VPWR VGND sky130_ef_sc_hd__decap_12
XFILLER_255_669 VGND VGND VPWR VPWR sky130_fd_sc_hd__decap_3
XFILLER_243_809 VPWR VGND VPWR VGND sky130_ef_sc_hd__decap_12
XFILLER_236_861 VGND VGND VPWR VPWR sky130_fd_sc_hd__decap_6
XFILLER_247_1413 VPWR VGND VPWR VGND sky130_ef_sc_hd__decap_12
XFILLER_78_1165 VPWR VGND VPWR VGND sky130_ef_sc_hd__decap_12
XFILLER_247_1457 VPWR VGND VPWR VGND sky130_ef_sc_hd__decap_12
XFILLER_235_393 VPWR VGND VPWR VGND sky130_ef_sc_hd__decap_12
XTAP_TAPCELL_ROW_204_2383 VGND VPWR sky130_fd_sc_hd__tapvpwrvgnd_1
XTAP_TAPCELL_ROW_204_2394 VGND VPWR sky130_fd_sc_hd__tapvpwrvgnd_1
XFILLER_251_853 VPWR VGND VPWR VGND sky130_ef_sc_hd__decap_12
XFILLER_251_897 VPWR VGND VPWR VGND sky130_ef_sc_hd__decap_12
XFILLER_250_363 VGND VGND VPWR VPWR sky130_fd_sc_hd__fill_1
XFILLER_241_1001 VGND VGND VPWR VPWR sky130_fd_sc_hd__decap_6
XFILLER_56_1463 VGND VGND VPWR VPWR sky130_fd_sc_hd__decap_6
XFILLER_91_1343 VPWR VGND VPWR VGND sky130_ef_sc_hd__decap_12
XFILLER_143_1411 VPWR VGND VPWR VGND sky130_ef_sc_hd__decap_12
XTAP_TAPCELL_ROW_196_2173 VGND VPWR sky130_fd_sc_hd__tapvpwrvgnd_1
XFILLER_195_429 VPWR VGND VPWR VGND sky130_ef_sc_hd__decap_12
XTAP_TAPCELL_ROW_196_2184 VGND VPWR sky130_fd_sc_hd__tapvpwrvgnd_1
XFILLER_52_1327 VPWR VGND VPWR VGND sky130_ef_sc_hd__decap_12
XFILLER_241_1045 VPWR VGND VPWR VGND sky130_ef_sc_hd__decap_12
XFILLER_91_1387 VPWR VGND VPWR VGND sky130_ef_sc_hd__decap_12
XFILLER_143_1455 VPWR VGND VPWR VGND sky130_ef_sc_hd__decap_12
XFILLER_176_643 VGND VGND VPWR VPWR sky130_fd_sc_hd__fill_1
XTAP_TAPCELL_ROW_192_2059 VGND VPWR sky130_fd_sc_hd__tapvpwrvgnd_1
XTAP_TAPCELL_ROW_217_2733 VGND VPWR sky130_fd_sc_hd__tapvpwrvgnd_1
XTAP_TAPCELL_ROW_217_2744 VGND VPWR sky130_fd_sc_hd__tapvpwrvgnd_1
XFILLER_104_1439 VPWR VGND VPWR VGND sky130_ef_sc_hd__decap_12
XFILLER_202_1029 VGND VGND VPWR VPWR sky130_fd_sc_hd__decap_6
XTAP_TAPCELL_ROW_217_2755 VGND VPWR sky130_fd_sc_hd__tapvpwrvgnd_1
XFILLER_241_1089 VPWR VGND VPWR VGND sky130_ef_sc_hd__decap_12
XFILLER_143_1499 VPWR VGND VPWR VGND sky130_ef_sc_hd__decap_12
XFILLER_248_77 VGND VGND VPWR VPWR sky130_fd_sc_hd__decap_6
XFILLER_117_15 VPWR VGND VPWR VGND sky130_ef_sc_hd__decap_12
XFILLER_176_1253 VGND VGND VPWR VPWR sky130_fd_sc_hd__decap_6
XFILLER_172_893 VPWR VGND VPWR VGND sky130_ef_sc_hd__decap_12
XFILLER_190_189 VGND VGND VPWR VPWR sky130_fd_sc_hd__decap_6
XPHY_EDGE_ROW_35_1_Left_290 VGND VGND VPWR VPWR sky130_fd_sc_hd__decap_3
XFILLER_172_1117 VPWR VGND VPWR VGND sky130_ef_sc_hd__decap_12
XFILLER_176_1297 VPWR VGND VPWR VGND sky130_ef_sc_hd__decap_12
XFILLER_63_1423 VPWR VGND VPWR VGND sky130_ef_sc_hd__decap_12
XFILLER_252_1141 VGND VGND VPWR VPWR sky130_fd_sc_hd__decap_6
XPHY_EDGE_ROW_123_2_Right_214 VGND VGND VPWR VPWR sky130_fd_sc_hd__decap_3
XFILLER_24_1407 VGND VGND VPWR VPWR sky130_fd_sc_hd__decap_6
XFILLER_63_1467 VPWR VGND VPWR VGND sky130_ef_sc_hd__decap_12
XFILLER_150_1415 VPWR VGND VPWR VGND sky130_ef_sc_hd__decap_12
XFILLER_252_1185 VPWR VGND VPWR VGND sky130_ef_sc_hd__decap_12
XTAP_TAPCELL_ROW_114_2_4439 VGND VPWR sky130_fd_sc_hd__tapvpwrvgnd_1
XPHY_EDGE_ROW_209_Left_464 VGND VGND VPWR VPWR sky130_fd_sc_hd__decap_3
XFILLER_219_839 VGND VGND VPWR VPWR sky130_fd_sc_hd__fill_1
XFILLER_246_625 VPWR VGND VPWR VGND sky130_ef_sc_hd__decap_12
XFILLER_245_113 VPWR VGND VPWR VGND sky130_ef_sc_hd__decap_12
XFILLER_213_1169 VGND VGND VPWR VPWR sky130_fd_sc_hd__decap_6
XFILLER_133_69 VGND VGND VPWR VPWR sky130_fd_sc_hd__fill_2
XFILLER_2_1203 VGND VGND VPWR VPWR sky130_fd_sc_hd__fill_1
XFILLER_246_669 VPWR VGND VPWR VGND sky130_ef_sc_hd__decap_12
XFILLER_230_1483 VGND VGND VPWR VPWR sky130_fd_sc_hd__fill_1
XTAP_TAPCELL_ROW_181_1763 VGND VPWR sky130_fd_sc_hd__tapvpwrvgnd_1
XTAP_TAPCELL_ROW_181_1774 VGND VPWR sky130_fd_sc_hd__tapvpwrvgnd_1
XPHY_EDGE_ROW_54_1_Left_309 VGND VGND VPWR VPWR sky130_fd_sc_hd__decap_3
XTAP_TAPCELL_ROW_181_1785 VGND VPWR sky130_fd_sc_hd__tapvpwrvgnd_1
XFILLER_183_1213 VPWR VGND VPWR VGND sky130_ef_sc_hd__decap_12
XFILLER_214_533 VPWR VGND VPWR VGND sky130_ef_sc_hd__decap_12
XFILLER_187_1393 VGND VGND VPWR VPWR sky130_fd_sc_hd__decap_6
XTAP_TAPCELL_ROW_62_2_4126 VGND VPWR sky130_fd_sc_hd__tapvpwrvgnd_1
XFILLER_183_1257 VPWR VGND VPWR VGND sky130_ef_sc_hd__decap_12
XFILLER_198_245 VGND VGND VPWR VPWR sky130_fd_sc_hd__decap_6
XFILLER_201_205 VPWR VGND VPWR VGND sky130_ef_sc_hd__decap_12
XFILLER_241_385 VGND VGND VPWR VPWR sky130_fd_sc_hd__decap_6
X_290_ net608 net181 rd_addr\[6\] VGND VGND VPWR VPWR _086_ sky130_fd_sc_hd__a21o_1
XFILLER_161_1511 VGND VGND VPWR VPWR sky130_fd_sc_hd__decap_4
XFILLER_198_289 VPWR VGND VPWR VGND sky130_ef_sc_hd__decap_12
XPHY_EDGE_ROW_218_Left_473 VGND VGND VPWR VPWR sky130_fd_sc_hd__decap_3
XFILLER_70_1427 VPWR VGND VPWR VGND sky130_ef_sc_hd__decap_12
XFILLER_201_249 VPWR VGND VPWR VGND sky130_ef_sc_hd__decap_12
XFILLER_167_665 VGND VGND VPWR VPWR sky130_fd_sc_hd__decap_6
XFILLER_220_1129 VPWR VGND VPWR VGND sky130_ef_sc_hd__decap_12
XFILLER_166_153 VPWR VGND VPWR VGND sky130_ef_sc_hd__decap_12
XPHY_EDGE_ROW_97_2_Left_599 VGND VGND VPWR VPWR sky130_fd_sc_hd__decap_3
XFILLER_182_613 VPWR VGND VPWR VGND sky130_ef_sc_hd__decap_12
XFILLER_213_3 VPWR VGND VPWR VGND sky130_ef_sc_hd__decap_12
XFILLER_68_1301 VGND VGND VPWR VPWR sky130_fd_sc_hd__fill_1
XFILLER_166_197 VPWR VGND VPWR VGND sky130_ef_sc_hd__decap_12
XFILLER_182_657 VPWR VGND VPWR VGND sky130_ef_sc_hd__decap_12
XFILLER_181_167 VGND VGND VPWR VPWR sky130_fd_sc_hd__fill_1
XFILLER_194_1353 VPWR VGND VPWR VGND sky130_ef_sc_hd__decap_12
XFILLER_29_1329 VGND VGND VPWR VPWR sky130_fd_sc_hd__fill_1
XFILLER_174_65 VPWR VGND VPWR VGND sky130_ef_sc_hd__decap_12
XFILLER_190_1217 VPWR VGND VPWR VGND sky130_ef_sc_hd__decap_12
XFILLER_194_1397 VPWR VGND VPWR VGND sky130_ef_sc_hd__decap_12
XFILLER_3_27 VPWR VGND VPWR VGND sky130_ef_sc_hd__decap_12
XPHY_EDGE_ROW_227_Left_482 VGND VGND VPWR VPWR sky130_fd_sc_hd__decap_3
XFILLER_249_441 VGND VGND VPWR VPWR sky130_fd_sc_hd__decap_6
XFILLER_42_1507 VGND VGND VPWR VPWR sky130_fd_sc_hd__decap_8
XFILLER_231_1225 VGND VGND VPWR VPWR sky130_fd_sc_hd__decap_6
XFILLER_209_305 VPWR VGND VPWR VGND sky130_ef_sc_hd__decap_12
XFILLER_249_485 VPWR VGND VPWR VGND sky130_ef_sc_hd__decap_12
XFILLER_7_1169 VGND VGND VPWR VPWR sky130_fd_sc_hd__decap_6
XFILLER_190_53 VPWR VGND VPWR VGND sky130_ef_sc_hd__decap_12
XFILLER_231_1269 VPWR VGND VPWR VGND sky130_ef_sc_hd__decap_12
XFILLER_209_349 VPWR VGND VPWR VGND sky130_ef_sc_hd__decap_12
XFILLER_225_809 VPWR VGND VPWR VGND sky130_ef_sc_hd__decap_12
XFILLER_190_97 VPWR VGND VPWR VGND sky130_ef_sc_hd__decap_12
XFILLER_218_861 VGND VGND VPWR VPWR sky130_fd_sc_hd__decap_6
XFILLER_79_1441 VGND VGND VPWR VPWR sky130_fd_sc_hd__fill_1
XFILLER_251_105 VGND VGND VPWR VPWR sky130_fd_sc_hd__decap_6
XTAP_TAPCELL_ROW_158_2_4704 VGND VPWR sky130_fd_sc_hd__tapvpwrvgnd_1
XFILLER_229_1121 VPWR VGND VPWR VGND sky130_ef_sc_hd__decap_12
X_626_ clknet_3_5__leaf_clk dout0\[24\] _034_ VGND VGND VPWR VPWR dout0_q\[24\] sky130_fd_sc_hd__dfrtp_1
XFILLER_83_51 VGND VGND VPWR VPWR sky130_fd_sc_hd__decap_4
XFILLER_217_393 VPWR VGND VPWR VGND sky130_ef_sc_hd__decap_12
XFILLER_251_149 VPWR VGND VPWR VGND sky130_ef_sc_hd__decap_12
XFILLER_233_853 VPWR VGND VPWR VGND sky130_ef_sc_hd__decap_12
XFILLER_189_223 VGND VGND VPWR VPWR sky130_fd_sc_hd__fill_1
XFILLER_199_51 VGND VGND VPWR VPWR sky130_fd_sc_hd__decap_4
XFILLER_225_1007 VGND VGND VPWR VPWR sky130_fd_sc_hd__fill_1
X_557_ net670 VGND VGND VPWR VPWR _039_ sky130_fd_sc_hd__inv_2
XFILLER_166_1477 VGND VGND VPWR VPWR sky130_fd_sc_hd__decap_6
XFILLER_232_363 VGND VGND VPWR VPWR sky130_fd_sc_hd__fill_1
XPHY_EDGE_ROW_236_Left_491 VGND VGND VPWR VPWR sky130_fd_sc_hd__decap_3
XFILLER_233_897 VPWR VGND VPWR VGND sky130_ef_sc_hd__decap_12
XFILLER_220_525 VGND VGND VPWR VPWR sky130_fd_sc_hd__decap_6
XFILLER_177_429 VPWR VGND VPWR VGND sky130_ef_sc_hd__decap_12
XPHY_EDGE_ROW_23_1_Right_679 VGND VGND VPWR VPWR sky130_fd_sc_hd__decap_3
X_488_ net172 _250_ VGND VGND VPWR VPWR acc_core.adder.cla_blocks\[4\].block.sum\[3\]
+ sky130_fd_sc_hd__xnor2_1
XFILLER_220_569 VPWR VGND VPWR VGND sky130_ef_sc_hd__decap_12
XFILLER_242_1365 VGND VGND VPWR VPWR sky130_fd_sc_hd__decap_6
XFILLER_199_1231 VGND VGND VPWR VPWR sky130_fd_sc_hd__fill_1
XFILLER_201_783 VGND VGND VPWR VPWR sky130_fd_sc_hd__fill_1
XFILLER_8_141 VPWR VGND VPWR VGND sky130_ef_sc_hd__decap_12
XFILLER_185_473 VPWR VGND VPWR VGND sky130_ef_sc_hd__decap_12
XFILLER_9_697 VGND VGND VPWR VPWR sky130_fd_sc_hd__decap_3
XFILLER_59_3 VPWR VGND VPWR VGND sky130_ef_sc_hd__decap_12
XFILLER_172_189 VGND VGND VPWR VPWR sky130_fd_sc_hd__decap_6
XFILLER_236_1147 VGND VGND VPWR VPWR sky130_fd_sc_hd__fill_1
XFILLER_173_1437 VPWR VGND VPWR VGND sky130_ef_sc_hd__decap_12
XFILLER_84_1191 VPWR VGND VPWR VGND sky130_ef_sc_hd__decap_12
XFILLER_228_625 VPWR VGND VPWR VGND sky130_ef_sc_hd__decap_12
XFILLER_210_1309 VGND VGND VPWR VPWR sky130_fd_sc_hd__decap_6
XFILLER_227_113 VPWR VGND VPWR VGND sky130_ef_sc_hd__decap_12
XFILLER_255_433 VPWR VGND VPWR VGND sky130_ef_sc_hd__decap_12
XTAP_TAPCELL_ROW_206_2434 VGND VPWR sky130_fd_sc_hd__tapvpwrvgnd_1
XTAP_TAPCELL_ROW_206_2445 VGND VPWR sky130_fd_sc_hd__tapvpwrvgnd_1
XFILLER_228_669 VPWR VGND VPWR VGND sky130_ef_sc_hd__decap_12
XTAP_TAPCELL_ROW_206_2456 VGND VPWR sky130_fd_sc_hd__tapvpwrvgnd_1
XFILLER_132_1189 VGND VGND VPWR VPWR sky130_fd_sc_hd__fill_1
XFILLER_255_477 VPWR VGND VPWR VGND sky130_ef_sc_hd__decap_12
XFILLER_243_617 VPWR VGND VPWR VGND sky130_ef_sc_hd__decap_12
XFILLER_103_39 VPWR VGND VPWR VGND sky130_ef_sc_hd__decap_12
XTAP_TAPCELL_ROW_198_2224 VGND VPWR sky130_fd_sc_hd__tapvpwrvgnd_1
XTAP_TAPCELL_ROW_198_2235 VGND VPWR sky130_fd_sc_hd__tapvpwrvgnd_1
XFILLER_208_1205 VPWR VGND VPWR VGND sky130_ef_sc_hd__decap_12
XTAP_TAPCELL_ROW_47_2_4039 VGND VPWR sky130_fd_sc_hd__tapvpwrvgnd_1
XTAP_TAPCELL_ROW_33_2_3950 VGND VPWR sky130_fd_sc_hd__tapvpwrvgnd_1
XFILLER_211_503 VGND VGND VPWR VPWR sky130_fd_sc_hd__fill_1
XFILLER_247_1287 VGND VGND VPWR VPWR sky130_fd_sc_hd__fill_1
XTAP_TAPCELL_ROW_219_2806 VGND VPWR sky130_fd_sc_hd__tapvpwrvgnd_1
XFILLER_223_385 VGND VGND VPWR VPWR sky130_fd_sc_hd__decap_6
XFILLER_196_749 VGND VGND VPWR VPWR sky130_fd_sc_hd__decap_6
XFILLER_56_1271 VPWR VGND VPWR VGND sky130_ef_sc_hd__decap_12
XFILLER_195_237 VPWR VGND VPWR VGND sky130_ef_sc_hd__decap_12
XFILLER_17_1255 VPWR VGND VPWR VGND sky130_ef_sc_hd__decap_12
XFILLER_104_1203 VPWR VGND VPWR VGND sky130_ef_sc_hd__decap_12
XFILLER_108_1383 VPWR VGND VPWR VGND sky130_ef_sc_hd__decap_12
XFILLER_221_1449 VGND VGND VPWR VPWR sky130_fd_sc_hd__decap_6
XFILLER_17_1299 VPWR VGND VPWR VGND sky130_ef_sc_hd__decap_12
XFILLER_104_1247 VPWR VGND VPWR VGND sky130_ef_sc_hd__decap_12
XFILLER_178_1315 VGND VGND VPWR VPWR sky130_fd_sc_hd__fill_1
XFILLER_219_1301 VPWR VGND VPWR VGND sky130_ef_sc_hd__decap_12
XFILLER_254_1203 VGND VGND VPWR VPWR sky130_fd_sc_hd__fill_1
XFILLER_2_306 VGND VGND VPWR VPWR sky130_fd_sc_hd__fill_2
XFILLER_88_29 VPWR VGND VPWR VGND sky130_ef_sc_hd__decap_12
XTAP_TAPCELL_ROW_170_1464 VGND VPWR sky130_fd_sc_hd__tapvpwrvgnd_1
XTAP_TAPCELL_ROW_170_1475 VGND VPWR sky130_fd_sc_hd__tapvpwrvgnd_1
XFILLER_176_1061 VPWR VGND VPWR VGND sky130_ef_sc_hd__decap_12
XFILLER_219_1345 VPWR VGND VPWR VGND sky130_ef_sc_hd__decap_12
XTAP_TAPCELL_ROW_170_1486 VGND VPWR sky130_fd_sc_hd__tapvpwrvgnd_1
XTAP_TAPCELL_ROW_45_1_1180 VGND VPWR sky130_fd_sc_hd__tapvpwrvgnd_1
XTAP_TAPCELL_ROW_164_2_4736 VGND VPWR sky130_fd_sc_hd__tapvpwrvgnd_1
XFILLER_63_1231 VPWR VGND VPWR VGND sky130_ef_sc_hd__decap_12
XFILLER_28_1351 VGND VGND VPWR VPWR sky130_fd_sc_hd__decap_6
XPHY_EDGE_ROW_124_2_Right_215 VGND VGND VPWR VPWR sky130_fd_sc_hd__decap_3
XFILLER_24_1215 VPWR VGND VPWR VGND sky130_ef_sc_hd__decap_12
XFILLER_63_1275 VPWR VGND VPWR VGND sky130_ef_sc_hd__decap_12
XFILLER_28_1395 VPWR VGND VPWR VGND sky130_ef_sc_hd__decap_12
Xfanout665 net671 VGND VGND VPWR VPWR net665 sky130_fd_sc_hd__buf_4
XFILLER_115_1343 VPWR VGND VPWR VGND sky130_ef_sc_hd__decap_12
XTAP_TAPCELL_ROW_183_1814 VGND VPWR sky130_fd_sc_hd__tapvpwrvgnd_1
XTAP_TAPCELL_ROW_183_1825 VGND VPWR sky130_fd_sc_hd__tapvpwrvgnd_1
XFILLER_247_945 VGND VGND VPWR VPWR sky130_fd_sc_hd__decap_6
XFILLER_4_1309 VGND VGND VPWR VPWR sky130_fd_sc_hd__decap_6
XFILLER_150_1245 VGND VGND VPWR VPWR sky130_fd_sc_hd__fill_1
XFILLER_246_433 VPWR VGND VPWR VGND sky130_ef_sc_hd__decap_12
XTAP_TAPCELL_ROW_183_1836 VGND VPWR sky130_fd_sc_hd__tapvpwrvgnd_1
XFILLER_24_1259 VPWR VGND VPWR VGND sky130_ef_sc_hd__decap_12
XFILLER_98_1327 VPWR VGND VPWR VGND sky130_ef_sc_hd__decap_12
XFILLER_115_1387 VPWR VGND VPWR VGND sky130_ef_sc_hd__decap_12
XFILLER_207_809 VPWR VGND VPWR VGND sky130_ef_sc_hd__decap_12
XFILLER_247_989 VPWR VGND VPWR VGND sky130_ef_sc_hd__decap_12
XFILLER_37_55 VGND VGND VPWR VPWR sky130_fd_sc_hd__fill_1
XFILLER_189_1455 VGND VGND VPWR VPWR sky130_fd_sc_hd__fill_1
XFILLER_246_477 VPWR VGND VPWR VGND sky130_ef_sc_hd__decap_12
XFILLER_248_1029 VGND VGND VPWR VPWR sky130_fd_sc_hd__decap_6
XFILLER_233_105 VGND VGND VPWR VPWR sky130_fd_sc_hd__decap_6
XFILLER_163_3 VPWR VGND VPWR VGND sky130_ef_sc_hd__decap_12
XFILLER_215_853 VPWR VGND VPWR VGND sky130_ef_sc_hd__decap_12
XFILLER_233_149 VPWR VGND VPWR VGND sky130_ef_sc_hd__decap_12
X_411_ _175_ net150 net205 VGND VGND VPWR VPWR _200_ sky130_fd_sc_hd__or3b_1
XFILLER_183_1021 VPWR VGND VPWR VGND sky130_ef_sc_hd__decap_12
XFILLER_214_363 VGND VGND VPWR VPWR sky130_fd_sc_hd__fill_1
XFILLER_215_897 VPWR VGND VPWR VGND sky130_ef_sc_hd__decap_12
XFILLER_53_54 VGND VGND VPWR VPWR sky130_fd_sc_hd__fill_2
XFILLER_183_1065 VPWR VGND VPWR VGND sky130_ef_sc_hd__decap_12
XFILLER_187_727 VGND VGND VPWR VPWR sky130_fd_sc_hd__fill_1
XFILLER_202_525 VGND VGND VPWR VPWR sky130_fd_sc_hd__decap_6
X_342_ net594 net570 net539 VGND VGND VPWR VPWR _131_ sky130_fd_sc_hd__a21o_1
XFILLER_35_1311 VPWR VGND VPWR VGND sky130_ef_sc_hd__decap_12
XFILLER_241_193 VPWR VGND VPWR VGND sky130_ef_sc_hd__decap_12
XFILLER_74_1371 VPWR VGND VPWR VGND sky130_ef_sc_hd__decap_12
XFILLER_39_1491 VGND VGND VPWR VPWR sky130_fd_sc_hd__decap_6
XFILLER_230_867 VGND VGND VPWR VPWR sky130_fd_sc_hd__fill_1
XFILLER_202_569 VPWR VGND VPWR VGND sky130_ef_sc_hd__decap_12
XFILLER_35_1355 VPWR VGND VPWR VGND sky130_ef_sc_hd__decap_12
XFILLER_122_1303 VPWR VGND VPWR VGND sky130_ef_sc_hd__decap_12
XFILLER_126_1483 VPWR VGND VPWR VGND sky130_ef_sc_hd__decap_12
XFILLER_224_1073 VPWR VGND VPWR VGND sky130_ef_sc_hd__decap_12
XFILLER_31_1219 VPWR VGND VPWR VGND sky130_ef_sc_hd__decap_12
XFILLER_161_1385 VGND VGND VPWR VPWR sky130_fd_sc_hd__fill_1
XFILLER_167_473 VPWR VGND VPWR VGND sky130_ef_sc_hd__decap_12
XFILLER_35_1399 VPWR VGND VPWR VGND sky130_ef_sc_hd__decap_12
XFILLER_183_933 VPWR VGND VPWR VGND sky130_ef_sc_hd__decap_12
XFILLER_182_421 VPWR VGND VPWR VGND sky130_ef_sc_hd__decap_12
XFILLER_6_645 VGND VGND VPWR VPWR sky130_fd_sc_hd__decap_4
XFILLER_202_1371 VGND VGND VPWR VPWR sky130_fd_sc_hd__fill_1
XFILLER_183_977 VPWR VGND VPWR VGND sky130_ef_sc_hd__decap_12
XFILLER_237_1401 VPWR VGND VPWR VGND sky130_ef_sc_hd__decap_12
XTAP_TAPCELL_ROW_92_1_1227 VGND VPWR sky130_fd_sc_hd__tapvpwrvgnd_1
XFILLER_194_1161 VPWR VGND VPWR VGND sky130_ef_sc_hd__decap_12
XFILLER_2_862 VGND VGND VPWR VPWR sky130_fd_sc_hd__decap_6
XFILLER_46_1451 VPWR VGND VPWR VGND sky130_ef_sc_hd__decap_12
XFILLER_81_1331 VPWR VGND VPWR VGND sky130_ef_sc_hd__decap_12
XFILLER_238_923 VGND VGND VPWR VPWR sky130_fd_sc_hd__fill_1
XFILLER_42_1315 VPWR VGND VPWR VGND sky130_ef_sc_hd__decap_12
XFILLER_46_1495 VPWR VGND VPWR VGND sky130_ef_sc_hd__decap_12
XFILLER_133_1443 VPWR VGND VPWR VGND sky130_ef_sc_hd__decap_12
XFILLER_231_1033 VPWR VGND VPWR VGND sky130_ef_sc_hd__decap_12
XFILLER_204_27 VGND VGND VPWR VPWR sky130_fd_sc_hd__fill_1
XFILLER_209_113 VPWR VGND VPWR VGND sky130_ef_sc_hd__decap_12
XFILLER_249_293 VPWR VGND VPWR VGND sky130_ef_sc_hd__decap_12
XFILLER_42_1359 VPWR VGND VPWR VGND sky130_ef_sc_hd__decap_12
XFILLER_231_1077 VPWR VGND VPWR VGND sky130_ef_sc_hd__decap_12
XFILLER_225_617 VPWR VGND VPWR VGND sky130_ef_sc_hd__decap_12
XTAP_TAPCELL_ROW_18_2_3863 VGND VPWR sky130_fd_sc_hd__tapvpwrvgnd_1
XTAP_TAPCELL_ROW_201_2320 VGND VPWR sky130_fd_sc_hd__tapvpwrvgnd_1
XFILLER_220_15 VPWR VGND VPWR VGND sky130_ef_sc_hd__decap_12
XFILLER_252_469 VGND VGND VPWR VPWR sky130_fd_sc_hd__decap_6
X_609_ clknet_3_1__leaf_clk dout0\[7\] _017_ VGND VGND VPWR VPWR dout0_q\[7\] sky130_fd_sc_hd__dfrtp_1
XFILLER_166_1241 VPWR VGND VPWR VGND sky130_ef_sc_hd__decap_12
XFILLER_244_1427 VGND VGND VPWR VPWR sky130_fd_sc_hd__fill_1
XFILLER_166_1285 VPWR VGND VPWR VGND sky130_ef_sc_hd__decap_12
XFILLER_205_385 VGND VGND VPWR VPWR sky130_fd_sc_hd__decap_6
XFILLER_53_1411 VPWR VGND VPWR VGND sky130_ef_sc_hd__decap_12
XFILLER_178_749 VGND VGND VPWR VPWR sky130_fd_sc_hd__decap_6
XFILLER_220_333 VPWR VGND VPWR VGND sky130_ef_sc_hd__decap_12
XFILLER_92_1471 VPWR VGND VPWR VGND sky130_ef_sc_hd__decap_12
XFILLER_177_237 VPWR VGND VPWR VGND sky130_ef_sc_hd__decap_12
XFILLER_221_889 VGND VGND VPWR VPWR sky130_fd_sc_hd__decap_6
XFILLER_203_1113 VGND VGND VPWR VPWR sky130_fd_sc_hd__decap_6
XFILLER_53_1455 VPWR VGND VPWR VGND sky130_ef_sc_hd__decap_12
XFILLER_220_377 VPWR VGND VPWR VGND sky130_ef_sc_hd__decap_12
XFILLER_242_1173 VPWR VGND VPWR VGND sky130_ef_sc_hd__decap_12
XFILLER_14_1439 VPWR VGND VPWR VGND sky130_ef_sc_hd__decap_12
XFILLER_203_1157 VPWR VGND VPWR VGND sky130_ef_sc_hd__decap_12
XFILLER_53_1499 VPWR VGND VPWR VGND sky130_ef_sc_hd__decap_12
XFILLER_88_1507 VGND VGND VPWR VPWR sky130_fd_sc_hd__decap_8
XFILLER_186_793 VPWR VGND VPWR VGND sky130_ef_sc_hd__decap_12
XFILLER_229_57 VPWR VGND VPWR VGND sky130_ef_sc_hd__decap_12
XFILLER_185_281 VPWR VGND VPWR VGND sky130_ef_sc_hd__decap_12
XFILLER_140_1469 VGND VGND VPWR VPWR sky130_fd_sc_hd__fill_1
XFILLER_173_1201 VPWR VGND VPWR VGND sky130_ef_sc_hd__decap_12
XTAP_TAPCELL_ROW_150_2_4655 VGND VPWR sky130_fd_sc_hd__tapvpwrvgnd_1
XFILLER_177_1381 VPWR VGND VPWR VGND sky130_ef_sc_hd__decap_12
XTAP_TAPCELL_ROW_149_2_4649 VGND VPWR sky130_fd_sc_hd__tapvpwrvgnd_1
XFILLER_173_1245 VPWR VGND VPWR VGND sky130_ef_sc_hd__decap_12
XFILLER_173_1289 VPWR VGND VPWR VGND sky130_ef_sc_hd__decap_12
XTAP_TAPCELL_ROW_208_2507 VGND VPWR sky130_fd_sc_hd__tapvpwrvgnd_1
XFILLER_60_1415 VPWR VGND VPWR VGND sky130_ef_sc_hd__decap_12
XFILLER_214_1253 VGND VGND VPWR VPWR sky130_fd_sc_hd__decap_6
XFILLER_229_945 VGND VGND VPWR VPWR sky130_fd_sc_hd__decap_6
XFILLER_114_27 VGND VGND VPWR VPWR sky130_fd_sc_hd__fill_1
XFILLER_228_433 VPWR VGND VPWR VGND sky130_ef_sc_hd__decap_12
XFILLER_210_1117 VPWR VGND VPWR VGND sky130_ef_sc_hd__decap_12
XFILLER_214_1297 VPWR VGND VPWR VGND sky130_ef_sc_hd__decap_12
XFILLER_229_989 VPWR VGND VPWR VGND sky130_ef_sc_hd__decap_12
XFILLER_228_477 VPWR VGND VPWR VGND sky130_ef_sc_hd__decap_12
XFILLER_244_937 VPWR VGND VPWR VGND sky130_ef_sc_hd__decap_12
XFILLER_215_105 VGND VGND VPWR VPWR sky130_fd_sc_hd__decap_6
XTAP_TAPCELL_ROW_97_2_4336 VGND VPWR sky130_fd_sc_hd__tapvpwrvgnd_1
XFILLER_243_447 VGND VGND VPWR VPWR sky130_fd_sc_hd__fill_1
XFILLER_130_15 VPWR VGND VPWR VGND sky130_ef_sc_hd__decap_12
XPHY_EDGE_ROW_171_Right_16 VGND VGND VPWR VPWR sky130_fd_sc_hd__decap_3
XFILLER_215_149 VPWR VGND VPWR VGND sky130_ef_sc_hd__decap_12
XFILLER_93_1213 VGND VGND VPWR VPWR sky130_fd_sc_hd__decap_4
XFILLER_231_609 VGND VGND VPWR VPWR sky130_fd_sc_hd__decap_6
XFILLER_184_1341 VPWR VGND VPWR VGND sky130_ef_sc_hd__decap_12
XFILLER_252_981 VPWR VGND VPWR VGND sky130_ef_sc_hd__decap_12
XFILLER_110_1295 VGND VGND VPWR VPWR sky130_fd_sc_hd__decap_6
XFILLER_180_1205 VPWR VGND VPWR VGND sky130_ef_sc_hd__decap_12
XFILLER_208_1035 VGND VGND VPWR VPWR sky130_fd_sc_hd__fill_1
XFILLER_169_727 VGND VGND VPWR VPWR sky130_fd_sc_hd__fill_1
XFILLER_196_513 VPWR VGND VPWR VGND sky130_ef_sc_hd__decap_12
XFILLER_184_1385 VPWR VGND VPWR VGND sky130_ef_sc_hd__decap_12
XFILLER_71_1511 VGND VGND VPWR VPWR sky130_fd_sc_hd__decap_4
XFILLER_212_867 VGND VGND VPWR VPWR sky130_fd_sc_hd__fill_1
XFILLER_223_193 VPWR VGND VPWR VGND sky130_ef_sc_hd__decap_12
XFILLER_196_557 VPWR VGND VPWR VGND sky130_ef_sc_hd__decap_12
XFILLER_23_46 VGND VGND VPWR VPWR sky130_fd_sc_hd__decap_8
XFILLER_221_1213 VPWR VGND VPWR VGND sky130_ef_sc_hd__decap_12
Xwire307 net308 VGND VGND VPWR VPWR net307 sky130_fd_sc_hd__clkbuf_1
XTAP_TAPCELL_ROW_176_1640 VGND VPWR sky130_fd_sc_hd__tapvpwrvgnd_1
XFILLER_23_57 VGND VGND VPWR VPWR sky130_fd_sc_hd__fill_2
Xwire318 net319 VGND VGND VPWR VPWR net318 sky130_fd_sc_hd__clkbuf_1
XFILLER_225_1393 VGND VGND VPWR VPWR sky130_fd_sc_hd__decap_6
Xwire329 net330 VGND VGND VPWR VPWR net329 sky130_fd_sc_hd__clkbuf_1
XFILLER_108_1191 VPWR VGND VPWR VGND sky130_ef_sc_hd__decap_12
XFILLER_139_57 VPWR VGND VPWR VGND sky130_ef_sc_hd__decap_12
XFILLER_221_1257 VPWR VGND VPWR VGND sky130_ef_sc_hd__decap_12
XTAP_TAPCELL_ROW_172_1526 VGND VPWR sky130_fd_sc_hd__tapvpwrvgnd_1
XTAP_TAPCELL_ROW_172_1537 VGND VPWR sky130_fd_sc_hd__tapvpwrvgnd_1
XFILLER_99_39 VPWR VGND VPWR VGND sky130_ef_sc_hd__decap_12
XFILLER_180_925 VPWR VGND VPWR VGND sky130_ef_sc_hd__decap_12
XPHY_EDGE_ROW_180_Right_25 VGND VGND VPWR VPWR sky130_fd_sc_hd__decap_3
XFILLER_191_273 VGND VGND VPWR VPWR sky130_fd_sc_hd__decap_6
XFILLER_191_1301 VPWR VGND VPWR VGND sky130_ef_sc_hd__decap_12
XFILLER_195_1481 VPWR VGND VPWR VGND sky130_ef_sc_hd__decap_12
XFILLER_191_1345 VPWR VGND VPWR VGND sky130_ef_sc_hd__decap_12
XFILLER_219_1175 VGND VGND VPWR VPWR sky130_fd_sc_hd__fill_1
XFILLER_239_709 VPWR VGND VPWR VGND sky130_ef_sc_hd__decap_12
XTAP_TAPCELL_ROW_153_1_1288 VGND VPWR sky130_fd_sc_hd__tapvpwrvgnd_1
XFILLER_8_1253 VGND VGND VPWR VPWR sky130_fd_sc_hd__decap_6
XFILLER_232_1353 VPWR VGND VPWR VGND sky130_ef_sc_hd__decap_12
XPHY_EDGE_ROW_125_2_Right_216 VGND VGND VPWR VPWR sky130_fd_sc_hd__decap_3
XFILLER_4_1117 VPWR VGND VPWR VGND sky130_ef_sc_hd__decap_12
XFILLER_247_753 VPWR VGND VPWR VGND sky130_ef_sc_hd__decap_12
XFILLER_171_55 VGND VGND VPWR VPWR sky130_fd_sc_hd__fill_1
XFILLER_8_1297 VPWR VGND VPWR VGND sky130_ef_sc_hd__decap_12
XFILLER_232_1397 VPWR VGND VPWR VGND sky130_ef_sc_hd__decap_12
XFILLER_207_617 VPWR VGND VPWR VGND sky130_ef_sc_hd__decap_12
XFILLER_247_797 VPWR VGND VPWR VGND sky130_ef_sc_hd__decap_12
XTAP_TAPCELL_ROW_241_3390 VGND VPWR sky130_fd_sc_hd__tapvpwrvgnd_1
XFILLER_234_469 VGND VGND VPWR VPWR sky130_fd_sc_hd__decap_6
XFILLER_199_373 VPWR VGND VPWR VGND sky130_ef_sc_hd__decap_12
XFILLER_202_333 VPWR VGND VPWR VGND sky130_ef_sc_hd__decap_12
XTAP_TAPCELL_ROW_254_3740 VGND VPWR sky130_fd_sc_hd__tapvpwrvgnd_1
XTAP_TAPCELL_ROW_254_3751 VGND VPWR sky130_fd_sc_hd__tapvpwrvgnd_1
X_325_ net504 _113_ VGND VGND VPWR VPWR _114_ sky130_fd_sc_hd__or2_1
XFILLER_203_889 VGND VGND VPWR VPWR sky130_fd_sc_hd__decap_6
XFILLER_80_41 VPWR VGND VPWR VGND sky130_ef_sc_hd__decap_12
XFILLER_202_377 VPWR VGND VPWR VGND sky130_ef_sc_hd__decap_12
XTAP_TAPCELL_ROW_250_3626 VGND VPWR sky130_fd_sc_hd__tapvpwrvgnd_1
XFILLER_243_1493 VPWR VGND VPWR VGND sky130_ef_sc_hd__decap_12
XTAP_TAPCELL_ROW_250_3637 VGND VPWR sky130_fd_sc_hd__tapvpwrvgnd_1
XFILLER_196_41 VPWR VGND VPWR VGND sky130_ef_sc_hd__decap_12
XTAP_TAPCELL_ROW_250_3648 VGND VPWR sky130_fd_sc_hd__tapvpwrvgnd_1
XFILLER_7_921 VPWR VGND VPWR VGND sky130_ef_sc_hd__decap_12
XFILLER_168_793 VPWR VGND VPWR VGND sky130_ef_sc_hd__decap_12
XFILLER_204_1477 VGND VGND VPWR VPWR sky130_fd_sc_hd__decap_6
XFILLER_167_281 VPWR VGND VPWR VGND sky130_ef_sc_hd__decap_12
XFILLER_183_741 VPWR VGND VPWR VGND sky130_ef_sc_hd__decap_12
XFILLER_196_85 VPWR VGND VPWR VGND sky130_ef_sc_hd__decap_12
XFILLER_7_965 VPWR VGND VPWR VGND sky130_ef_sc_hd__decap_12
XFILLER_122_1177 VPWR VGND VPWR VGND sky130_ef_sc_hd__decap_12
Xmax_cap607 net608 VGND VGND VPWR VPWR net607 sky130_fd_sc_hd__clkbuf_1
Xmax_cap618 rd_addr\[0\] VGND VGND VPWR VPWR net618 sky130_fd_sc_hd__clkbuf_1
XFILLER_182_251 VGND VGND VPWR VPWR sky130_fd_sc_hd__fill_1
XFILLER_183_785 VPWR VGND VPWR VGND sky130_ef_sc_hd__decap_12
XFILLER_170_413 VGND VGND VPWR VPWR sky130_fd_sc_hd__decap_6
XFILLER_237_1231 VGND VGND VPWR VPWR sky130_fd_sc_hd__fill_1
XFILLER_170_457 VPWR VGND VPWR VGND sky130_ef_sc_hd__decap_12
XTAP_TAPCELL_ROW_248_3577 VGND VPWR sky130_fd_sc_hd__tapvpwrvgnd_1
XFILLER_215_15 VPWR VGND VPWR VGND sky130_ef_sc_hd__decap_12
XTAP_TAPCELL_ROW_248_3588 VGND VPWR sky130_fd_sc_hd__tapvpwrvgnd_1
XFILLER_2_670 VGND VGND VPWR VPWR sky130_fd_sc_hd__decap_8
XFILLER_2_681 VGND VGND VPWR VPWR sky130_fd_sc_hd__fill_1
XFILLER_170_1429 VPWR VGND VPWR VGND sky130_ef_sc_hd__decap_12
XTAP_TAPCELL_ROW_115_2_4444 VGND VPWR sky130_fd_sc_hd__tapvpwrvgnd_1
XFILLER_250_1453 VPWR VGND VPWR VGND sky130_ef_sc_hd__decap_12
XFILLER_133_1273 VGND VGND VPWR VPWR sky130_fd_sc_hd__fill_1
XFILLER_211_1437 VPWR VGND VPWR VGND sky130_ef_sc_hd__decap_12
XFILLER_250_1497 VPWR VGND VPWR VGND sky130_ef_sc_hd__decap_12
XTAP_TAPCELL_ROW_83_2_4255 VGND VPWR sky130_fd_sc_hd__tapvpwrvgnd_1
XFILLER_226_937 VPWR VGND VPWR VGND sky130_ef_sc_hd__decap_12
XFILLER_77_1219 VPWR VGND VPWR VGND sky130_ef_sc_hd__decap_12
XFILLER_252_233 VPWR VGND VPWR VGND sky130_ef_sc_hd__decap_12
XFILLER_225_447 VGND VGND VPWR VPWR sky130_fd_sc_hd__fill_1
XFILLER_231_69 VPWR VGND VPWR VGND sky130_ef_sc_hd__decap_12
XFILLER_213_609 VGND VGND VPWR VPWR sky130_fd_sc_hd__decap_6
XFILLER_248_1371 VGND VGND VPWR VPWR sky130_fd_sc_hd__fill_1
XFILLER_252_277 VPWR VGND VPWR VGND sky130_ef_sc_hd__decap_12
XFILLER_234_981 VPWR VGND VPWR VGND sky130_ef_sc_hd__decap_12
XTAP_TAPCELL_ROW_63_2_4131 VGND VPWR sky130_fd_sc_hd__tapvpwrvgnd_1
XFILLER_178_513 VPWR VGND VPWR VGND sky130_ef_sc_hd__decap_12
XFILLER_205_193 VPWR VGND VPWR VGND sky130_ef_sc_hd__decap_12
XFILLER_100_29 VPWR VGND VPWR VGND sky130_ef_sc_hd__decap_12
XFILLER_166_1093 VPWR VGND VPWR VGND sky130_ef_sc_hd__decap_12
XFILLER_221_653 VPWR VGND VPWR VGND sky130_ef_sc_hd__decap_12
XFILLER_178_557 VPWR VGND VPWR VGND sky130_ef_sc_hd__decap_12
XFILLER_209_1399 VGND VGND VPWR VPWR sky130_fd_sc_hd__fill_1
XFILLER_220_141 VPWR VGND VPWR VGND sky130_ef_sc_hd__decap_12
XFILLER_193_505 VPWR VGND VPWR VGND sky130_ef_sc_hd__decap_12
XFILLER_14_1203 VPWR VGND VPWR VGND sky130_ef_sc_hd__decap_12
XFILLER_221_697 VPWR VGND VPWR VGND sky130_ef_sc_hd__decap_12
XFILLER_18_1383 VPWR VGND VPWR VGND sky130_ef_sc_hd__decap_12
XFILLER_105_1331 VPWR VGND VPWR VGND sky130_ef_sc_hd__decap_12
XFILLER_197_1009 VPWR VGND VPWR VGND sky130_ef_sc_hd__decap_12
XFILLER_14_1247 VPWR VGND VPWR VGND sky130_ef_sc_hd__decap_12
XFILLER_88_1315 VPWR VGND VPWR VGND sky130_ef_sc_hd__decap_12
XFILLER_101_1217 VGND VGND VPWR VPWR sky130_fd_sc_hd__fill_1
XFILLER_109_27 VPWR VGND VPWR VGND sky130_ef_sc_hd__decap_12
XFILLER_238_1017 VPWR VGND VPWR VGND sky130_ef_sc_hd__decap_12
XFILLER_88_1359 VPWR VGND VPWR VGND sky130_ef_sc_hd__decap_12
XFILLER_173_273 VGND VGND VPWR VPWR sky130_fd_sc_hd__decap_6
XPHY_EDGE_ROW_63_1_Left_318 VGND VGND VPWR VPWR sky130_fd_sc_hd__decap_3
XFILLER_216_1315 VGND VGND VPWR VPWR sky130_fd_sc_hd__fill_1
XFILLER_125_15 VPWR VGND VPWR VGND sky130_ef_sc_hd__decap_12
XFILLER_255_1397 VGND VGND VPWR VPWR sky130_fd_sc_hd__decap_3
XFILLER_25_1343 VPWR VGND VPWR VGND sky130_ef_sc_hd__decap_12
XFILLER_214_1061 VPWR VGND VPWR VGND sky130_ef_sc_hd__decap_12
XFILLER_99_1411 VPWR VGND VPWR VGND sky130_ef_sc_hd__decap_12
XFILLER_116_1471 VPWR VGND VPWR VGND sky130_ef_sc_hd__decap_12
XFILLER_229_753 VPWR VGND VPWR VGND sky130_ef_sc_hd__decap_12
XFILLER_60_1245 VGND VGND VPWR VPWR sky130_fd_sc_hd__fill_1
XFILLER_5_1437 VPWR VGND VPWR VGND sky130_ef_sc_hd__decap_12
XTAP_TAPCELL_ROW_165_1330 VGND VPWR sky130_fd_sc_hd__tapvpwrvgnd_1
XTAP_TAPCELL_ROW_4_957 VGND VPWR sky130_fd_sc_hd__tapvpwrvgnd_1
XTAP_TAPCELL_ROW_165_1341 VGND VPWR sky130_fd_sc_hd__tapvpwrvgnd_1
XFILLER_205_81 VPWR VGND VPWR VGND sky130_ef_sc_hd__decap_12
XFILLER_244_701 VPWR VGND VPWR VGND sky130_ef_sc_hd__decap_12
XFILLER_25_1387 VPWR VGND VPWR VGND sky130_ef_sc_hd__decap_12
XTAP_TAPCELL_ROW_4_968 VGND VPWR sky130_fd_sc_hd__tapvpwrvgnd_1
XTAP_TAPCELL_ROW_165_1352 VGND VPWR sky130_fd_sc_hd__tapvpwrvgnd_1
XTAP_TAPCELL_ROW_4_979 VGND VPWR sky130_fd_sc_hd__tapvpwrvgnd_1
XFILLER_249_1113 VGND VGND VPWR VPWR sky130_fd_sc_hd__decap_6
XFILLER_99_1455 VPWR VGND VPWR VGND sky130_ef_sc_hd__decap_12
XFILLER_229_797 VPWR VGND VPWR VGND sky130_ef_sc_hd__decap_12
XFILLER_112_1357 VGND VGND VPWR VPWR sky130_fd_sc_hd__fill_1
XFILLER_249_1157 VPWR VGND VPWR VGND sky130_ef_sc_hd__decap_12
XFILLER_99_1499 VPWR VGND VPWR VGND sky130_ef_sc_hd__decap_12
XFILLER_141_69 VGND VGND VPWR VPWR sky130_fd_sc_hd__fill_2
XFILLER_216_469 VGND VGND VPWR VPWR sky130_fd_sc_hd__decap_6
XFILLER_231_417 VPWR VGND VPWR VGND sky130_ef_sc_hd__decap_12
XTAP_TAPCELL_ROW_178_1702 VGND VPWR sky130_fd_sc_hd__tapvpwrvgnd_1
XFILLER_197_833 VGND VGND VPWR VPWR sky130_fd_sc_hd__decap_6
XFILLER_227_1455 VGND VGND VPWR VPWR sky130_fd_sc_hd__fill_1
XFILLER_196_321 VPWR VGND VPWR VGND sky130_ef_sc_hd__decap_12
XFILLER_180_1035 VGND VGND VPWR VPWR sky130_fd_sc_hd__fill_1
XFILLER_240_973 VGND VGND VPWR VPWR sky130_fd_sc_hd__decap_6
XFILLER_197_877 VPWR VGND VPWR VGND sky130_ef_sc_hd__decap_12
XFILLER_145_1177 VPWR VGND VPWR VGND sky130_ef_sc_hd__decap_12
XFILLER_196_365 VPWR VGND VPWR VGND sky130_ef_sc_hd__decap_12
XFILLER_200_837 VPWR VGND VPWR VGND sky130_ef_sc_hd__decap_12
XFILLER_32_1303 VPWR VGND VPWR VGND sky130_ef_sc_hd__decap_12
XFILLER_221_1021 VPWR VGND VPWR VGND sky130_ef_sc_hd__decap_12
XFILLER_36_1483 VPWR VGND VPWR VGND sky130_ef_sc_hd__decap_12
XFILLER_7_206 VGND VGND VPWR VPWR sky130_fd_sc_hd__decap_6
Xclkload0 clknet_3_0__leaf_clk VGND VGND VPWR VPWR clkload0/Y sky130_fd_sc_hd__inv_8
Xwire126 _147_ VGND VGND VPWR VPWR net126 sky130_fd_sc_hd__clkbuf_1
XFILLER_71_1385 VGND VGND VPWR VPWR sky130_fd_sc_hd__fill_1
XFILLER_126_3 VPWR VGND VPWR VGND sky130_ef_sc_hd__decap_12
XFILLER_165_741 VPWR VGND VPWR VGND sky130_ef_sc_hd__decap_12
XFILLER_221_1065 VPWR VGND VPWR VGND sky130_ef_sc_hd__decap_12
XFILLER_4_902 VPWR VGND VPWR VGND sky130_ef_sc_hd__decap_12
XFILLER_123_1497 VGND VGND VPWR VPWR sky130_fd_sc_hd__fill_1
XFILLER_165_785 VPWR VGND VPWR VGND sky130_ef_sc_hd__decap_12
XFILLER_166_77 VGND VGND VPWR VPWR sky130_fd_sc_hd__decap_6
XFILLER_180_755 VGND VGND VPWR VPWR sky130_fd_sc_hd__fill_1
XTAP_TAPCELL_ROW_230_3091 VGND VPWR sky130_fd_sc_hd__tapvpwrvgnd_1
XPHY_EDGE_ROW_168_Left_423 VGND VGND VPWR VPWR sky130_fd_sc_hd__decap_3
XFILLER_4_979 VGND VGND VPWR VPWR sky130_fd_sc_hd__fill_1
XFILLER_117_1213 VGND VGND VPWR VPWR sky130_fd_sc_hd__decap_4
XTAP_TAPCELL_ROW_101_2_4363 VGND VPWR sky130_fd_sc_hd__tapvpwrvgnd_1
XFILLER_239_517 VPWR VGND VPWR VGND sky130_ef_sc_hd__decap_12
XFILLER_156_1295 VGND VGND VPWR VPWR sky130_fd_sc_hd__decap_6
XFILLER_191_1175 VGND VGND VPWR VPWR sky130_fd_sc_hd__fill_1
XFILLER_65_1189 VPWR VGND VPWR VGND sky130_ef_sc_hd__decap_12
XFILLER_182_65 VPWR VGND VPWR VGND sky130_ef_sc_hd__decap_12
XTAP_TAPCELL_ROW_243_3441 VGND VPWR sky130_fd_sc_hd__tapvpwrvgnd_1
XTAP_TAPCELL_ROW_243_3452 VGND VPWR sky130_fd_sc_hd__tapvpwrvgnd_1
XFILLER_43_1443 VPWR VGND VPWR VGND sky130_ef_sc_hd__decap_12
XFILLER_8_1061 VPWR VGND VPWR VGND sky130_ef_sc_hd__decap_12
XFILLER_232_1161 VPWR VGND VPWR VGND sky130_ef_sc_hd__decap_12
XFILLER_130_1413 VGND VGND VPWR VPWR sky130_fd_sc_hd__fill_1
XFILLER_247_561 VPWR VGND VPWR VGND sky130_ef_sc_hd__decap_12
XTAP_TAPCELL_ROW_87_1_1222 VGND VPWR sky130_fd_sc_hd__tapvpwrvgnd_1
XPHY_EDGE_ROW_126_2_Right_217 VGND VGND VPWR VPWR sky130_fd_sc_hd__decap_3
XTAP_TAPCELL_ROW_101_1_1236 VGND VPWR sky130_fd_sc_hd__tapvpwrvgnd_1
XFILLER_208_937 VPWR VGND VPWR VGND sky130_ef_sc_hd__decap_12
XFILLER_207_447 VGND VGND VPWR VPWR sky130_fd_sc_hd__fill_1
XFILLER_234_233 VPWR VGND VPWR VGND sky130_ef_sc_hd__decap_12
XFILLER_165_1509 VGND VGND VPWR VPWR sky130_fd_sc_hd__decap_3
XTAP_TAPCELL_ROW_48_2_4044 VGND VPWR sky130_fd_sc_hd__tapvpwrvgnd_1
XPHY_EDGE_ROW_177_Left_432 VGND VGND VPWR VPWR sky130_fd_sc_hd__decap_3
XFILLER_245_1511 VGND VGND VPWR VPWR sky130_fd_sc_hd__fill_1
XFILLER_234_277 VPWR VGND VPWR VGND sky130_ef_sc_hd__decap_12
XFILLER_250_737 VPWR VGND VPWR VGND sky130_ef_sc_hd__decap_12
XFILLER_216_981 VPWR VGND VPWR VGND sky130_ef_sc_hd__decap_12
XFILLER_188_811 VGND VGND VPWR VPWR sky130_fd_sc_hd__fill_1
XFILLER_201_39 VPWR VGND VPWR VGND sky130_ef_sc_hd__decap_12
XFILLER_91_51 VGND VGND VPWR VPWR sky130_fd_sc_hd__decap_4
XFILLER_231_951 VGND VGND VPWR VPWR sky130_fd_sc_hd__fill_1
XFILLER_199_181 VPWR VGND VPWR VGND sky130_ef_sc_hd__decap_12
XFILLER_203_653 VPWR VGND VPWR VGND sky130_ef_sc_hd__decap_12
XFILLER_163_1255 VPWR VGND VPWR VGND sky130_ef_sc_hd__decap_12
XFILLER_202_141 VPWR VGND VPWR VGND sky130_ef_sc_hd__decap_12
XTAP_TAPCELL_ROW_237_3278 VGND VPWR sky130_fd_sc_hd__tapvpwrvgnd_1
XTAP_TAPCELL_ROW_237_3289 VGND VPWR sky130_fd_sc_hd__tapvpwrvgnd_1
XFILLER_175_505 VPWR VGND VPWR VGND sky130_ef_sc_hd__decap_12
XFILLER_124_1239 VGND VGND VPWR VPWR sky130_fd_sc_hd__decap_6
XFILLER_203_697 VPWR VGND VPWR VGND sky130_ef_sc_hd__decap_12
XFILLER_163_1299 VPWR VGND VPWR VGND sky130_ef_sc_hd__decap_12
X_308_ net508 VGND VGND VPWR VPWR _097_ sky130_fd_sc_hd__inv_2
XFILLER_204_1241 VPWR VGND VPWR VGND sky130_ef_sc_hd__decap_12
XFILLER_198_1329 VPWR VGND VPWR VGND sky130_ef_sc_hd__decap_12
XFILLER_200_1105 VPWR VGND VPWR VGND sky130_ef_sc_hd__decap_12
XFILLER_204_1285 VPWR VGND VPWR VGND sky130_ef_sc_hd__decap_12
XFILLER_50_1469 VGND VGND VPWR VPWR sky130_fd_sc_hd__fill_1
Xwire660 net12 VGND VGND VPWR VPWR net660 sky130_fd_sc_hd__buf_1
XFILLER_200_1149 VPWR VGND VPWR VGND sky130_ef_sc_hd__decap_12
XFILLER_239_1337 VGND VGND VPWR VPWR sky130_fd_sc_hd__decap_6
XPHY_EDGE_ROW_186_Left_441 VGND VGND VPWR VPWR sky130_fd_sc_hd__decap_3
XFILLER_170_221 VPWR VGND VPWR VGND sky130_ef_sc_hd__decap_12
XFILLER_83_1201 VPWR VGND VPWR VGND sky130_ef_sc_hd__decap_12
XFILLER_171_777 VGND VGND VPWR VPWR sky130_fd_sc_hd__decap_6
XFILLER_41_3 VPWR VGND VPWR VGND sky130_ef_sc_hd__decap_12
XFILLER_100_1283 VPWR VGND VPWR VGND sky130_ef_sc_hd__decap_12
XFILLER_170_265 VPWR VGND VPWR VGND sky130_ef_sc_hd__decap_12
XFILLER_174_1373 VPWR VGND VPWR VGND sky130_ef_sc_hd__decap_12
XFILLER_83_1267 VGND VGND VPWR VPWR sky130_fd_sc_hd__decap_6
XFILLER_135_1379 VGND VGND VPWR VPWR sky130_fd_sc_hd__decap_6
XFILLER_170_1259 VGND VGND VPWR VPWR sky130_fd_sc_hd__fill_1
XFILLER_211_1201 VPWR VGND VPWR VGND sky130_ef_sc_hd__decap_12
XFILLER_250_1261 VPWR VGND VPWR VGND sky130_ef_sc_hd__decap_12
XFILLER_215_1381 VPWR VGND VPWR VGND sky130_ef_sc_hd__decap_12
XFILLER_226_701 VPWR VGND VPWR VGND sky130_ef_sc_hd__decap_12
XFILLER_211_1245 VPWR VGND VPWR VGND sky130_ef_sc_hd__decap_12
XTAP_TAPCELL_ROW_226_2982 VGND VPWR sky130_fd_sc_hd__tapvpwrvgnd_1
XTAP_TAPCELL_ROW_226_2993 VGND VPWR sky130_fd_sc_hd__tapvpwrvgnd_1
XPHY_EDGE_ROW_195_Left_450 VGND VGND VPWR VPWR sky130_fd_sc_hd__decap_3
XFILLER_211_1289 VPWR VGND VPWR VGND sky130_ef_sc_hd__decap_12
XFILLER_0_1301 VPWR VGND VPWR VGND sky130_ef_sc_hd__decap_12
XFILLER_253_553 VGND VGND VPWR VPWR sky130_fd_sc_hd__decap_6
XFILLER_1_93 VGND VGND VPWR VPWR sky130_fd_sc_hd__fill_1
XTAP_TAPCELL_ROW_222_2868 VGND VPWR sky130_fd_sc_hd__tapvpwrvgnd_1
XTAP_TAPCELL_ROW_222_2879 VGND VPWR sky130_fd_sc_hd__tapvpwrvgnd_1
XFILLER_0_1345 VPWR VGND VPWR VGND sky130_ef_sc_hd__decap_12
XFILLER_213_417 VPWR VGND VPWR VGND sky130_ef_sc_hd__decap_12
XFILLER_253_597 VPWR VGND VPWR VGND sky130_ef_sc_hd__decap_12
XFILLER_111_39 VPWR VGND VPWR VGND sky130_ef_sc_hd__decap_12
XFILLER_20_1295 VGND VGND VPWR VPWR sky130_fd_sc_hd__decap_6
XFILLER_179_833 VGND VGND VPWR VPWR sky130_fd_sc_hd__decap_6
XFILLER_178_321 VPWR VGND VPWR VGND sky130_ef_sc_hd__decap_12
XFILLER_90_1227 VPWR VGND VPWR VGND sky130_ef_sc_hd__decap_12
XFILLER_222_973 VGND VGND VPWR VPWR sky130_fd_sc_hd__decap_6
XFILLER_179_877 VPWR VGND VPWR VGND sky130_ef_sc_hd__decap_12
XFILLER_221_461 VPWR VGND VPWR VGND sky130_ef_sc_hd__decap_12
XFILLER_178_365 VPWR VGND VPWR VGND sky130_ef_sc_hd__decap_12
XFILLER_142_1339 VPWR VGND VPWR VGND sky130_ef_sc_hd__decap_12
XFILLER_194_825 VPWR VGND VPWR VGND sky130_ef_sc_hd__decap_12
XFILLER_181_1399 VGND VGND VPWR VPWR sky130_fd_sc_hd__fill_1
XFILLER_222_1341 VPWR VGND VPWR VGND sky130_ef_sc_hd__decap_12
XFILLER_18_1191 VPWR VGND VPWR VGND sky130_ef_sc_hd__decap_12
XFILLER_193_335 VGND VGND VPWR VPWR sky130_fd_sc_hd__fill_1
XFILLER_194_869 VPWR VGND VPWR VGND sky130_ef_sc_hd__decap_12
XTAP_TAPCELL_ROW_106_2_4389 VGND VPWR sky130_fd_sc_hd__tapvpwrvgnd_1
XFILLER_222_1385 VPWR VGND VPWR VGND sky130_ef_sc_hd__decap_12
XFILLER_88_1189 VGND VGND VPWR VPWR sky130_fd_sc_hd__fill_1
XFILLER_255_1161 VPWR VGND VPWR VGND sky130_ef_sc_hd__decap_12
XFILLER_0_415 VGND VGND VPWR VPWR sky130_fd_sc_hd__fill_2
XFILLER_96_29 VPWR VGND VPWR VGND sky130_ef_sc_hd__decap_12
XPHY_EDGE_ROW_114_1_Right_770 VGND VGND VPWR VPWR sky130_fd_sc_hd__decap_3
XFILLER_153_1435 VGND VGND VPWR VPWR sky130_fd_sc_hd__decap_6
XTAP_TAPCELL_ROW_167_1403 VGND VPWR sky130_fd_sc_hd__tapvpwrvgnd_1
XTAP_TAPCELL_ROW_54_2_4076 VGND VPWR sky130_fd_sc_hd__tapvpwrvgnd_1
XFILLER_5_1201 VPWR VGND VPWR VGND sky130_ef_sc_hd__decap_12
XFILLER_153_1479 VPWR VGND VPWR VGND sky130_ef_sc_hd__decap_12
XFILLER_233_1481 VPWR VGND VPWR VGND sky130_ef_sc_hd__decap_12
XFILLER_188_1509 VGND VGND VPWR VPWR sky130_fd_sc_hd__decap_6
XFILLER_229_561 VPWR VGND VPWR VGND sky130_ef_sc_hd__decap_12
XFILLER_5_1245 VPWR VGND VPWR VGND sky130_ef_sc_hd__decap_12
XFILLER_244_531 VGND VGND VPWR VPWR sky130_fd_sc_hd__fill_1
XFILLER_112_1165 VPWR VGND VPWR VGND sky130_ef_sc_hd__decap_12
XFILLER_5_1289 VPWR VGND VPWR VGND sky130_ef_sc_hd__decap_12
X_590_ net670 VGND VGND VPWR VPWR _072_ sky130_fd_sc_hd__inv_2
XFILLER_216_233 VPWR VGND VPWR VGND sky130_ef_sc_hd__decap_12
XPHY_EDGE_ROW_50_2_Right_141 VGND VGND VPWR VPWR sky130_fd_sc_hd__decap_3
XFILLER_45_55 VGND VGND VPWR VPWR sky130_fd_sc_hd__fill_1
XFILLER_147_1217 VGND VGND VPWR VPWR sky130_fd_sc_hd__fill_1
XFILLER_216_277 VPWR VGND VPWR VGND sky130_ef_sc_hd__decap_12
XTAP_TAPCELL_ROW_148_1_1283 VGND VPWR sky130_fd_sc_hd__tapvpwrvgnd_1
XFILLER_232_737 VPWR VGND VPWR VGND sky130_ef_sc_hd__decap_12
XFILLER_231_225 VPWR VGND VPWR VGND sky130_ef_sc_hd__decap_12
XTAP_TAPCELL_ROW_32_2_3946 VGND VPWR sky130_fd_sc_hd__tapvpwrvgnd_1
XFILLER_213_951 VGND VGND VPWR VPWR sky130_fd_sc_hd__fill_1
XFILLER_243_3 VPWR VGND VPWR VGND sky130_ef_sc_hd__decap_12
XFILLER_197_641 VPWR VGND VPWR VGND sky130_ef_sc_hd__decap_12
XFILLER_200_601 VPWR VGND VPWR VGND sky130_ef_sc_hd__decap_12
XFILLER_240_781 VPWR VGND VPWR VGND sky130_ef_sc_hd__decap_12
XFILLER_197_685 VPWR VGND VPWR VGND sky130_ef_sc_hd__decap_12
XFILLER_160_1439 VPWR VGND VPWR VGND sky130_ef_sc_hd__decap_12
XFILLER_200_645 VPWR VGND VPWR VGND sky130_ef_sc_hd__decap_12
XFILLER_240_1441 VPWR VGND VPWR VGND sky130_ef_sc_hd__decap_12
XFILLER_196_195 VGND VGND VPWR VPWR sky130_fd_sc_hd__fill_1
XTAP_TAPCELL_ROW_232_3142 VGND VPWR sky130_fd_sc_hd__tapvpwrvgnd_1
XFILLER_184_357 VGND VGND VPWR VPWR sky130_fd_sc_hd__decap_6
XFILLER_201_1425 VPWR VGND VPWR VGND sky130_ef_sc_hd__decap_12
XTAP_TAPCELL_ROW_232_3153 VGND VPWR sky130_fd_sc_hd__tapvpwrvgnd_1
XFILLER_240_1485 VPWR VGND VPWR VGND sky130_ef_sc_hd__decap_12
XFILLER_32_1177 VPWR VGND VPWR VGND sky130_ef_sc_hd__decap_12
XFILLER_6_27 VGND VGND VPWR VPWR sky130_fd_sc_hd__fill_1
XFILLER_201_1469 VPWR VGND VPWR VGND sky130_ef_sc_hd__decap_12
XTAP_TAPCELL_ROW_151_2_4660 VGND VPWR sky130_fd_sc_hd__tapvpwrvgnd_1
XFILLER_158_1357 VGND VGND VPWR VPWR sky130_fd_sc_hd__fill_1
XTAP_TAPCELL_ROW_245_3503 VGND VPWR sky130_fd_sc_hd__tapvpwrvgnd_1
XFILLER_4_798 VPWR VGND VPWR VGND sky130_ef_sc_hd__decap_12
XFILLER_171_1513 VGND VGND VPWR VPWR sky130_fd_sc_hd__fill_2
XFILLER_80_1407 VGND VGND VPWR VPWR sky130_fd_sc_hd__decap_6
XFILLER_0_993 VPWR VGND VPWR VGND sky130_ef_sc_hd__decap_12
XFILLER_208_701 VPWR VGND VPWR VGND sky130_ef_sc_hd__decap_12
XFILLER_248_881 VPWR VGND VPWR VGND sky130_ef_sc_hd__decap_12
XFILLER_43_1273 VGND VGND VPWR VPWR sky130_fd_sc_hd__fill_1
XTAP_TAPCELL_ROW_7_1048 VGND VPWR sky130_fd_sc_hd__tapvpwrvgnd_1
XTAP_TAPCELL_ROW_7_1059 VGND VPWR sky130_fd_sc_hd__tapvpwrvgnd_1
XFILLER_78_1303 VPWR VGND VPWR VGND sky130_ef_sc_hd__decap_12
XFILLER_247_391 VGND VGND VPWR VPWR sky130_fd_sc_hd__fill_1
XTAP_TAPCELL_ROW_98_2_4341 VGND VPWR sky130_fd_sc_hd__tapvpwrvgnd_1
XPHY_EDGE_ROW_127_2_Right_218 VGND VGND VPWR VPWR sky130_fd_sc_hd__decap_3
XFILLER_212_27 VGND VGND VPWR VPWR sky130_fd_sc_hd__fill_1
XFILLER_235_553 VGND VGND VPWR VPWR sky130_fd_sc_hd__decap_6
XFILLER_228_1005 VPWR VGND VPWR VGND sky130_ef_sc_hd__decap_12
XFILLER_250_501 VPWR VGND VPWR VGND sky130_ef_sc_hd__decap_12
XFILLER_165_1317 VPWR VGND VPWR VGND sky130_ef_sc_hd__decap_12
XTAP_TAPCELL_ROW_239_3329 VGND VPWR sky130_fd_sc_hd__tapvpwrvgnd_1
XFILLER_235_597 VPWR VGND VPWR VGND sky130_ef_sc_hd__decap_12
XFILLER_228_1049 VPWR VGND VPWR VGND sky130_ef_sc_hd__decap_12
XFILLER_250_545 VPWR VGND VPWR VGND sky130_ef_sc_hd__decap_12
XFILLER_204_973 VGND VGND VPWR VPWR sky130_fd_sc_hd__decap_6
XFILLER_250_589 VPWR VGND VPWR VGND sky130_ef_sc_hd__decap_12
XFILLER_203_461 VPWR VGND VPWR VGND sky130_ef_sc_hd__decap_12
XFILLER_176_825 VPWR VGND VPWR VGND sky130_ef_sc_hd__decap_12
XFILLER_89_3 VPWR VGND VPWR VGND sky130_ef_sc_hd__decap_12
XFILLER_15_1331 VPWR VGND VPWR VGND sky130_ef_sc_hd__decap_12
XFILLER_175_335 VGND VGND VPWR VPWR sky130_fd_sc_hd__fill_1
XFILLER_176_869 VPWR VGND VPWR VGND sky130_ef_sc_hd__decap_12
XFILLER_102_1301 VGND VGND VPWR VPWR sky130_fd_sc_hd__fill_1
XFILLER_239_1101 VPWR VGND VPWR VGND sky130_ef_sc_hd__decap_12
XFILLER_11_1217 VGND VGND VPWR VPWR sky130_fd_sc_hd__fill_1
XFILLER_89_1443 VPWR VGND VPWR VGND sky130_ef_sc_hd__decap_12
XFILLER_191_839 VGND VGND VPWR VPWR sky130_fd_sc_hd__fill_1
XFILLER_204_1093 VPWR VGND VPWR VGND sky130_ef_sc_hd__decap_12
Xmax_cap201 net202 VGND VGND VPWR VPWR net201 sky130_fd_sc_hd__clkbuf_1
XTAP_TAPCELL_ROW_215_2683 VGND VPWR sky130_fd_sc_hd__tapvpwrvgnd_1
XFILLER_237_57 VPWR VGND VPWR VGND sky130_ef_sc_hd__decap_12
Xwire490 net491 VGND VGND VPWR VPWR net490 sky130_fd_sc_hd__clkbuf_1
XFILLER_239_1145 VPWR VGND VPWR VGND sky130_ef_sc_hd__decap_12
XTAP_TAPCELL_ROW_215_2694 VGND VPWR sky130_fd_sc_hd__tapvpwrvgnd_1
XFILLER_85_1329 VGND VGND VPWR VPWR sky130_fd_sc_hd__fill_1
XFILLER_171_541 VPWR VGND VPWR VGND sky130_ef_sc_hd__decap_12
Xmax_cap245 _158_ VGND VGND VPWR VPWR net245 sky130_fd_sc_hd__clkbuf_1
XFILLER_235_1009 VPWR VGND VPWR VGND sky130_ef_sc_hd__decap_12
XTAP_TAPCELL_ROW_211_2569 VGND VPWR sky130_fd_sc_hd__tapvpwrvgnd_1
XFILLER_239_1189 VPWR VGND VPWR VGND sky130_ef_sc_hd__decap_12
XFILLER_171_585 VPWR VGND VPWR VGND sky130_ef_sc_hd__decap_12
XFILLER_135_1165 VPWR VGND VPWR VGND sky130_ef_sc_hd__decap_12
XFILLER_26_1471 VPWR VGND VPWR VGND sky130_ef_sc_hd__decap_12
XFILLER_245_317 VPWR VGND VPWR VGND sky130_ef_sc_hd__decap_12
XFILLER_113_1441 VGND VGND VPWR VPWR sky130_fd_sc_hd__fill_1
XFILLER_250_1091 VGND VGND VPWR VPWR sky130_fd_sc_hd__fill_1
XFILLER_22_1357 VGND VGND VPWR VPWR sky130_fd_sc_hd__fill_1
XFILLER_2_1429 VPWR VGND VPWR VGND sky130_ef_sc_hd__decap_12
XFILLER_122_27 VGND VGND VPWR VPWR sky130_fd_sc_hd__fill_1
XFILLER_226_531 VGND VGND VPWR VPWR sky130_fd_sc_hd__fill_1
XFILLER_246_1105 VPWR VGND VPWR VGND sky130_ef_sc_hd__decap_12
XFILLER_253_361 VPWR VGND VPWR VGND sky130_ef_sc_hd__decap_12
XFILLER_96_1469 VGND VGND VPWR VPWR sky130_fd_sc_hd__fill_1
XFILLER_214_737 VPWR VGND VPWR VGND sky130_ef_sc_hd__decap_12
XFILLER_246_1149 VPWR VGND VPWR VGND sky130_ef_sc_hd__decap_12
XTAP_TAPCELL_ROW_17_2_3859 VGND VPWR sky130_fd_sc_hd__tapvpwrvgnd_1
XFILLER_213_225 VPWR VGND VPWR VGND sky130_ef_sc_hd__decap_12
XFILLER_107_1201 VPWR VGND VPWR VGND sky130_ef_sc_hd__decap_12
XFILLER_179_641 VPWR VGND VPWR VGND sky130_ef_sc_hd__decap_12
XFILLER_222_781 VPWR VGND VPWR VGND sky130_ef_sc_hd__decap_12
XFILLER_146_1283 VPWR VGND VPWR VGND sky130_ef_sc_hd__decap_12
XFILLER_55_1177 VPWR VGND VPWR VGND sky130_ef_sc_hd__decap_12
XPHY_EDGE_ROW_137_2_Left_639 VGND VGND VPWR VPWR sky130_fd_sc_hd__decap_3
XFILLER_179_685 VPWR VGND VPWR VGND sky130_ef_sc_hd__decap_12
XFILLER_107_1267 VGND VGND VPWR VPWR sky130_fd_sc_hd__decap_6
XFILLER_178_195 VGND VGND VPWR VPWR sky130_fd_sc_hd__fill_1
XFILLER_166_357 VGND VGND VPWR VPWR sky130_fd_sc_hd__decap_6
XFILLER_181_305 VPWR VGND VPWR VGND sky130_ef_sc_hd__decap_12
XFILLER_194_699 VGND VGND VPWR VPWR sky130_fd_sc_hd__fill_1
XFILLER_33_1497 VGND VGND VPWR VPWR sky130_fd_sc_hd__fill_1
XFILLER_147_57 VPWR VGND VPWR VGND sky130_ef_sc_hd__decap_12
XFILLER_181_349 VPWR VGND VPWR VGND sky130_ef_sc_hd__decap_12
XTAP_TAPCELL_ROW_136_2_4573 VGND VPWR sky130_fd_sc_hd__tapvpwrvgnd_1
XFILLER_190_861 VGND VGND VPWR VPWR sky130_fd_sc_hd__decap_6
XFILLER_218_1229 VPWR VGND VPWR VGND sky130_ef_sc_hd__decap_12
Xoutput46 net545 VGND VGND VPWR VPWR acc_out[12] sky130_fd_sc_hd__buf_2
XFILLER_27_1213 VGND VGND VPWR VPWR sky130_fd_sc_hd__decap_4
Xoutput57 net57 VGND VGND VPWR VPWR acc_out[22] sky130_fd_sc_hd__buf_2
Xoutput68 net560 VGND VGND VPWR VPWR acc_out[3] sky130_fd_sc_hd__buf_2
XFILLER_66_1295 VGND VGND VPWR VPWR sky130_fd_sc_hd__decap_6
XFILLER_153_1243 VPWR VGND VPWR VGND sky130_ef_sc_hd__decap_12
XPHY_EDGE_ROW_115_1_Right_771 VGND VGND VPWR VPWR sky130_fd_sc_hd__decap_3
XFILLER_248_133 VGND VGND VPWR VPWR sky130_fd_sc_hd__decap_6
XFILLER_114_1227 VPWR VGND VPWR VGND sky130_ef_sc_hd__decap_12
XFILLER_193_3 VPWR VGND VPWR VGND sky130_ef_sc_hd__decap_12
XFILLER_153_1287 VPWR VGND VPWR VGND sky130_ef_sc_hd__decap_12
XFILLER_248_177 VPWR VGND VPWR VGND sky130_ef_sc_hd__decap_12
XFILLER_40_1413 VGND VGND VPWR VPWR sky130_fd_sc_hd__fill_1
XTAP_TAPCELL_ROW_84_2_4260 VGND VPWR sky130_fd_sc_hd__tapvpwrvgnd_1
XFILLER_188_1317 VPWR VGND VPWR VGND sky130_ef_sc_hd__decap_12
X_642_ clknet_3_0__leaf_clk acc_core.adder.cla_blocks\[2\].block.sum\[0\] _050_ VGND
+ VGND VPWR VPWR net73 sky130_fd_sc_hd__dfrtp_1
XFILLER_229_391 VGND VGND VPWR VPWR sky130_fd_sc_hd__fill_1
XFILLER_56_65 VGND VGND VPWR VPWR sky130_fd_sc_hd__decap_6
XFILLER_217_553 VGND VGND VPWR VPWR sky130_fd_sc_hd__decap_6
XFILLER_229_1325 VPWR VGND VPWR VGND sky130_ef_sc_hd__decap_12
XFILLER_232_501 VPWR VGND VPWR VGND sky130_ef_sc_hd__decap_12
XFILLER_245_895 VGND VGND VPWR VPWR sky130_fd_sc_hd__fill_1
X_573_ net666 VGND VGND VPWR VPWR _055_ sky130_fd_sc_hd__inv_2
XFILLER_189_405 VPWR VGND VPWR VGND sky130_ef_sc_hd__decap_12
XFILLER_217_597 VPWR VGND VPWR VGND sky130_ef_sc_hd__decap_12
XFILLER_229_1369 VPWR VGND VPWR VGND sky130_ef_sc_hd__decap_12
XPHY_EDGE_ROW_51_2_Right_142 VGND VGND VPWR VPWR sky130_fd_sc_hd__decap_3
XFILLER_186_1085 VGND VGND VPWR VPWR sky130_fd_sc_hd__decap_6
XFILLER_232_545 VPWR VGND VPWR VGND sky130_ef_sc_hd__decap_12
XFILLER_189_449 VPWR VGND VPWR VGND sky130_ef_sc_hd__decap_12
XFILLER_72_53 VPWR VGND VPWR VGND sky130_ef_sc_hd__decap_12
XFILLER_198_961 VPWR VGND VPWR VGND sky130_ef_sc_hd__decap_12
XTAP_TAPCELL_ROW_234_3204 VGND VPWR sky130_fd_sc_hd__tapvpwrvgnd_1
XFILLER_232_589 VPWR VGND VPWR VGND sky130_ef_sc_hd__decap_12
XFILLER_201_921 VPWR VGND VPWR VGND sky130_ef_sc_hd__decap_12
XTAP_TAPCELL_ROW_234_3215 VGND VPWR sky130_fd_sc_hd__tapvpwrvgnd_1
XFILLER_73_1255 VPWR VGND VPWR VGND sky130_ef_sc_hd__decap_12
XTAP_TAPCELL_ROW_76_2_4208 VGND VPWR sky130_fd_sc_hd__tapvpwrvgnd_1
XFILLER_125_1323 VGND VGND VPWR VPWR sky130_fd_sc_hd__decap_6
XFILLER_160_1203 VPWR VGND VPWR VGND sky130_ef_sc_hd__decap_12
XFILLER_188_53 VPWR VGND VPWR VGND sky130_ef_sc_hd__decap_12
XFILLER_9_813 VPWR VGND VPWR VGND sky130_ef_sc_hd__decap_12
XFILLER_164_1383 VPWR VGND VPWR VGND sky130_ef_sc_hd__decap_12
XFILLER_34_1239 VGND VGND VPWR VPWR sky130_fd_sc_hd__decap_6
XFILLER_8_312 VPWR VGND VPWR VGND sky130_ef_sc_hd__decap_12
XFILLER_73_1299 VPWR VGND VPWR VGND sky130_ef_sc_hd__decap_12
XFILLER_160_1247 VPWR VGND VPWR VGND sky130_ef_sc_hd__decap_12
XFILLER_199_1413 VPWR VGND VPWR VGND sky130_ef_sc_hd__decap_12
XFILLER_201_965 VPWR VGND VPWR VGND sky130_ef_sc_hd__decap_12
XFILLER_125_1367 VPWR VGND VPWR VGND sky130_ef_sc_hd__decap_12
XFILLER_184_121 VPWR VGND VPWR VGND sky130_ef_sc_hd__decap_12
XFILLER_188_97 VPWR VGND VPWR VGND sky130_ef_sc_hd__decap_12
XFILLER_200_475 VGND VGND VPWR VPWR sky130_fd_sc_hd__fill_1
Xclkbuf_3_1__f_clk clknet_0_clk VGND VGND VPWR VPWR clknet_3_1__leaf_clk sky130_fd_sc_hd__clkbuf_16
XFILLER_199_1457 VPWR VGND VPWR VGND sky130_ef_sc_hd__decap_12
XFILLER_184_165 VPWR VGND VPWR VGND sky130_ef_sc_hd__decap_12
XFILLER_201_1233 VPWR VGND VPWR VGND sky130_ef_sc_hd__decap_12
XFILLER_173_839 VGND VGND VPWR VPWR sky130_fd_sc_hd__fill_1
XFILLER_193_1001 VGND VGND VPWR VPWR sky130_fd_sc_hd__decap_6
XFILLER_236_1329 VPWR VGND VPWR VGND sky130_ef_sc_hd__decap_12
XFILLER_158_1165 VPWR VGND VPWR VGND sky130_ef_sc_hd__decap_12
XFILLER_193_1045 VPWR VGND VPWR VGND sky130_ef_sc_hd__decap_12
XFILLER_207_27 VPWR VGND VPWR VGND sky130_ef_sc_hd__decap_12
XFILLER_10_1283 VPWR VGND VPWR VGND sky130_ef_sc_hd__decap_12
XFILLER_84_1351 VGND VGND VPWR VPWR sky130_fd_sc_hd__decap_6
XFILLER_193_1089 VPWR VGND VPWR VGND sky130_ef_sc_hd__decap_12
XFILLER_80_1215 VPWR VGND VPWR VGND sky130_ef_sc_hd__decap_12
XFILLER_239_111 VGND VGND VPWR VPWR sky130_fd_sc_hd__fill_1
XFILLER_84_1395 VPWR VGND VPWR VGND sky130_ef_sc_hd__decap_12
XFILLER_136_1463 VGND VGND VPWR VPWR sky130_fd_sc_hd__decap_6
XFILLER_171_1343 VGND VGND VPWR VPWR sky130_fd_sc_hd__fill_1
XFILLER_45_1379 VGND VGND VPWR VPWR sky130_fd_sc_hd__decap_6
XFILLER_80_1259 VPWR VGND VPWR VGND sky130_ef_sc_hd__decap_12
XFILLER_132_1327 VPWR VGND VPWR VGND sky130_ef_sc_hd__decap_12
XFILLER_223_15 VPWR VGND VPWR VGND sky130_ef_sc_hd__decap_12
XFILLER_227_317 VPWR VGND VPWR VGND sky130_ef_sc_hd__decap_12
XFILLER_208_531 VGND VGND VPWR VPWR sky130_fd_sc_hd__fill_1
XFILLER_212_1373 VPWR VGND VPWR VGND sky130_ef_sc_hd__decap_12
XFILLER_242_309 VPWR VGND VPWR VGND sky130_ef_sc_hd__decap_12
XFILLER_247_1425 VPWR VGND VPWR VGND sky130_ef_sc_hd__decap_12
XFILLER_235_361 VPWR VGND VPWR VGND sky130_ef_sc_hd__decap_12
XFILLER_251_821 VPWR VGND VPWR VGND sky130_ef_sc_hd__decap_12
XPHY_EDGE_ROW_128_2_Right_219 VGND VGND VPWR VPWR sky130_fd_sc_hd__decap_3
XFILLER_78_1177 VPWR VGND VPWR VGND sky130_ef_sc_hd__decap_12
XTAP_TAPCELL_ROW_204_2384 VGND VPWR sky130_fd_sc_hd__tapvpwrvgnd_1
XFILLER_208_1409 VPWR VGND VPWR VGND sky130_ef_sc_hd__decap_12
XFILLER_247_1469 VPWR VGND VPWR VGND sky130_ef_sc_hd__decap_12
XTAP_TAPCELL_ROW_204_2395 VGND VPWR sky130_fd_sc_hd__tapvpwrvgnd_1
XFILLER_251_865 VPWR VGND VPWR VGND sky130_ef_sc_hd__decap_12
XFILLER_91_1311 VPWR VGND VPWR VGND sky130_ef_sc_hd__decap_12
XFILLER_95_1491 VGND VGND VPWR VPWR sky130_fd_sc_hd__decap_6
XPHY_EDGE_ROW_72_1_Left_327 VGND VGND VPWR VPWR sky130_fd_sc_hd__decap_3
XFILLER_211_729 VPWR VGND VPWR VGND sky130_ef_sc_hd__decap_12
XFILLER_91_1355 VPWR VGND VPWR VGND sky130_ef_sc_hd__decap_12
XTAP_TAPCELL_ROW_196_2174 VGND VPWR sky130_fd_sc_hd__tapvpwrvgnd_1
XFILLER_204_781 VPWR VGND VPWR VGND sky130_ef_sc_hd__decap_12
XFILLER_143_1423 VPWR VGND VPWR VGND sky130_ef_sc_hd__decap_12
XTAP_TAPCELL_ROW_196_2185 VGND VPWR sky130_fd_sc_hd__tapvpwrvgnd_1
XFILLER_182_1483 VGND VGND VPWR VPWR sky130_fd_sc_hd__fill_1
XFILLER_52_1339 VPWR VGND VPWR VGND sky130_ef_sc_hd__decap_12
XFILLER_104_1407 VGND VGND VPWR VPWR sky130_fd_sc_hd__decap_6
XFILLER_241_1057 VGND VGND VPWR VPWR sky130_fd_sc_hd__decap_6
XFILLER_91_1399 VPWR VGND VPWR VGND sky130_ef_sc_hd__decap_12
XFILLER_143_1467 VPWR VGND VPWR VGND sky130_ef_sc_hd__decap_12
XTAP_TAPCELL_ROW_217_2734 VGND VPWR sky130_fd_sc_hd__tapvpwrvgnd_1
XTAP_TAPCELL_ROW_217_2745 VGND VPWR sky130_fd_sc_hd__tapvpwrvgnd_1
XTAP_TAPCELL_ROW_217_2756 VGND VPWR sky130_fd_sc_hd__tapvpwrvgnd_1
XFILLER_176_699 VGND VGND VPWR VPWR sky130_fd_sc_hd__fill_1
XFILLER_7_81 VPWR VGND VPWR VGND sky130_ef_sc_hd__decap_12
XFILLER_89_1273 VGND VGND VPWR VPWR sky130_fd_sc_hd__fill_1
XFILLER_219_1505 VGND VGND VPWR VPWR sky130_fd_sc_hd__decap_6
XFILLER_172_861 VGND VGND VPWR VPWR sky130_fd_sc_hd__decap_6
XTAP_TAPCELL_ROW_90_2_4292 VGND VPWR sky130_fd_sc_hd__tapvpwrvgnd_1
XFILLER_117_27 VPWR VGND VPWR VGND sky130_ef_sc_hd__decap_12
XFILLER_254_1429 VPWR VGND VPWR VGND sky130_ef_sc_hd__decap_12
XTAP_TAPCELL_ROW_89_2_4286 VGND VPWR sky130_fd_sc_hd__tapvpwrvgnd_1
XFILLER_171_393 VPWR VGND VPWR VGND sky130_ef_sc_hd__decap_12
XFILLER_172_1129 VPWR VGND VPWR VGND sky130_ef_sc_hd__decap_12
XFILLER_63_1435 VGND VGND VPWR VPWR sky130_fd_sc_hd__decap_6
XFILLER_63_1479 VPWR VGND VPWR VGND sky130_ef_sc_hd__decap_12
XFILLER_133_15 VPWR VGND VPWR VGND sky130_ef_sc_hd__decap_12
XFILLER_150_1427 VPWR VGND VPWR VGND sky130_ef_sc_hd__decap_12
XFILLER_252_1197 VGND VGND VPWR VPWR sky130_fd_sc_hd__decap_6
XFILLER_246_637 VGND VGND VPWR VPWR sky130_fd_sc_hd__decap_6
XFILLER_245_125 VPWR VGND VPWR VGND sky130_ef_sc_hd__decap_12
XFILLER_6_1373 VPWR VGND VPWR VGND sky130_ef_sc_hd__decap_12
XFILLER_245_169 VPWR VGND VPWR VGND sky130_ef_sc_hd__decap_12
XFILLER_22_1165 VPWR VGND VPWR VGND sky130_ef_sc_hd__decap_12
XFILLER_148_1301 VGND VGND VPWR VPWR sky130_fd_sc_hd__fill_1
XTAP_TAPCELL_ROW_181_1764 VGND VPWR sky130_fd_sc_hd__tapvpwrvgnd_1
XFILLER_2_1259 VGND VGND VPWR VPWR sky130_fd_sc_hd__fill_1
XTAP_TAPCELL_ROW_181_1775 VGND VPWR sky130_fd_sc_hd__tapvpwrvgnd_1
XFILLER_213_81 VPWR VGND VPWR VGND sky130_ef_sc_hd__decap_12
XFILLER_214_501 VPWR VGND VPWR VGND sky130_ef_sc_hd__decap_12
XFILLER_254_681 VPWR VGND VPWR VGND sky130_ef_sc_hd__decap_12
XFILLER_227_895 VGND VGND VPWR VPWR sky130_fd_sc_hd__fill_1
XFILLER_57_1217 VGND VGND VPWR VPWR sky130_fd_sc_hd__fill_1
XFILLER_183_1225 VGND VGND VPWR VPWR sky130_fd_sc_hd__decap_6
XFILLER_214_545 VPWR VGND VPWR VGND sky130_ef_sc_hd__decap_12
XFILLER_226_1509 VGND VGND VPWR VPWR sky130_fd_sc_hd__decap_6
XFILLER_187_909 VPWR VGND VPWR VGND sky130_ef_sc_hd__decap_12
XTAP_TAPCELL_ROW_62_2_4127 VGND VPWR sky130_fd_sc_hd__tapvpwrvgnd_1
XFILLER_109_1329 VGND VGND VPWR VPWR sky130_fd_sc_hd__fill_1
XFILLER_183_1269 VPWR VGND VPWR VGND sky130_ef_sc_hd__decap_12
XFILLER_214_589 VPWR VGND VPWR VGND sky130_ef_sc_hd__decap_12
XFILLER_186_419 VGND VGND VPWR VPWR sky130_fd_sc_hd__fill_1
XFILLER_201_217 VGND VGND VPWR VPWR sky130_fd_sc_hd__decap_6
XFILLER_9_109 VGND VGND VPWR VPWR sky130_fd_sc_hd__decap_3
XFILLER_70_1439 VPWR VGND VPWR VGND sky130_ef_sc_hd__decap_12
XFILLER_122_1507 VGND VGND VPWR VPWR sky130_fd_sc_hd__decap_8
XFILLER_195_953 VPWR VGND VPWR VGND sky130_ef_sc_hd__decap_12
XFILLER_166_121 VPWR VGND VPWR VGND sky130_ef_sc_hd__decap_12
XFILLER_166_165 VPWR VGND VPWR VGND sky130_ef_sc_hd__decap_12
XFILLER_182_625 VPWR VGND VPWR VGND sky130_ef_sc_hd__decap_12
XFILLER_177_1007 VGND VGND VPWR VPWR sky130_fd_sc_hd__fill_1
XFILLER_181_113 VPWR VGND VPWR VGND sky130_ef_sc_hd__decap_12
XFILLER_159_1441 VGND VGND VPWR VPWR sky130_fd_sc_hd__fill_1
XFILLER_182_669 VPWR VGND VPWR VGND sky130_ef_sc_hd__decap_12
XFILLER_206_3 VPWR VGND VPWR VGND sky130_ef_sc_hd__decap_12
XFILLER_68_1357 VGND VGND VPWR VPWR sky130_fd_sc_hd__fill_1
XFILLER_194_1365 VGND VGND VPWR VPWR sky130_fd_sc_hd__decap_6
XFILLER_218_1037 VPWR VGND VPWR VGND sky130_ef_sc_hd__decap_12
XFILLER_174_77 VGND VGND VPWR VPWR sky130_fd_sc_hd__decap_6
XFILLER_190_1229 VPWR VGND VPWR VGND sky130_ef_sc_hd__decap_12
XFILLER_3_39 VPWR VGND VPWR VGND sky130_ef_sc_hd__decap_12
XFILLER_237_615 VGND VGND VPWR VPWR sky130_fd_sc_hd__fill_1
XPHY_EDGE_ROW_116_1_Right_772 VGND VGND VPWR VPWR sky130_fd_sc_hd__decap_3
XFILLER_209_317 VPWR VGND VPWR VGND sky130_ef_sc_hd__decap_12
XFILLER_249_497 VGND VGND VPWR VPWR sky130_fd_sc_hd__decap_6
XFILLER_190_65 VPWR VGND VPWR VGND sky130_ef_sc_hd__decap_12
XFILLER_188_1147 VGND VGND VPWR VPWR sky130_fd_sc_hd__fill_1
XFILLER_224_309 VPWR VGND VPWR VGND sky130_ef_sc_hd__decap_12
XTAP_TAPCELL_ROW_158_2_4705 VGND VPWR sky130_fd_sc_hd__tapvpwrvgnd_1
X_625_ clknet_3_4__leaf_clk dout0\[23\] _033_ VGND VGND VPWR VPWR dout0_q\[23\] sky130_fd_sc_hd__dfrtp_1
XFILLER_217_361 VPWR VGND VPWR VGND sky130_ef_sc_hd__decap_12
XFILLER_233_821 VPWR VGND VPWR VGND sky130_ef_sc_hd__decap_12
XFILLER_229_1133 VPWR VGND VPWR VGND sky130_ef_sc_hd__decap_12
XFILLER_79_1497 VGND VGND VPWR VPWR sky130_fd_sc_hd__fill_1
XFILLER_233_865 VPWR VGND VPWR VGND sky130_ef_sc_hd__decap_12
X_556_ net670 VGND VGND VPWR VPWR _038_ sky130_fd_sc_hd__inv_2
XFILLER_229_1177 VPWR VGND VPWR VGND sky130_ef_sc_hd__decap_12
XPHY_EDGE_ROW_52_2_Right_143 VGND VGND VPWR VPWR sky130_fd_sc_hd__decap_3
X_487_ _122_ net87 net495 VGND VGND VPWR VPWR _250_ sky130_fd_sc_hd__a21o_1
XFILLER_189_279 VGND VGND VPWR VPWR sky130_fd_sc_hd__fill_1
XFILLER_164_1191 VPWR VGND VPWR VGND sky130_ef_sc_hd__decap_12
XFILLER_185_441 VGND VGND VPWR VPWR sky130_fd_sc_hd__decap_6
XFILLER_12_1301 VGND VGND VPWR VPWR sky130_fd_sc_hd__fill_1
XTAP_TAPCELL_ROW_107_2_4394 VGND VPWR sky130_fd_sc_hd__tapvpwrvgnd_1
XFILLER_8_153 VPWR VGND VPWR VGND sky130_ef_sc_hd__decap_12
XFILLER_185_485 VPWR VGND VPWR VGND sky130_ef_sc_hd__decap_12
XFILLER_8_175 VGND VGND VPWR VPWR sky130_fd_sc_hd__decap_4
XFILLER_218_15 VPWR VGND VPWR VGND sky130_ef_sc_hd__decap_12
XFILLER_199_1287 VGND VGND VPWR VPWR sky130_fd_sc_hd__fill_1
XFILLER_8_197 VGND VGND VPWR VPWR sky130_fd_sc_hd__decap_6
XFILLER_201_1063 VGND VGND VPWR VPWR sky130_fd_sc_hd__fill_1
XTAP_TAPCELL_ROW_212_2620 VGND VPWR sky130_fd_sc_hd__tapvpwrvgnd_1
XFILLER_86_1413 VGND VGND VPWR VPWR sky130_fd_sc_hd__fill_1
XFILLER_173_1449 VGND VGND VPWR VPWR sky130_fd_sc_hd__decap_6
XFILLER_136_1271 VPWR VGND VPWR VGND sky130_ef_sc_hd__decap_12
XFILLER_228_637 VGND VGND VPWR VPWR sky130_fd_sc_hd__decap_6
XFILLER_227_125 VPWR VGND VPWR VGND sky130_ef_sc_hd__decap_12
XFILLER_255_445 VGND VGND VPWR VPWR sky130_fd_sc_hd__decap_3
XFILLER_23_1441 VGND VGND VPWR VPWR sky130_fd_sc_hd__fill_1
XFILLER_3_1513 VGND VGND VPWR VPWR sky130_fd_sc_hd__fill_2
XTAP_TAPCELL_ROW_206_2435 VGND VPWR sky130_fd_sc_hd__tapvpwrvgnd_1
XTAP_TAPCELL_ROW_206_2446 VGND VPWR sky130_fd_sc_hd__tapvpwrvgnd_1
XTAP_TAPCELL_ROW_206_2457 VGND VPWR sky130_fd_sc_hd__tapvpwrvgnd_1
XFILLER_227_169 VPWR VGND VPWR VGND sky130_ef_sc_hd__decap_12
XFILLER_255_489 VPWR VGND VPWR VGND sky130_ef_sc_hd__decap_12
XFILLER_243_629 VPWR VGND VPWR VGND sky130_ef_sc_hd__decap_12
XFILLER_209_895 VGND VGND VPWR VPWR sky130_fd_sc_hd__fill_1
XFILLER_236_681 VPWR VGND VPWR VGND sky130_ef_sc_hd__decap_12
XTAP_TAPCELL_ROW_198_2225 VGND VPWR sky130_fd_sc_hd__tapvpwrvgnd_1
XFILLER_247_1233 VPWR VGND VPWR VGND sky130_ef_sc_hd__decap_12
XFILLER_242_139 VGND VGND VPWR VPWR sky130_fd_sc_hd__fill_1
XTAP_TAPCELL_ROW_198_2236 VGND VPWR sky130_fd_sc_hd__tapvpwrvgnd_1
XTAP_TAPCELL_ROW_33_2_3951 VGND VPWR sky130_fd_sc_hd__tapvpwrvgnd_1
XFILLER_208_1217 VPWR VGND VPWR VGND sky130_ef_sc_hd__decap_12
XFILLER_1_1281 VGND VGND VPWR VPWR sky130_fd_sc_hd__decap_6
XFILLER_169_909 VPWR VGND VPWR VGND sky130_ef_sc_hd__decap_12
XFILLER_251_673 VPWR VGND VPWR VGND sky130_ef_sc_hd__decap_12
XFILLER_243_1119 VGND VGND VPWR VPWR sky130_fd_sc_hd__fill_1
XFILLER_180_1409 VPWR VGND VPWR VGND sky130_ef_sc_hd__decap_12
XTAP_TAPCELL_ROW_219_2807 VGND VPWR sky130_fd_sc_hd__tapvpwrvgnd_1
XFILLER_17_1201 VPWR VGND VPWR VGND sky130_ef_sc_hd__decap_12
XFILLER_168_419 VGND VGND VPWR VPWR sky130_fd_sc_hd__fill_1
XFILLER_195_205 VPWR VGND VPWR VGND sky130_ef_sc_hd__decap_12
XFILLER_56_1283 VPWR VGND VPWR VGND sky130_ef_sc_hd__decap_12
XFILLER_143_1231 VPWR VGND VPWR VGND sky130_ef_sc_hd__decap_12
XFILLER_211_559 VGND VGND VPWR VPWR sky130_fd_sc_hd__fill_1
XFILLER_108_1351 VGND VGND VPWR VPWR sky130_fd_sc_hd__decap_6
XFILLER_177_953 VPWR VGND VPWR VGND sky130_ef_sc_hd__decap_12
XFILLER_195_249 VPWR VGND VPWR VGND sky130_ef_sc_hd__decap_12
XFILLER_17_1267 VGND VGND VPWR VPWR sky130_fd_sc_hd__decap_6
XFILLER_104_1215 VPWR VGND VPWR VGND sky130_ef_sc_hd__decap_12
XFILLER_108_1395 VPWR VGND VPWR VGND sky130_ef_sc_hd__decap_12
XFILLER_143_1275 VPWR VGND VPWR VGND sky130_ef_sc_hd__decap_12
XFILLER_192_923 VGND VGND VPWR VPWR sky130_fd_sc_hd__fill_1
XFILLER_104_1259 VPWR VGND VPWR VGND sky130_ef_sc_hd__decap_12
XFILLER_128_15 VPWR VGND VPWR VGND sky130_ef_sc_hd__decap_12
XTAP_TAPCELL_ROW_174_1590 VGND VPWR sky130_fd_sc_hd__tapvpwrvgnd_1
XFILLER_219_1313 VPWR VGND VPWR VGND sky130_ef_sc_hd__decap_12
XTAP_TAPCELL_ROW_170_1465 VGND VPWR sky130_fd_sc_hd__tapvpwrvgnd_1
XTAP_TAPCELL_ROW_170_1476 VGND VPWR sky130_fd_sc_hd__tapvpwrvgnd_1
XFILLER_191_1505 VGND VGND VPWR VPWR sky130_fd_sc_hd__decap_6
XTAP_TAPCELL_ROW_170_1487 VGND VPWR sky130_fd_sc_hd__tapvpwrvgnd_1
XFILLER_176_1073 VPWR VGND VPWR VGND sky130_ef_sc_hd__decap_12
XFILLER_219_1357 VPWR VGND VPWR VGND sky130_ef_sc_hd__decap_12
XFILLER_254_1259 VGND VGND VPWR VPWR sky130_fd_sc_hd__fill_1
XTAP_TAPCELL_ROW_164_2_4737 VGND VPWR sky130_fd_sc_hd__tapvpwrvgnd_1
XTAP_TAPCELL_ROW_187_1940 VGND VPWR sky130_fd_sc_hd__tapvpwrvgnd_1
XFILLER_63_1243 VPWR VGND VPWR VGND sky130_ef_sc_hd__decap_12
XFILLER_115_1311 VPWR VGND VPWR VGND sky130_ef_sc_hd__decap_12
XFILLER_154_1371 VPWR VGND VPWR VGND sky130_ef_sc_hd__decap_12
XFILLER_119_1491 VGND VGND VPWR VPWR sky130_fd_sc_hd__decap_6
XFILLER_246_401 VPWR VGND VPWR VGND sky130_ef_sc_hd__decap_12
XFILLER_219_615 VGND VGND VPWR VPWR sky130_fd_sc_hd__fill_1
XFILLER_24_1227 VPWR VGND VPWR VGND sky130_ef_sc_hd__decap_12
Xfanout666 net671 VGND VGND VPWR VPWR net666 sky130_fd_sc_hd__buf_4
XTAP_TAPCELL_ROW_183_1815 VGND VPWR sky130_fd_sc_hd__tapvpwrvgnd_1
XFILLER_189_1401 VPWR VGND VPWR VGND sky130_ef_sc_hd__decap_12
XFILLER_63_1287 VPWR VGND VPWR VGND sky130_ef_sc_hd__decap_12
XFILLER_115_1355 VPWR VGND VPWR VGND sky130_ef_sc_hd__decap_12
XTAP_TAPCELL_ROW_183_1826 VGND VPWR sky130_fd_sc_hd__tapvpwrvgnd_1
XTAP_TAPCELL_ROW_183_1837 VGND VPWR sky130_fd_sc_hd__tapvpwrvgnd_1
XFILLER_246_445 VPWR VGND VPWR VGND sky130_ef_sc_hd__decap_12
XFILLER_111_1219 VPWR VGND VPWR VGND sky130_ef_sc_hd__decap_12
XFILLER_98_1339 VPWR VGND VPWR VGND sky130_ef_sc_hd__decap_12
XFILLER_115_1399 VPWR VGND VPWR VGND sky130_ef_sc_hd__decap_12
XFILLER_206_309 VPWR VGND VPWR VGND sky130_ef_sc_hd__decap_12
XFILLER_246_489 VPWR VGND VPWR VGND sky130_ef_sc_hd__decap_12
XFILLER_215_821 VPWR VGND VPWR VGND sky130_ef_sc_hd__decap_12
X_410_ _184_ _198_ net206 VGND VGND VPWR VPWR _199_ sky130_fd_sc_hd__a21o_1
XFILLER_215_865 VPWR VGND VPWR VGND sky130_ef_sc_hd__decap_12
XTAP_TAPCELL_ROW_124_2_4500 VGND VPWR sky130_fd_sc_hd__tapvpwrvgnd_1
XFILLER_183_1033 VPWR VGND VPWR VGND sky130_ef_sc_hd__decap_12
XFILLER_226_1317 VPWR VGND VPWR VGND sky130_ef_sc_hd__decap_12
XFILLER_230_813 VPWR VGND VPWR VGND sky130_ef_sc_hd__decap_12
XFILLER_156_3 VPWR VGND VPWR VGND sky130_ef_sc_hd__decap_12
XFILLER_241_161 VGND VGND VPWR VPWR sky130_fd_sc_hd__decap_6
X_341_ net594 net539 net570 VGND VGND VPWR VPWR _130_ sky130_fd_sc_hd__nand3_1
XFILLER_183_1077 VPWR VGND VPWR VGND sky130_ef_sc_hd__decap_12
XFILLER_70_1203 VPWR VGND VPWR VGND sky130_ef_sc_hd__decap_12
XFILLER_35_1323 VGND VGND VPWR VPWR sky130_fd_sc_hd__decap_6
XFILLER_74_1383 VPWR VGND VPWR VGND sky130_ef_sc_hd__decap_12
XFILLER_126_1451 VPWR VGND VPWR VGND sky130_ef_sc_hd__decap_12
XFILLER_161_1331 VPWR VGND VPWR VGND sky130_ef_sc_hd__decap_12
XFILLER_169_55 VGND VGND VPWR VPWR sky130_fd_sc_hd__fill_1
XPHY_EDGE_ROW_18_2_Left_520 VGND VGND VPWR VPWR sky130_fd_sc_hd__decap_3
XFILLER_167_441 VGND VGND VPWR VPWR sky130_fd_sc_hd__decap_6
XFILLER_70_1247 VPWR VGND VPWR VGND sky130_ef_sc_hd__decap_12
XFILLER_35_1367 VPWR VGND VPWR VGND sky130_ef_sc_hd__decap_12
XFILLER_122_1315 VPWR VGND VPWR VGND sky130_ef_sc_hd__decap_12
XFILLER_126_1495 VPWR VGND VPWR VGND sky130_ef_sc_hd__decap_12
XFILLER_224_1085 VGND VGND VPWR VPWR sky130_fd_sc_hd__decap_6
XFILLER_210_581 VGND VGND VPWR VPWR sky130_fd_sc_hd__decap_6
XFILLER_195_783 VGND VGND VPWR VPWR sky130_fd_sc_hd__fill_1
XFILLER_167_485 VPWR VGND VPWR VGND sky130_ef_sc_hd__decap_12
XTAP_TAPCELL_ROW_252_3690 VGND VPWR sky130_fd_sc_hd__tapvpwrvgnd_1
XFILLER_122_1359 VPWR VGND VPWR VGND sky130_ef_sc_hd__decap_12
XFILLER_183_945 VGND VGND VPWR VPWR sky130_fd_sc_hd__decap_6
XFILLER_6_635 VGND VGND VPWR VPWR sky130_fd_sc_hd__decap_8
XFILLER_182_433 VPWR VGND VPWR VGND sky130_ef_sc_hd__decap_12
XFILLER_196_1427 VGND VGND VPWR VPWR sky130_fd_sc_hd__fill_1
XFILLER_183_989 VPWR VGND VPWR VGND sky130_ef_sc_hd__decap_12
XFILLER_182_477 VPWR VGND VPWR VGND sky130_ef_sc_hd__decap_12
XFILLER_237_1413 VPWR VGND VPWR VGND sky130_ef_sc_hd__decap_12
XFILLER_5_167 VGND VGND VPWR VPWR sky130_fd_sc_hd__fill_1
XFILLER_68_1165 VPWR VGND VPWR VGND sky130_ef_sc_hd__decap_12
XFILLER_237_1457 VPWR VGND VPWR VGND sky130_ef_sc_hd__decap_12
XFILLER_194_1173 VPWR VGND VPWR VGND sky130_ef_sc_hd__decap_12
XFILLER_78_41 VPWR VGND VPWR VGND sky130_ef_sc_hd__decap_12
XFILLER_190_1037 VPWR VGND VPWR VGND sky130_ef_sc_hd__decap_12
XFILLER_155_1168 VPWR VGND VPWR VGND sky130_ef_sc_hd__decap_12
XFILLER_46_1463 VGND VGND VPWR VPWR sky130_fd_sc_hd__decap_6
XFILLER_81_1343 VPWR VGND VPWR VGND sky130_ef_sc_hd__decap_12
XFILLER_133_1411 VPWR VGND VPWR VGND sky130_ef_sc_hd__decap_12
XFILLER_231_1001 VGND VGND VPWR VPWR sky130_fd_sc_hd__decap_6
XFILLER_1_384 VGND VGND VPWR VPWR sky130_fd_sc_hd__fill_2
XFILLER_249_261 VPWR VGND VPWR VGND sky130_ef_sc_hd__decap_12
XFILLER_42_1327 VPWR VGND VPWR VGND sky130_ef_sc_hd__decap_12
XFILLER_231_1045 VPWR VGND VPWR VGND sky130_ef_sc_hd__decap_12
XFILLER_81_1387 VPWR VGND VPWR VGND sky130_ef_sc_hd__decap_12
XFILLER_133_1455 VPWR VGND VPWR VGND sky130_ef_sc_hd__decap_12
XFILLER_209_125 VPWR VGND VPWR VGND sky130_ef_sc_hd__decap_12
XPHY_EDGE_ROW_117_1_Right_773 VGND VGND VPWR VPWR sky130_fd_sc_hd__decap_3
XFILLER_238_979 VGND VGND VPWR VPWR sky130_fd_sc_hd__fill_1
XFILLER_231_1089 VPWR VGND VPWR VGND sky130_ef_sc_hd__decap_12
XFILLER_133_1499 VPWR VGND VPWR VGND sky130_ef_sc_hd__decap_12
XFILLER_209_169 VPWR VGND VPWR VGND sky130_ef_sc_hd__decap_12
XFILLER_225_629 VPWR VGND VPWR VGND sky130_ef_sc_hd__decap_12
XFILLER_218_681 VPWR VGND VPWR VGND sky130_ef_sc_hd__decap_12
XFILLER_224_139 VGND VGND VPWR VPWR sky130_fd_sc_hd__fill_1
XTAP_TAPCELL_ROW_201_2310 VGND VPWR sky130_fd_sc_hd__tapvpwrvgnd_1
XTAP_TAPCELL_ROW_18_2_3864 VGND VPWR sky130_fd_sc_hd__tapvpwrvgnd_1
X_608_ clknet_3_1__leaf_clk dout0\[6\] _016_ VGND VGND VPWR VPWR dout0_q\[6\] sky130_fd_sc_hd__dfrtp_1
XTAP_TAPCELL_ROW_201_2321 VGND VPWR sky130_fd_sc_hd__tapvpwrvgnd_1
XFILLER_220_27 VGND VGND VPWR VPWR sky130_fd_sc_hd__fill_1
XFILLER_166_1253 VGND VGND VPWR VPWR sky130_fd_sc_hd__decap_6
XFILLER_233_673 VPWR VGND VPWR VGND sky130_ef_sc_hd__decap_12
XFILLER_220_301 VGND VGND VPWR VPWR sky130_fd_sc_hd__decap_6
X_539_ net667 VGND VGND VPWR VPWR _021_ sky130_fd_sc_hd__inv_2
XTAP_TAPCELL_ROW_193_2100 VGND VPWR sky130_fd_sc_hd__tapvpwrvgnd_1
XFILLER_177_205 VPWR VGND VPWR VGND sky130_ef_sc_hd__decap_12
XFILLER_166_1297 VPWR VGND VPWR VGND sky130_ef_sc_hd__decap_12
XPHY_EDGE_ROW_53_2_Right_144 VGND VGND VPWR VPWR sky130_fd_sc_hd__decap_3
XFILLER_53_1423 VPWR VGND VPWR VGND sky130_ef_sc_hd__decap_12
XFILLER_220_345 VPWR VGND VPWR VGND sky130_ef_sc_hd__decap_12
XFILLER_242_1141 VGND VGND VPWR VPWR sky130_fd_sc_hd__decap_6
XFILLER_92_1483 VPWR VGND VPWR VGND sky130_ef_sc_hd__decap_12
XFILLER_177_249 VPWR VGND VPWR VGND sky130_ef_sc_hd__decap_12
XFILLER_193_709 VPWR VGND VPWR VGND sky130_ef_sc_hd__decap_12
XFILLER_14_1407 VGND VGND VPWR VPWR sky130_fd_sc_hd__decap_6
XFILLER_53_1467 VPWR VGND VPWR VGND sky130_ef_sc_hd__decap_12
XFILLER_140_1415 VPWR VGND VPWR VGND sky130_ef_sc_hd__decap_12
XFILLER_220_389 VPWR VGND VPWR VGND sky130_ef_sc_hd__decap_12
XFILLER_242_1185 VPWR VGND VPWR VGND sky130_ef_sc_hd__decap_12
XFILLER_174_923 VGND VGND VPWR VPWR sky130_fd_sc_hd__fill_1
XFILLER_71_3 VPWR VGND VPWR VGND sky130_ef_sc_hd__decap_12
XTAP_TAPCELL_ROW_11_2_3818 VGND VPWR sky130_fd_sc_hd__tapvpwrvgnd_1
XFILLER_203_1169 VGND VGND VPWR VPWR sky130_fd_sc_hd__decap_6
XFILLER_229_69 VPWR VGND VPWR VGND sky130_ef_sc_hd__decap_12
XFILLER_9_495 VGND VGND VPWR VPWR sky130_fd_sc_hd__decap_8
XFILLER_185_293 VPWR VGND VPWR VGND sky130_ef_sc_hd__decap_12
XFILLER_220_1483 VGND VGND VPWR VPWR sky130_fd_sc_hd__fill_1
XFILLER_255_1513 VGND VGND VPWR VPWR sky130_fd_sc_hd__fill_2
XFILLER_173_1213 VPWR VGND VPWR VGND sky130_ef_sc_hd__decap_12
XTAP_TAPCELL_ROW_150_2_4656 VGND VPWR sky130_fd_sc_hd__tapvpwrvgnd_1
XFILLER_245_57 VPWR VGND VPWR VGND sky130_ef_sc_hd__decap_12
XFILLER_177_1393 VGND VGND VPWR VPWR sky130_fd_sc_hd__decap_6
XFILLER_173_1257 VPWR VGND VPWR VGND sky130_ef_sc_hd__decap_12
XFILLER_151_1511 VGND VGND VPWR VPWR sky130_fd_sc_hd__decap_4
XTAP_TAPCELL_ROW_208_2508 VGND VPWR sky130_fd_sc_hd__tapvpwrvgnd_1
XFILLER_253_1281 VGND VGND VPWR VPWR sky130_fd_sc_hd__decap_6
XFILLER_228_401 VPWR VGND VPWR VGND sky130_ef_sc_hd__decap_12
XFILLER_60_1427 VPWR VGND VPWR VGND sky130_ef_sc_hd__decap_12
XTAP_TAPCELL_ROW_130_2_4532 VGND VPWR sky130_fd_sc_hd__tapvpwrvgnd_1
XTAP_TAPCELL_ROW_129_2_4526 VGND VPWR sky130_fd_sc_hd__tapvpwrvgnd_1
XPHY_EDGE_ROW_146_2_Left_648 VGND VGND VPWR VPWR sky130_fd_sc_hd__decap_3
XFILLER_228_445 VPWR VGND VPWR VGND sky130_ef_sc_hd__decap_12
XFILLER_244_905 VPWR VGND VPWR VGND sky130_ef_sc_hd__decap_12
XFILLER_210_1129 VPWR VGND VPWR VGND sky130_ef_sc_hd__decap_12
XFILLER_255_253 VPWR VGND VPWR VGND sky130_ef_sc_hd__decap_12
XFILLER_3_1343 VGND VGND VPWR VPWR sky130_fd_sc_hd__fill_1
XFILLER_228_489 VPWR VGND VPWR VGND sky130_ef_sc_hd__decap_12
XFILLER_244_949 VPWR VGND VPWR VGND sky130_ef_sc_hd__decap_12
XPHY_EDGE_ROW_16_1_Left_271 VGND VGND VPWR VPWR sky130_fd_sc_hd__decap_3
XTAP_TAPCELL_ROW_97_2_4337 VGND VPWR sky130_fd_sc_hd__tapvpwrvgnd_1
XFILLER_58_1301 VGND VGND VPWR VPWR sky130_fd_sc_hd__fill_1
XFILLER_130_27 VGND VGND VPWR VPWR sky130_fd_sc_hd__fill_1
XFILLER_247_1063 VGND VGND VPWR VPWR sky130_fd_sc_hd__fill_1
XFILLER_184_1353 VPWR VGND VPWR VGND sky130_ef_sc_hd__decap_12
XFILLER_212_813 VPWR VGND VPWR VGND sky130_ef_sc_hd__decap_12
XFILLER_230_109 VPWR VGND VPWR VGND sky130_ef_sc_hd__decap_12
XFILLER_252_993 VPWR VGND VPWR VGND sky130_ef_sc_hd__decap_12
XFILLER_19_1329 VGND VGND VPWR VPWR sky130_fd_sc_hd__fill_1
XFILLER_223_161 VGND VGND VPWR VPWR sky130_fd_sc_hd__decap_6
XFILLER_180_1217 VPWR VGND VPWR VGND sky130_ef_sc_hd__decap_12
XFILLER_184_1397 VPWR VGND VPWR VGND sky130_ef_sc_hd__decap_12
XFILLER_196_525 VGND VGND VPWR VPWR sky130_fd_sc_hd__decap_6
XTAP_TAPCELL_ROW_176_1630 VGND VPWR sky130_fd_sc_hd__tapvpwrvgnd_1
XFILLER_196_569 VPWR VGND VPWR VGND sky130_ef_sc_hd__decap_12
XFILLER_32_1507 VGND VGND VPWR VPWR sky130_fd_sc_hd__decap_8
XTAP_TAPCELL_ROW_176_1641 VGND VPWR sky130_fd_sc_hd__tapvpwrvgnd_1
Xwire308 net309 VGND VGND VPWR VPWR net308 sky130_fd_sc_hd__clkbuf_1
XFILLER_221_1225 VGND VGND VPWR VPWR sky130_fd_sc_hd__decap_6
Xwire319 net320 VGND VGND VPWR VPWR net319 sky130_fd_sc_hd__clkbuf_1
XFILLER_177_783 VGND VGND VPWR VPWR sky130_fd_sc_hd__fill_1
XTAP_TAPCELL_ROW_172_1516 VGND VPWR sky130_fd_sc_hd__tapvpwrvgnd_1
XFILLER_139_69 VGND VGND VPWR VPWR sky130_fd_sc_hd__fill_2
XTAP_TAPCELL_ROW_172_1527 VGND VPWR sky130_fd_sc_hd__tapvpwrvgnd_1
XFILLER_221_1269 VPWR VGND VPWR VGND sky130_ef_sc_hd__decap_12
XTAP_TAPCELL_ROW_172_1538 VGND VPWR sky130_fd_sc_hd__tapvpwrvgnd_1
XFILLER_69_1441 VGND VGND VPWR VPWR sky130_fd_sc_hd__fill_1
XFILLER_180_937 VPWR VGND VPWR VGND sky130_ef_sc_hd__decap_12
XFILLER_219_1121 VPWR VGND VPWR VGND sky130_ef_sc_hd__decap_12
XFILLER_191_1313 VPWR VGND VPWR VGND sky130_ef_sc_hd__decap_12
XFILLER_155_57 VPWR VGND VPWR VGND sky130_ef_sc_hd__decap_12
XFILLER_195_1493 VPWR VGND VPWR VGND sky130_ef_sc_hd__decap_12
XFILLER_215_1007 VGND VGND VPWR VPWR sky130_fd_sc_hd__fill_1
XFILLER_191_1357 VPWR VGND VPWR VGND sky130_ef_sc_hd__decap_12
XFILLER_238_209 VPWR VGND VPWR VGND sky130_ef_sc_hd__decap_12
XTAP_TAPCELL_ROW_24_2_3896 VGND VPWR sky130_fd_sc_hd__tapvpwrvgnd_1
XFILLER_247_721 VGND VGND VPWR VPWR sky130_fd_sc_hd__decap_6
XFILLER_232_1365 VGND VGND VPWR VPWR sky130_fd_sc_hd__decap_6
XFILLER_247_765 VPWR VGND VPWR VGND sky130_ef_sc_hd__decap_12
XFILLER_4_1129 VPWR VGND VPWR VGND sky130_ef_sc_hd__decap_12
XFILLER_189_1231 VGND VGND VPWR VPWR sky130_fd_sc_hd__fill_1
XFILLER_246_253 VPWR VGND VPWR VGND sky130_ef_sc_hd__decap_12
XFILLER_0_29 VPWR VGND VPWR VGND sky130_ef_sc_hd__decap_12
XFILLER_207_629 VPWR VGND VPWR VGND sky130_ef_sc_hd__decap_12
XTAP_TAPCELL_ROW_241_3380 VGND VPWR sky130_fd_sc_hd__tapvpwrvgnd_1
XTAP_TAPCELL_ROW_241_3391 VGND VPWR sky130_fd_sc_hd__tapvpwrvgnd_1
XFILLER_206_139 VGND VGND VPWR VPWR sky130_fd_sc_hd__fill_1
XFILLER_215_673 VPWR VGND VPWR VGND sky130_ef_sc_hd__decap_12
XFILLER_187_503 VGND VGND VPWR VPWR sky130_fd_sc_hd__fill_1
XFILLER_202_301 VGND VGND VPWR VPWR sky130_fd_sc_hd__decap_6
XFILLER_226_1147 VGND VGND VPWR VPWR sky130_fd_sc_hd__fill_1
XTAP_TAPCELL_ROW_254_3730 VGND VPWR sky130_fd_sc_hd__tapvpwrvgnd_1
XFILLER_9_27 VGND VGND VPWR VPWR sky130_fd_sc_hd__fill_1
XFILLER_199_385 VGND VGND VPWR VPWR sky130_fd_sc_hd__decap_6
XFILLER_230_643 VGND VGND VPWR VPWR sky130_fd_sc_hd__fill_1
XTAP_TAPCELL_ROW_254_3741 VGND VPWR sky130_fd_sc_hd__tapvpwrvgnd_1
X_324_ net595 dout0_q\[24\] net59 VGND VGND VPWR VPWR _113_ sky130_fd_sc_hd__a21oi_1
XFILLER_202_345 VPWR VGND VPWR VGND sky130_ef_sc_hd__decap_12
XTAP_TAPCELL_ROW_254_3752 VGND VPWR sky130_fd_sc_hd__tapvpwrvgnd_1
XFILLER_175_709 VPWR VGND VPWR VGND sky130_ef_sc_hd__decap_12
XFILLER_74_1191 VPWR VGND VPWR VGND sky130_ef_sc_hd__decap_12
XFILLER_80_53 VPWR VGND VPWR VGND sky130_ef_sc_hd__decap_12
XFILLER_202_389 VPWR VGND VPWR VGND sky130_ef_sc_hd__decap_12
XTAP_TAPCELL_ROW_250_3627 VGND VPWR sky130_fd_sc_hd__tapvpwrvgnd_1
XTAP_TAPCELL_ROW_250_3638 VGND VPWR sky130_fd_sc_hd__tapvpwrvgnd_1
XFILLER_196_53 VPWR VGND VPWR VGND sky130_ef_sc_hd__decap_12
XFILLER_7_933 VPWR VGND VPWR VGND sky130_ef_sc_hd__decap_12
XFILLER_200_1309 VGND VGND VPWR VPWR sky130_fd_sc_hd__decap_6
XFILLER_167_293 VPWR VGND VPWR VGND sky130_ef_sc_hd__decap_12
XFILLER_183_753 VPWR VGND VPWR VGND sky130_ef_sc_hd__decap_12
XFILLER_196_97 VPWR VGND VPWR VGND sky130_ef_sc_hd__decap_12
Xmax_cap608 rd_addr\[5\] VGND VGND VPWR VPWR net608 sky130_fd_sc_hd__clkbuf_1
XFILLER_7_977 VPWR VGND VPWR VGND sky130_ef_sc_hd__decap_12
XFILLER_122_1189 VGND VGND VPWR VPWR sky130_fd_sc_hd__fill_1
Xmax_cap619 net620 VGND VGND VPWR VPWR net619 sky130_fd_sc_hd__buf_1
XFILLER_183_797 VPWR VGND VPWR VGND sky130_ef_sc_hd__decap_12
XFILLER_157_1219 VPWR VGND VPWR VGND sky130_ef_sc_hd__decap_12
XFILLER_89_51 VGND VGND VPWR VPWR sky130_fd_sc_hd__decap_4
XPHY_EDGE_ROW_144_1_Left_399 VGND VGND VPWR VPWR sky130_fd_sc_hd__decap_3
XFILLER_170_469 VGND VGND VPWR VPWR sky130_fd_sc_hd__decap_6
XTAP_TAPCELL_ROW_248_3578 VGND VPWR sky130_fd_sc_hd__tapvpwrvgnd_1
XTAP_TAPCELL_ROW_248_3589 VGND VPWR sky130_fd_sc_hd__tapvpwrvgnd_1
XFILLER_237_1287 VGND VGND VPWR VPWR sky130_fd_sc_hd__fill_1
XFILLER_215_27 VPWR VGND VPWR VGND sky130_ef_sc_hd__decap_12
XFILLER_250_1421 VGND VGND VPWR VPWR sky130_fd_sc_hd__decap_6
XFILLER_2_693 VGND VGND VPWR VPWR sky130_fd_sc_hd__decap_6
XPHY_EDGE_ROW_81_1_Left_336 VGND VGND VPWR VPWR sky130_fd_sc_hd__decap_3
XTAP_TAPCELL_ROW_115_2_4445 VGND VPWR sky130_fd_sc_hd__tapvpwrvgnd_1
XFILLER_46_1271 VPWR VGND VPWR VGND sky130_ef_sc_hd__decap_12
XFILLER_1_181 VGND VGND VPWR VPWR sky130_fd_sc_hd__fill_2
XFILLER_250_1465 VPWR VGND VPWR VGND sky130_ef_sc_hd__decap_12
XFILLER_226_905 VPWR VGND VPWR VGND sky130_ef_sc_hd__decap_12
XFILLER_42_1168 VPWR VGND VPWR VGND sky130_ef_sc_hd__decap_12
XFILLER_211_1449 VGND VGND VPWR VPWR sky130_fd_sc_hd__decap_6
XPHY_EDGE_ROW_118_1_Right_774 VGND VGND VPWR VPWR sky130_fd_sc_hd__decap_3
XFILLER_231_15 VPWR VGND VPWR VGND sky130_ef_sc_hd__decap_12
XFILLER_168_1315 VGND VGND VPWR VPWR sky130_fd_sc_hd__fill_1
XFILLER_226_949 VPWR VGND VPWR VGND sky130_ef_sc_hd__decap_12
XFILLER_252_245 VGND VGND VPWR VPWR sky130_fd_sc_hd__decap_6
XFILLER_209_1301 VPWR VGND VPWR VGND sky130_ef_sc_hd__decap_12
XFILLER_244_1203 VGND VGND VPWR VPWR sky130_fd_sc_hd__fill_1
XFILLER_212_109 VPWR VGND VPWR VGND sky130_ef_sc_hd__decap_12
XTAP_TAPCELL_ROW_63_2_4132 VGND VPWR sky130_fd_sc_hd__tapvpwrvgnd_1
XFILLER_252_289 VPWR VGND VPWR VGND sky130_ef_sc_hd__decap_12
XFILLER_234_993 VPWR VGND VPWR VGND sky130_ef_sc_hd__decap_12
XFILLER_205_161 VGND VGND VPWR VPWR sky130_fd_sc_hd__decap_6
XFILLER_209_1345 VPWR VGND VPWR VGND sky130_ef_sc_hd__decap_12
XFILLER_166_1061 VPWR VGND VPWR VGND sky130_ef_sc_hd__decap_12
XFILLER_178_525 VGND VGND VPWR VPWR sky130_fd_sc_hd__decap_6
XFILLER_221_665 VGND VGND VPWR VPWR sky130_fd_sc_hd__decap_6
XFILLER_53_1231 VPWR VGND VPWR VGND sky130_ef_sc_hd__decap_12
XFILLER_18_1351 VGND VGND VPWR VPWR sky130_fd_sc_hd__decap_6
XFILLER_178_569 VPWR VGND VPWR VGND sky130_ef_sc_hd__decap_12
XFILLER_220_153 VPWR VGND VPWR VGND sky130_ef_sc_hd__decap_12
XPHY_EDGE_ROW_54_2_Right_145 VGND VGND VPWR VPWR sky130_fd_sc_hd__decap_3
XFILLER_193_517 VPWR VGND VPWR VGND sky130_ef_sc_hd__decap_12
XFILLER_14_1215 VPWR VGND VPWR VGND sky130_ef_sc_hd__decap_12
XFILLER_53_1275 VPWR VGND VPWR VGND sky130_ef_sc_hd__decap_12
XFILLER_18_1395 VPWR VGND VPWR VGND sky130_ef_sc_hd__decap_12
XFILLER_105_1343 VPWR VGND VPWR VGND sky130_ef_sc_hd__decap_12
XFILLER_220_197 VPWR VGND VPWR VGND sky130_ef_sc_hd__decap_12
XFILLER_140_1245 VGND VGND VPWR VPWR sky130_fd_sc_hd__fill_1
XFILLER_14_1259 VPWR VGND VPWR VGND sky130_ef_sc_hd__decap_12
XFILLER_105_1387 VPWR VGND VPWR VGND sky130_ef_sc_hd__decap_12
XFILLER_88_1327 VPWR VGND VPWR VGND sky130_ef_sc_hd__decap_12
XFILLER_179_1455 VGND VGND VPWR VPWR sky130_fd_sc_hd__fill_1
XFILLER_109_39 VPWR VGND VPWR VGND sky130_ef_sc_hd__decap_12
XFILLER_238_1029 VGND VGND VPWR VPWR sky130_fd_sc_hd__decap_6
XFILLER_173_1021 VPWR VGND VPWR VGND sky130_ef_sc_hd__decap_12
XFILLER_170_981 VPWR VGND VPWR VGND sky130_ef_sc_hd__decap_12
XFILLER_125_27 VPWR VGND VPWR VGND sky130_ef_sc_hd__decap_12
XFILLER_173_1065 VPWR VGND VPWR VGND sky130_ef_sc_hd__decap_12
XFILLER_25_1311 VPWR VGND VPWR VGND sky130_ef_sc_hd__decap_12
XFILLER_64_1371 VPWR VGND VPWR VGND sky130_ef_sc_hd__decap_12
XFILLER_29_1491 VGND VGND VPWR VPWR sky130_fd_sc_hd__decap_6
XFILLER_229_721 VGND VGND VPWR VPWR sky130_fd_sc_hd__decap_6
XPHY_EDGE_ROW_254_Left_509 VGND VGND VPWR VPWR sky130_fd_sc_hd__decap_3
XFILLER_25_1355 VPWR VGND VPWR VGND sky130_ef_sc_hd__decap_12
XFILLER_112_1303 VPWR VGND VPWR VGND sky130_ef_sc_hd__decap_12
XTAP_TAPCELL_ROW_165_1320 VGND VPWR sky130_fd_sc_hd__tapvpwrvgnd_1
XTAP_TAPCELL_ROW_165_1331 VGND VPWR sky130_fd_sc_hd__tapvpwrvgnd_1
XFILLER_214_1073 VPWR VGND VPWR VGND sky130_ef_sc_hd__decap_12
XTAP_TAPCELL_ROW_4_958 VGND VPWR sky130_fd_sc_hd__tapvpwrvgnd_1
XFILLER_99_1423 VPWR VGND VPWR VGND sky130_ef_sc_hd__decap_12
XFILLER_116_1483 VPWR VGND VPWR VGND sky130_ef_sc_hd__decap_12
XFILLER_229_765 VPWR VGND VPWR VGND sky130_ef_sc_hd__decap_12
XFILLER_5_1449 VGND VGND VPWR VPWR sky130_fd_sc_hd__decap_6
XTAP_TAPCELL_ROW_4_969 VGND VPWR sky130_fd_sc_hd__tapvpwrvgnd_1
XTAP_TAPCELL_ROW_165_1342 VGND VPWR sky130_fd_sc_hd__tapvpwrvgnd_1
XFILLER_21_1219 VPWR VGND VPWR VGND sky130_ef_sc_hd__decap_12
XFILLER_151_1385 VGND VGND VPWR VPWR sky130_fd_sc_hd__fill_1
XTAP_TAPCELL_ROW_165_1353 VGND VPWR sky130_fd_sc_hd__tapvpwrvgnd_1
XFILLER_205_93 VPWR VGND VPWR VGND sky130_ef_sc_hd__decap_12
XFILLER_228_253 VPWR VGND VPWR VGND sky130_ef_sc_hd__decap_12
XFILLER_244_713 VPWR VGND VPWR VGND sky130_ef_sc_hd__decap_12
XFILLER_25_1399 VPWR VGND VPWR VGND sky130_ef_sc_hd__decap_12
XFILLER_141_15 VPWR VGND VPWR VGND sky130_ef_sc_hd__decap_12
XTAP_TAPCELL_ROW_159_2_4710 VGND VPWR sky130_fd_sc_hd__tapvpwrvgnd_1
XFILLER_99_1467 VPWR VGND VPWR VGND sky130_ef_sc_hd__decap_12
XFILLER_244_757 VPWR VGND VPWR VGND sky130_ef_sc_hd__decap_12
XFILLER_243_223 VGND VGND VPWR VPWR sky130_fd_sc_hd__fill_1
XFILLER_249_1169 VGND VGND VPWR VPWR sky130_fd_sc_hd__decap_6
XFILLER_227_1401 VPWR VGND VPWR VGND sky130_ef_sc_hd__decap_12
XFILLER_231_429 VPWR VGND VPWR VGND sky130_ef_sc_hd__decap_12
XFILLER_169_503 VGND VGND VPWR VPWR sky130_fd_sc_hd__fill_1
XTAP_TAPCELL_ROW_178_1703 VGND VPWR sky130_fd_sc_hd__tapvpwrvgnd_1
XFILLER_184_1161 VPWR VGND VPWR VGND sky130_ef_sc_hd__decap_12
XFILLER_221_81 VPWR VGND VPWR VGND sky130_ef_sc_hd__decap_12
XFILLER_212_643 VGND VGND VPWR VPWR sky130_fd_sc_hd__fill_1
XFILLER_196_333 VPWR VGND VPWR VGND sky130_ef_sc_hd__decap_12
XFILLER_200_805 VGND VGND VPWR VPWR sky130_fd_sc_hd__decap_6
XFILLER_71_1331 VPWR VGND VPWR VGND sky130_ef_sc_hd__decap_12
XFILLER_36_1451 VPWR VGND VPWR VGND sky130_ef_sc_hd__decap_12
XFILLER_197_889 VGND VGND VPWR VPWR sky130_fd_sc_hd__decap_6
XFILLER_145_1189 VPWR VGND VPWR VGND sky130_ef_sc_hd__decap_12
XFILLER_196_377 VPWR VGND VPWR VGND sky130_ef_sc_hd__decap_12
XFILLER_200_849 VPWR VGND VPWR VGND sky130_ef_sc_hd__decap_12
XFILLER_32_1315 VPWR VGND VPWR VGND sky130_ef_sc_hd__decap_12
Xclkload1 clknet_3_1__leaf_clk VGND VGND VPWR VPWR clkload1/Y sky130_fd_sc_hd__inv_6
XFILLER_36_1495 VPWR VGND VPWR VGND sky130_ef_sc_hd__decap_12
XFILLER_123_1443 VPWR VGND VPWR VGND sky130_ef_sc_hd__decap_12
XFILLER_221_1033 VPWR VGND VPWR VGND sky130_ef_sc_hd__decap_12
XFILLER_197_1511 VGND VGND VPWR VPWR sky130_fd_sc_hd__fill_1
Xwire149 _181_ VGND VGND VPWR VPWR net149 sky130_fd_sc_hd__clkbuf_1
XFILLER_32_1359 VPWR VGND VPWR VGND sky130_ef_sc_hd__decap_12
XFILLER_165_753 VGND VGND VPWR VPWR sky130_fd_sc_hd__decap_3
XFILLER_221_1077 VPWR VGND VPWR VGND sky130_ef_sc_hd__decap_12
XFILLER_180_701 VPWR VGND VPWR VGND sky130_ef_sc_hd__decap_12
XFILLER_4_914 VGND VGND VPWR VPWR sky130_fd_sc_hd__decap_8
XFILLER_119_3 VPWR VGND VPWR VGND sky130_ef_sc_hd__decap_12
XFILLER_4_925 VPWR VGND VPWR VGND sky130_ef_sc_hd__decap_12
XFILLER_165_797 VPWR VGND VPWR VGND sky130_ef_sc_hd__decap_12
XTAP_TAPCELL_ROW_230_3092 VGND VPWR sky130_fd_sc_hd__tapvpwrvgnd_1
XFILLER_3_446 VGND VGND VPWR VPWR sky130_fd_sc_hd__fill_2
XFILLER_191_1121 VPWR VGND VPWR VGND sky130_ef_sc_hd__decap_12
XFILLER_234_1427 VGND VGND VPWR VPWR sky130_fd_sc_hd__fill_1
XFILLER_239_529 VPWR VGND VPWR VGND sky130_ef_sc_hd__decap_12
XFILLER_43_1411 VPWR VGND VPWR VGND sky130_ef_sc_hd__decap_12
XFILLER_82_1471 VPWR VGND VPWR VGND sky130_ef_sc_hd__decap_12
XFILLER_182_77 VGND VGND VPWR VPWR sky130_fd_sc_hd__decap_6
XTAP_TAPCELL_ROW_243_3442 VGND VPWR sky130_fd_sc_hd__tapvpwrvgnd_1
XTAP_TAPCELL_ROW_243_3453 VGND VPWR sky130_fd_sc_hd__tapvpwrvgnd_1
XFILLER_43_1455 VPWR VGND VPWR VGND sky130_ef_sc_hd__decap_12
XFILLER_8_1073 VPWR VGND VPWR VGND sky130_ef_sc_hd__decap_12
XFILLER_208_905 VPWR VGND VPWR VGND sky130_ef_sc_hd__decap_12
XFILLER_232_1173 VPWR VGND VPWR VGND sky130_ef_sc_hd__decap_12
XFILLER_247_573 VPWR VGND VPWR VGND sky130_ef_sc_hd__decap_12
XFILLER_43_1499 VPWR VGND VPWR VGND sky130_ef_sc_hd__decap_12
XFILLER_78_1507 VGND VGND VPWR VPWR sky130_fd_sc_hd__decap_8
XFILLER_208_949 VPWR VGND VPWR VGND sky130_ef_sc_hd__decap_12
XFILLER_130_1469 VGND VGND VPWR VPWR sky130_fd_sc_hd__fill_1
XFILLER_234_245 VGND VGND VPWR VPWR sky130_fd_sc_hd__decap_6
XTAP_TAPCELL_ROW_48_2_4045 VGND VPWR sky130_fd_sc_hd__tapvpwrvgnd_1
XFILLER_216_993 VPWR VGND VPWR VGND sky130_ef_sc_hd__decap_12
XFILLER_234_289 VPWR VGND VPWR VGND sky130_ef_sc_hd__decap_12
XFILLER_250_749 VGND VGND VPWR VPWR sky130_fd_sc_hd__decap_6
XFILLER_163_1201 VPWR VGND VPWR VGND sky130_ef_sc_hd__decap_12
XFILLER_167_1381 VPWR VGND VPWR VGND sky130_ef_sc_hd__decap_12
XFILLER_199_193 VPWR VGND VPWR VGND sky130_ef_sc_hd__decap_12
XFILLER_188_867 VGND VGND VPWR VPWR sky130_fd_sc_hd__fill_1
XFILLER_203_665 VGND VGND VPWR VPWR sky130_fd_sc_hd__decap_6
XTAP_TAPCELL_ROW_237_3279 VGND VPWR sky130_fd_sc_hd__tapvpwrvgnd_1
XFILLER_163_1267 VGND VGND VPWR VPWR sky130_fd_sc_hd__decap_6
XFILLER_202_153 VPWR VGND VPWR VGND sky130_ef_sc_hd__decap_12
X_307_ net595 net530 dout0_q\[25\] VGND VGND VPWR VPWR _096_ sky130_fd_sc_hd__and3_1
XFILLER_175_517 VPWR VGND VPWR VGND sky130_ef_sc_hd__decap_12
XFILLER_50_1415 VPWR VGND VPWR VGND sky130_ef_sc_hd__decap_12
XFILLER_202_197 VPWR VGND VPWR VGND sky130_ef_sc_hd__decap_12
XFILLER_204_1253 VGND VGND VPWR VPWR sky130_fd_sc_hd__decap_6
XFILLER_200_1117 VPWR VGND VPWR VGND sky130_ef_sc_hd__decap_12
XFILLER_7_741 VGND VGND VPWR VPWR sky130_fd_sc_hd__decap_3
Xwire650 net20 VGND VGND VPWR VPWR net650 sky130_fd_sc_hd__buf_1
Xwire661 net11 VGND VGND VPWR VPWR net661 sky130_fd_sc_hd__buf_1
XFILLER_204_1297 VPWR VGND VPWR VGND sky130_ef_sc_hd__decap_12
XFILLER_183_561 VPWR VGND VPWR VGND sky130_ef_sc_hd__decap_12
Xwire672 net1 VGND VGND VPWR VPWR net672 sky130_fd_sc_hd__clkbuf_1
XFILLER_6_251 VGND VGND VPWR VPWR sky130_fd_sc_hd__fill_1
XFILLER_7_785 VGND VGND VPWR VPWR sky130_fd_sc_hd__fill_2
XFILLER_226_15 VPWR VGND VPWR VGND sky130_ef_sc_hd__decap_12
XFILLER_170_233 VPWR VGND VPWR VGND sky130_ef_sc_hd__decap_12
XFILLER_83_1213 VGND VGND VPWR VPWR sky130_fd_sc_hd__decap_4
XFILLER_174_1341 VPWR VGND VPWR VGND sky130_ef_sc_hd__decap_12
XFILLER_100_1295 VGND VGND VPWR VPWR sky130_fd_sc_hd__decap_6
XFILLER_170_277 VPWR VGND VPWR VGND sky130_ef_sc_hd__decap_12
XFILLER_170_1205 VPWR VGND VPWR VGND sky130_ef_sc_hd__decap_12
XFILLER_34_3 VPWR VGND VPWR VGND sky130_ef_sc_hd__decap_12
XFILLER_174_1385 VPWR VGND VPWR VGND sky130_ef_sc_hd__decap_12
XFILLER_61_1511 VGND VGND VPWR VPWR sky130_fd_sc_hd__decap_4
XFILLER_211_1213 VPWR VGND VPWR VGND sky130_ef_sc_hd__decap_12
XFILLER_250_1273 VPWR VGND VPWR VGND sky130_ef_sc_hd__decap_12
XFILLER_215_1393 VGND VGND VPWR VPWR sky130_fd_sc_hd__decap_6
XFILLER_226_713 VPWR VGND VPWR VGND sky130_ef_sc_hd__decap_12
XFILLER_211_1257 VPWR VGND VPWR VGND sky130_ef_sc_hd__decap_12
XTAP_TAPCELL_ROW_226_2983 VGND VPWR sky130_fd_sc_hd__tapvpwrvgnd_1
XTAP_TAPCELL_ROW_226_2994 VGND VPWR sky130_fd_sc_hd__tapvpwrvgnd_1
XFILLER_225_223 VGND VGND VPWR VPWR sky130_fd_sc_hd__fill_1
XFILLER_226_757 VPWR VGND VPWR VGND sky130_ef_sc_hd__decap_12
XPHY_EDGE_ROW_119_1_Right_775 VGND VGND VPWR VPWR sky130_fd_sc_hd__decap_3
XFILLER_246_1309 VGND VGND VPWR VPWR sky130_fd_sc_hd__decap_6
XFILLER_0_1313 VGND VGND VPWR VPWR sky130_fd_sc_hd__decap_3
XTAP_TAPCELL_ROW_222_2869 VGND VPWR sky130_fd_sc_hd__tapvpwrvgnd_1
XFILLER_241_727 VGND VGND VPWR VPWR sky130_fd_sc_hd__fill_1
XFILLER_213_429 VPWR VGND VPWR VGND sky130_ef_sc_hd__decap_12
XFILLER_0_1357 VPWR VGND VPWR VGND sky130_ef_sc_hd__decap_12
XFILLER_181_1301 VPWR VGND VPWR VGND sky130_ef_sc_hd__decap_12
XFILLER_185_1481 VPWR VGND VPWR VGND sky130_ef_sc_hd__decap_12
XFILLER_209_1175 VGND VGND VPWR VPWR sky130_fd_sc_hd__fill_1
XFILLER_178_333 VPWR VGND VPWR VGND sky130_ef_sc_hd__decap_12
XFILLER_181_1345 VPWR VGND VPWR VGND sky130_ef_sc_hd__decap_12
XFILLER_90_1239 VGND VGND VPWR VPWR sky130_fd_sc_hd__decap_6
XFILLER_179_889 VGND VGND VPWR VPWR sky130_fd_sc_hd__decap_6
XFILLER_221_473 VPWR VGND VPWR VGND sky130_ef_sc_hd__decap_12
XFILLER_178_377 VPWR VGND VPWR VGND sky130_ef_sc_hd__decap_12
XFILLER_194_837 VPWR VGND VPWR VGND sky130_ef_sc_hd__decap_12
XFILLER_222_1353 VPWR VGND VPWR VGND sky130_ef_sc_hd__decap_12
XPHY_EDGE_ROW_55_2_Right_146 VGND VGND VPWR VPWR sky130_fd_sc_hd__decap_3
XFILLER_222_1397 VPWR VGND VPWR VGND sky130_ef_sc_hd__decap_12
XFILLER_20_15 VPWR VGND VPWR VGND sky130_ef_sc_hd__decap_12
XFILLER_136_15 VPWR VGND VPWR VGND sky130_ef_sc_hd__decap_12
XFILLER_192_1441 VPWR VGND VPWR VGND sky130_ef_sc_hd__decap_12
XFILLER_255_1173 VGND VGND VPWR VPWR sky130_fd_sc_hd__decap_3
XTAP_TAPCELL_ROW_167_1404 VGND VPWR sky130_fd_sc_hd__tapvpwrvgnd_1
XFILLER_192_1485 VPWR VGND VPWR VGND sky130_ef_sc_hd__decap_12
XFILLER_0_449 VGND VGND VPWR VPWR sky130_fd_sc_hd__fill_1
XTAP_TAPCELL_ROW_54_2_4077 VGND VPWR sky130_fd_sc_hd__tapvpwrvgnd_1
XFILLER_29_57 VGND VGND VPWR VPWR sky130_fd_sc_hd__decap_8
XFILLER_5_1213 VPWR VGND VPWR VGND sky130_ef_sc_hd__decap_12
XFILLER_29_68 VGND VGND VPWR VPWR sky130_fd_sc_hd__decap_3
XFILLER_233_1493 VPWR VGND VPWR VGND sky130_ef_sc_hd__decap_12
XFILLER_99_1231 VPWR VGND VPWR VGND sky130_ef_sc_hd__decap_12
XFILLER_229_573 VPWR VGND VPWR VGND sky130_ef_sc_hd__decap_12
XFILLER_5_1257 VPWR VGND VPWR VGND sky130_ef_sc_hd__decap_12
XFILLER_99_1275 VPWR VGND VPWR VGND sky130_ef_sc_hd__decap_12
XFILLER_112_1177 VPWR VGND VPWR VGND sky130_ef_sc_hd__decap_12
XFILLER_216_245 VGND VGND VPWR VPWR sky130_fd_sc_hd__decap_6
XFILLER_189_609 VGND VGND VPWR VPWR sky130_fd_sc_hd__decap_6
XFILLER_244_587 VGND VGND VPWR VPWR sky130_fd_sc_hd__fill_1
XFILLER_216_289 VPWR VGND VPWR VGND sky130_ef_sc_hd__decap_12
XFILLER_227_1231 VGND VGND VPWR VPWR sky130_fd_sc_hd__fill_1
XFILLER_232_749 VGND VGND VPWR VPWR sky130_fd_sc_hd__decap_6
XFILLER_231_237 VPWR VGND VPWR VGND sky130_ef_sc_hd__decap_12
XTAP_TAPCELL_ROW_32_2_3947 VGND VPWR sky130_fd_sc_hd__tapvpwrvgnd_1
XFILLER_101_51 VGND VGND VPWR VPWR sky130_fd_sc_hd__decap_4
XFILLER_197_653 VPWR VGND VPWR VGND sky130_ef_sc_hd__decap_12
XFILLER_160_1407 VGND VGND VPWR VPWR sky130_fd_sc_hd__decap_6
XFILLER_196_141 VPWR VGND VPWR VGND sky130_ef_sc_hd__decap_12
XFILLER_200_613 VPWR VGND VPWR VGND sky130_ef_sc_hd__decap_12
XFILLER_240_793 VPWR VGND VPWR VGND sky130_ef_sc_hd__decap_12
XFILLER_236_3 VPWR VGND VPWR VGND sky130_ef_sc_hd__decap_12
XFILLER_197_697 VPWR VGND VPWR VGND sky130_ef_sc_hd__decap_12
XFILLER_61_66 VGND VGND VPWR VPWR sky130_fd_sc_hd__decap_4
XFILLER_200_657 VPWR VGND VPWR VGND sky130_ef_sc_hd__decap_12
XFILLER_240_1453 VPWR VGND VPWR VGND sky130_ef_sc_hd__decap_12
XFILLER_177_55 VGND VGND VPWR VPWR sky130_fd_sc_hd__fill_1
XTAP_TAPCELL_ROW_232_3143 VGND VPWR sky130_fd_sc_hd__tapvpwrvgnd_1
XTAP_TAPCELL_ROW_232_3154 VGND VPWR sky130_fd_sc_hd__tapvpwrvgnd_1
XFILLER_201_1437 VPWR VGND VPWR VGND sky130_ef_sc_hd__decap_12
XFILLER_240_1497 VPWR VGND VPWR VGND sky130_ef_sc_hd__decap_12
XFILLER_123_1273 VGND VGND VPWR VPWR sky130_fd_sc_hd__fill_1
XFILLER_165_561 VPWR VGND VPWR VGND sky130_ef_sc_hd__decap_12
XFILLER_158_1303 VPWR VGND VPWR VGND sky130_ef_sc_hd__decap_12
XFILLER_32_1189 VGND VGND VPWR VPWR sky130_fd_sc_hd__fill_1
XFILLER_67_1219 VPWR VGND VPWR VGND sky130_ef_sc_hd__decap_12
XFILLER_4_733 VGND VGND VPWR VPWR sky130_fd_sc_hd__fill_1
XFILLER_180_531 VGND VGND VPWR VPWR sky130_fd_sc_hd__fill_1
XTAP_TAPCELL_ROW_151_2_4661 VGND VPWR sky130_fd_sc_hd__tapvpwrvgnd_1
XTAP_TAPCELL_ROW_245_3504 VGND VPWR sky130_fd_sc_hd__tapvpwrvgnd_1
XFILLER_238_1371 VGND VGND VPWR VPWR sky130_fd_sc_hd__fill_1
XFILLER_3_287 VGND VGND VPWR VPWR sky130_fd_sc_hd__fill_1
XFILLER_239_337 VPWR VGND VPWR VGND sky130_ef_sc_hd__decap_12
XFILLER_86_41 VPWR VGND VPWR VGND sky130_ef_sc_hd__decap_12
XFILLER_254_307 VGND VGND VPWR VPWR sky130_fd_sc_hd__fill_1
XTAP_TAPCELL_ROW_7_1038 VGND VPWR sky130_fd_sc_hd__tapvpwrvgnd_1
XFILLER_187_1009 VPWR VGND VPWR VGND sky130_ef_sc_hd__decap_12
XFILLER_208_713 VPWR VGND VPWR VGND sky130_ef_sc_hd__decap_12
XFILLER_248_893 VPWR VGND VPWR VGND sky130_ef_sc_hd__decap_12
XTAP_TAPCELL_ROW_7_1049 VGND VPWR sky130_fd_sc_hd__tapvpwrvgnd_1
XFILLER_78_1315 VPWR VGND VPWR VGND sky130_ef_sc_hd__decap_12
XTAP_TAPCELL_ROW_98_2_4342 VGND VPWR sky130_fd_sc_hd__tapvpwrvgnd_1
XFILLER_207_223 VGND VGND VPWR VPWR sky130_fd_sc_hd__fill_1
XFILLER_208_757 VPWR VGND VPWR VGND sky130_ef_sc_hd__decap_12
XFILLER_78_1359 VPWR VGND VPWR VGND sky130_ef_sc_hd__decap_12
XFILLER_228_1017 VPWR VGND VPWR VGND sky130_ef_sc_hd__decap_12
XFILLER_250_513 VPWR VGND VPWR VGND sky130_ef_sc_hd__decap_12
XFILLER_223_727 VGND VGND VPWR VPWR sky130_fd_sc_hd__fill_1
XFILLER_165_1329 VPWR VGND VPWR VGND sky130_ef_sc_hd__decap_12
XFILLER_250_557 VPWR VGND VPWR VGND sky130_ef_sc_hd__decap_12
XFILLER_206_1315 VGND VGND VPWR VPWR sky130_fd_sc_hd__fill_1
XFILLER_203_473 VPWR VGND VPWR VGND sky130_ef_sc_hd__decap_12
XFILLER_176_837 VPWR VGND VPWR VGND sky130_ef_sc_hd__decap_12
XFILLER_198_1105 VPWR VGND VPWR VGND sky130_ef_sc_hd__decap_12
XFILLER_15_1343 VPWR VGND VPWR VGND sky130_ef_sc_hd__decap_12
XFILLER_89_1411 VPWR VGND VPWR VGND sky130_ef_sc_hd__decap_12
XFILLER_106_1471 VPWR VGND VPWR VGND sky130_ef_sc_hd__decap_12
XFILLER_204_1061 VPWR VGND VPWR VGND sky130_ef_sc_hd__decap_12
XFILLER_50_1245 VGND VGND VPWR VPWR sky130_fd_sc_hd__fill_1
XPHY_EDGE_ROW_155_2_Left_657 VGND VGND VPWR VPWR sky130_fd_sc_hd__decap_3
XFILLER_198_1149 VPWR VGND VPWR VGND sky130_ef_sc_hd__decap_12
XFILLER_15_1387 VPWR VGND VPWR VGND sky130_ef_sc_hd__decap_12
XFILLER_239_1113 VGND VGND VPWR VPWR sky130_fd_sc_hd__decap_6
Xmax_cap202 _187_ VGND VGND VPWR VPWR net202 sky130_fd_sc_hd__clkbuf_1
XFILLER_89_1455 VPWR VGND VPWR VGND sky130_ef_sc_hd__decap_12
XFILLER_184_881 VPWR VGND VPWR VGND sky130_ef_sc_hd__decap_12
Xwire480 net481 VGND VGND VPWR VPWR net480 sky130_fd_sc_hd__clkbuf_1
XFILLER_102_1357 VGND VGND VPWR VPWR sky130_fd_sc_hd__fill_1
Xmax_cap213 net214 VGND VGND VPWR VPWR net213 sky130_fd_sc_hd__clkbuf_1
XTAP_TAPCELL_ROW_215_2684 VGND VPWR sky130_fd_sc_hd__tapvpwrvgnd_1
Xwire491 net492 VGND VGND VPWR VPWR net491 sky130_fd_sc_hd__clkbuf_1
XTAP_TAPCELL_ROW_215_2695 VGND VPWR sky130_fd_sc_hd__tapvpwrvgnd_1
XFILLER_237_69 VPWR VGND VPWR VGND sky130_ef_sc_hd__decap_12
XFILLER_183_391 VGND VGND VPWR VPWR sky130_fd_sc_hd__fill_1
XFILLER_239_1157 VPWR VGND VPWR VGND sky130_ef_sc_hd__decap_12
XPHY_EDGE_ROW_25_1_Left_280 VGND VGND VPWR VPWR sky130_fd_sc_hd__decap_3
Xmax_cap246 net247 VGND VGND VPWR VPWR net246 sky130_fd_sc_hd__clkbuf_1
XFILLER_89_1499 VPWR VGND VPWR VGND sky130_ef_sc_hd__decap_12
XFILLER_171_553 VGND VGND VPWR VPWR sky130_fd_sc_hd__decap_6
XFILLER_171_597 VPWR VGND VPWR VGND sky130_ef_sc_hd__decap_12
XFILLER_217_1455 VGND VGND VPWR VPWR sky130_fd_sc_hd__fill_1
XFILLER_106_29 VPWR VGND VPWR VGND sky130_ef_sc_hd__decap_12
XFILLER_253_57 VPWR VGND VPWR VGND sky130_ef_sc_hd__decap_12
XFILLER_170_1035 VGND VGND VPWR VPWR sky130_fd_sc_hd__fill_1
XFILLER_135_1177 VPWR VGND VPWR VGND sky130_ef_sc_hd__decap_12
XFILLER_22_1303 VPWR VGND VPWR VGND sky130_ef_sc_hd__decap_12
XFILLER_211_1021 VPWR VGND VPWR VGND sky130_ef_sc_hd__decap_12
XFILLER_26_1483 VPWR VGND VPWR VGND sky130_ef_sc_hd__decap_12
XFILLER_245_329 VGND VGND VPWR VPWR sky130_fd_sc_hd__decap_6
XFILLER_61_1385 VGND VGND VPWR VPWR sky130_fd_sc_hd__fill_1
XFILLER_211_1065 VPWR VGND VPWR VGND sky130_ef_sc_hd__decap_12
XFILLER_96_1415 VPWR VGND VPWR VGND sky130_ef_sc_hd__decap_12
XFILLER_113_1497 VGND VGND VPWR VPWR sky130_fd_sc_hd__fill_1
XFILLER_246_1117 VPWR VGND VPWR VGND sky130_ef_sc_hd__decap_12
XFILLER_0_1121 VPWR VGND VPWR VGND sky130_ef_sc_hd__decap_12
XFILLER_226_587 VGND VGND VPWR VPWR sky130_fd_sc_hd__fill_1
XFILLER_253_373 VPWR VGND VPWR VGND sky130_ef_sc_hd__decap_12
XFILLER_214_749 VGND VGND VPWR VPWR sky130_fd_sc_hd__decap_6
XFILLER_213_237 VPWR VGND VPWR VGND sky130_ef_sc_hd__decap_12
XFILLER_202_83 VGND VGND VPWR VPWR sky130_fd_sc_hd__fill_1
XFILLER_107_1213 VGND VGND VPWR VPWR sky130_fd_sc_hd__decap_4
XFILLER_179_653 VPWR VGND VPWR VGND sky130_ef_sc_hd__decap_12
XFILLER_178_141 VPWR VGND VPWR VGND sky130_ef_sc_hd__decap_12
XFILLER_194_601 VPWR VGND VPWR VGND sky130_ef_sc_hd__decap_12
XFILLER_222_793 VPWR VGND VPWR VGND sky130_ef_sc_hd__decap_12
XFILLER_146_1295 VGND VGND VPWR VPWR sky130_fd_sc_hd__decap_6
XFILLER_181_1175 VGND VGND VPWR VPWR sky130_fd_sc_hd__fill_1
XFILLER_55_1189 VPWR VGND VPWR VGND sky130_ef_sc_hd__decap_12
XFILLER_179_697 VPWR VGND VPWR VGND sky130_ef_sc_hd__decap_12
XFILLER_221_281 VPWR VGND VPWR VGND sky130_ef_sc_hd__decap_12
XFILLER_193_111 VGND VGND VPWR VPWR sky130_fd_sc_hd__fill_1
XPHY_EDGE_ROW_87_2_Left_589 VGND VGND VPWR VPWR sky130_fd_sc_hd__decap_3
XFILLER_194_645 VPWR VGND VPWR VGND sky130_ef_sc_hd__decap_12
XFILLER_33_1443 VPWR VGND VPWR VGND sky130_ef_sc_hd__decap_12
XFILLER_222_1161 VPWR VGND VPWR VGND sky130_ef_sc_hd__decap_12
XFILLER_120_1413 VGND VGND VPWR VPWR sky130_fd_sc_hd__fill_1
XPHY_EDGE_ROW_56_2_Right_147 VGND VGND VPWR VPWR sky130_fd_sc_hd__decap_3
XFILLER_181_317 VPWR VGND VPWR VGND sky130_ef_sc_hd__decap_12
XFILLER_147_69 VGND VGND VPWR VPWR sky130_fd_sc_hd__fill_2
XFILLER_235_1511 VGND VGND VPWR VPWR sky130_fd_sc_hd__fill_1
Xoutput47 net543 VGND VGND VPWR VPWR acc_out[13] sky130_fd_sc_hd__buf_2
Xoutput58 net58 VGND VGND VPWR VPWR acc_out[23] sky130_fd_sc_hd__buf_2
Xoutput69 net557 VGND VGND VPWR VPWR acc_out[4] sky130_fd_sc_hd__buf_2
XTAP_TAPCELL_ROW_116_2_4450 VGND VPWR sky130_fd_sc_hd__tapvpwrvgnd_1
XFILLER_163_57 VPWR VGND VPWR VGND sky130_ef_sc_hd__decap_12
XFILLER_153_1255 VPWR VGND VPWR VGND sky130_ef_sc_hd__decap_12
XFILLER_114_1239 VGND VGND VPWR VPWR sky130_fd_sc_hd__decap_6
XFILLER_236_307 VGND VGND VPWR VPWR sky130_fd_sc_hd__fill_1
XFILLER_5_1021 VPWR VGND VPWR VGND sky130_ef_sc_hd__decap_12
XFILLER_153_1299 VPWR VGND VPWR VGND sky130_ef_sc_hd__decap_12
XTAP_TAPCELL_ROW_84_2_4261 VGND VPWR sky130_fd_sc_hd__tapvpwrvgnd_1
XFILLER_248_189 VGND VGND VPWR VPWR sky130_fd_sc_hd__decap_6
XFILLER_186_3 VPWR VGND VPWR VGND sky130_ef_sc_hd__decap_12
XFILLER_188_1329 VPWR VGND VPWR VGND sky130_ef_sc_hd__decap_12
X_641_ clknet_3_0__leaf_clk acc_core.adder.cla_blocks\[1\].block.sum\[3\] _049_ VGND
+ VGND VPWR VPWR net72 sky130_fd_sc_hd__dfrtp_1
XFILLER_245_841 VPWR VGND VPWR VGND sky130_ef_sc_hd__decap_12
XFILLER_5_1065 VPWR VGND VPWR VGND sky130_ef_sc_hd__decap_12
XFILLER_40_1469 VGND VGND VPWR VPWR sky130_fd_sc_hd__fill_1
X_572_ net666 VGND VGND VPWR VPWR _054_ sky130_fd_sc_hd__inv_2
XFILLER_205_727 VGND VGND VPWR VPWR sky130_fd_sc_hd__fill_1
XFILLER_229_1337 VGND VGND VPWR VPWR sky130_fd_sc_hd__decap_6
XFILLER_232_513 VPWR VGND VPWR VGND sky130_ef_sc_hd__decap_12
XTAP_TAPCELL_ROW_21_1_1156 VGND VPWR sky130_fd_sc_hd__tapvpwrvgnd_1
XFILLER_189_417 VPWR VGND VPWR VGND sky130_ef_sc_hd__decap_12
XFILLER_73_1201 VPWR VGND VPWR VGND sky130_ef_sc_hd__decap_12
XFILLER_232_557 VPWR VGND VPWR VGND sky130_ef_sc_hd__decap_12
XFILLER_72_65 VGND VGND VPWR VPWR sky130_fd_sc_hd__decap_6
XFILLER_164_1351 VGND VGND VPWR VPWR sky130_fd_sc_hd__decap_6
XTAP_TAPCELL_ROW_234_3205 VGND VPWR sky130_fd_sc_hd__tapvpwrvgnd_1
XFILLER_198_973 VGND VGND VPWR VPWR sky130_fd_sc_hd__decap_6
XTAP_TAPCELL_ROW_234_3216 VGND VPWR sky130_fd_sc_hd__tapvpwrvgnd_1
XTAP_TAPCELL_ROW_76_2_4209 VGND VPWR sky130_fd_sc_hd__tapvpwrvgnd_1
XFILLER_73_1267 VGND VGND VPWR VPWR sky130_fd_sc_hd__decap_6
XFILLER_160_1215 VPWR VGND VPWR VGND sky130_ef_sc_hd__decap_12
XFILLER_197_461 VPWR VGND VPWR VGND sky130_ef_sc_hd__decap_12
XFILLER_201_933 VPWR VGND VPWR VGND sky130_ef_sc_hd__decap_12
XFILLER_188_65 VPWR VGND VPWR VGND sky130_ef_sc_hd__decap_12
XFILLER_9_825 VPWR VGND VPWR VGND sky130_ef_sc_hd__decap_12
XFILLER_164_1395 VPWR VGND VPWR VGND sky130_ef_sc_hd__decap_12
XFILLER_200_421 VPWR VGND VPWR VGND sky130_ef_sc_hd__decap_12
XFILLER_8_324 VGND VGND VPWR VPWR sky130_fd_sc_hd__decap_6
XPHY_EDGE_ROW_90_1_Left_345 VGND VGND VPWR VPWR sky130_fd_sc_hd__decap_3
XFILLER_125_1379 VGND VGND VPWR VPWR sky130_fd_sc_hd__decap_6
XFILLER_160_1259 VPWR VGND VPWR VGND sky130_ef_sc_hd__decap_12
XFILLER_199_1425 VPWR VGND VPWR VGND sky130_ef_sc_hd__decap_12
XFILLER_201_977 VPWR VGND VPWR VGND sky130_ef_sc_hd__decap_12
XFILLER_184_133 VGND VGND VPWR VPWR sky130_fd_sc_hd__decap_6
XFILLER_201_1201 VPWR VGND VPWR VGND sky130_ef_sc_hd__decap_12
XFILLER_240_1261 VPWR VGND VPWR VGND sky130_ef_sc_hd__decap_12
XFILLER_9_869 VPWR VGND VPWR VGND sky130_ef_sc_hd__decap_12
XFILLER_205_1381 VPWR VGND VPWR VGND sky130_ef_sc_hd__decap_12
XFILLER_199_1469 VPWR VGND VPWR VGND sky130_ef_sc_hd__decap_12
XFILLER_166_881 VPWR VGND VPWR VGND sky130_ef_sc_hd__decap_12
XFILLER_184_177 VPWR VGND VPWR VGND sky130_ef_sc_hd__decap_12
XFILLER_201_1245 VPWR VGND VPWR VGND sky130_ef_sc_hd__decap_12
XFILLER_201_1289 VPWR VGND VPWR VGND sky130_ef_sc_hd__decap_12
XFILLER_158_1177 VPWR VGND VPWR VGND sky130_ef_sc_hd__decap_12
XFILLER_181_895 VGND VGND VPWR VPWR sky130_fd_sc_hd__fill_1
XFILLER_193_1057 VGND VGND VPWR VPWR sky130_fd_sc_hd__decap_6
XFILLER_207_39 VPWR VGND VPWR VGND sky130_ef_sc_hd__decap_12
XFILLER_10_1295 VGND VGND VPWR VPWR sky130_fd_sc_hd__decap_6
XFILLER_97_51 VGND VGND VPWR VPWR sky130_fd_sc_hd__decap_4
XFILLER_80_1227 VPWR VGND VPWR VGND sky130_ef_sc_hd__decap_12
XFILLER_132_1339 VPWR VGND VPWR VGND sky130_ef_sc_hd__decap_12
XFILLER_223_27 VPWR VGND VPWR VGND sky130_ef_sc_hd__decap_12
XFILLER_239_167 VGND VGND VPWR VPWR sky130_fd_sc_hd__fill_1
XFILLER_171_1399 VGND VGND VPWR VPWR sky130_fd_sc_hd__fill_1
XFILLER_212_1341 VPWR VGND VPWR VGND sky130_ef_sc_hd__decap_12
XFILLER_227_329 VGND VGND VPWR VPWR sky130_fd_sc_hd__decap_6
XFILLER_212_1385 VPWR VGND VPWR VGND sky130_ef_sc_hd__decap_12
XFILLER_247_1437 VPWR VGND VPWR VGND sky130_ef_sc_hd__decap_12
XFILLER_235_373 VPWR VGND VPWR VGND sky130_ef_sc_hd__decap_12
XFILLER_208_587 VGND VGND VPWR VPWR sky130_fd_sc_hd__fill_1
XFILLER_251_833 VGND VGND VPWR VPWR sky130_fd_sc_hd__decap_6
XTAP_TAPCELL_ROW_204_2385 VGND VPWR sky130_fd_sc_hd__tapvpwrvgnd_1
XFILLER_250_321 VPWR VGND VPWR VGND sky130_ef_sc_hd__decap_12
XFILLER_78_1189 VGND VGND VPWR VPWR sky130_fd_sc_hd__fill_1
XTAP_TAPCELL_ROW_204_2396 VGND VPWR sky130_fd_sc_hd__tapvpwrvgnd_1
XFILLER_251_877 VPWR VGND VPWR VGND sky130_ef_sc_hd__decap_12
XFILLER_91_1323 VGND VGND VPWR VPWR sky130_fd_sc_hd__decap_6
XFILLER_189_951 VGND VGND VPWR VPWR sky130_fd_sc_hd__fill_1
XFILLER_250_365 VPWR VGND VPWR VGND sky130_ef_sc_hd__decap_12
XTAP_TAPCELL_ROW_196_2164 VGND VPWR sky130_fd_sc_hd__tapvpwrvgnd_1
XTAP_TAPCELL_ROW_196_2175 VGND VPWR sky130_fd_sc_hd__tapvpwrvgnd_1
XFILLER_176_601 VPWR VGND VPWR VGND sky130_ef_sc_hd__decap_12
XTAP_TAPCELL_ROW_196_2186 VGND VPWR sky130_fd_sc_hd__tapvpwrvgnd_1
XFILLER_91_1367 VPWR VGND VPWR VGND sky130_ef_sc_hd__decap_12
XFILLER_143_1435 VGND VGND VPWR VPWR sky130_fd_sc_hd__decap_6
XFILLER_204_793 VPWR VGND VPWR VGND sky130_ef_sc_hd__decap_12
XFILLER_203_281 VPWR VGND VPWR VGND sky130_ef_sc_hd__decap_12
XFILLER_175_111 VGND VGND VPWR VPWR sky130_fd_sc_hd__fill_1
XFILLER_176_645 VPWR VGND VPWR VGND sky130_ef_sc_hd__decap_12
XTAP_TAPCELL_ROW_217_2735 VGND VPWR sky130_fd_sc_hd__tapvpwrvgnd_1
XFILLER_143_1479 VPWR VGND VPWR VGND sky130_ef_sc_hd__decap_12
XTAP_TAPCELL_ROW_217_2746 VGND VPWR sky130_fd_sc_hd__tapvpwrvgnd_1
XTAP_TAPCELL_ROW_217_2757 VGND VPWR sky130_fd_sc_hd__tapvpwrvgnd_1
XFILLER_223_1481 VPWR VGND VPWR VGND sky130_ef_sc_hd__decap_12
XFILLER_178_1509 VGND VGND VPWR VPWR sky130_fd_sc_hd__decap_6
XFILLER_191_615 VGND VGND VPWR VPWR sky130_fd_sc_hd__fill_1
XFILLER_7_93 VGND VGND VPWR VPWR sky130_fd_sc_hd__fill_2
XFILLER_102_1165 VPWR VGND VPWR VGND sky130_ef_sc_hd__decap_12
XTAP_TAPCELL_ROW_90_2_4293 VGND VPWR sky130_fd_sc_hd__tapvpwrvgnd_1
XTAP_TAPCELL_ROW_89_2_4287 VGND VPWR sky130_fd_sc_hd__tapvpwrvgnd_1
XFILLER_117_39 VPWR VGND VPWR VGND sky130_ef_sc_hd__decap_12
XFILLER_137_1217 VGND VGND VPWR VPWR sky130_fd_sc_hd__fill_1
XFILLER_171_361 VPWR VGND VPWR VGND sky130_ef_sc_hd__decap_12
XFILLER_133_27 VPWR VGND VPWR VGND sky130_ef_sc_hd__decap_12
XFILLER_150_1439 VPWR VGND VPWR VGND sky130_ef_sc_hd__decap_12
XFILLER_218_307 VGND VGND VPWR VPWR sky130_fd_sc_hd__fill_1
XFILLER_6_1341 VPWR VGND VPWR VGND sky130_ef_sc_hd__decap_12
XFILLER_230_1441 VPWR VGND VPWR VGND sky130_ef_sc_hd__decap_12
XFILLER_245_137 VPWR VGND VPWR VGND sky130_ef_sc_hd__decap_12
XFILLER_2_1205 VPWR VGND VPWR VGND sky130_ef_sc_hd__decap_12
XTAP_TAPCELL_ROW_185_1890 VGND VPWR sky130_fd_sc_hd__tapvpwrvgnd_1
XFILLER_227_841 VPWR VGND VPWR VGND sky130_ef_sc_hd__decap_12
XFILLER_6_1385 VPWR VGND VPWR VGND sky130_ef_sc_hd__decap_12
XFILLER_230_1485 VPWR VGND VPWR VGND sky130_ef_sc_hd__decap_12
XFILLER_22_1177 VPWR VGND VPWR VGND sky130_ef_sc_hd__decap_12
XFILLER_242_811 VGND VGND VPWR VPWR sky130_fd_sc_hd__fill_1
XTAP_TAPCELL_ROW_181_1765 VGND VPWR sky130_fd_sc_hd__tapvpwrvgnd_1
XTAP_TAPCELL_ROW_49_2_4050 VGND VPWR sky130_fd_sc_hd__tapvpwrvgnd_1
XFILLER_96_1245 VGND VGND VPWR VPWR sky130_fd_sc_hd__fill_1
XTAP_TAPCELL_ROW_181_1776 VGND VPWR sky130_fd_sc_hd__tapvpwrvgnd_1
XFILLER_213_93 VPWR VGND VPWR VGND sky130_ef_sc_hd__decap_12
XFILLER_214_513 VPWR VGND VPWR VGND sky130_ef_sc_hd__decap_12
XFILLER_26_47 VGND VGND VPWR VPWR sky130_fd_sc_hd__fill_1
XFILLER_254_693 VGND VGND VPWR VPWR sky130_fd_sc_hd__decap_6
XFILLER_253_181 VPWR VGND VPWR VGND sky130_ef_sc_hd__decap_12
XFILLER_148_1357 VGND VGND VPWR VPWR sky130_fd_sc_hd__fill_1
XFILLER_214_557 VPWR VGND VPWR VGND sky130_ef_sc_hd__decap_12
XTAP_TAPCELL_ROW_62_2_4128 VGND VPWR sky130_fd_sc_hd__tapvpwrvgnd_1
XFILLER_179_461 VPWR VGND VPWR VGND sky130_ef_sc_hd__decap_12
XFILLER_70_1407 VGND VGND VPWR VPWR sky130_fd_sc_hd__decap_6
XFILLER_195_921 VPWR VGND VPWR VGND sky130_ef_sc_hd__decap_12
XFILLER_195_965 VPWR VGND VPWR VGND sky130_ef_sc_hd__decap_12
XFILLER_166_133 VGND VGND VPWR VPWR sky130_fd_sc_hd__decap_6
XTAP_TAPCELL_ROW_42_2_4004 VGND VPWR sky130_fd_sc_hd__tapvpwrvgnd_1
XFILLER_194_475 VGND VGND VPWR VPWR sky130_fd_sc_hd__fill_1
XFILLER_33_1273 VGND VGND VPWR VPWR sky130_fd_sc_hd__fill_1
XFILLER_166_177 VPWR VGND VPWR VGND sky130_ef_sc_hd__decap_12
XFILLER_182_637 VGND VGND VPWR VPWR sky130_fd_sc_hd__decap_6
XFILLER_68_1303 VPWR VGND VPWR VGND sky130_ef_sc_hd__decap_12
XFILLER_181_125 VPWR VGND VPWR VGND sky130_ef_sc_hd__decap_12
XPHY_EDGE_ROW_57_2_Right_148 VGND VGND VPWR VPWR sky130_fd_sc_hd__decap_3
XFILLER_181_169 VPWR VGND VPWR VGND sky130_ef_sc_hd__decap_12
XFILLER_218_1005 VPWR VGND VPWR VGND sky130_ef_sc_hd__decap_12
XFILLER_101_3 VPWR VGND VPWR VGND sky130_ef_sc_hd__decap_12
XFILLER_190_681 VPWR VGND VPWR VGND sky130_ef_sc_hd__decap_12
XFILLER_159_1497 VGND VGND VPWR VPWR sky130_fd_sc_hd__fill_1
XFILLER_218_1049 VPWR VGND VPWR VGND sky130_ef_sc_hd__decap_12
XTAP_TAPCELL_ROW_227_3020 VGND VPWR sky130_fd_sc_hd__tapvpwrvgnd_1
XFILLER_209_329 VGND VGND VPWR VPWR sky130_fd_sc_hd__decap_6
XFILLER_190_77 VGND VGND VPWR VPWR sky130_fd_sc_hd__decap_6
XFILLER_229_1101 VPWR VGND VPWR VGND sky130_ef_sc_hd__decap_12
X_624_ clknet_3_4__leaf_clk dout0\[22\] _032_ VGND VGND VPWR VPWR dout0_q\[22\] sky130_fd_sc_hd__dfrtp_1
XFILLER_79_1443 VPWR VGND VPWR VGND sky130_ef_sc_hd__decap_12
XFILLER_245_671 VGND VGND VPWR VPWR sky130_fd_sc_hd__fill_1
XFILLER_217_373 VPWR VGND VPWR VGND sky130_ef_sc_hd__decap_12
XFILLER_233_833 VGND VGND VPWR VPWR sky130_fd_sc_hd__decap_6
XFILLER_229_1145 VPWR VGND VPWR VGND sky130_ef_sc_hd__decap_12
X_555_ net670 VGND VGND VPWR VPWR _037_ sky130_fd_sc_hd__inv_2
XFILLER_75_1329 VGND VGND VPWR VPWR sky130_fd_sc_hd__fill_1
XFILLER_232_321 VPWR VGND VPWR VGND sky130_ef_sc_hd__decap_12
XFILLER_189_225 VPWR VGND VPWR VGND sky130_ef_sc_hd__decap_12
XFILLER_233_877 VPWR VGND VPWR VGND sky130_ef_sc_hd__decap_12
XFILLER_225_1009 VPWR VGND VPWR VGND sky130_ef_sc_hd__decap_12
XFILLER_229_1189 VPWR VGND VPWR VGND sky130_ef_sc_hd__decap_12
XFILLER_232_365 VPWR VGND VPWR VGND sky130_ef_sc_hd__decap_12
X_486_ net499 _248_ VGND VGND VPWR VPWR _249_ sky130_fd_sc_hd__or2_1
XFILLER_198_781 VPWR VGND VPWR VGND sky130_ef_sc_hd__decap_12
XFILLER_201_741 VPWR VGND VPWR VGND sky130_ef_sc_hd__decap_12
XFILLER_8_121 VPWR VGND VPWR VGND sky130_ef_sc_hd__decap_12
XFILLER_125_1165 VPWR VGND VPWR VGND sky130_ef_sc_hd__decap_12
XFILLER_199_1233 VPWR VGND VPWR VGND sky130_ef_sc_hd__decap_12
XFILLER_200_251 VGND VGND VPWR VPWR sky130_fd_sc_hd__fill_1
XTAP_TAPCELL_ROW_191_2050 VGND VPWR sky130_fd_sc_hd__tapvpwrvgnd_1
XFILLER_201_785 VPWR VGND VPWR VGND sky130_ef_sc_hd__decap_12
XFILLER_16_1471 VPWR VGND VPWR VGND sky130_ef_sc_hd__decap_12
XTAP_TAPCELL_ROW_107_2_4395 VGND VPWR sky130_fd_sc_hd__tapvpwrvgnd_1
XFILLER_173_615 VGND VGND VPWR VPWR sky130_fd_sc_hd__fill_1
XFILLER_8_165 VGND VGND VPWR VPWR sky130_fd_sc_hd__fill_2
XFILLER_240_1091 VGND VGND VPWR VPWR sky130_fd_sc_hd__fill_1
XFILLER_103_1441 VGND VGND VPWR VPWR sky130_fd_sc_hd__fill_1
XFILLER_185_497 VGND VGND VPWR VPWR sky130_fd_sc_hd__decap_6
XFILLER_195_1119 VGND VGND VPWR VPWR sky130_fd_sc_hd__fill_1
XFILLER_218_27 VGND VGND VPWR VPWR sky130_fd_sc_hd__fill_1
XFILLER_66_6 VPWR VGND VPWR VGND sky130_ef_sc_hd__decap_12
XTAP_TAPCELL_ROW_212_2610 VGND VPWR sky130_fd_sc_hd__tapvpwrvgnd_1
XFILLER_12_1357 VGND VGND VPWR VPWR sky130_fd_sc_hd__fill_1
XTAP_TAPCELL_ROW_212_2621 VGND VPWR sky130_fd_sc_hd__tapvpwrvgnd_1
XFILLER_236_1105 VPWR VGND VPWR VGND sky130_ef_sc_hd__decap_12
XFILLER_5_883 VPWR VGND VPWR VGND sky130_ef_sc_hd__decap_12
XFILLER_86_1469 VGND VGND VPWR VPWR sky130_fd_sc_hd__fill_1
XFILLER_236_1149 VPWR VGND VPWR VGND sky130_ef_sc_hd__decap_12
XFILLER_4_382 VGND VGND VPWR VPWR sky130_fd_sc_hd__fill_1
XFILLER_234_15 VPWR VGND VPWR VGND sky130_ef_sc_hd__decap_12
XTAP_TAPCELL_ROW_55_2_4082 VGND VPWR sky130_fd_sc_hd__tapvpwrvgnd_1
XFILLER_136_1283 VPWR VGND VPWR VGND sky130_ef_sc_hd__decap_12
XPHY_EDGE_ROW_19_2_Right_110 VGND VGND VPWR VPWR sky130_fd_sc_hd__decap_3
XTAP_TAPCELL_ROW_206_2436 VGND VPWR sky130_fd_sc_hd__tapvpwrvgnd_1
XTAP_TAPCELL_ROW_206_2447 VGND VPWR sky130_fd_sc_hd__tapvpwrvgnd_1
XFILLER_209_841 VPWR VGND VPWR VGND sky130_ef_sc_hd__decap_12
XFILLER_227_137 VPWR VGND VPWR VGND sky130_ef_sc_hd__decap_12
XTAP_TAPCELL_ROW_206_2458 VGND VPWR sky130_fd_sc_hd__tapvpwrvgnd_1
XFILLER_247_1201 VPWR VGND VPWR VGND sky130_ef_sc_hd__decap_12
XPHY_EDGE_ROW_209_Right_54 VGND VGND VPWR VPWR sky130_fd_sc_hd__decap_3
XFILLER_23_1497 VGND VGND VPWR VPWR sky130_fd_sc_hd__fill_1
XFILLER_224_811 VGND VGND VPWR VPWR sky130_fd_sc_hd__fill_1
XFILLER_236_693 VGND VGND VPWR VPWR sky130_fd_sc_hd__decap_6
XTAP_TAPCELL_ROW_198_2226 VGND VPWR sky130_fd_sc_hd__tapvpwrvgnd_1
XTAP_TAPCELL_ROW_198_2237 VGND VPWR sky130_fd_sc_hd__tapvpwrvgnd_1
XFILLER_247_1245 VPWR VGND VPWR VGND sky130_ef_sc_hd__decap_12
XFILLER_235_181 VPWR VGND VPWR VGND sky130_ef_sc_hd__decap_12
XFILLER_251_641 VPWR VGND VPWR VGND sky130_ef_sc_hd__decap_12
XTAP_TAPCELL_ROW_33_2_3952 VGND VPWR sky130_fd_sc_hd__tapvpwrvgnd_1
XFILLER_208_1229 VPWR VGND VPWR VGND sky130_ef_sc_hd__decap_12
XFILLER_211_505 VPWR VGND VPWR VGND sky130_ef_sc_hd__decap_12
XFILLER_247_1289 VPWR VGND VPWR VGND sky130_ef_sc_hd__decap_12
XFILLER_251_685 VPWR VGND VPWR VGND sky130_ef_sc_hd__decap_12
XTAP_TAPCELL_ROW_219_2808 VGND VPWR sky130_fd_sc_hd__tapvpwrvgnd_1
XFILLER_17_1213 VGND VGND VPWR VPWR sky130_fd_sc_hd__decap_4
XFILLER_177_921 VPWR VGND VPWR VGND sky130_ef_sc_hd__decap_12
XFILLER_195_217 VGND VGND VPWR VPWR sky130_fd_sc_hd__decap_6
XFILLER_250_195 VGND VGND VPWR VPWR sky130_fd_sc_hd__fill_1
XFILLER_56_1295 VGND VGND VPWR VPWR sky130_fd_sc_hd__decap_6
XFILLER_143_1243 VPWR VGND VPWR VGND sky130_ef_sc_hd__decap_12
XFILLER_177_965 VPWR VGND VPWR VGND sky130_ef_sc_hd__decap_12
XFILLER_104_1227 VPWR VGND VPWR VGND sky130_ef_sc_hd__decap_12
XFILLER_12_16 VPWR VGND VPWR VGND sky130_ef_sc_hd__decap_12
XFILLER_143_1287 VPWR VGND VPWR VGND sky130_ef_sc_hd__decap_12
XFILLER_176_475 VGND VGND VPWR VPWR sky130_fd_sc_hd__fill_1
XFILLER_30_1413 VGND VGND VPWR VPWR sky130_fd_sc_hd__fill_1
XFILLER_178_1317 VPWR VGND VPWR VGND sky130_ef_sc_hd__decap_12
XPHY_EDGE_ROW_218_Right_63 VGND VGND VPWR VPWR sky130_fd_sc_hd__decap_3
XFILLER_128_27 VGND VGND VPWR VPWR sky130_fd_sc_hd__fill_1
XTAP_TAPCELL_ROW_174_1580 VGND VPWR sky130_fd_sc_hd__tapvpwrvgnd_1
XTAP_TAPCELL_ROW_174_1591 VGND VPWR sky130_fd_sc_hd__tapvpwrvgnd_1
XFILLER_192_979 VGND VGND VPWR VPWR sky130_fd_sc_hd__fill_1
XFILLER_3_809 VPWR VGND VPWR VGND sky130_ef_sc_hd__decap_12
XFILLER_254_1205 VPWR VGND VPWR VGND sky130_ef_sc_hd__decap_12
XFILLER_219_1325 VPWR VGND VPWR VGND sky130_ef_sc_hd__decap_12
XTAP_TAPCELL_ROW_170_1466 VGND VPWR sky130_fd_sc_hd__tapvpwrvgnd_1
XTAP_TAPCELL_ROW_170_1477 VGND VPWR sky130_fd_sc_hd__tapvpwrvgnd_1
XFILLER_172_681 VPWR VGND VPWR VGND sky130_ef_sc_hd__decap_12
XTAP_TAPCELL_ROW_170_1488 VGND VPWR sky130_fd_sc_hd__tapvpwrvgnd_1
XFILLER_176_1085 VGND VGND VPWR VPWR sky130_fd_sc_hd__decap_6
XFILLER_219_1369 VPWR VGND VPWR VGND sky130_ef_sc_hd__decap_12
XFILLER_144_15 VPWR VGND VPWR VGND sky130_ef_sc_hd__decap_12
XTAP_TAPCELL_ROW_164_2_4738 VGND VPWR sky130_fd_sc_hd__tapvpwrvgnd_1
XTAP_TAPCELL_ROW_187_1930 VGND VPWR sky130_fd_sc_hd__tapvpwrvgnd_1
XTAP_TAPCELL_ROW_187_1941 VGND VPWR sky130_fd_sc_hd__tapvpwrvgnd_1
XFILLER_63_1255 VPWR VGND VPWR VGND sky130_ef_sc_hd__decap_12
XFILLER_115_1323 VGND VGND VPWR VPWR sky130_fd_sc_hd__decap_6
XFILLER_150_1203 VPWR VGND VPWR VGND sky130_ef_sc_hd__decap_12
XFILLER_154_1383 VPWR VGND VPWR VGND sky130_ef_sc_hd__decap_12
Xfanout667 net671 VGND VGND VPWR VPWR net667 sky130_fd_sc_hd__buf_4
XTAP_TAPCELL_ROW_183_1816 VGND VPWR sky130_fd_sc_hd__tapvpwrvgnd_1
XFILLER_246_413 VGND VGND VPWR VPWR sky130_fd_sc_hd__decap_6
XFILLER_24_1239 VGND VGND VPWR VPWR sky130_fd_sc_hd__decap_6
XTAP_TAPCELL_ROW_183_1827 VGND VPWR sky130_fd_sc_hd__tapvpwrvgnd_1
XFILLER_189_1413 VPWR VGND VPWR VGND sky130_ef_sc_hd__decap_12
XFILLER_63_1299 VPWR VGND VPWR VGND sky130_ef_sc_hd__decap_12
XFILLER_115_1367 VPWR VGND VPWR VGND sky130_ef_sc_hd__decap_12
XFILLER_150_1247 VPWR VGND VPWR VGND sky130_ef_sc_hd__decap_12
XTAP_TAPCELL_ROW_183_1838 VGND VPWR sky130_fd_sc_hd__tapvpwrvgnd_1
XPHY_EDGE_ROW_227_Right_72 VGND VGND VPWR VPWR sky130_fd_sc_hd__decap_3
XFILLER_246_457 VPWR VGND VPWR VGND sky130_ef_sc_hd__decap_12
XFILLER_189_1457 VPWR VGND VPWR VGND sky130_ef_sc_hd__decap_12
XFILLER_37_57 VPWR VGND VPWR VGND sky130_ef_sc_hd__decap_12
XFILLER_2_1035 VGND VGND VPWR VPWR sky130_fd_sc_hd__fill_1
XFILLER_227_671 VGND VGND VPWR VPWR sky130_fd_sc_hd__fill_1
XFILLER_215_833 VGND VGND VPWR VPWR sky130_fd_sc_hd__decap_6
XFILLER_183_1001 VGND VGND VPWR VPWR sky130_fd_sc_hd__decap_6
XFILLER_214_321 VPWR VGND VPWR VGND sky130_ef_sc_hd__decap_12
XFILLER_215_877 VPWR VGND VPWR VGND sky130_ef_sc_hd__decap_12
XTAP_TAPCELL_ROW_124_2_4501 VGND VPWR sky130_fd_sc_hd__tapvpwrvgnd_1
XFILLER_226_1329 VPWR VGND VPWR VGND sky130_ef_sc_hd__decap_12
X_340_ _117_ _125_ _128_ VGND VGND VPWR VPWR _129_ sky130_fd_sc_hd__o21ba_1
XFILLER_148_1165 VPWR VGND VPWR VGND sky130_ef_sc_hd__decap_12
XFILLER_183_1045 VPWR VGND VPWR VGND sky130_ef_sc_hd__decap_12
XFILLER_214_365 VPWR VGND VPWR VGND sky130_ef_sc_hd__decap_12
XFILLER_230_825 VPWR VGND VPWR VGND sky130_ef_sc_hd__decap_12
XFILLER_74_1351 VGND VGND VPWR VPWR sky130_fd_sc_hd__decap_6
XFILLER_187_729 VPWR VGND VPWR VGND sky130_ef_sc_hd__decap_12
XFILLER_183_1089 VPWR VGND VPWR VGND sky130_ef_sc_hd__decap_12
XFILLER_149_3 VPWR VGND VPWR VGND sky130_ef_sc_hd__decap_12
XFILLER_230_869 VPWR VGND VPWR VGND sky130_ef_sc_hd__decap_12
XFILLER_70_1215 VPWR VGND VPWR VGND sky130_ef_sc_hd__decap_12
XFILLER_74_1395 VPWR VGND VPWR VGND sky130_ef_sc_hd__decap_12
XFILLER_126_1463 VGND VGND VPWR VPWR sky130_fd_sc_hd__decap_6
XFILLER_161_1343 VPWR VGND VPWR VGND sky130_ef_sc_hd__decap_12
XFILLER_70_1259 VPWR VGND VPWR VGND sky130_ef_sc_hd__decap_12
XPHY_EDGE_ROW_236_Right_81 VGND VGND VPWR VPWR sky130_fd_sc_hd__decap_3
XFILLER_35_1379 VGND VGND VPWR VPWR sky130_fd_sc_hd__decap_6
XFILLER_122_1327 VPWR VGND VPWR VGND sky130_ef_sc_hd__decap_12
XFILLER_161_1387 VPWR VGND VPWR VGND sky130_ef_sc_hd__decap_12
XFILLER_182_401 VPWR VGND VPWR VGND sky130_ef_sc_hd__decap_12
XTAP_TAPCELL_ROW_252_3680 VGND VPWR sky130_fd_sc_hd__tapvpwrvgnd_1
XTAP_TAPCELL_ROW_16_1_1151 VGND VPWR sky130_fd_sc_hd__tapvpwrvgnd_1
XTAP_TAPCELL_ROW_252_3691 VGND VPWR sky130_fd_sc_hd__tapvpwrvgnd_1
XFILLER_5_102 VGND VGND VPWR VPWR sky130_fd_sc_hd__decap_8
XFILLER_167_497 VGND VGND VPWR VPWR sky130_fd_sc_hd__decap_6
XFILLER_5_113 VPWR VGND VPWR VGND sky130_ef_sc_hd__decap_12
XFILLER_182_445 VPWR VGND VPWR VGND sky130_ef_sc_hd__decap_12
XFILLER_202_1373 VPWR VGND VPWR VGND sky130_ef_sc_hd__decap_12
XFILLER_185_55 VGND VGND VPWR VPWR sky130_fd_sc_hd__fill_1
XFILLER_5_157 VGND VGND VPWR VPWR sky130_fd_sc_hd__fill_1
XFILLER_182_489 VPWR VGND VPWR VGND sky130_ef_sc_hd__decap_12
XFILLER_237_1425 VPWR VGND VPWR VGND sky130_ef_sc_hd__decap_12
XPHY_EDGE_ROW_58_2_Right_149 VGND VGND VPWR VPWR sky130_fd_sc_hd__decap_3
XFILLER_194_1141 VGND VGND VPWR VPWR sky130_fd_sc_hd__decap_6
XFILLER_68_1177 VPWR VGND VPWR VGND sky130_ef_sc_hd__decap_12
XFILLER_190_1005 VPWR VGND VPWR VGND sky130_ef_sc_hd__decap_12
XFILLER_237_1469 VPWR VGND VPWR VGND sky130_ef_sc_hd__decap_12
XFILLER_194_1185 VPWR VGND VPWR VGND sky130_ef_sc_hd__decap_12
XFILLER_78_53 VPWR VGND VPWR VGND sky130_ef_sc_hd__decap_12
XFILLER_81_1311 VPWR VGND VPWR VGND sky130_ef_sc_hd__decap_12
XFILLER_85_1491 VGND VGND VPWR VPWR sky130_fd_sc_hd__decap_6
XFILLER_190_1049 VPWR VGND VPWR VGND sky130_ef_sc_hd__decap_12
XFILLER_81_1355 VPWR VGND VPWR VGND sky130_ef_sc_hd__decap_12
XFILLER_133_1423 VPWR VGND VPWR VGND sky130_ef_sc_hd__decap_12
XFILLER_238_925 VPWR VGND VPWR VGND sky130_ef_sc_hd__decap_12
XFILLER_172_1483 VGND VGND VPWR VPWR sky130_fd_sc_hd__fill_1
XPHY_EDGE_ROW_245_Right_90 VGND VGND VPWR VPWR sky130_fd_sc_hd__decap_3
XFILLER_249_273 VGND VGND VPWR VPWR sky130_fd_sc_hd__decap_6
XFILLER_42_1339 VPWR VGND VPWR VGND sky130_ef_sc_hd__decap_12
XFILLER_204_29 VPWR VGND VPWR VGND sky130_ef_sc_hd__decap_12
XFILLER_231_1057 VGND VGND VPWR VPWR sky130_fd_sc_hd__decap_6
XFILLER_81_1399 VPWR VGND VPWR VGND sky130_ef_sc_hd__decap_12
XFILLER_133_1467 VPWR VGND VPWR VGND sky130_ef_sc_hd__decap_12
XFILLER_209_137 VPWR VGND VPWR VGND sky130_ef_sc_hd__decap_12
XFILLER_94_41 VPWR VGND VPWR VGND sky130_ef_sc_hd__decap_12
XFILLER_206_811 VGND VGND VPWR VPWR sky130_fd_sc_hd__fill_1
XPHY_EDGE_ROW_164_2_Left_666 VGND VGND VPWR VPWR sky130_fd_sc_hd__decap_3
XTAP_TAPCELL_ROW_201_2300 VGND VPWR sky130_fd_sc_hd__tapvpwrvgnd_1
XFILLER_218_693 VGND VGND VPWR VPWR sky130_fd_sc_hd__decap_6
XTAP_TAPCELL_ROW_201_2311 VGND VPWR sky130_fd_sc_hd__tapvpwrvgnd_1
XTAP_TAPCELL_ROW_18_2_3865 VGND VPWR sky130_fd_sc_hd__tapvpwrvgnd_1
X_607_ clknet_3_1__leaf_clk dout0\[5\] _015_ VGND VGND VPWR VPWR dout0_q\[5\] sky130_fd_sc_hd__dfrtp_1
XFILLER_79_1273 VGND VGND VPWR VPWR sky130_fd_sc_hd__fill_1
XTAP_TAPCELL_ROW_201_2322 VGND VPWR sky130_fd_sc_hd__tapvpwrvgnd_1
XFILLER_209_1505 VGND VGND VPWR VPWR sky130_fd_sc_hd__decap_6
XFILLER_217_181 VPWR VGND VPWR VGND sky130_ef_sc_hd__decap_12
XFILLER_233_641 VPWR VGND VPWR VGND sky130_ef_sc_hd__decap_12
XFILLER_244_1429 VPWR VGND VPWR VGND sky130_ef_sc_hd__decap_12
XFILLER_233_685 VPWR VGND VPWR VGND sky130_ef_sc_hd__decap_12
X_538_ net666 VGND VGND VPWR VPWR _020_ sky130_fd_sc_hd__inv_2
XTAP_TAPCELL_ROW_193_2101 VGND VPWR sky130_fd_sc_hd__tapvpwrvgnd_1
XFILLER_92_1451 VPWR VGND VPWR VGND sky130_ef_sc_hd__decap_12
XFILLER_177_217 VGND VGND VPWR VPWR sky130_fd_sc_hd__decap_6
XFILLER_232_195 VGND VGND VPWR VPWR sky130_fd_sc_hd__fill_1
XFILLER_53_1435 VGND VGND VPWR VPWR sky130_fd_sc_hd__decap_6
X_469_ net149 net116 VGND VGND VPWR VPWR acc_core.adder.cla_blocks\[1\].block.sum\[1\]
+ sky130_fd_sc_hd__xnor2_1
XFILLER_220_357 VGND VGND VPWR VPWR sky130_fd_sc_hd__decap_6
XFILLER_92_1495 VPWR VGND VPWR VGND sky130_ef_sc_hd__decap_12
XFILLER_229_15 VPWR VGND VPWR VGND sky130_ef_sc_hd__decap_12
XFILLER_53_1479 VPWR VGND VPWR VGND sky130_ef_sc_hd__decap_12
XFILLER_140_1427 VPWR VGND VPWR VGND sky130_ef_sc_hd__decap_12
XFILLER_192_209 VPWR VGND VPWR VGND sky130_ef_sc_hd__decap_12
XFILLER_242_1197 VGND VGND VPWR VPWR sky130_fd_sc_hd__decap_6
XFILLER_185_261 VPWR VGND VPWR VGND sky130_ef_sc_hd__decap_12
XTAP_TAPCELL_ROW_11_2_3819 VGND VPWR sky130_fd_sc_hd__tapvpwrvgnd_1
XFILLER_199_1063 VGND VGND VPWR VPWR sky130_fd_sc_hd__fill_1
XFILLER_174_979 VGND VGND VPWR VPWR sky130_fd_sc_hd__fill_1
XFILLER_12_1165 VPWR VGND VPWR VGND sky130_ef_sc_hd__decap_12
XPHY_EDGE_ROW_53_1_Left_308 VGND VGND VPWR VPWR sky130_fd_sc_hd__decap_3
XFILLER_138_1301 VGND VGND VPWR VPWR sky130_fd_sc_hd__fill_1
XFILLER_47_1217 VGND VGND VPWR VPWR sky130_fd_sc_hd__fill_1
XFILLER_5_680 VGND VGND VPWR VPWR sky130_fd_sc_hd__decap_4
XTAP_TAPCELL_ROW_150_2_4657 VGND VPWR sky130_fd_sc_hd__tapvpwrvgnd_1
XFILLER_173_1225 VGND VGND VPWR VPWR sky130_fd_sc_hd__decap_6
XFILLER_216_1509 VGND VGND VPWR VPWR sky130_fd_sc_hd__decap_6
XFILLER_245_69 VPWR VGND VPWR VGND sky130_ef_sc_hd__decap_12
XFILLER_173_1269 VPWR VGND VPWR VGND sky130_ef_sc_hd__decap_12
XFILLER_4_83 VGND VGND VPWR VPWR sky130_fd_sc_hd__fill_1
XTAP_TAPCELL_ROW_208_2509 VGND VPWR sky130_fd_sc_hd__tapvpwrvgnd_1
XTAP_TAPCELL_ROW_130_2_4533 VGND VPWR sky130_fd_sc_hd__tapvpwrvgnd_1
XFILLER_228_413 VGND VGND VPWR VPWR sky130_fd_sc_hd__decap_6
XFILLER_60_1439 VPWR VGND VPWR VGND sky130_ef_sc_hd__decap_12
XFILLER_112_1507 VGND VGND VPWR VPWR sky130_fd_sc_hd__decap_8
XFILLER_114_29 VPWR VGND VPWR VGND sky130_ef_sc_hd__decap_12
XTAP_TAPCELL_ROW_129_2_4527 VGND VPWR sky130_fd_sc_hd__tapvpwrvgnd_1
XFILLER_255_221 VGND VGND VPWR VPWR sky130_fd_sc_hd__decap_3
XPHY_EDGE_ROW_96_2_Left_598 VGND VGND VPWR VPWR sky130_fd_sc_hd__decap_3
XFILLER_228_457 VPWR VGND VPWR VGND sky130_ef_sc_hd__decap_12
XFILLER_244_917 VGND VGND VPWR VPWR sky130_fd_sc_hd__decap_6
XFILLER_243_405 VPWR VGND VPWR VGND sky130_ef_sc_hd__decap_12
XFILLER_255_265 VPWR VGND VPWR VGND sky130_ef_sc_hd__decap_12
XFILLER_167_1007 VGND VGND VPWR VPWR sky130_fd_sc_hd__fill_1
XFILLER_209_671 VGND VGND VPWR VPWR sky130_fd_sc_hd__fill_1
XTAP_TAPCELL_ROW_97_2_4338 VGND VPWR sky130_fd_sc_hd__tapvpwrvgnd_1
XFILLER_243_449 VPWR VGND VPWR VGND sky130_ef_sc_hd__decap_12
XFILLER_149_1441 VGND VGND VPWR VPWR sky130_fd_sc_hd__fill_1
XFILLER_252_961 VPWR VGND VPWR VGND sky130_ef_sc_hd__decap_12
XFILLER_3_1399 VGND VGND VPWR VPWR sky130_fd_sc_hd__fill_1
XFILLER_58_1357 VGND VGND VPWR VPWR sky130_fd_sc_hd__fill_1
XFILLER_184_1365 VGND VGND VPWR VPWR sky130_fd_sc_hd__decap_6
XFILLER_208_1037 VPWR VGND VPWR VGND sky130_ef_sc_hd__decap_12
XFILLER_212_825 VPWR VGND VPWR VGND sky130_ef_sc_hd__decap_12
XFILLER_169_729 VPWR VGND VPWR VGND sky130_ef_sc_hd__decap_12
XTAP_TAPCELL_ROW_77_2_4214 VGND VPWR sky130_fd_sc_hd__tapvpwrvgnd_1
XFILLER_180_1229 VPWR VGND VPWR VGND sky130_ef_sc_hd__decap_12
XFILLER_211_335 VGND VGND VPWR VPWR sky130_fd_sc_hd__fill_1
XFILLER_212_869 VPWR VGND VPWR VGND sky130_ef_sc_hd__decap_12
XFILLER_23_15 VPWR VGND VPWR VGND sky130_ef_sc_hd__decap_12
XFILLER_210_83 VGND VGND VPWR VPWR sky130_fd_sc_hd__fill_1
XTAP_TAPCELL_ROW_176_1631 VGND VPWR sky130_fd_sc_hd__tapvpwrvgnd_1
Xwire309 net310 VGND VGND VPWR VPWR net309 sky130_fd_sc_hd__clkbuf_1
XFILLER_139_15 VPWR VGND VPWR VGND sky130_ef_sc_hd__decap_12
XTAP_TAPCELL_ROW_176_1642 VGND VPWR sky130_fd_sc_hd__tapvpwrvgnd_1
XTAP_TAPCELL_ROW_172_1517 VGND VPWR sky130_fd_sc_hd__tapvpwrvgnd_1
XTAP_TAPCELL_ROW_172_1528 VGND VPWR sky130_fd_sc_hd__tapvpwrvgnd_1
XTAP_TAPCELL_ROW_172_1539 VGND VPWR sky130_fd_sc_hd__tapvpwrvgnd_1
XFILLER_165_979 VGND VGND VPWR VPWR sky130_fd_sc_hd__fill_1
XFILLER_180_905 VPWR VGND VPWR VGND sky130_ef_sc_hd__decap_12
XFILLER_178_1147 VGND VGND VPWR VPWR sky130_fd_sc_hd__fill_1
XFILLER_219_81 VPWR VGND VPWR VGND sky130_ef_sc_hd__decap_12
XFILLER_180_949 VPWR VGND VPWR VGND sky130_ef_sc_hd__decap_12
XFILLER_219_1133 VPWR VGND VPWR VGND sky130_ef_sc_hd__decap_12
XFILLER_254_1035 VGND VGND VPWR VPWR sky130_fd_sc_hd__fill_1
XFILLER_69_1497 VGND VGND VPWR VPWR sky130_fd_sc_hd__fill_1
XFILLER_191_1325 VPWR VGND VPWR VGND sky130_ef_sc_hd__decap_12
XFILLER_155_69 VGND VGND VPWR VPWR sky130_fd_sc_hd__fill_2
XFILLER_219_1177 VPWR VGND VPWR VGND sky130_ef_sc_hd__decap_12
XFILLER_191_1369 VPWR VGND VPWR VGND sky130_ef_sc_hd__decap_12
XTAP_TAPCELL_ROW_24_2_3897 VGND VPWR sky130_fd_sc_hd__tapvpwrvgnd_1
XFILLER_154_1191 VPWR VGND VPWR VGND sky130_ef_sc_hd__decap_12
XFILLER_246_221 VPWR VGND VPWR VGND sky130_ef_sc_hd__decap_12
XFILLER_171_57 VPWR VGND VPWR VGND sky130_ef_sc_hd__decap_12
XFILLER_247_777 VGND VGND VPWR VPWR sky130_fd_sc_hd__decap_6
XFILLER_246_265 VPWR VGND VPWR VGND sky130_ef_sc_hd__decap_12
XTAP_TAPCELL_ROW_241_3381 VGND VPWR sky130_fd_sc_hd__tapvpwrvgnd_1
XTAP_TAPCELL_ROW_241_3392 VGND VPWR sky130_fd_sc_hd__tapvpwrvgnd_1
XFILLER_189_1287 VGND VGND VPWR VPWR sky130_fd_sc_hd__fill_1
XFILLER_76_1413 VGND VGND VPWR VPWR sky130_fd_sc_hd__fill_1
XFILLER_215_641 VPWR VGND VPWR VGND sky130_ef_sc_hd__decap_12
XFILLER_215_685 VPWR VGND VPWR VGND sky130_ef_sc_hd__decap_12
XTAP_TAPCELL_ROW_254_3731 VGND VPWR sky130_fd_sc_hd__tapvpwrvgnd_1
XFILLER_214_195 VGND VGND VPWR VPWR sky130_fd_sc_hd__fill_1
XTAP_TAPCELL_ROW_254_3742 VGND VPWR sky130_fd_sc_hd__tapvpwrvgnd_1
X_323_ net595 net531 dout0_q\[24\] VGND VGND VPWR VPWR _112_ sky130_fd_sc_hd__and3_1
XTAP_TAPCELL_ROW_254_3753 VGND VPWR sky130_fd_sc_hd__tapvpwrvgnd_1
XFILLER_202_357 VGND VGND VPWR VPWR sky130_fd_sc_hd__decap_6
XFILLER_187_559 VGND VGND VPWR VPWR sky130_fd_sc_hd__fill_1
XFILLER_126_1271 VPWR VGND VPWR VGND sky130_ef_sc_hd__decap_12
XFILLER_230_699 VGND VGND VPWR VPWR sky130_fd_sc_hd__fill_1
XTAP_TAPCELL_ROW_250_3628 VGND VPWR sky130_fd_sc_hd__tapvpwrvgnd_1
XFILLER_35_1165 VPWR VGND VPWR VGND sky130_ef_sc_hd__decap_12
XFILLER_80_65 VGND VGND VPWR VPWR sky130_fd_sc_hd__decap_6
XFILLER_174_209 VPWR VGND VPWR VGND sky130_ef_sc_hd__decap_12
XTAP_TAPCELL_ROW_250_3639 VGND VPWR sky130_fd_sc_hd__tapvpwrvgnd_1
XFILLER_167_261 VPWR VGND VPWR VGND sky130_ef_sc_hd__decap_12
XFILLER_183_721 VGND VGND VPWR VPWR sky130_fd_sc_hd__decap_6
XFILLER_196_65 VPWR VGND VPWR VGND sky130_ef_sc_hd__decap_12
XFILLER_196_1203 VGND VGND VPWR VPWR sky130_fd_sc_hd__fill_1
XFILLER_7_945 VGND VGND VPWR VPWR sky130_fd_sc_hd__decap_6
XFILLER_13_1441 VGND VGND VPWR VPWR sky130_fd_sc_hd__fill_1
XFILLER_183_765 VPWR VGND VPWR VGND sky130_ef_sc_hd__decap_12
Xmax_cap609 net610 VGND VGND VPWR VPWR net609 sky130_fd_sc_hd__clkbuf_1
XFILLER_182_253 VPWR VGND VPWR VGND sky130_ef_sc_hd__decap_12
XFILLER_7_989 VPWR VGND VPWR VGND sky130_ef_sc_hd__decap_12
XFILLER_6_477 VGND VGND VPWR VPWR sky130_fd_sc_hd__fill_2
XTAP_TAPCELL_ROW_124_1_1259 VGND VPWR sky130_fd_sc_hd__tapvpwrvgnd_1
XFILLER_237_1233 VPWR VGND VPWR VGND sky130_ef_sc_hd__decap_12
XTAP_TAPCELL_ROW_248_3568 VGND VPWR sky130_fd_sc_hd__tapvpwrvgnd_1
XTAP_TAPCELL_ROW_248_3579 VGND VPWR sky130_fd_sc_hd__tapvpwrvgnd_1
XFILLER_233_1119 VGND VGND VPWR VPWR sky130_fd_sc_hd__fill_1
XFILLER_2_661 VGND VGND VPWR VPWR sky130_fd_sc_hd__fill_1
XFILLER_170_1409 VPWR VGND VPWR VGND sky130_ef_sc_hd__decap_12
XFILLER_215_39 VPWR VGND VPWR VGND sky130_ef_sc_hd__decap_12
XTAP_TAPCELL_ROW_115_2_4446 VGND VPWR sky130_fd_sc_hd__tapvpwrvgnd_1
XFILLER_46_1283 VPWR VGND VPWR VGND sky130_ef_sc_hd__decap_12
XFILLER_133_1231 VPWR VGND VPWR VGND sky130_ef_sc_hd__decap_12
XFILLER_250_1477 VGND VGND VPWR VPWR sky130_fd_sc_hd__decap_6
XFILLER_238_755 VGND VGND VPWR VPWR sky130_fd_sc_hd__fill_1
XFILLER_133_1275 VPWR VGND VPWR VGND sky130_ef_sc_hd__decap_12
XFILLER_226_917 VGND VGND VPWR VPWR sky130_fd_sc_hd__decap_6
XFILLER_225_405 VPWR VGND VPWR VGND sky130_ef_sc_hd__decap_12
XFILLER_231_27 VPWR VGND VPWR VGND sky130_ef_sc_hd__decap_12
XFILLER_225_449 VPWR VGND VPWR VGND sky130_ef_sc_hd__decap_12
XFILLER_241_909 VPWR VGND VPWR VGND sky130_ef_sc_hd__decap_12
XFILLER_234_961 VPWR VGND VPWR VGND sky130_ef_sc_hd__decap_12
XFILLER_209_1313 VPWR VGND VPWR VGND sky130_ef_sc_hd__decap_12
XFILLER_248_1373 VPWR VGND VPWR VGND sky130_ef_sc_hd__decap_12
XFILLER_240_419 VGND VGND VPWR VPWR sky130_fd_sc_hd__fill_1
XTAP_TAPCELL_ROW_63_2_4133 VGND VPWR sky130_fd_sc_hd__tapvpwrvgnd_1
XFILLER_181_1505 VGND VGND VPWR VPWR sky130_fd_sc_hd__decap_6
XFILLER_166_1073 VPWR VGND VPWR VGND sky130_ef_sc_hd__decap_12
XFILLER_209_1357 VPWR VGND VPWR VGND sky130_ef_sc_hd__decap_12
XFILLER_244_1259 VGND VGND VPWR VPWR sky130_fd_sc_hd__fill_1
XFILLER_220_121 VPWR VGND VPWR VGND sky130_ef_sc_hd__decap_12
XFILLER_53_1243 VPWR VGND VPWR VGND sky130_ef_sc_hd__decap_12
XFILLER_105_1311 VPWR VGND VPWR VGND sky130_ef_sc_hd__decap_12
XFILLER_220_165 VPWR VGND VPWR VGND sky130_ef_sc_hd__decap_12
XFILLER_109_1491 VGND VGND VPWR VPWR sky130_fd_sc_hd__decap_6
XFILLER_144_1371 VPWR VGND VPWR VGND sky130_ef_sc_hd__decap_12
XFILLER_165_209 VPWR VGND VPWR VGND sky130_ef_sc_hd__decap_12
XFILLER_193_529 VPWR VGND VPWR VGND sky130_ef_sc_hd__decap_12
XFILLER_14_1227 VPWR VGND VPWR VGND sky130_ef_sc_hd__decap_12
XFILLER_179_1401 VPWR VGND VPWR VGND sky130_ef_sc_hd__decap_12
XFILLER_53_1287 VPWR VGND VPWR VGND sky130_ef_sc_hd__decap_12
XFILLER_105_1355 VPWR VGND VPWR VGND sky130_ef_sc_hd__decap_12
XFILLER_186_581 VGND VGND VPWR VPWR sky130_fd_sc_hd__decap_6
XFILLER_101_1219 VPWR VGND VPWR VGND sky130_ef_sc_hd__decap_12
XFILLER_88_1339 VPWR VGND VPWR VGND sky130_ef_sc_hd__decap_12
XFILLER_105_1399 VPWR VGND VPWR VGND sky130_ef_sc_hd__decap_12
XFILLER_0_609 VGND VGND VPWR VPWR sky130_fd_sc_hd__fill_1
XFILLER_173_1033 VPWR VGND VPWR VGND sky130_ef_sc_hd__decap_12
XFILLER_216_1317 VPWR VGND VPWR VGND sky130_ef_sc_hd__decap_12
XFILLER_170_993 VPWR VGND VPWR VGND sky130_ef_sc_hd__decap_12
XFILLER_125_39 VPWR VGND VPWR VGND sky130_ef_sc_hd__decap_12
XFILLER_173_1077 VPWR VGND VPWR VGND sky130_ef_sc_hd__decap_12
XFILLER_60_1203 VPWR VGND VPWR VGND sky130_ef_sc_hd__decap_12
XFILLER_25_1323 VGND VGND VPWR VPWR sky130_fd_sc_hd__decap_6
XPHY_EDGE_ROW_255_Right_100 VGND VGND VPWR VPWR sky130_fd_sc_hd__decap_3
XFILLER_64_1383 VPWR VGND VPWR VGND sky130_ef_sc_hd__decap_12
XFILLER_151_1331 VPWR VGND VPWR VGND sky130_ef_sc_hd__decap_12
XFILLER_116_1451 VPWR VGND VPWR VGND sky130_ef_sc_hd__decap_12
XTAP_TAPCELL_ROW_165_1310 VGND VPWR sky130_fd_sc_hd__tapvpwrvgnd_1
XTAP_TAPCELL_ROW_165_1321 VGND VPWR sky130_fd_sc_hd__tapvpwrvgnd_1
XFILLER_228_221 VPWR VGND VPWR VGND sky130_ef_sc_hd__decap_12
XFILLER_60_1247 VPWR VGND VPWR VGND sky130_ef_sc_hd__decap_12
XFILLER_25_1367 VPWR VGND VPWR VGND sky130_ef_sc_hd__decap_12
XFILLER_18_15 VGND VGND VPWR VPWR sky130_fd_sc_hd__fill_1
XFILLER_112_1315 VPWR VGND VPWR VGND sky130_ef_sc_hd__decap_12
XTAP_TAPCELL_ROW_165_1332 VGND VPWR sky130_fd_sc_hd__tapvpwrvgnd_1
XTAP_TAPCELL_ROW_4_959 VGND VPWR sky130_fd_sc_hd__tapvpwrvgnd_1
XFILLER_116_1495 VPWR VGND VPWR VGND sky130_ef_sc_hd__decap_12
XTAP_TAPCELL_ROW_165_1343 VGND VPWR sky130_fd_sc_hd__tapvpwrvgnd_1
XFILLER_214_1085 VGND VGND VPWR VPWR sky130_fd_sc_hd__decap_6
XFILLER_99_1435 VGND VGND VPWR VPWR sky130_fd_sc_hd__decap_6
XFILLER_229_777 VGND VGND VPWR VPWR sky130_fd_sc_hd__decap_6
XFILLER_228_265 VPWR VGND VPWR VGND sky130_ef_sc_hd__decap_12
XFILLER_244_725 VPWR VGND VPWR VGND sky130_ef_sc_hd__decap_12
XFILLER_112_1359 VPWR VGND VPWR VGND sky130_ef_sc_hd__decap_12
XFILLER_141_27 VPWR VGND VPWR VGND sky130_ef_sc_hd__decap_12
XTAP_TAPCELL_ROW_159_2_4711 VGND VPWR sky130_fd_sc_hd__tapvpwrvgnd_1
XFILLER_99_1479 VPWR VGND VPWR VGND sky130_ef_sc_hd__decap_12
XFILLER_186_1427 VGND VGND VPWR VPWR sky130_fd_sc_hd__fill_1
XFILLER_244_769 VPWR VGND VPWR VGND sky130_ef_sc_hd__decap_12
XFILLER_227_1413 VPWR VGND VPWR VGND sky130_ef_sc_hd__decap_12
XFILLER_243_279 VGND VGND VPWR VPWR sky130_fd_sc_hd__fill_1
XFILLER_58_1165 VPWR VGND VPWR VGND sky130_ef_sc_hd__decap_12
XTAP_TAPCELL_ROW_178_1704 VGND VPWR sky130_fd_sc_hd__tapvpwrvgnd_1
XFILLER_184_1173 VPWR VGND VPWR VGND sky130_ef_sc_hd__decap_12
XFILLER_196_301 VGND VGND VPWR VPWR sky130_fd_sc_hd__decap_6
XFILLER_221_93 VPWR VGND VPWR VGND sky130_ef_sc_hd__decap_12
XFILLER_227_1457 VPWR VGND VPWR VGND sky130_ef_sc_hd__decap_12
XFILLER_169_559 VGND VGND VPWR VPWR sky130_fd_sc_hd__fill_1
XFILLER_180_1037 VPWR VGND VPWR VGND sky130_ef_sc_hd__decap_12
XFILLER_196_345 VPWR VGND VPWR VGND sky130_ef_sc_hd__decap_12
XFILLER_36_1463 VGND VGND VPWR VPWR sky130_fd_sc_hd__decap_6
XFILLER_71_1343 VPWR VGND VPWR VGND sky130_ef_sc_hd__decap_12
XFILLER_123_1411 VPWR VGND VPWR VGND sky130_ef_sc_hd__decap_12
XFILLER_221_1001 VGND VGND VPWR VPWR sky130_fd_sc_hd__decap_6
XFILLER_212_699 VGND VGND VPWR VPWR sky130_fd_sc_hd__fill_1
Xwire106 net108 VGND VGND VPWR VPWR net106 sky130_fd_sc_hd__clkbuf_1
XFILLER_162_1471 VPWR VGND VPWR VGND sky130_ef_sc_hd__decap_12
Xclkload2 clknet_3_2__leaf_clk VGND VGND VPWR VPWR clkload2/Y sky130_fd_sc_hd__clkinv_2
XFILLER_196_389 VPWR VGND VPWR VGND sky130_ef_sc_hd__decap_12
XFILLER_32_1327 VPWR VGND VPWR VGND sky130_ef_sc_hd__decap_12
Xwire139 _085_ VGND VGND VPWR VPWR net139 sky130_fd_sc_hd__clkbuf_1
XFILLER_71_1387 VPWR VGND VPWR VGND sky130_ef_sc_hd__decap_12
XFILLER_123_1455 VPWR VGND VPWR VGND sky130_ef_sc_hd__decap_12
XFILLER_221_1045 VPWR VGND VPWR VGND sky130_ef_sc_hd__decap_12
XTAP_TAPCELL_ROW_121_2_4478 VGND VPWR sky130_fd_sc_hd__tapvpwrvgnd_1
XFILLER_123_1499 VPWR VGND VPWR VGND sky130_ef_sc_hd__decap_12
XFILLER_158_1507 VGND VGND VPWR VPWR sky130_fd_sc_hd__decap_8
XFILLER_221_1089 VPWR VGND VPWR VGND sky130_ef_sc_hd__decap_12
XFILLER_180_713 VPWR VGND VPWR VGND sky130_ef_sc_hd__decap_12
XFILLER_4_937 VPWR VGND VPWR VGND sky130_ef_sc_hd__decap_12
XTAP_TAPCELL_ROW_230_3082 VGND VPWR sky130_fd_sc_hd__tapvpwrvgnd_1
XTAP_TAPCELL_ROW_230_3093 VGND VPWR sky130_fd_sc_hd__tapvpwrvgnd_1
XFILLER_180_757 VPWR VGND VPWR VGND sky130_ef_sc_hd__decap_12
XFILLER_191_1133 VPWR VGND VPWR VGND sky130_ef_sc_hd__decap_12
XFILLER_59_55 VGND VGND VPWR VPWR sky130_fd_sc_hd__fill_1
XFILLER_191_1177 VPWR VGND VPWR VGND sky130_ef_sc_hd__decap_12
XFILLER_43_1423 VPWR VGND VPWR VGND sky130_ef_sc_hd__decap_12
XTAP_TAPCELL_ROW_243_3443 VGND VPWR sky130_fd_sc_hd__tapvpwrvgnd_1
XFILLER_82_1483 VPWR VGND VPWR VGND sky130_ef_sc_hd__decap_12
XFILLER_232_1141 VGND VGND VPWR VPWR sky130_fd_sc_hd__decap_6
XTAP_TAPCELL_ROW_243_3454 VGND VPWR sky130_fd_sc_hd__tapvpwrvgnd_1
XFILLER_247_541 VPWR VGND VPWR VGND sky130_ef_sc_hd__decap_12
XFILLER_43_1467 VPWR VGND VPWR VGND sky130_ef_sc_hd__decap_12
XFILLER_8_1085 VGND VGND VPWR VPWR sky130_fd_sc_hd__decap_6
XFILLER_130_1415 VPWR VGND VPWR VGND sky130_ef_sc_hd__decap_12
XFILLER_208_917 VGND VGND VPWR VPWR sky130_fd_sc_hd__decap_6
XFILLER_232_1185 VPWR VGND VPWR VGND sky130_ef_sc_hd__decap_12
XFILLER_207_405 VPWR VGND VPWR VGND sky130_ef_sc_hd__decap_12
XFILLER_247_585 VPWR VGND VPWR VGND sky130_ef_sc_hd__decap_12
XFILLER_207_449 VPWR VGND VPWR VGND sky130_ef_sc_hd__decap_12
XFILLER_223_909 VPWR VGND VPWR VGND sky130_ef_sc_hd__decap_12
XFILLER_210_1483 VGND VGND VPWR VPWR sky130_fd_sc_hd__fill_1
XFILLER_216_961 VPWR VGND VPWR VGND sky130_ef_sc_hd__decap_12
XFILLER_245_1513 VGND VGND VPWR VPWR sky130_fd_sc_hd__fill_2
XFILLER_222_419 VGND VGND VPWR VPWR sky130_fd_sc_hd__fill_1
XFILLER_188_813 VPWR VGND VPWR VGND sky130_ef_sc_hd__decap_12
XFILLER_163_1213 VGND VGND VPWR VPWR sky130_fd_sc_hd__decap_4
XFILLER_199_161 VGND VGND VPWR VPWR sky130_fd_sc_hd__decap_6
XFILLER_167_1393 VGND VGND VPWR VPWR sky130_fd_sc_hd__decap_6
XFILLER_202_121 VPWR VGND VPWR VGND sky130_ef_sc_hd__decap_12
XFILLER_231_953 VPWR VGND VPWR VGND sky130_ef_sc_hd__decap_12
XFILLER_202_165 VPWR VGND VPWR VGND sky130_ef_sc_hd__decap_12
X_306_ _094_ VGND VGND VPWR VPWR _095_ sky130_fd_sc_hd__inv_2
XFILLER_141_1511 VGND VGND VPWR VPWR sky130_fd_sc_hd__decap_4
XFILLER_243_1281 VGND VGND VPWR VPWR sky130_fd_sc_hd__decap_6
XFILLER_175_529 VPWR VGND VPWR VGND sky130_ef_sc_hd__decap_12
XFILLER_198_1309 VGND VGND VPWR VPWR sky130_fd_sc_hd__decap_6
XFILLER_50_1427 VPWR VGND VPWR VGND sky130_ef_sc_hd__decap_12
XFILLER_168_581 VGND VGND VPWR VPWR sky130_fd_sc_hd__decap_6
XFILLER_7_720 VGND VGND VPWR VPWR sky130_fd_sc_hd__decap_8
Xwire640 net3 VGND VGND VPWR VPWR net640 sky130_fd_sc_hd__clkbuf_1
Xwire651 net652 VGND VGND VPWR VPWR net651 sky130_fd_sc_hd__clkbuf_1
XFILLER_200_1129 VPWR VGND VPWR VGND sky130_ef_sc_hd__decap_12
Xwire662 net10 VGND VGND VPWR VPWR net662 sky130_fd_sc_hd__buf_1
XFILLER_183_573 VPWR VGND VPWR VGND sky130_ef_sc_hd__decap_12
XFILLER_48_1301 VGND VGND VPWR VPWR sky130_fd_sc_hd__fill_1
XFILLER_170_245 VGND VGND VPWR VPWR sky130_fd_sc_hd__decap_6
XFILLER_226_27 VGND VGND VPWR VPWR sky130_fd_sc_hd__fill_1
XFILLER_237_1063 VGND VGND VPWR VPWR sky130_fd_sc_hd__fill_1
XFILLER_174_1353 VPWR VGND VPWR VGND sky130_ef_sc_hd__decap_12
XFILLER_170_289 VPWR VGND VPWR VGND sky130_ef_sc_hd__decap_12
XFILLER_170_1217 VPWR VGND VPWR VGND sky130_ef_sc_hd__decap_12
XFILLER_174_1397 VPWR VGND VPWR VGND sky130_ef_sc_hd__decap_12
XFILLER_250_1241 VPWR VGND VPWR VGND sky130_ef_sc_hd__decap_12
XFILLER_242_15 VPWR VGND VPWR VGND sky130_ef_sc_hd__decap_12
XFILLER_27_3 VPWR VGND VPWR VGND sky130_ef_sc_hd__decap_12
XFILLER_22_1507 VGND VGND VPWR VPWR sky130_fd_sc_hd__decap_8
XFILLER_211_1225 VGND VGND VPWR VPWR sky130_fd_sc_hd__decap_6
XFILLER_250_1285 VPWR VGND VPWR VGND sky130_ef_sc_hd__decap_12
XTAP_TAPCELL_ROW_226_2984 VGND VPWR sky130_fd_sc_hd__tapvpwrvgnd_1
XFILLER_226_725 VPWR VGND VPWR VGND sky130_ef_sc_hd__decap_12
XFILLER_211_1269 VPWR VGND VPWR VGND sky130_ef_sc_hd__decap_12
XTAP_TAPCELL_ROW_226_2995 VGND VPWR sky130_fd_sc_hd__tapvpwrvgnd_1
XFILLER_226_769 VPWR VGND VPWR VGND sky130_ef_sc_hd__decap_12
XFILLER_4_1483 VGND VGND VPWR VPWR sky130_fd_sc_hd__fill_1
XFILLER_59_1441 VGND VGND VPWR VPWR sky130_fd_sc_hd__fill_1
XFILLER_225_279 VGND VGND VPWR VPWR sky130_fd_sc_hd__fill_1
XFILLER_209_1121 VPWR VGND VPWR VGND sky130_ef_sc_hd__decap_12
XFILLER_0_1369 VGND VGND VPWR VPWR sky130_fd_sc_hd__decap_3
XFILLER_178_301 VGND VGND VPWR VPWR sky130_fd_sc_hd__decap_6
XFILLER_181_1313 VPWR VGND VPWR VGND sky130_ef_sc_hd__decap_12
XFILLER_185_1493 VPWR VGND VPWR VGND sky130_ef_sc_hd__decap_12
XPHY_EDGE_ROW_127_2_Left_629 VGND VGND VPWR VPWR sky130_fd_sc_hd__decap_3
XFILLER_205_1007 VGND VGND VPWR VPWR sky130_fd_sc_hd__fill_1
XFILLER_221_441 VGND VGND VPWR VPWR sky130_fd_sc_hd__decap_6
XFILLER_178_345 VPWR VGND VPWR VGND sky130_ef_sc_hd__decap_12
XFILLER_181_1357 VPWR VGND VPWR VGND sky130_ef_sc_hd__decap_12
XFILLER_194_805 VGND VGND VPWR VPWR sky130_fd_sc_hd__decap_6
XFILLER_221_485 VPWR VGND VPWR VGND sky130_ef_sc_hd__decap_12
XFILLER_178_389 VPWR VGND VPWR VGND sky130_ef_sc_hd__decap_12
XFILLER_194_849 VPWR VGND VPWR VGND sky130_ef_sc_hd__decap_12
XFILLER_193_337 VPWR VGND VPWR VGND sky130_ef_sc_hd__decap_12
XFILLER_222_1365 VGND VGND VPWR VPWR sky130_fd_sc_hd__decap_6
XFILLER_179_1231 VGND VGND VPWR VPWR sky130_fd_sc_hd__fill_1
XFILLER_20_27 VGND VGND VPWR VPWR sky130_fd_sc_hd__fill_1
XFILLER_136_27 VGND VGND VPWR VPWR sky130_fd_sc_hd__fill_1
XFILLER_192_1453 VPWR VGND VPWR VGND sky130_ef_sc_hd__decap_12
XTAP_TAPCELL_ROW_167_1405 VGND VPWR sky130_fd_sc_hd__tapvpwrvgnd_1
XFILLER_216_1147 VGND VGND VPWR VPWR sky130_fd_sc_hd__fill_1
XFILLER_249_839 VGND VGND VPWR VPWR sky130_fd_sc_hd__fill_1
XFILLER_192_1497 VPWR VGND VPWR VGND sky130_ef_sc_hd__decap_12
XTAP_TAPCELL_ROW_54_2_4078 VGND VPWR sky130_fd_sc_hd__tapvpwrvgnd_1
XFILLER_29_36 VPWR VGND VPWR VGND sky130_ef_sc_hd__decap_12
XPHY_EDGE_ROW_168_Right_13 VGND VGND VPWR VPWR sky130_fd_sc_hd__decap_3
XFILLER_152_15 VPWR VGND VPWR VGND sky130_ef_sc_hd__decap_12
XFILLER_64_1191 VPWR VGND VPWR VGND sky130_ef_sc_hd__decap_12
XFILLER_229_541 VPWR VGND VPWR VGND sky130_ef_sc_hd__decap_12
XFILLER_5_1225 VGND VGND VPWR VPWR sky130_fd_sc_hd__decap_6
XFILLER_99_1243 VPWR VGND VPWR VGND sky130_ef_sc_hd__decap_12
XFILLER_229_585 VPWR VGND VPWR VGND sky130_ef_sc_hd__decap_12
XFILLER_5_1269 VPWR VGND VPWR VGND sky130_ef_sc_hd__decap_12
XFILLER_244_533 VPWR VGND VPWR VGND sky130_ef_sc_hd__decap_12
XFILLER_99_1287 VPWR VGND VPWR VGND sky130_ef_sc_hd__decap_12
XFILLER_205_909 VPWR VGND VPWR VGND sky130_ef_sc_hd__decap_12
XFILLER_112_1189 VGND VGND VPWR VPWR sky130_fd_sc_hd__fill_1
XTAP_TAPCELL_ROW_19_2_3870 VGND VPWR sky130_fd_sc_hd__tapvpwrvgnd_1
XFILLER_147_1219 VPWR VGND VPWR VGND sky130_ef_sc_hd__decap_12
XFILLER_204_419 VGND VGND VPWR VPWR sky130_fd_sc_hd__fill_1
XFILLER_231_205 VPWR VGND VPWR VGND sky130_ef_sc_hd__decap_12
XFILLER_45_68 VGND VGND VPWR VPWR sky130_fd_sc_hd__decap_3
XFILLER_188_109 VPWR VGND VPWR VGND sky130_ef_sc_hd__decap_12
XTAP_TAPCELL_ROW_32_2_3948 VGND VPWR sky130_fd_sc_hd__tapvpwrvgnd_1
XFILLER_231_249 VPWR VGND VPWR VGND sky130_ef_sc_hd__decap_12
XFILLER_213_953 VPWR VGND VPWR VGND sky130_ef_sc_hd__decap_12
XFILLER_227_1287 VGND VGND VPWR VPWR sky130_fd_sc_hd__fill_1
XPHY_EDGE_ROW_177_Right_22 VGND VGND VPWR VPWR sky130_fd_sc_hd__decap_3
XFILLER_197_665 VGND VGND VPWR VPWR sky130_fd_sc_hd__decap_6
XFILLER_196_153 VPWR VGND VPWR VGND sky130_ef_sc_hd__decap_12
XFILLER_200_625 VPWR VGND VPWR VGND sky130_ef_sc_hd__decap_12
XFILLER_240_1421 VGND VGND VPWR VPWR sky130_fd_sc_hd__decap_6
XFILLER_36_1271 VPWR VGND VPWR VGND sky130_ef_sc_hd__decap_12
XFILLER_8_517 VGND VGND VPWR VPWR sky130_fd_sc_hd__decap_3
XFILLER_131_3 VPWR VGND VPWR VGND sky130_ef_sc_hd__decap_12
XFILLER_196_197 VPWR VGND VPWR VGND sky130_ef_sc_hd__decap_12
XFILLER_229_3 VPWR VGND VPWR VGND sky130_ef_sc_hd__decap_12
XFILLER_240_1465 VPWR VGND VPWR VGND sky130_ef_sc_hd__decap_12
XTAP_TAPCELL_ROW_12_2_3824 VGND VPWR sky130_fd_sc_hd__tapvpwrvgnd_1
XFILLER_200_669 VPWR VGND VPWR VGND sky130_ef_sc_hd__decap_12
XTAP_TAPCELL_ROW_232_3144 VGND VPWR sky130_fd_sc_hd__tapvpwrvgnd_1
XTAP_TAPCELL_ROW_232_3155 VGND VPWR sky130_fd_sc_hd__tapvpwrvgnd_1
XFILLER_201_1449 VGND VGND VPWR VPWR sky130_fd_sc_hd__decap_6
XFILLER_6_29 VPWR VGND VPWR VGND sky130_ef_sc_hd__decap_12
XFILLER_165_573 VPWR VGND VPWR VGND sky130_ef_sc_hd__decap_12
XFILLER_158_1315 VPWR VGND VPWR VGND sky130_ef_sc_hd__decap_12
XFILLER_3_222 VGND VGND VPWR VPWR sky130_fd_sc_hd__fill_2
XFILLER_3_233 VGND VGND VPWR VPWR sky130_fd_sc_hd__fill_1
XTAP_TAPCELL_ROW_151_2_4662 VGND VPWR sky130_fd_sc_hd__tapvpwrvgnd_1
XFILLER_158_1359 VPWR VGND VPWR VGND sky130_ef_sc_hd__decap_12
XFILLER_193_55 VGND VGND VPWR VPWR sky130_fd_sc_hd__fill_1
XTAP_TAPCELL_ROW_245_3505 VGND VPWR sky130_fd_sc_hd__tapvpwrvgnd_1
XFILLER_234_1203 VGND VGND VPWR VPWR sky130_fd_sc_hd__fill_1
XFILLER_180_587 VGND VGND VPWR VPWR sky130_fd_sc_hd__fill_1
XFILLER_239_305 VPWR VGND VPWR VGND sky130_ef_sc_hd__decap_12
XPHY_EDGE_ROW_186_Right_31 VGND VGND VPWR VPWR sky130_fd_sc_hd__decap_3
XFILLER_239_349 VPWR VGND VPWR VGND sky130_ef_sc_hd__decap_12
XFILLER_255_809 VGND VGND VPWR VPWR sky130_fd_sc_hd__decap_3
XFILLER_43_1231 VPWR VGND VPWR VGND sky130_ef_sc_hd__decap_12
XFILLER_86_53 VPWR VGND VPWR VGND sky130_ef_sc_hd__decap_12
XTAP_TAPCELL_ROW_119_1_1254 VGND VPWR sky130_fd_sc_hd__tapvpwrvgnd_1
XFILLER_248_861 VGND VGND VPWR VPWR sky130_fd_sc_hd__decap_6
XTAP_TAPCELL_ROW_7_1039 VGND VPWR sky130_fd_sc_hd__tapvpwrvgnd_1
XFILLER_43_1275 VPWR VGND VPWR VGND sky130_ef_sc_hd__decap_12
XFILLER_208_725 VPWR VGND VPWR VGND sky130_ef_sc_hd__decap_12
XFILLER_130_1245 VGND VGND VPWR VPWR sky130_fd_sc_hd__fill_1
XTAP_TAPCELL_ROW_98_2_4343 VGND VPWR sky130_fd_sc_hd__tapvpwrvgnd_1
XFILLER_247_393 VPWR VGND VPWR VGND sky130_ef_sc_hd__decap_12
XFILLER_212_29 VPWR VGND VPWR VGND sky130_ef_sc_hd__decap_12
XFILLER_78_1327 VPWR VGND VPWR VGND sky130_ef_sc_hd__decap_12
XFILLER_169_1455 VGND VGND VPWR VPWR sky130_fd_sc_hd__fill_1
XFILLER_208_769 VPWR VGND VPWR VGND sky130_ef_sc_hd__decap_12
XFILLER_228_1029 VGND VGND VPWR VPWR sky130_fd_sc_hd__decap_6
XFILLER_207_279 VGND VGND VPWR VPWR sky130_fd_sc_hd__fill_1
XFILLER_250_525 VGND VGND VPWR VPWR sky130_fd_sc_hd__decap_6
XPHY_EDGE_ROW_62_1_Left_317 VGND VGND VPWR VPWR sky130_fd_sc_hd__decap_3
XFILLER_245_1343 VGND VGND VPWR VPWR sky130_fd_sc_hd__fill_1
XPHY_EDGE_ROW_195_Right_40 VGND VGND VPWR VPWR sky130_fd_sc_hd__decap_3
XFILLER_250_569 VPWR VGND VPWR VGND sky130_ef_sc_hd__decap_12
XFILLER_203_441 VGND VGND VPWR VPWR sky130_fd_sc_hd__decap_6
XFILLER_188_643 VGND VGND VPWR VPWR sky130_fd_sc_hd__fill_1
XFILLER_176_805 VGND VGND VPWR VPWR sky130_fd_sc_hd__decap_6
XFILLER_231_783 VGND VGND VPWR VPWR sky130_fd_sc_hd__fill_1
XFILLER_203_485 VPWR VGND VPWR VGND sky130_ef_sc_hd__decap_12
XFILLER_15_1311 VPWR VGND VPWR VGND sky130_ef_sc_hd__decap_12
XFILLER_54_1371 VPWR VGND VPWR VGND sky130_ef_sc_hd__decap_12
XFILLER_19_1491 VGND VGND VPWR VPWR sky130_fd_sc_hd__decap_6
XFILLER_176_849 VPWR VGND VPWR VGND sky130_ef_sc_hd__decap_12
XFILLER_175_337 VPWR VGND VPWR VGND sky130_ef_sc_hd__decap_12
XFILLER_198_1117 VPWR VGND VPWR VGND sky130_ef_sc_hd__decap_12
XFILLER_15_1355 VPWR VGND VPWR VGND sky130_ef_sc_hd__decap_12
XFILLER_102_1303 VPWR VGND VPWR VGND sky130_ef_sc_hd__decap_12
XFILLER_204_1073 VPWR VGND VPWR VGND sky130_ef_sc_hd__decap_12
XFILLER_89_1423 VPWR VGND VPWR VGND sky130_ef_sc_hd__decap_12
XFILLER_106_1483 VPWR VGND VPWR VGND sky130_ef_sc_hd__decap_12
XFILLER_190_307 VGND VGND VPWR VPWR sky130_fd_sc_hd__fill_1
XFILLER_237_15 VPWR VGND VPWR VGND sky130_ef_sc_hd__decap_12
XFILLER_11_1219 VPWR VGND VPWR VGND sky130_ef_sc_hd__decap_12
XFILLER_7_550 VGND VGND VPWR VPWR sky130_fd_sc_hd__fill_1
XFILLER_141_1385 VGND VGND VPWR VPWR sky130_fd_sc_hd__fill_1
XFILLER_15_1399 VPWR VGND VPWR VGND sky130_ef_sc_hd__decap_12
Xwire470 net471 VGND VGND VPWR VPWR net470 sky130_fd_sc_hd__clkbuf_1
XFILLER_7_561 VGND VGND VPWR VPWR sky130_fd_sc_hd__fill_1
Xmax_cap203 net204 VGND VGND VPWR VPWR net203 sky130_fd_sc_hd__clkbuf_1
XFILLER_184_893 VPWR VGND VPWR VGND sky130_ef_sc_hd__decap_12
Xwire481 net482 VGND VGND VPWR VPWR net481 sky130_fd_sc_hd__clkbuf_1
Xmax_cap214 _171_ VGND VGND VPWR VPWR net214 sky130_fd_sc_hd__clkbuf_1
XFILLER_89_1467 VPWR VGND VPWR VGND sky130_ef_sc_hd__decap_12
XTAP_TAPCELL_ROW_215_2685 VGND VPWR sky130_fd_sc_hd__tapvpwrvgnd_1
XTAP_TAPCELL_ROW_215_2696 VGND VPWR sky130_fd_sc_hd__tapvpwrvgnd_1
XFILLER_239_1169 VGND VGND VPWR VPWR sky130_fd_sc_hd__decap_6
XFILLER_217_1401 VPWR VGND VPWR VGND sky130_ef_sc_hd__decap_12
XFILLER_174_1161 VPWR VGND VPWR VGND sky130_ef_sc_hd__decap_12
XFILLER_253_69 VPWR VGND VPWR VGND sky130_ef_sc_hd__decap_12
XFILLER_61_1331 VPWR VGND VPWR VGND sky130_ef_sc_hd__decap_12
XFILLER_26_1451 VPWR VGND VPWR VGND sky130_ef_sc_hd__decap_12
XFILLER_135_1189 VPWR VGND VPWR VGND sky130_ef_sc_hd__decap_12
XFILLER_22_1315 VPWR VGND VPWR VGND sky130_ef_sc_hd__decap_12
XFILLER_211_1033 VPWR VGND VPWR VGND sky130_ef_sc_hd__decap_12
XFILLER_250_1093 VPWR VGND VPWR VGND sky130_ef_sc_hd__decap_12
XFILLER_26_1495 VPWR VGND VPWR VGND sky130_ef_sc_hd__decap_12
XFILLER_113_1443 VPWR VGND VPWR VGND sky130_ef_sc_hd__decap_12
XFILLER_2_1409 VPWR VGND VPWR VGND sky130_ef_sc_hd__decap_12
XFILLER_187_1511 VGND VGND VPWR VPWR sky130_fd_sc_hd__fill_1
XFILLER_22_1359 VPWR VGND VPWR VGND sky130_ef_sc_hd__decap_12
XFILLER_122_29 VPWR VGND VPWR VGND sky130_ef_sc_hd__decap_12
XFILLER_226_533 VPWR VGND VPWR VGND sky130_ef_sc_hd__decap_12
XFILLER_211_1077 VPWR VGND VPWR VGND sky130_ef_sc_hd__decap_12
XFILLER_96_1427 VPWR VGND VPWR VGND sky130_ef_sc_hd__decap_12
XPHY_EDGE_ROW_149_2_Right_240 VGND VGND VPWR VPWR sky130_fd_sc_hd__decap_3
XFILLER_241_503 VGND VGND VPWR VPWR sky130_fd_sc_hd__fill_1
XFILLER_246_1129 VPWR VGND VPWR VGND sky130_ef_sc_hd__decap_12
XFILLER_0_1133 VPWR VGND VPWR VGND sky130_ef_sc_hd__decap_12
XFILLER_213_205 VPWR VGND VPWR VGND sky130_ef_sc_hd__decap_12
XFILLER_253_385 VGND VGND VPWR VPWR sky130_fd_sc_hd__decap_6
XFILLER_0_1177 VPWR VGND VPWR VGND sky130_ef_sc_hd__decap_12
XFILLER_213_249 VPWR VGND VPWR VGND sky130_ef_sc_hd__decap_12
XFILLER_181_1121 VPWR VGND VPWR VGND sky130_ef_sc_hd__decap_12
XFILLER_179_665 VGND VGND VPWR VPWR sky130_fd_sc_hd__decap_6
XFILLER_224_1427 VGND VGND VPWR VPWR sky130_fd_sc_hd__fill_1
XFILLER_210_923 VGND VGND VPWR VPWR sky130_fd_sc_hd__fill_1
XFILLER_178_153 VPWR VGND VPWR VGND sky130_ef_sc_hd__decap_12
XFILLER_194_613 VPWR VGND VPWR VGND sky130_ef_sc_hd__decap_12
XFILLER_33_1411 VPWR VGND VPWR VGND sky130_ef_sc_hd__decap_12
XTAP_TAPCELL_ROW_156_2_4688 VGND VPWR sky130_fd_sc_hd__tapvpwrvgnd_1
XFILLER_221_293 VPWR VGND VPWR VGND sky130_ef_sc_hd__decap_12
XFILLER_72_1471 VPWR VGND VPWR VGND sky130_ef_sc_hd__decap_12
XFILLER_178_197 VPWR VGND VPWR VGND sky130_ef_sc_hd__decap_12
XFILLER_31_15 VPWR VGND VPWR VGND sky130_ef_sc_hd__decap_12
XFILLER_194_657 VPWR VGND VPWR VGND sky130_ef_sc_hd__decap_12
XFILLER_33_1455 VPWR VGND VPWR VGND sky130_ef_sc_hd__decap_12
XFILLER_222_1173 VPWR VGND VPWR VGND sky130_ef_sc_hd__decap_12
XFILLER_147_15 VPWR VGND VPWR VGND sky130_ef_sc_hd__decap_12
XFILLER_193_167 VGND VGND VPWR VPWR sky130_fd_sc_hd__fill_1
XFILLER_33_1499 VPWR VGND VPWR VGND sky130_ef_sc_hd__decap_12
XFILLER_181_329 VGND VGND VPWR VPWR sky130_fd_sc_hd__decap_6
XFILLER_68_1507 VGND VGND VPWR VPWR sky130_fd_sc_hd__decap_8
XFILLER_120_1469 VGND VGND VPWR VPWR sky130_fd_sc_hd__fill_1
XPHY_EDGE_ROW_1_Right_1 VGND VGND VPWR VPWR sky130_fd_sc_hd__decap_3
XFILLER_1_704 VGND VGND VPWR VPWR sky130_fd_sc_hd__fill_1
XFILLER_227_81 VPWR VGND VPWR VGND sky130_ef_sc_hd__decap_12
Xoutput48 net541 VGND VGND VPWR VPWR acc_out[14] sky130_fd_sc_hd__buf_2
XFILLER_153_1201 VPWR VGND VPWR VGND sky130_ef_sc_hd__decap_12
Xoutput59 net531 VGND VGND VPWR VPWR acc_out[24] sky130_fd_sc_hd__buf_2
XFILLER_192_1261 VPWR VGND VPWR VGND sky130_ef_sc_hd__decap_12
XFILLER_0_225 VPWR VGND VPWR VGND sky130_ef_sc_hd__decap_12
XTAP_TAPCELL_ROW_116_2_4451 VGND VPWR sky130_fd_sc_hd__tapvpwrvgnd_1
XFILLER_163_69 VGND VGND VPWR VPWR sky130_fd_sc_hd__fill_2
XFILLER_237_809 VPWR VGND VPWR VGND sky130_ef_sc_hd__decap_12
XFILLER_153_1267 VGND VGND VPWR VPWR sky130_fd_sc_hd__decap_6
XFILLER_40_1415 VPWR VGND VPWR VGND sky130_ef_sc_hd__decap_12
XFILLER_5_1033 VPWR VGND VPWR VGND sky130_ef_sc_hd__decap_12
X_640_ clknet_3_3__leaf_clk acc_core.adder.cla_blocks\[1\].block.sum\[2\] _048_ VGND
+ VGND VPWR VPWR net71 sky130_fd_sc_hd__dfrtp_1
XFILLER_229_393 VPWR VGND VPWR VGND sky130_ef_sc_hd__decap_12
XFILLER_245_853 VPWR VGND VPWR VGND sky130_ef_sc_hd__decap_12
XFILLER_5_1077 VPWR VGND VPWR VGND sky130_ef_sc_hd__decap_12
XFILLER_179_3 VPWR VGND VPWR VGND sky130_ef_sc_hd__decap_12
X_571_ net666 VGND VGND VPWR VPWR _053_ sky130_fd_sc_hd__inv_2
XFILLER_244_363 VGND VGND VPWR VPWR sky130_fd_sc_hd__fill_1
XFILLER_245_897 VPWR VGND VPWR VGND sky130_ef_sc_hd__decap_12
XFILLER_232_525 VGND VGND VPWR VPWR sky130_fd_sc_hd__decap_6
XFILLER_189_429 VPWR VGND VPWR VGND sky130_ef_sc_hd__decap_12
XTAP_TAPCELL_ROW_238_3320 VGND VPWR sky130_fd_sc_hd__tapvpwrvgnd_1
XFILLER_73_1213 VGND VGND VPWR VPWR sky130_fd_sc_hd__decap_4
XFILLER_232_569 VPWR VGND VPWR VGND sky130_ef_sc_hd__decap_12
XTAP_TAPCELL_ROW_234_3206 VGND VPWR sky130_fd_sc_hd__tapvpwrvgnd_1
XFILLER_213_783 VGND VGND VPWR VPWR sky130_fd_sc_hd__fill_1
XFILLER_160_1227 VPWR VGND VPWR VGND sky130_ef_sc_hd__decap_12
XFILLER_197_473 VPWR VGND VPWR VGND sky130_ef_sc_hd__decap_12
XFILLER_201_945 VGND VGND VPWR VPWR sky130_fd_sc_hd__decap_6
XFILLER_51_1511 VGND VGND VPWR VPWR sky130_fd_sc_hd__decap_4
XFILLER_188_77 VGND VGND VPWR VPWR sky130_fd_sc_hd__decap_6
XFILLER_9_837 VGND VGND VPWR VPWR sky130_fd_sc_hd__decap_3
XFILLER_200_433 VPWR VGND VPWR VGND sky130_ef_sc_hd__decap_12
XFILLER_199_1437 VPWR VGND VPWR VGND sky130_ef_sc_hd__decap_12
XFILLER_201_989 VPWR VGND VPWR VGND sky130_ef_sc_hd__decap_12
XFILLER_200_477 VPWR VGND VPWR VGND sky130_ef_sc_hd__decap_12
XFILLER_201_1213 VPWR VGND VPWR VGND sky130_ef_sc_hd__decap_12
XFILLER_240_1273 VPWR VGND VPWR VGND sky130_ef_sc_hd__decap_12
XFILLER_205_1393 VGND VGND VPWR VPWR sky130_fd_sc_hd__decap_6
XFILLER_172_307 VGND VGND VPWR VPWR sky130_fd_sc_hd__fill_1
XFILLER_166_893 VPWR VGND VPWR VGND sky130_ef_sc_hd__decap_12
XFILLER_184_189 VGND VGND VPWR VPWR sky130_fd_sc_hd__decap_6
XFILLER_201_1257 VPWR VGND VPWR VGND sky130_ef_sc_hd__decap_12
XFILLER_181_841 VPWR VGND VPWR VGND sky130_ef_sc_hd__decap_12
XFILLER_236_1309 VGND VGND VPWR VPWR sky130_fd_sc_hd__decap_6
XFILLER_158_1189 VGND VGND VPWR VPWR sky130_fd_sc_hd__fill_1
XFILLER_171_1301 VPWR VGND VPWR VGND sky130_ef_sc_hd__decap_12
XTAP_TAPCELL_ROW_210_2560 VGND VPWR sky130_fd_sc_hd__tapvpwrvgnd_1
XFILLER_175_1481 VPWR VGND VPWR VGND sky130_ef_sc_hd__decap_12
XFILLER_239_113 VPWR VGND VPWR VGND sky130_ef_sc_hd__decap_12
XFILLER_171_1345 VPWR VGND VPWR VGND sky130_ef_sc_hd__decap_12
XFILLER_80_1239 VGND VGND VPWR VPWR sky130_fd_sc_hd__decap_6
XFILLER_0_770 VGND VGND VPWR VPWR sky130_fd_sc_hd__fill_2
XFILLER_255_617 VPWR VGND VPWR VGND sky130_ef_sc_hd__decap_12
XFILLER_223_39 VPWR VGND VPWR VGND sky130_ef_sc_hd__decap_12
XFILLER_212_1353 VPWR VGND VPWR VGND sky130_ef_sc_hd__decap_12
XTAP_TAPCELL_ROW_223_2910 VGND VPWR sky130_fd_sc_hd__tapvpwrvgnd_1
XFILLER_208_533 VPWR VGND VPWR VGND sky130_ef_sc_hd__decap_12
XFILLER_212_1397 VPWR VGND VPWR VGND sky130_ef_sc_hd__decap_12
XFILLER_223_503 VGND VGND VPWR VPWR sky130_fd_sc_hd__fill_1
XFILLER_165_1105 VPWR VGND VPWR VGND sky130_ef_sc_hd__decap_12
XFILLER_247_1449 VGND VGND VPWR VPWR sky130_fd_sc_hd__decap_6
XFILLER_235_385 VGND VGND VPWR VPWR sky130_fd_sc_hd__decap_6
XTAP_TAPCELL_ROW_204_2386 VGND VPWR sky130_fd_sc_hd__tapvpwrvgnd_1
XTAP_TAPCELL_ROW_204_2397 VGND VPWR sky130_fd_sc_hd__tapvpwrvgnd_1
XFILLER_250_333 VPWR VGND VPWR VGND sky130_ef_sc_hd__decap_12
XFILLER_165_1149 VPWR VGND VPWR VGND sky130_ef_sc_hd__decap_12
XFILLER_211_709 VPWR VGND VPWR VGND sky130_ef_sc_hd__decap_12
XFILLER_251_889 VGND VGND VPWR VPWR sky130_fd_sc_hd__decap_6
XFILLER_182_1441 VPWR VGND VPWR VGND sky130_ef_sc_hd__decap_12
XFILLER_250_377 VPWR VGND VPWR VGND sky130_ef_sc_hd__decap_12
XTAP_TAPCELL_ROW_196_2165 VGND VPWR sky130_fd_sc_hd__tapvpwrvgnd_1
XFILLER_94_3 VPWR VGND VPWR VGND sky130_ef_sc_hd__decap_12
XTAP_TAPCELL_ROW_196_2176 VGND VPWR sky130_fd_sc_hd__tapvpwrvgnd_1
XTAP_TAPCELL_ROW_196_2187 VGND VPWR sky130_fd_sc_hd__tapvpwrvgnd_1
XFILLER_176_613 VPWR VGND VPWR VGND sky130_ef_sc_hd__decap_12
XFILLER_182_1485 VPWR VGND VPWR VGND sky130_ef_sc_hd__decap_12
XFILLER_91_1379 VGND VGND VPWR VPWR sky130_fd_sc_hd__decap_6
XFILLER_203_293 VPWR VGND VPWR VGND sky130_ef_sc_hd__decap_12
XTAP_TAPCELL_ROW_217_2736 VGND VPWR sky130_fd_sc_hd__tapvpwrvgnd_1
XFILLER_176_657 VPWR VGND VPWR VGND sky130_ef_sc_hd__decap_12
XTAP_TAPCELL_ROW_217_2747 VGND VPWR sky130_fd_sc_hd__tapvpwrvgnd_1
XFILLER_223_1493 VPWR VGND VPWR VGND sky130_ef_sc_hd__decap_12
XFILLER_175_167 VGND VGND VPWR VPWR sky130_fd_sc_hd__fill_1
XFILLER_89_1231 VPWR VGND VPWR VGND sky130_ef_sc_hd__decap_12
XFILLER_8_881 VPWR VGND VPWR VGND sky130_ef_sc_hd__decap_12
XFILLER_89_1275 VPWR VGND VPWR VGND sky130_ef_sc_hd__decap_12
XFILLER_7_391 VGND VGND VPWR VPWR sky130_fd_sc_hd__fill_1
XFILLER_102_1177 VPWR VGND VPWR VGND sky130_ef_sc_hd__decap_12
XFILLER_254_1409 VPWR VGND VPWR VGND sky130_ef_sc_hd__decap_12
XTAP_TAPCELL_ROW_90_2_4294 VGND VPWR sky130_fd_sc_hd__tapvpwrvgnd_1
XTAP_TAPCELL_ROW_89_2_4288 VGND VPWR sky130_fd_sc_hd__tapvpwrvgnd_1
XFILLER_171_373 VPWR VGND VPWR VGND sky130_ef_sc_hd__decap_12
XFILLER_217_1231 VGND VGND VPWR VPWR sky130_fd_sc_hd__fill_1
XFILLER_150_1407 VGND VGND VPWR VPWR sky130_fd_sc_hd__decap_6
XFILLER_219_809 VPWR VGND VPWR VGND sky130_ef_sc_hd__decap_12
XFILLER_133_39 VPWR VGND VPWR VGND sky130_ef_sc_hd__decap_12
XFILLER_245_105 VGND VGND VPWR VPWR sky130_fd_sc_hd__decap_6
XFILLER_6_1353 VPWR VGND VPWR VGND sky130_ef_sc_hd__decap_12
XTAP_TAPCELL_ROW_185_1880 VGND VPWR sky130_fd_sc_hd__tapvpwrvgnd_1
XFILLER_230_1453 VPWR VGND VPWR VGND sky130_ef_sc_hd__decap_12
XTAP_TAPCELL_ROW_185_1891 VGND VPWR sky130_fd_sc_hd__tapvpwrvgnd_1
XFILLER_245_149 VPWR VGND VPWR VGND sky130_ef_sc_hd__decap_12
XFILLER_2_1217 VPWR VGND VPWR VGND sky130_ef_sc_hd__decap_12
XFILLER_227_853 VPWR VGND VPWR VGND sky130_ef_sc_hd__decap_12
XFILLER_6_1397 VPWR VGND VPWR VGND sky130_ef_sc_hd__decap_12
XFILLER_113_1273 VGND VGND VPWR VPWR sky130_fd_sc_hd__fill_1
XFILLER_26_15 VPWR VGND VPWR VGND sky130_ef_sc_hd__decap_12
XFILLER_230_1497 VPWR VGND VPWR VGND sky130_ef_sc_hd__decap_12
XTAP_TAPCELL_ROW_181_1766 VGND VPWR sky130_fd_sc_hd__tapvpwrvgnd_1
XFILLER_22_1189 VGND VGND VPWR VPWR sky130_fd_sc_hd__fill_1
XFILLER_148_1303 VPWR VGND VPWR VGND sky130_ef_sc_hd__decap_12
XTAP_TAPCELL_ROW_181_1777 VGND VPWR sky130_fd_sc_hd__tapvpwrvgnd_1
XFILLER_226_363 VGND VGND VPWR VPWR sky130_fd_sc_hd__fill_1
XTAP_TAPCELL_ROW_49_2_4051 VGND VPWR sky130_fd_sc_hd__tapvpwrvgnd_1
XFILLER_227_897 VPWR VGND VPWR VGND sky130_ef_sc_hd__decap_12
XFILLER_214_525 VGND VGND VPWR VPWR sky130_fd_sc_hd__decap_6
XFILLER_57_1219 VPWR VGND VPWR VGND sky130_ef_sc_hd__decap_12
XFILLER_199_727 VGND VGND VPWR VPWR sky130_fd_sc_hd__fill_1
XFILLER_253_193 VPWR VGND VPWR VGND sky130_ef_sc_hd__decap_12
XFILLER_242_867 VGND VGND VPWR VPWR sky130_fd_sc_hd__fill_1
XFILLER_214_569 VPWR VGND VPWR VGND sky130_ef_sc_hd__decap_12
XTAP_TAPCELL_ROW_62_2_4129 VGND VPWR sky130_fd_sc_hd__tapvpwrvgnd_1
XFILLER_228_1371 VGND VGND VPWR VPWR sky130_fd_sc_hd__fill_1
XTAP_TAPCELL_ROW_81_1_1216 VGND VPWR sky130_fd_sc_hd__tapvpwrvgnd_1
XFILLER_179_473 VPWR VGND VPWR VGND sky130_ef_sc_hd__decap_12
XFILLER_195_933 VPWR VGND VPWR VGND sky130_ef_sc_hd__decap_12
XFILLER_194_421 VPWR VGND VPWR VGND sky130_ef_sc_hd__decap_12
XFILLER_42_69 VGND VGND VPWR VPWR sky130_fd_sc_hd__fill_2
XFILLER_195_977 VPWR VGND VPWR VGND sky130_ef_sc_hd__decap_12
XTAP_TAPCELL_ROW_42_2_4005 VGND VPWR sky130_fd_sc_hd__tapvpwrvgnd_1
XFILLER_166_189 VGND VGND VPWR VPWR sky130_fd_sc_hd__decap_6
XFILLER_177_1009 VPWR VGND VPWR VGND sky130_ef_sc_hd__decap_12
XFILLER_68_1315 VPWR VGND VPWR VGND sky130_ef_sc_hd__decap_12
XFILLER_181_137 VPWR VGND VPWR VGND sky130_ef_sc_hd__decap_12
XFILLER_159_1443 VPWR VGND VPWR VGND sky130_ef_sc_hd__decap_12
XFILLER_68_1359 VPWR VGND VPWR VGND sky130_ef_sc_hd__decap_12
XFILLER_218_1017 VPWR VGND VPWR VGND sky130_ef_sc_hd__decap_12
XFILLER_155_1329 VGND VGND VPWR VPWR sky130_fd_sc_hd__fill_1
XFILLER_190_693 VGND VGND VPWR VPWR sky130_fd_sc_hd__decap_6
XTAP_TAPCELL_ROW_227_3010 VGND VPWR sky130_fd_sc_hd__tapvpwrvgnd_1
XTAP_TAPCELL_ROW_227_3021 VGND VPWR sky130_fd_sc_hd__tapvpwrvgnd_1
XFILLER_107_51 VGND VGND VPWR VPWR sky130_fd_sc_hd__decap_4
XFILLER_192_1091 VGND VGND VPWR VPWR sky130_fd_sc_hd__fill_1
XFILLER_67_55 VGND VGND VPWR VPWR sky130_fd_sc_hd__fill_1
XFILLER_237_617 VPWR VGND VPWR VGND sky130_ef_sc_hd__decap_12
XFILLER_188_1105 VPWR VGND VPWR VGND sky130_ef_sc_hd__decap_12
XFILLER_40_1245 VGND VGND VPWR VPWR sky130_fd_sc_hd__fill_1
XFILLER_79_1411 VPWR VGND VPWR VGND sky130_ef_sc_hd__decap_12
XFILLER_188_1149 VPWR VGND VPWR VGND sky130_ef_sc_hd__decap_12
X_623_ clknet_3_4__leaf_clk dout0\[21\] _031_ VGND VGND VPWR VPWR dout0_q\[21\] sky130_fd_sc_hd__dfrtp_1
XFILLER_79_1455 VPWR VGND VPWR VGND sky130_ef_sc_hd__decap_12
XFILLER_205_503 VGND VGND VPWR VPWR sky130_fd_sc_hd__fill_1
XFILLER_229_1113 VGND VGND VPWR VPWR sky130_fd_sc_hd__decap_6
XFILLER_217_385 VGND VGND VPWR VPWR sky130_fd_sc_hd__decap_6
X_554_ net669 VGND VGND VPWR VPWR _036_ sky130_fd_sc_hd__inv_2
XFILLER_79_1499 VPWR VGND VPWR VGND sky130_ef_sc_hd__decap_12
XFILLER_229_1157 VPWR VGND VPWR VGND sky130_ef_sc_hd__decap_12
XFILLER_232_333 VPWR VGND VPWR VGND sky130_ef_sc_hd__decap_12
XFILLER_189_237 VPWR VGND VPWR VGND sky130_ef_sc_hd__decap_12
XFILLER_233_889 VGND VGND VPWR VPWR sky130_fd_sc_hd__decap_6
X_485_ net494 net101 net173 VGND VGND VPWR VPWR _248_ sky130_fd_sc_hd__a21oi_1
XFILLER_232_377 VPWR VGND VPWR VGND sky130_ef_sc_hd__decap_12
XFILLER_207_1455 VGND VGND VPWR VPWR sky130_fd_sc_hd__fill_1
XFILLER_198_793 VPWR VGND VPWR VGND sky130_ef_sc_hd__decap_12
XFILLER_197_281 VPWR VGND VPWR VGND sky130_ef_sc_hd__decap_12
XFILLER_199_1201 VPWR VGND VPWR VGND sky130_ef_sc_hd__decap_12
XFILLER_201_753 VPWR VGND VPWR VGND sky130_ef_sc_hd__decap_12
XFILLER_9_645 VPWR VGND VPWR VGND sky130_ef_sc_hd__decap_12
XFILLER_8_133 VGND VGND VPWR VPWR sky130_fd_sc_hd__decap_6
XFILLER_125_1177 VPWR VGND VPWR VGND sky130_ef_sc_hd__decap_12
XTAP_TAPCELL_ROW_191_2040 VGND VPWR sky130_fd_sc_hd__tapvpwrvgnd_1
XTAP_TAPCELL_ROW_107_2_4396 VGND VPWR sky130_fd_sc_hd__tapvpwrvgnd_1
XTAP_TAPCELL_ROW_191_2051 VGND VPWR sky130_fd_sc_hd__tapvpwrvgnd_1
XFILLER_199_1245 VPWR VGND VPWR VGND sky130_ef_sc_hd__decap_12
XPHY_EDGE_ROW_205_Left_460 VGND VGND VPWR VPWR sky130_fd_sc_hd__decap_3
XFILLER_12_1303 VPWR VGND VPWR VGND sky130_ef_sc_hd__decap_12
XFILLER_201_797 VPWR VGND VPWR VGND sky130_ef_sc_hd__decap_12
XFILLER_16_1483 VPWR VGND VPWR VGND sky130_ef_sc_hd__decap_12
XFILLER_201_1021 VPWR VGND VPWR VGND sky130_ef_sc_hd__decap_12
XFILLER_51_1385 VGND VGND VPWR VPWR sky130_fd_sc_hd__fill_1
XTAP_TAPCELL_ROW_212_2600 VGND VPWR sky130_fd_sc_hd__tapvpwrvgnd_1
XFILLER_199_1289 VPWR VGND VPWR VGND sky130_ef_sc_hd__decap_12
XTAP_TAPCELL_ROW_212_2611 VGND VPWR sky130_fd_sc_hd__tapvpwrvgnd_1
XFILLER_201_1065 VPWR VGND VPWR VGND sky130_ef_sc_hd__decap_12
XFILLER_86_1415 VPWR VGND VPWR VGND sky130_ef_sc_hd__decap_12
XTAP_TAPCELL_ROW_212_2622 VGND VPWR sky130_fd_sc_hd__tapvpwrvgnd_1
XFILLER_103_1497 VGND VGND VPWR VPWR sky130_fd_sc_hd__fill_1
XFILLER_236_1117 VPWR VGND VPWR VGND sky130_ef_sc_hd__decap_12
XFILLER_181_671 VGND VGND VPWR VPWR sky130_fd_sc_hd__fill_1
XFILLER_5_895 VGND VGND VPWR VPWR sky130_fd_sc_hd__fill_1
XFILLER_234_27 VGND VGND VPWR VPWR sky130_fd_sc_hd__fill_1
XTAP_TAPCELL_ROW_55_2_4083 VGND VPWR sky130_fd_sc_hd__tapvpwrvgnd_1
XPHY_EDGE_ROW_136_2_Left_638 VGND VGND VPWR VPWR sky130_fd_sc_hd__decap_3
XFILLER_136_1295 VGND VGND VPWR VPWR sky130_fd_sc_hd__decap_6
XFILLER_171_1175 VGND VGND VPWR VPWR sky130_fd_sc_hd__fill_1
XFILLER_227_105 VGND VGND VPWR VPWR sky130_fd_sc_hd__decap_6
XFILLER_23_1443 VPWR VGND VPWR VGND sky130_ef_sc_hd__decap_12
XTAP_TAPCELL_ROW_206_2437 VGND VPWR sky130_fd_sc_hd__tapvpwrvgnd_1
XFILLER_250_15 VPWR VGND VPWR VGND sky130_ef_sc_hd__decap_12
XFILLER_97_1511 VGND VGND VPWR VPWR sky130_fd_sc_hd__decap_4
XTAP_TAPCELL_ROW_206_2448 VGND VPWR sky130_fd_sc_hd__tapvpwrvgnd_1
XFILLER_212_1161 VPWR VGND VPWR VGND sky130_ef_sc_hd__decap_12
XFILLER_227_149 VPWR VGND VPWR VGND sky130_ef_sc_hd__decap_12
XFILLER_243_609 VGND VGND VPWR VPWR sky130_fd_sc_hd__decap_6
XFILLER_110_1413 VGND VGND VPWR VPWR sky130_fd_sc_hd__fill_1
XTAP_TAPCELL_ROW_206_2459 VGND VPWR sky130_fd_sc_hd__tapvpwrvgnd_1
XFILLER_209_853 VPWR VGND VPWR VGND sky130_ef_sc_hd__decap_12
XFILLER_247_1213 VPWR VGND VPWR VGND sky130_ef_sc_hd__decap_12
XFILLER_208_363 VGND VGND VPWR VPWR sky130_fd_sc_hd__fill_1
XFILLER_209_897 VPWR VGND VPWR VGND sky130_ef_sc_hd__decap_12
XTAP_TAPCELL_ROW_198_2227 VGND VPWR sky130_fd_sc_hd__tapvpwrvgnd_1
XTAP_TAPCELL_ROW_198_2238 VGND VPWR sky130_fd_sc_hd__tapvpwrvgnd_1
XFILLER_247_1257 VPWR VGND VPWR VGND sky130_ef_sc_hd__decap_12
XFILLER_235_193 VPWR VGND VPWR VGND sky130_ef_sc_hd__decap_12
XFILLER_224_867 VGND VGND VPWR VPWR sky130_fd_sc_hd__fill_1
XFILLER_251_653 VPWR VGND VPWR VGND sky130_ef_sc_hd__decap_12
XTAP_TAPCELL_ROW_33_2_3953 VGND VPWR sky130_fd_sc_hd__tapvpwrvgnd_1
XFILLER_250_141 VPWR VGND VPWR VGND sky130_ef_sc_hd__decap_12
XFILLER_225_1511 VGND VGND VPWR VPWR sky130_fd_sc_hd__fill_1
XFILLER_211_517 VPWR VGND VPWR VGND sky130_ef_sc_hd__decap_12
XTAP_TAPCELL_ROW_219_2809 VGND VPWR sky130_fd_sc_hd__tapvpwrvgnd_1
XFILLER_251_697 VPWR VGND VPWR VGND sky130_ef_sc_hd__decap_12
XFILLER_91_1165 VPWR VGND VPWR VGND sky130_ef_sc_hd__decap_12
XFILLER_177_933 VPWR VGND VPWR VGND sky130_ef_sc_hd__decap_12
XFILLER_176_421 VPWR VGND VPWR VGND sky130_ef_sc_hd__decap_12
XFILLER_143_1255 VPWR VGND VPWR VGND sky130_ef_sc_hd__decap_12
XFILLER_177_977 VPWR VGND VPWR VGND sky130_ef_sc_hd__decap_12
XFILLER_104_1239 VGND VGND VPWR VPWR sky130_fd_sc_hd__decap_6
XFILLER_192_925 VPWR VGND VPWR VGND sky130_ef_sc_hd__decap_12
XFILLER_143_1299 VPWR VGND VPWR VGND sky130_ef_sc_hd__decap_12
XTAP_TAPCELL_ROW_142_1_1277 VGND VPWR sky130_fd_sc_hd__tapvpwrvgnd_1
XTAP_TAPCELL_ROW_174_1570 VGND VPWR sky130_fd_sc_hd__tapvpwrvgnd_1
XFILLER_178_1329 VPWR VGND VPWR VGND sky130_ef_sc_hd__decap_12
XTAP_TAPCELL_ROW_174_1581 VGND VPWR sky130_fd_sc_hd__tapvpwrvgnd_1
XTAP_TAPCELL_ROW_174_1592 VGND VPWR sky130_fd_sc_hd__tapvpwrvgnd_1
XFILLER_30_1469 VGND VGND VPWR VPWR sky130_fd_sc_hd__fill_1
XFILLER_254_1217 VPWR VGND VPWR VGND sky130_ef_sc_hd__decap_12
XFILLER_2_309 VPWR VGND VPWR VGND sky130_ef_sc_hd__decap_12
XTAP_TAPCELL_ROW_170_1467 VGND VPWR sky130_fd_sc_hd__tapvpwrvgnd_1
XFILLER_219_1337 VGND VGND VPWR VPWR sky130_fd_sc_hd__decap_6
XTAP_TAPCELL_ROW_170_1478 VGND VPWR sky130_fd_sc_hd__tapvpwrvgnd_1
XFILLER_172_693 VGND VGND VPWR VPWR sky130_fd_sc_hd__decap_6
XFILLER_171_181 VPWR VGND VPWR VGND sky130_ef_sc_hd__decap_12
XFILLER_208_83 VGND VGND VPWR VPWR sky130_fd_sc_hd__fill_1
XFILLER_63_1201 VPWR VGND VPWR VGND sky130_ef_sc_hd__decap_12
XFILLER_144_27 VGND VGND VPWR VPWR sky130_fd_sc_hd__fill_1
XTAP_TAPCELL_ROW_164_2_4739 VGND VPWR sky130_fd_sc_hd__tapvpwrvgnd_1
XTAP_TAPCELL_ROW_187_1931 VGND VPWR sky130_fd_sc_hd__tapvpwrvgnd_1
XFILLER_154_1351 VGND VGND VPWR VPWR sky130_fd_sc_hd__decap_6
XTAP_TAPCELL_ROW_187_1942 VGND VPWR sky130_fd_sc_hd__tapvpwrvgnd_1
XFILLER_63_1267 VGND VGND VPWR VPWR sky130_fd_sc_hd__decap_6
XFILLER_150_1215 VPWR VGND VPWR VGND sky130_ef_sc_hd__decap_12
XFILLER_219_617 VPWR VGND VPWR VGND sky130_ef_sc_hd__decap_12
Xfanout668 net671 VGND VGND VPWR VPWR net668 sky130_fd_sc_hd__clkbuf_4
XFILLER_154_1395 VPWR VGND VPWR VGND sky130_ef_sc_hd__decap_12
XTAP_TAPCELL_ROW_183_1817 VGND VPWR sky130_fd_sc_hd__tapvpwrvgnd_1
XTAP_TAPCELL_ROW_183_1828 VGND VPWR sky130_fd_sc_hd__tapvpwrvgnd_1
XTAP_TAPCELL_ROW_183_1839 VGND VPWR sky130_fd_sc_hd__tapvpwrvgnd_1
XFILLER_189_1425 VPWR VGND VPWR VGND sky130_ef_sc_hd__decap_12
XFILLER_115_1379 VGND VGND VPWR VPWR sky130_fd_sc_hd__decap_6
XFILLER_150_1259 VPWR VGND VPWR VGND sky130_ef_sc_hd__decap_12
XFILLER_6_1161 VPWR VGND VPWR VGND sky130_ef_sc_hd__decap_12
XFILLER_160_15 VPWR VGND VPWR VGND sky130_ef_sc_hd__decap_12
XFILLER_230_1261 VPWR VGND VPWR VGND sky130_ef_sc_hd__decap_12
XFILLER_246_469 VGND VGND VPWR VPWR sky130_fd_sc_hd__decap_6
XFILLER_37_69 VGND VGND VPWR VPWR sky130_fd_sc_hd__fill_2
XFILLER_189_1469 VPWR VGND VPWR VGND sky130_ef_sc_hd__decap_12
XFILLER_255_981 VPWR VGND VPWR VGND sky130_ef_sc_hd__decap_12
XFILLER_214_333 VPWR VGND VPWR VGND sky130_ef_sc_hd__decap_12
XFILLER_215_889 VGND VGND VPWR VPWR sky130_fd_sc_hd__decap_6
XFILLER_183_1057 VGND VGND VPWR VPWR sky130_fd_sc_hd__decap_6
XFILLER_148_1177 VPWR VGND VPWR VGND sky130_ef_sc_hd__decap_12
XFILLER_214_377 VPWR VGND VPWR VGND sky130_ef_sc_hd__decap_12
XFILLER_230_837 VPWR VGND VPWR VGND sky130_ef_sc_hd__decap_12
XFILLER_161_1311 VPWR VGND VPWR VGND sky130_ef_sc_hd__decap_12
XFILLER_169_57 VPWR VGND VPWR VGND sky130_ef_sc_hd__decap_12
XFILLER_70_1227 VPWR VGND VPWR VGND sky130_ef_sc_hd__decap_12
XFILLER_179_281 VPWR VGND VPWR VGND sky130_ef_sc_hd__decap_12
XFILLER_195_741 VPWR VGND VPWR VGND sky130_ef_sc_hd__decap_12
XFILLER_161_1355 VPWR VGND VPWR VGND sky130_ef_sc_hd__decap_12
XFILLER_122_1339 VPWR VGND VPWR VGND sky130_ef_sc_hd__decap_12
XFILLER_194_251 VGND VGND VPWR VPWR sky130_fd_sc_hd__fill_1
XFILLER_195_785 VPWR VGND VPWR VGND sky130_ef_sc_hd__decap_12
XTAP_TAPCELL_ROW_252_3681 VGND VPWR sky130_fd_sc_hd__tapvpwrvgnd_1
XFILLER_161_1399 VPWR VGND VPWR VGND sky130_ef_sc_hd__decap_12
XFILLER_182_413 VGND VGND VPWR VPWR sky130_fd_sc_hd__decap_6
XFILLER_202_1341 VPWR VGND VPWR VGND sky130_ef_sc_hd__decap_12
XTAP_TAPCELL_ROW_252_3692 VGND VPWR sky130_fd_sc_hd__tapvpwrvgnd_1
XFILLER_196_1429 VPWR VGND VPWR VGND sky130_ef_sc_hd__decap_12
XFILLER_211_3 VPWR VGND VPWR VGND sky130_ef_sc_hd__decap_12
XFILLER_5_125 VPWR VGND VPWR VGND sky130_ef_sc_hd__decap_12
XPHY_EDGE_ROW_134_1_Left_389 VGND VGND VPWR VPWR sky130_fd_sc_hd__decap_3
XFILLER_182_457 VPWR VGND VPWR VGND sky130_ef_sc_hd__decap_12
XFILLER_202_1385 VPWR VGND VPWR VGND sky130_ef_sc_hd__decap_12
XFILLER_237_1437 VPWR VGND VPWR VGND sky130_ef_sc_hd__decap_12
XFILLER_159_1273 VGND VGND VPWR VPWR sky130_fd_sc_hd__fill_1
XFILLER_68_1189 VGND VGND VPWR VPWR sky130_fd_sc_hd__fill_1
XFILLER_190_1017 VPWR VGND VPWR VGND sky130_ef_sc_hd__decap_12
XPHY_EDGE_ROW_71_1_Left_326 VGND VGND VPWR VPWR sky130_fd_sc_hd__decap_3
XFILLER_194_1197 VGND VGND VPWR VPWR sky130_fd_sc_hd__decap_6
XFILLER_78_65 VGND VGND VPWR VPWR sky130_fd_sc_hd__decap_6
XFILLER_81_1323 VGND VGND VPWR VPWR sky130_fd_sc_hd__decap_6
XFILLER_81_1367 VPWR VGND VPWR VGND sky130_ef_sc_hd__decap_12
XFILLER_133_1435 VGND VGND VPWR VPWR sky130_fd_sc_hd__decap_6
XFILLER_238_937 VPWR VGND VPWR VGND sky130_ef_sc_hd__decap_12
XFILLER_209_105 VGND VGND VPWR VPWR sky130_fd_sc_hd__decap_6
XFILLER_237_447 VGND VGND VPWR VPWR sky130_fd_sc_hd__fill_1
XFILLER_133_1479 VPWR VGND VPWR VGND sky130_ef_sc_hd__decap_12
XFILLER_209_149 VPWR VGND VPWR VGND sky130_ef_sc_hd__decap_12
XFILLER_94_53 VPWR VGND VPWR VGND sky130_ef_sc_hd__decap_12
XFILLER_168_1509 VGND VGND VPWR VPWR sky130_fd_sc_hd__decap_6
XFILLER_213_1481 VPWR VGND VPWR VGND sky130_ef_sc_hd__decap_12
XFILLER_225_609 VGND VGND VPWR VPWR sky130_fd_sc_hd__decap_6
XFILLER_246_981 VPWR VGND VPWR VGND sky130_ef_sc_hd__decap_12
X_606_ clknet_3_1__leaf_clk dout0\[4\] _014_ VGND VGND VPWR VPWR dout0_q\[4\] sky130_fd_sc_hd__dfrtp_1
XTAP_TAPCELL_ROW_201_2301 VGND VPWR sky130_fd_sc_hd__tapvpwrvgnd_1
XTAP_TAPCELL_ROW_201_2312 VGND VPWR sky130_fd_sc_hd__tapvpwrvgnd_1
XTAP_TAPCELL_ROW_201_2323 VGND VPWR sky130_fd_sc_hd__tapvpwrvgnd_1
XFILLER_217_193 VPWR VGND VPWR VGND sky130_ef_sc_hd__decap_12
XFILLER_206_867 VGND VGND VPWR VPWR sky130_fd_sc_hd__fill_1
XFILLER_220_29 VPWR VGND VPWR VGND sky130_ef_sc_hd__decap_12
XFILLER_233_653 VPWR VGND VPWR VGND sky130_ef_sc_hd__decap_12
XFILLER_232_141 VPWR VGND VPWR VGND sky130_ef_sc_hd__decap_12
X_537_ net666 VGND VGND VPWR VPWR _019_ sky130_fd_sc_hd__inv_2
XFILLER_127_1217 VGND VGND VPWR VPWR sky130_fd_sc_hd__fill_1
XFILLER_233_697 VPWR VGND VPWR VGND sky130_ef_sc_hd__decap_12
XTAP_TAPCELL_ROW_193_2102 VGND VPWR sky130_fd_sc_hd__tapvpwrvgnd_1
XFILLER_92_1463 VGND VGND VPWR VPWR sky130_fd_sc_hd__decap_6
X_468_ net153 net104 VGND VGND VPWR VPWR acc_core.adder.cla_blocks\[1\].block.sum\[2\]
+ sky130_fd_sc_hd__xnor2_1
XFILLER_201_561 VPWR VGND VPWR VGND sky130_ef_sc_hd__decap_12
XFILLER_229_27 VPWR VGND VPWR VGND sky130_ef_sc_hd__decap_12
X_399_ net590 net586 net563 VGND VGND VPWR VPWR _188_ sky130_fd_sc_hd__nand3_1
XFILLER_140_1439 VPWR VGND VPWR VGND sky130_ef_sc_hd__decap_12
XFILLER_174_925 VPWR VGND VPWR VGND sky130_ef_sc_hd__decap_12
XFILLER_185_273 VGND VGND VPWR VPWR sky130_fd_sc_hd__decap_6
XFILLER_220_1441 VPWR VGND VPWR VGND sky130_ef_sc_hd__decap_12
XFILLER_220_1485 VPWR VGND VPWR VGND sky130_ef_sc_hd__decap_12
XFILLER_57_3 VPWR VGND VPWR VGND sky130_ef_sc_hd__decap_12
XFILLER_12_1177 VPWR VGND VPWR VGND sky130_ef_sc_hd__decap_12
XFILLER_245_15 VPWR VGND VPWR VGND sky130_ef_sc_hd__decap_12
XFILLER_86_1245 VGND VGND VPWR VPWR sky130_fd_sc_hd__fill_1
XFILLER_138_1357 VGND VGND VPWR VPWR sky130_fd_sc_hd__fill_1
XFILLER_60_1407 VGND VGND VPWR VPWR sky130_fd_sc_hd__decap_6
XTAP_TAPCELL_ROW_130_2_4534 VGND VPWR sky130_fd_sc_hd__tapvpwrvgnd_1
XTAP_TAPCELL_ROW_129_2_4528 VGND VPWR sky130_fd_sc_hd__tapvpwrvgnd_1
XFILLER_3_1301 VPWR VGND VPWR VGND sky130_ef_sc_hd__decap_12
XFILLER_7_1481 VPWR VGND VPWR VGND sky130_ef_sc_hd__decap_12
XFILLER_228_469 VGND VGND VPWR VPWR sky130_fd_sc_hd__decap_6
XFILLER_255_277 VGND VGND VPWR VPWR sky130_fd_sc_hd__decap_3
XFILLER_243_417 VPWR VGND VPWR VGND sky130_ef_sc_hd__decap_12
XFILLER_23_1273 VGND VGND VPWR VPWR sky130_fd_sc_hd__fill_1
XFILLER_3_1345 VPWR VGND VPWR VGND sky130_ef_sc_hd__decap_12
XTAP_TAPCELL_ROW_97_2_4339 VGND VPWR sky130_fd_sc_hd__tapvpwrvgnd_1
XFILLER_58_1303 VPWR VGND VPWR VGND sky130_ef_sc_hd__decap_12
XFILLER_247_1021 VPWR VGND VPWR VGND sky130_ef_sc_hd__decap_12
XFILLER_97_1385 VGND VGND VPWR VPWR sky130_fd_sc_hd__fill_1
XFILLER_130_29 VPWR VGND VPWR VGND sky130_ef_sc_hd__decap_12
XFILLER_208_1005 VPWR VGND VPWR VGND sky130_ef_sc_hd__decap_12
XFILLER_252_973 VGND VGND VPWR VPWR sky130_fd_sc_hd__decap_6
XFILLER_247_1065 VPWR VGND VPWR VGND sky130_ef_sc_hd__decap_12
XFILLER_251_461 VPWR VGND VPWR VGND sky130_ef_sc_hd__decap_12
XFILLER_149_1497 VGND VGND VPWR VPWR sky130_fd_sc_hd__fill_1
XFILLER_212_837 VPWR VGND VPWR VGND sky130_ef_sc_hd__decap_12
XFILLER_208_1049 VPWR VGND VPWR VGND sky130_ef_sc_hd__decap_12
XTAP_TAPCELL_ROW_77_2_4215 VGND VPWR sky130_fd_sc_hd__tapvpwrvgnd_1
XFILLER_23_27 VGND VGND VPWR VPWR sky130_fd_sc_hd__decap_4
XTAP_TAPCELL_ROW_176_1632 VGND VPWR sky130_fd_sc_hd__tapvpwrvgnd_1
XFILLER_177_741 VPWR VGND VPWR VGND sky130_ef_sc_hd__decap_12
XFILLER_139_27 VPWR VGND VPWR VGND sky130_ef_sc_hd__decap_12
XTAP_TAPCELL_ROW_176_1643 VGND VPWR sky130_fd_sc_hd__tapvpwrvgnd_1
XFILLER_220_881 VPWR VGND VPWR VGND sky130_ef_sc_hd__decap_12
XFILLER_165_925 VPWR VGND VPWR VGND sky130_ef_sc_hd__decap_12
XFILLER_176_251 VGND VGND VPWR VPWR sky130_fd_sc_hd__fill_1
XFILLER_177_785 VPWR VGND VPWR VGND sky130_ef_sc_hd__decap_12
XTAP_TAPCELL_ROW_172_1518 VGND VPWR sky130_fd_sc_hd__tapvpwrvgnd_1
XTAP_TAPCELL_ROW_172_1529 VGND VPWR sky130_fd_sc_hd__tapvpwrvgnd_1
XFILLER_192_755 VGND VGND VPWR VPWR sky130_fd_sc_hd__fill_1
XFILLER_180_917 VGND VGND VPWR VPWR sky130_fd_sc_hd__decap_6
XFILLER_69_1443 VPWR VGND VPWR VGND sky130_ef_sc_hd__decap_12
XFILLER_219_93 VPWR VGND VPWR VGND sky130_ef_sc_hd__decap_12
XFILLER_219_1101 VPWR VGND VPWR VGND sky130_ef_sc_hd__decap_12
XTAP_TAPCELL_ROW_76_1_1211 VGND VPWR sky130_fd_sc_hd__tapvpwrvgnd_1
XFILLER_155_15 VPWR VGND VPWR VGND sky130_ef_sc_hd__decap_12
XFILLER_156_1413 VGND VGND VPWR VPWR sky130_fd_sc_hd__fill_1
XFILLER_219_1145 VPWR VGND VPWR VGND sky130_ef_sc_hd__decap_12
XFILLER_65_1329 VGND VGND VPWR VPWR sky130_fd_sc_hd__fill_1
XFILLER_2_139 VGND VGND VPWR VPWR sky130_fd_sc_hd__fill_1
XFILLER_191_1337 VGND VGND VPWR VPWR sky130_fd_sc_hd__decap_6
XFILLER_215_1009 VPWR VGND VPWR VGND sky130_ef_sc_hd__decap_12
XFILLER_219_1189 VPWR VGND VPWR VGND sky130_ef_sc_hd__decap_12
XFILLER_235_81 VPWR VGND VPWR VGND sky130_ef_sc_hd__decap_12
XTAP_TAPCELL_ROW_24_2_3898 VGND VPWR sky130_fd_sc_hd__tapvpwrvgnd_1
XFILLER_48_68 VGND VGND VPWR VPWR sky130_fd_sc_hd__decap_3
XFILLER_115_1165 VPWR VGND VPWR VGND sky130_ef_sc_hd__decap_12
XFILLER_219_447 VGND VGND VPWR VPWR sky130_fd_sc_hd__fill_1
XFILLER_246_233 VPWR VGND VPWR VGND sky130_ef_sc_hd__decap_12
XFILLER_171_69 VPWR VGND VPWR VGND sky130_ef_sc_hd__decap_12
XFILLER_189_1233 VPWR VGND VPWR VGND sky130_ef_sc_hd__decap_12
XFILLER_207_609 VGND VGND VPWR VPWR sky130_fd_sc_hd__decap_6
XFILLER_104_41 VPWR VGND VPWR VGND sky130_ef_sc_hd__decap_12
XFILLER_246_277 VPWR VGND VPWR VGND sky130_ef_sc_hd__decap_12
XTAP_TAPCELL_ROW_241_3382 VGND VPWR sky130_fd_sc_hd__tapvpwrvgnd_1
XFILLER_228_981 VPWR VGND VPWR VGND sky130_ef_sc_hd__decap_12
XTAP_TAPCELL_ROW_241_3393 VGND VPWR sky130_fd_sc_hd__tapvpwrvgnd_1
XFILLER_185_1119 VGND VGND VPWR VPWR sky130_fd_sc_hd__fill_1
XFILLER_230_1091 VGND VGND VPWR VPWR sky130_fd_sc_hd__fill_1
XFILLER_243_951 VGND VGND VPWR VPWR sky130_fd_sc_hd__fill_1
XFILLER_161_3 VPWR VGND VPWR VGND sky130_ef_sc_hd__decap_12
XFILLER_215_653 VPWR VGND VPWR VGND sky130_ef_sc_hd__decap_12
XFILLER_226_1105 VPWR VGND VPWR VGND sky130_ef_sc_hd__decap_12
XFILLER_214_141 VPWR VGND VPWR VGND sky130_ef_sc_hd__decap_12
XFILLER_230_601 VPWR VGND VPWR VGND sky130_ef_sc_hd__decap_12
XFILLER_76_1469 VGND VGND VPWR VPWR sky130_fd_sc_hd__fill_1
XFILLER_187_505 VPWR VGND VPWR VGND sky130_ef_sc_hd__decap_12
XFILLER_215_697 VPWR VGND VPWR VGND sky130_ef_sc_hd__decap_12
XFILLER_226_1149 VPWR VGND VPWR VGND sky130_ef_sc_hd__decap_12
XTAP_TAPCELL_ROW_254_3732 VGND VPWR sky130_fd_sc_hd__tapvpwrvgnd_1
XFILLER_9_29 VPWR VGND VPWR VGND sky130_ef_sc_hd__decap_12
X_322_ _103_ _107_ _110_ VGND VGND VPWR VPWR _111_ sky130_fd_sc_hd__o21bai_1
XFILLER_230_645 VPWR VGND VPWR VGND sky130_ef_sc_hd__decap_12
XTAP_TAPCELL_ROW_254_3743 VGND VPWR sky130_fd_sc_hd__tapvpwrvgnd_1
XTAP_TAPCELL_ROW_254_3754 VGND VPWR sky130_fd_sc_hd__tapvpwrvgnd_1
XTAP_TAPCELL_ROW_250_3629 VGND VPWR sky130_fd_sc_hd__tapvpwrvgnd_1
XFILLER_126_1283 VPWR VGND VPWR VGND sky130_ef_sc_hd__decap_12
XFILLER_35_1177 VPWR VGND VPWR VGND sky130_ef_sc_hd__decap_12
XFILLER_167_273 VGND VGND VPWR VPWR sky130_fd_sc_hd__decap_6
XFILLER_196_77 VGND VGND VPWR VPWR sky130_fd_sc_hd__decap_6
XFILLER_182_221 VPWR VGND VPWR VGND sky130_ef_sc_hd__decap_12
XFILLER_183_777 VGND VGND VPWR VPWR sky130_fd_sc_hd__decap_6
XFILLER_237_1201 VPWR VGND VPWR VGND sky130_ef_sc_hd__decap_12
XFILLER_182_265 VPWR VGND VPWR VGND sky130_ef_sc_hd__decap_12
XFILLER_196_1259 VGND VGND VPWR VPWR sky130_fd_sc_hd__fill_1
XFILLER_13_1497 VGND VGND VPWR VPWR sky130_fd_sc_hd__fill_1
XFILLER_237_1245 VPWR VGND VPWR VGND sky130_ef_sc_hd__decap_12
XTAP_TAPCELL_ROW_248_3569 VGND VPWR sky130_fd_sc_hd__tapvpwrvgnd_1
XFILLER_9_1009 VPWR VGND VPWR VGND sky130_ef_sc_hd__decap_12
XFILLER_237_1289 VPWR VGND VPWR VGND sky130_ef_sc_hd__decap_12
XFILLER_1_161 VGND VGND VPWR VPWR sky130_fd_sc_hd__decap_6
XFILLER_238_701 VPWR VGND VPWR VGND sky130_ef_sc_hd__decap_12
XTAP_TAPCELL_ROW_115_2_4447 VGND VPWR sky130_fd_sc_hd__tapvpwrvgnd_1
XFILLER_46_1295 VGND VGND VPWR VPWR sky130_fd_sc_hd__decap_6
XFILLER_133_1243 VPWR VGND VPWR VGND sky130_ef_sc_hd__decap_12
XFILLER_133_1287 VPWR VGND VPWR VGND sky130_ef_sc_hd__decap_12
XFILLER_20_1413 VGND VGND VPWR VPWR sky130_fd_sc_hd__fill_1
XFILLER_168_1317 VPWR VGND VPWR VGND sky130_ef_sc_hd__decap_12
XFILLER_225_417 VPWR VGND VPWR VGND sky130_ef_sc_hd__decap_12
XFILLER_231_39 VPWR VGND VPWR VGND sky130_ef_sc_hd__decap_12
Xclkbuf_3_7__f_clk clknet_0_clk VGND VGND VPWR VPWR clknet_3_7__leaf_clk sky130_fd_sc_hd__clkbuf_16
XFILLER_248_1341 VPWR VGND VPWR VGND sky130_ef_sc_hd__decap_12
XFILLER_244_1205 VPWR VGND VPWR VGND sky130_ef_sc_hd__decap_12
XFILLER_234_973 VGND VGND VPWR VPWR sky130_fd_sc_hd__decap_6
XFILLER_209_1325 VPWR VGND VPWR VGND sky130_ef_sc_hd__decap_12
XFILLER_248_1385 VPWR VGND VPWR VGND sky130_ef_sc_hd__decap_12
XFILLER_233_461 VPWR VGND VPWR VGND sky130_ef_sc_hd__decap_12
XTAP_TAPCELL_ROW_63_2_4134 VGND VPWR sky130_fd_sc_hd__tapvpwrvgnd_1
XFILLER_166_1085 VGND VGND VPWR VPWR sky130_fd_sc_hd__decap_6
XFILLER_209_1369 VPWR VGND VPWR VGND sky130_ef_sc_hd__decap_12
XFILLER_220_133 VGND VGND VPWR VPWR sky130_fd_sc_hd__decap_6
XFILLER_92_1271 VPWR VGND VPWR VGND sky130_ef_sc_hd__decap_12
XFILLER_53_1255 VPWR VGND VPWR VGND sky130_ef_sc_hd__decap_12
XFILLER_105_1323 VGND VGND VPWR VPWR sky130_fd_sc_hd__decap_6
XFILLER_140_1203 VPWR VGND VPWR VGND sky130_ef_sc_hd__decap_12
XFILLER_220_177 VPWR VGND VPWR VGND sky130_ef_sc_hd__decap_12
XTAP_TAPCELL_ROW_43_2_4010 VGND VPWR sky130_fd_sc_hd__tapvpwrvgnd_1
XFILLER_202_881 VPWR VGND VPWR VGND sky130_ef_sc_hd__decap_12
XFILLER_144_1383 VPWR VGND VPWR VGND sky130_ef_sc_hd__decap_12
XFILLER_14_1239 VGND VGND VPWR VPWR sky130_fd_sc_hd__decap_6
XFILLER_179_1413 VPWR VGND VPWR VGND sky130_ef_sc_hd__decap_12
XFILLER_53_1299 VPWR VGND VPWR VGND sky130_ef_sc_hd__decap_12
XFILLER_105_1367 VPWR VGND VPWR VGND sky130_ef_sc_hd__decap_12
XFILLER_140_1247 VPWR VGND VPWR VGND sky130_ef_sc_hd__decap_12
XFILLER_201_391 VGND VGND VPWR VPWR sky130_fd_sc_hd__fill_1
XFILLER_174_755 VGND VGND VPWR VPWR sky130_fd_sc_hd__fill_1
XFILLER_9_294 VPWR VGND VPWR VGND sky130_ef_sc_hd__decap_12
XFILLER_179_1457 VPWR VGND VPWR VGND sky130_ef_sc_hd__decap_12
XFILLER_255_1301 VPWR VGND VPWR VGND sky130_ef_sc_hd__decap_12
XFILLER_173_1001 VGND VGND VPWR VPWR sky130_fd_sc_hd__decap_6
XFILLER_255_1345 VPWR VGND VPWR VGND sky130_ef_sc_hd__decap_12
XFILLER_170_961 VPWR VGND VPWR VGND sky130_ef_sc_hd__decap_12
XFILLER_138_1165 VPWR VGND VPWR VGND sky130_ef_sc_hd__decap_12
XFILLER_173_1045 VPWR VGND VPWR VGND sky130_ef_sc_hd__decap_12
XFILLER_216_1329 VPWR VGND VPWR VGND sky130_ef_sc_hd__decap_12
XFILLER_64_1351 VGND VGND VPWR VPWR sky130_fd_sc_hd__decap_6
XTAP_TAPCELL_ROW_137_1_1272 VGND VPWR sky130_fd_sc_hd__tapvpwrvgnd_1
XFILLER_173_1089 VPWR VGND VPWR VGND sky130_ef_sc_hd__decap_12
XFILLER_60_1215 VPWR VGND VPWR VGND sky130_ef_sc_hd__decap_12
XTAP_TAPCELL_ROW_165_1300 VGND VPWR sky130_fd_sc_hd__tapvpwrvgnd_1
XFILLER_64_1395 VPWR VGND VPWR VGND sky130_ef_sc_hd__decap_12
XFILLER_116_1463 VGND VGND VPWR VPWR sky130_fd_sc_hd__decap_6
XFILLER_151_1343 VPWR VGND VPWR VGND sky130_ef_sc_hd__decap_12
XTAP_TAPCELL_ROW_165_1311 VGND VPWR sky130_fd_sc_hd__tapvpwrvgnd_1
XTAP_TAPCELL_ROW_165_1322 VGND VPWR sky130_fd_sc_hd__tapvpwrvgnd_1
XFILLER_205_51 VGND VGND VPWR VPWR sky130_fd_sc_hd__decap_4
XFILLER_228_233 VPWR VGND VPWR VGND sky130_ef_sc_hd__decap_12
XTAP_TAPCELL_ROW_165_1333 VGND VPWR sky130_fd_sc_hd__tapvpwrvgnd_1
XFILLER_60_1259 VPWR VGND VPWR VGND sky130_ef_sc_hd__decap_12
XFILLER_25_1379 VGND VGND VPWR VPWR sky130_fd_sc_hd__decap_6
XFILLER_18_27 VGND VGND VPWR VPWR sky130_fd_sc_hd__fill_1
XFILLER_112_1327 VPWR VGND VPWR VGND sky130_ef_sc_hd__decap_12
XTAP_TAPCELL_ROW_165_1344 VGND VPWR sky130_fd_sc_hd__tapvpwrvgnd_1
XFILLER_151_1387 VPWR VGND VPWR VGND sky130_ef_sc_hd__decap_12
XFILLER_228_277 VPWR VGND VPWR VGND sky130_ef_sc_hd__decap_12
XFILLER_244_737 VPWR VGND VPWR VGND sky130_ef_sc_hd__decap_12
XFILLER_141_39 VPWR VGND VPWR VGND sky130_ef_sc_hd__decap_12
XFILLER_243_225 VPWR VGND VPWR VGND sky130_ef_sc_hd__decap_12
XFILLER_3_1175 VGND VGND VPWR VPWR sky130_fd_sc_hd__fill_1
XFILLER_225_951 VGND VGND VPWR VPWR sky130_fd_sc_hd__fill_1
XFILLER_184_1141 VGND VGND VPWR VPWR sky130_fd_sc_hd__decap_6
XFILLER_212_601 VPWR VGND VPWR VGND sky130_ef_sc_hd__decap_12
XFILLER_227_1425 VPWR VGND VPWR VGND sky130_ef_sc_hd__decap_12
XFILLER_34_15 VPWR VGND VPWR VGND sky130_ef_sc_hd__decap_12
XFILLER_252_781 VPWR VGND VPWR VGND sky130_ef_sc_hd__decap_12
XFILLER_169_505 VPWR VGND VPWR VGND sky130_ef_sc_hd__decap_12
XFILLER_58_1177 VPWR VGND VPWR VGND sky130_ef_sc_hd__decap_12
XFILLER_180_1005 VPWR VGND VPWR VGND sky130_ef_sc_hd__decap_12
XFILLER_211_111 VGND VGND VPWR VPWR sky130_fd_sc_hd__fill_1
XFILLER_184_1185 VPWR VGND VPWR VGND sky130_ef_sc_hd__decap_12
XFILLER_212_645 VPWR VGND VPWR VGND sky130_ef_sc_hd__decap_12
XFILLER_227_1469 VPWR VGND VPWR VGND sky130_ef_sc_hd__decap_12
XFILLER_71_1311 VPWR VGND VPWR VGND sky130_ef_sc_hd__decap_12
XFILLER_180_1049 VPWR VGND VPWR VGND sky130_ef_sc_hd__decap_12
XFILLER_75_1491 VGND VGND VPWR VPWR sky130_fd_sc_hd__decap_6
XFILLER_196_357 VGND VGND VPWR VPWR sky130_fd_sc_hd__decap_6
XFILLER_71_1355 VPWR VGND VPWR VGND sky130_ef_sc_hd__decap_12
XFILLER_123_1423 VPWR VGND VPWR VGND sky130_ef_sc_hd__decap_12
XFILLER_162_1483 VPWR VGND VPWR VGND sky130_ef_sc_hd__decap_12
Xclkload3 clknet_3_3__leaf_clk VGND VGND VPWR VPWR clkload3/Y sky130_fd_sc_hd__clkinv_4
XFILLER_32_1339 VPWR VGND VPWR VGND sky130_ef_sc_hd__decap_12
XFILLER_197_1513 VGND VGND VPWR VPWR sky130_fd_sc_hd__fill_2
XFILLER_71_1399 VPWR VGND VPWR VGND sky130_ef_sc_hd__decap_12
XFILLER_123_1467 VPWR VGND VPWR VGND sky130_ef_sc_hd__decap_12
XFILLER_221_1057 VGND VGND VPWR VPWR sky130_fd_sc_hd__decap_6
XTAP_TAPCELL_ROW_121_2_4479 VGND VPWR sky130_fd_sc_hd__tapvpwrvgnd_1
XFILLER_180_725 VPWR VGND VPWR VGND sky130_ef_sc_hd__decap_12
XTAP_TAPCELL_ROW_230_3083 VGND VPWR sky130_fd_sc_hd__tapvpwrvgnd_1
XFILLER_4_949 VPWR VGND VPWR VGND sky130_ef_sc_hd__decap_12
XTAP_TAPCELL_ROW_230_3094 VGND VPWR sky130_fd_sc_hd__tapvpwrvgnd_1
XFILLER_69_1273 VGND VGND VPWR VPWR sky130_fd_sc_hd__fill_1
XFILLER_180_769 VPWR VGND VPWR VGND sky130_ef_sc_hd__decap_12
XFILLER_191_1101 VPWR VGND VPWR VGND sky130_ef_sc_hd__decap_12
XFILLER_195_1281 VGND VGND VPWR VPWR sky130_fd_sc_hd__decap_6
XFILLER_3_459 VGND VGND VPWR VPWR sky130_fd_sc_hd__fill_1
XFILLER_234_1429 VPWR VGND VPWR VGND sky130_ef_sc_hd__decap_12
XFILLER_191_1145 VPWR VGND VPWR VGND sky130_ef_sc_hd__decap_12
XFILLER_82_1451 VPWR VGND VPWR VGND sky130_ef_sc_hd__decap_12
XFILLER_191_1189 VPWR VGND VPWR VGND sky130_ef_sc_hd__decap_12
XTAP_TAPCELL_ROW_243_3433 VGND VPWR sky130_fd_sc_hd__tapvpwrvgnd_1
XTAP_TAPCELL_ROW_243_3444 VGND VPWR sky130_fd_sc_hd__tapvpwrvgnd_1
XFILLER_43_1435 VGND VGND VPWR VPWR sky130_fd_sc_hd__decap_6
XTAP_TAPCELL_ROW_243_3455 VGND VPWR sky130_fd_sc_hd__tapvpwrvgnd_1
XFILLER_82_1495 VPWR VGND VPWR VGND sky130_ef_sc_hd__decap_12
XFILLER_115_51 VGND VGND VPWR VPWR sky130_fd_sc_hd__decap_4
XFILLER_247_553 VGND VGND VPWR VPWR sky130_fd_sc_hd__decap_6
XFILLER_43_1479 VPWR VGND VPWR VGND sky130_ef_sc_hd__decap_12
XFILLER_130_1427 VPWR VGND VPWR VGND sky130_ef_sc_hd__decap_12
XFILLER_232_1197 VGND VGND VPWR VPWR sky130_fd_sc_hd__decap_6
XFILLER_75_55 VGND VGND VPWR VPWR sky130_fd_sc_hd__fill_1
XFILLER_207_417 VPWR VGND VPWR VGND sky130_ef_sc_hd__decap_12
XTAP_TAPCELL_ROW_9_1092 VGND VPWR sky130_fd_sc_hd__tapvpwrvgnd_1
XFILLER_247_597 VPWR VGND VPWR VGND sky130_ef_sc_hd__decap_12
XFILLER_189_1063 VGND VGND VPWR VPWR sky130_fd_sc_hd__fill_1
XFILLER_216_973 VGND VGND VPWR VPWR sky130_fd_sc_hd__decap_6
XFILLER_128_1301 VGND VGND VPWR VPWR sky130_fd_sc_hd__fill_1
XFILLER_215_461 VPWR VGND VPWR VGND sky130_ef_sc_hd__decap_12
XFILLER_231_921 VPWR VGND VPWR VGND sky130_ef_sc_hd__decap_12
XFILLER_37_1217 VGND VGND VPWR VPWR sky130_fd_sc_hd__fill_1
XFILLER_188_825 VPWR VGND VPWR VGND sky130_ef_sc_hd__decap_12
XFILLER_206_1509 VGND VGND VPWR VPWR sky130_fd_sc_hd__decap_6
XFILLER_187_335 VGND VGND VPWR VPWR sky130_fd_sc_hd__fill_1
XFILLER_202_133 VGND VGND VPWR VPWR sky130_fd_sc_hd__decap_6
XFILLER_231_965 VPWR VGND VPWR VGND sky130_ef_sc_hd__decap_12
XFILLER_188_869 VPWR VGND VPWR VGND sky130_ef_sc_hd__decap_12
X_305_ _092_ _093_ VGND VGND VPWR VPWR _094_ sky130_fd_sc_hd__or2_1
XFILLER_230_475 VGND VGND VPWR VPWR sky130_fd_sc_hd__fill_1
XFILLER_24_70 VGND VGND VPWR VPWR sky130_fd_sc_hd__fill_1
XFILLER_202_177 VPWR VGND VPWR VGND sky130_ef_sc_hd__decap_12
XPHY_EDGE_ROW_145_2_Left_647 VGND VGND VPWR VPWR sky130_fd_sc_hd__decap_3
XFILLER_50_1439 VPWR VGND VPWR VGND sky130_ef_sc_hd__decap_12
Xwire630 net38 VGND VGND VPWR VPWR net630 sky130_fd_sc_hd__buf_1
XFILLER_102_1507 VGND VGND VPWR VPWR sky130_fd_sc_hd__decap_8
Xwire641 net29 VGND VGND VPWR VPWR net641 sky130_fd_sc_hd__buf_1
Xwire652 net2 VGND VGND VPWR VPWR net652 sky130_fd_sc_hd__clkbuf_1
XFILLER_183_541 VPWR VGND VPWR VGND sky130_ef_sc_hd__decap_12
XFILLER_6_231 VGND VGND VPWR VPWR sky130_fd_sc_hd__decap_6
XPHY_EDGE_ROW_15_1_Left_270 VGND VGND VPWR VPWR sky130_fd_sc_hd__decap_3
XFILLER_6_253 VGND VGND VPWR VPWR sky130_fd_sc_hd__fill_1
XFILLER_183_585 VPWR VGND VPWR VGND sky130_ef_sc_hd__decap_12
XFILLER_6_297 VGND VGND VPWR VPWR sky130_fd_sc_hd__fill_2
XFILLER_139_1441 VGND VGND VPWR VPWR sky130_fd_sc_hd__fill_1
XFILLER_48_1357 VGND VGND VPWR VPWR sky130_fd_sc_hd__fill_1
XFILLER_174_1365 VGND VGND VPWR VPWR sky130_fd_sc_hd__decap_6
XFILLER_170_1229 VPWR VGND VPWR VGND sky130_ef_sc_hd__decap_12
XFILLER_250_1253 VGND VGND VPWR VPWR sky130_fd_sc_hd__decap_6
XFILLER_242_27 VGND VGND VPWR VPWR sky130_fd_sc_hd__fill_1
XFILLER_238_531 VGND VGND VPWR VPWR sky130_fd_sc_hd__fill_1
XFILLER_250_1297 VPWR VGND VPWR VGND sky130_ef_sc_hd__decap_12
XTAP_TAPCELL_ROW_226_2974 VGND VPWR sky130_fd_sc_hd__tapvpwrvgnd_1
XTAP_TAPCELL_ROW_226_2985 VGND VPWR sky130_fd_sc_hd__tapvpwrvgnd_1
XFILLER_226_737 VPWR VGND VPWR VGND sky130_ef_sc_hd__decap_12
XTAP_TAPCELL_ROW_226_2996 VGND VPWR sky130_fd_sc_hd__tapvpwrvgnd_1
XFILLER_225_225 VPWR VGND VPWR VGND sky130_ef_sc_hd__decap_12
XFILLER_168_1147 VGND VGND VPWR VPWR sky130_fd_sc_hd__fill_1
XFILLER_207_951 VGND VGND VPWR VPWR sky130_fd_sc_hd__fill_1
XPHY_EDGE_ROW_159_1_Left_414 VGND VGND VPWR VPWR sky130_fd_sc_hd__decap_3
XFILLER_241_729 VPWR VGND VPWR VGND sky130_ef_sc_hd__decap_12
XFILLER_234_781 VPWR VGND VPWR VGND sky130_ef_sc_hd__decap_12
XFILLER_209_1133 VPWR VGND VPWR VGND sky130_ef_sc_hd__decap_12
XFILLER_244_1035 VGND VGND VPWR VPWR sky130_fd_sc_hd__fill_1
XFILLER_181_1325 VPWR VGND VPWR VGND sky130_ef_sc_hd__decap_12
XFILLER_59_1497 VGND VGND VPWR VPWR sky130_fd_sc_hd__fill_1
XFILLER_209_1177 VPWR VGND VPWR VGND sky130_ef_sc_hd__decap_12
XPHY_EDGE_ROW_77_2_Left_579 VGND VGND VPWR VPWR sky130_fd_sc_hd__decap_3
XFILLER_178_357 VGND VGND VPWR VPWR sky130_fd_sc_hd__decap_6
XFILLER_181_1369 VPWR VGND VPWR VGND sky130_ef_sc_hd__decap_12
XFILLER_193_305 VPWR VGND VPWR VGND sky130_ef_sc_hd__decap_12
XFILLER_221_497 VGND VGND VPWR VPWR sky130_fd_sc_hd__decap_6
XFILLER_144_1191 VPWR VGND VPWR VGND sky130_ef_sc_hd__decap_12
XFILLER_193_349 VPWR VGND VPWR VGND sky130_ef_sc_hd__decap_12
XFILLER_179_1287 VGND VGND VPWR VPWR sky130_fd_sc_hd__fill_1
XFILLER_66_1413 VGND VGND VPWR VPWR sky130_fd_sc_hd__fill_1
XFILLER_192_1421 VGND VGND VPWR VPWR sky130_fd_sc_hd__decap_6
XFILLER_192_1465 VPWR VGND VPWR VGND sky130_ef_sc_hd__decap_12
XTAP_TAPCELL_ROW_167_1406 VGND VPWR sky130_fd_sc_hd__tapvpwrvgnd_1
XFILLER_29_15 VPWR VGND VPWR VGND sky130_ef_sc_hd__decap_12
XFILLER_216_83 VGND VGND VPWR VPWR sky130_fd_sc_hd__fill_1
XTAP_TAPCELL_ROW_54_2_4079 VGND VPWR sky130_fd_sc_hd__tapvpwrvgnd_1
XFILLER_29_48 VGND VGND VPWR VPWR sky130_fd_sc_hd__decap_8
XFILLER_9_1373 VPWR VGND VPWR VGND sky130_ef_sc_hd__decap_12
XFILLER_152_27 VGND VGND VPWR VPWR sky130_fd_sc_hd__fill_1
XFILLER_116_1271 VPWR VGND VPWR VGND sky130_ef_sc_hd__decap_12
XFILLER_25_1165 VPWR VGND VPWR VGND sky130_ef_sc_hd__decap_12
XFILLER_229_553 VGND VGND VPWR VPWR sky130_fd_sc_hd__decap_6
XFILLER_244_501 VPWR VGND VPWR VGND sky130_ef_sc_hd__decap_12
XFILLER_99_1255 VPWR VGND VPWR VGND sky130_ef_sc_hd__decap_12
XFILLER_186_1203 VGND VGND VPWR VPWR sky130_fd_sc_hd__fill_1
XFILLER_229_597 VPWR VGND VPWR VGND sky130_ef_sc_hd__decap_12
XFILLER_244_545 VPWR VGND VPWR VGND sky130_ef_sc_hd__decap_12
XTAP_TAPCELL_ROW_19_2_3871 VGND VPWR sky130_fd_sc_hd__tapvpwrvgnd_1
XFILLER_99_1299 VPWR VGND VPWR VGND sky130_ef_sc_hd__decap_12
XPHY_EDGE_ROW_143_1_Left_398 VGND VGND VPWR VPWR sky130_fd_sc_hd__decap_3
XFILLER_244_589 VPWR VGND VPWR VGND sky130_ef_sc_hd__decap_12
XFILLER_231_217 VGND VGND VPWR VPWR sky130_fd_sc_hd__decap_6
XFILLER_213_921 VPWR VGND VPWR VGND sky130_ef_sc_hd__decap_12
XFILLER_227_1233 VPWR VGND VPWR VGND sky130_ef_sc_hd__decap_12
XTAP_TAPCELL_ROW_32_2_3949 VGND VPWR sky130_fd_sc_hd__tapvpwrvgnd_1
XFILLER_213_965 VPWR VGND VPWR VGND sky130_ef_sc_hd__decap_12
XFILLER_169_335 VGND VGND VPWR VPWR sky130_fd_sc_hd__fill_1
XFILLER_196_121 VPWR VGND VPWR VGND sky130_ef_sc_hd__decap_12
XFILLER_223_1119 VGND VGND VPWR VPWR sky130_fd_sc_hd__fill_1
XPHY_EDGE_ROW_80_1_Left_335 VGND VGND VPWR VPWR sky130_fd_sc_hd__decap_3
XFILLER_212_475 VGND VGND VPWR VPWR sky130_fd_sc_hd__fill_1
XFILLER_196_165 VPWR VGND VPWR VGND sky130_ef_sc_hd__decap_12
XTAP_TAPCELL_ROW_236_3270 VGND VPWR sky130_fd_sc_hd__tapvpwrvgnd_1
XFILLER_185_839 VGND VGND VPWR VPWR sky130_fd_sc_hd__fill_1
XFILLER_200_637 VGND VGND VPWR VPWR sky130_fd_sc_hd__decap_6
XFILLER_36_1283 VPWR VGND VPWR VGND sky130_ef_sc_hd__decap_12
XFILLER_123_1231 VPWR VGND VPWR VGND sky130_ef_sc_hd__decap_12
XTAP_TAPCELL_ROW_12_2_3825 VGND VPWR sky130_fd_sc_hd__tapvpwrvgnd_1
XFILLER_177_57 VPWR VGND VPWR VGND sky130_ef_sc_hd__decap_12
XTAP_TAPCELL_ROW_232_3145 VGND VPWR sky130_fd_sc_hd__tapvpwrvgnd_1
XFILLER_240_1477 VGND VGND VPWR VPWR sky130_fd_sc_hd__decap_6
XTAP_TAPCELL_ROW_232_3156 VGND VPWR sky130_fd_sc_hd__tapvpwrvgnd_1
XFILLER_124_3 VPWR VGND VPWR VGND sky130_ef_sc_hd__decap_12
XFILLER_6_19 VGND VGND VPWR VPWR sky130_fd_sc_hd__decap_8
XFILLER_123_1275 VPWR VGND VPWR VGND sky130_ef_sc_hd__decap_12
XFILLER_197_1343 VGND VGND VPWR VPWR sky130_fd_sc_hd__fill_1
XFILLER_165_585 VGND VGND VPWR VPWR sky130_fd_sc_hd__decap_3
XFILLER_4_724 VGND VGND VPWR VPWR sky130_fd_sc_hd__fill_2
XFILLER_158_1327 VPWR VGND VPWR VGND sky130_ef_sc_hd__decap_12
XTAP_TAPCELL_ROW_249_3620 VGND VPWR sky130_fd_sc_hd__tapvpwrvgnd_1
XFILLER_180_533 VPWR VGND VPWR VGND sky130_ef_sc_hd__decap_12
XTAP_TAPCELL_ROW_151_2_4663 VGND VPWR sky130_fd_sc_hd__tapvpwrvgnd_1
XTAP_TAPCELL_ROW_245_3506 VGND VPWR sky130_fd_sc_hd__tapvpwrvgnd_1
XFILLER_238_1373 VPWR VGND VPWR VGND sky130_ef_sc_hd__decap_12
XFILLER_171_1505 VGND VGND VPWR VPWR sky130_fd_sc_hd__decap_6
XTAP_TAPCELL_ROW_44_1_1179 VGND VPWR sky130_fd_sc_hd__tapvpwrvgnd_1
XFILLER_239_317 VPWR VGND VPWR VGND sky130_ef_sc_hd__decap_12
XFILLER_234_1259 VGND VGND VPWR VPWR sky130_fd_sc_hd__fill_1
XFILLER_86_65 VGND VGND VPWR VPWR sky130_fd_sc_hd__decap_6
XFILLER_43_1243 VPWR VGND VPWR VGND sky130_ef_sc_hd__decap_12
XFILLER_134_1371 VPWR VGND VPWR VGND sky130_ef_sc_hd__decap_12
XFILLER_254_309 VPWR VGND VPWR VGND sky130_ef_sc_hd__decap_12
XFILLER_247_361 VPWR VGND VPWR VGND sky130_ef_sc_hd__decap_12
XFILLER_43_1287 VPWR VGND VPWR VGND sky130_ef_sc_hd__decap_12
XFILLER_169_1401 VPWR VGND VPWR VGND sky130_ef_sc_hd__decap_12
XFILLER_208_737 VPWR VGND VPWR VGND sky130_ef_sc_hd__decap_12
XTAP_TAPCELL_ROW_98_2_4344 VGND VPWR sky130_fd_sc_hd__tapvpwrvgnd_1
XFILLER_207_225 VPWR VGND VPWR VGND sky130_ef_sc_hd__decap_12
XFILLER_78_1339 VPWR VGND VPWR VGND sky130_ef_sc_hd__decap_12
XFILLER_223_729 VPWR VGND VPWR VGND sky130_ef_sc_hd__decap_12
XTAP_TAPCELL_ROW_221_2860 VGND VPWR sky130_fd_sc_hd__tapvpwrvgnd_1
XFILLER_216_781 VPWR VGND VPWR VGND sky130_ef_sc_hd__decap_12
XTAP_TAPCELL_ROW_78_2_4220 VGND VPWR sky130_fd_sc_hd__tapvpwrvgnd_1
XFILLER_206_1317 VPWR VGND VPWR VGND sky130_ef_sc_hd__decap_12
XFILLER_245_1399 VGND VGND VPWR VPWR sky130_fd_sc_hd__fill_1
XFILLER_175_305 VPWR VGND VPWR VGND sky130_ef_sc_hd__decap_12
XFILLER_188_699 VGND VGND VPWR VPWR sky130_fd_sc_hd__fill_1
XFILLER_203_497 VGND VGND VPWR VPWR sky130_fd_sc_hd__decap_6
XFILLER_50_1203 VPWR VGND VPWR VGND sky130_ef_sc_hd__decap_12
XFILLER_15_1323 VGND VGND VPWR VPWR sky130_fd_sc_hd__decap_6
XFILLER_54_1383 VPWR VGND VPWR VGND sky130_ef_sc_hd__decap_12
XFILLER_106_1451 VPWR VGND VPWR VGND sky130_ef_sc_hd__decap_12
XFILLER_141_1331 VPWR VGND VPWR VGND sky130_ef_sc_hd__decap_12
XFILLER_175_349 VPWR VGND VPWR VGND sky130_ef_sc_hd__decap_12
XFILLER_198_1129 VPWR VGND VPWR VGND sky130_ef_sc_hd__decap_12
XFILLER_191_809 VPWR VGND VPWR VGND sky130_ef_sc_hd__decap_12
XFILLER_50_1247 VPWR VGND VPWR VGND sky130_ef_sc_hd__decap_12
XFILLER_15_1367 VPWR VGND VPWR VGND sky130_ef_sc_hd__decap_12
XFILLER_102_1315 VPWR VGND VPWR VGND sky130_ef_sc_hd__decap_12
XFILLER_184_861 VGND VGND VPWR VPWR sky130_fd_sc_hd__decap_6
XFILLER_204_1085 VGND VGND VPWR VPWR sky130_fd_sc_hd__decap_6
XFILLER_89_1435 VGND VGND VPWR VPWR sky130_fd_sc_hd__decap_6
XFILLER_106_1495 VPWR VGND VPWR VGND sky130_ef_sc_hd__decap_12
XFILLER_237_27 VPWR VGND VPWR VGND sky130_ef_sc_hd__decap_12
Xwire460 net461 VGND VGND VPWR VPWR net460 sky130_fd_sc_hd__clkbuf_1
Xwire471 net472 VGND VGND VPWR VPWR net471 sky130_fd_sc_hd__clkbuf_1
Xmax_cap204 _186_ VGND VGND VPWR VPWR net204 sky130_fd_sc_hd__clkbuf_1
XFILLER_102_1359 VPWR VGND VPWR VGND sky130_ef_sc_hd__decap_12
Xwire482 net483 VGND VGND VPWR VPWR net482 sky130_fd_sc_hd__clkbuf_1
Xmax_cap215 _168_ VGND VGND VPWR VPWR net215 sky130_fd_sc_hd__clkbuf_1
XTAP_TAPCELL_ROW_215_2686 VGND VPWR sky130_fd_sc_hd__tapvpwrvgnd_1
XFILLER_89_1479 VPWR VGND VPWR VGND sky130_ef_sc_hd__decap_12
XFILLER_176_1427 VGND VGND VPWR VPWR sky130_fd_sc_hd__fill_1
XFILLER_183_393 VPWR VGND VPWR VGND sky130_ef_sc_hd__decap_12
XTAP_TAPCELL_ROW_215_2697 VGND VPWR sky130_fd_sc_hd__tapvpwrvgnd_1
XFILLER_217_1413 VPWR VGND VPWR VGND sky130_ef_sc_hd__decap_12
XFILLER_252_1315 VGND VGND VPWR VPWR sky130_fd_sc_hd__fill_1
XFILLER_253_15 VPWR VGND VPWR VGND sky130_ef_sc_hd__decap_12
XFILLER_48_1165 VPWR VGND VPWR VGND sky130_ef_sc_hd__decap_12
XFILLER_174_1173 VPWR VGND VPWR VGND sky130_ef_sc_hd__decap_12
XFILLER_217_1457 VPWR VGND VPWR VGND sky130_ef_sc_hd__decap_12
XFILLER_170_1037 VPWR VGND VPWR VGND sky130_ef_sc_hd__decap_12
XFILLER_61_1343 VPWR VGND VPWR VGND sky130_ef_sc_hd__decap_12
XFILLER_211_1001 VGND VGND VPWR VPWR sky130_fd_sc_hd__decap_6
XFILLER_250_1061 VPWR VGND VPWR VGND sky130_ef_sc_hd__decap_12
XFILLER_26_1463 VGND VGND VPWR VPWR sky130_fd_sc_hd__decap_6
XFILLER_113_1411 VPWR VGND VPWR VGND sky130_ef_sc_hd__decap_12
XFILLER_152_1471 VPWR VGND VPWR VGND sky130_ef_sc_hd__decap_12
XFILLER_22_1327 VPWR VGND VPWR VGND sky130_ef_sc_hd__decap_12
XFILLER_226_501 VPWR VGND VPWR VGND sky130_ef_sc_hd__decap_12
XFILLER_239_895 VGND VGND VPWR VPWR sky130_fd_sc_hd__fill_1
XFILLER_61_1387 VPWR VGND VPWR VGND sky130_ef_sc_hd__decap_12
XFILLER_113_1455 VPWR VGND VPWR VGND sky130_ef_sc_hd__decap_12
XFILLER_211_1045 VPWR VGND VPWR VGND sky130_ef_sc_hd__decap_12
XFILLER_226_545 VPWR VGND VPWR VGND sky130_ef_sc_hd__decap_12
XFILLER_96_1439 VPWR VGND VPWR VGND sky130_ef_sc_hd__decap_12
XFILLER_113_1499 VPWR VGND VPWR VGND sky130_ef_sc_hd__decap_12
XFILLER_211_1089 VPWR VGND VPWR VGND sky130_ef_sc_hd__decap_12
XFILLER_148_1507 VGND VGND VPWR VPWR sky130_fd_sc_hd__decap_8
XFILLER_199_909 VPWR VGND VPWR VGND sky130_ef_sc_hd__decap_12
XFILLER_202_41 VPWR VGND VPWR VGND sky130_ef_sc_hd__decap_12
XFILLER_226_589 VPWR VGND VPWR VGND sky130_ef_sc_hd__decap_12
XFILLER_0_1145 VGND VGND VPWR VPWR sky130_fd_sc_hd__decap_3
XFILLER_198_419 VGND VGND VPWR VPWR sky130_fd_sc_hd__fill_1
XFILLER_213_217 VGND VGND VPWR VPWR sky130_fd_sc_hd__decap_6
XFILLER_202_85 VPWR VGND VPWR VGND sky130_ef_sc_hd__decap_12
XFILLER_241_559 VGND VGND VPWR VPWR sky130_fd_sc_hd__fill_1
XFILLER_0_1189 VPWR VGND VPWR VGND sky130_ef_sc_hd__decap_12
XFILLER_178_121 VPWR VGND VPWR VGND sky130_ef_sc_hd__decap_12
XFILLER_181_1133 VPWR VGND VPWR VGND sky130_ef_sc_hd__decap_12
XFILLER_221_261 VPWR VGND VPWR VGND sky130_ef_sc_hd__decap_12
XFILLER_178_165 VPWR VGND VPWR VGND sky130_ef_sc_hd__decap_12
XFILLER_181_1177 VPWR VGND VPWR VGND sky130_ef_sc_hd__decap_12
XTAP_TAPCELL_ROW_156_2_4689 VGND VPWR sky130_fd_sc_hd__tapvpwrvgnd_1
XFILLER_167_839 VGND VGND VPWR VPWR sky130_fd_sc_hd__fill_1
XFILLER_194_625 VPWR VGND VPWR VGND sky130_ef_sc_hd__decap_12
XFILLER_33_1423 VPWR VGND VPWR VGND sky130_ef_sc_hd__decap_12
XFILLER_193_113 VPWR VGND VPWR VGND sky130_ef_sc_hd__decap_12
XFILLER_222_1141 VGND VGND VPWR VPWR sky130_fd_sc_hd__decap_6
XFILLER_72_1483 VPWR VGND VPWR VGND sky130_ef_sc_hd__decap_12
XFILLER_210_979 VGND VGND VPWR VPWR sky130_fd_sc_hd__fill_1
XFILLER_31_27 VPWR VGND VPWR VGND sky130_ef_sc_hd__decap_12
XFILLER_194_669 VPWR VGND VPWR VGND sky130_ef_sc_hd__decap_12
XFILLER_33_1467 VPWR VGND VPWR VGND sky130_ef_sc_hd__decap_12
XFILLER_120_1415 VPWR VGND VPWR VGND sky130_ef_sc_hd__decap_12
XFILLER_222_1185 VPWR VGND VPWR VGND sky130_ef_sc_hd__decap_12
XFILLER_147_27 VPWR VGND VPWR VGND sky130_ef_sc_hd__decap_12
XFILLER_200_1483 VGND VGND VPWR VPWR sky130_fd_sc_hd__fill_1
XFILLER_235_1513 VGND VGND VPWR VPWR sky130_fd_sc_hd__fill_2
Xoutput49 net49 VGND VGND VPWR VPWR acc_out[15] sky130_fd_sc_hd__buf_2
XFILLER_163_15 VPWR VGND VPWR VGND sky130_ef_sc_hd__decap_12
XFILLER_227_93 VPWR VGND VPWR VGND sky130_ef_sc_hd__decap_12
XFILLER_153_1213 VGND VGND VPWR VPWR sky130_fd_sc_hd__decap_4
XFILLER_249_615 VGND VGND VPWR VPWR sky130_fd_sc_hd__fill_1
XFILLER_192_1273 VPWR VGND VPWR VGND sky130_ef_sc_hd__decap_12
XFILLER_0_237 VGND VGND VPWR VPWR sky130_fd_sc_hd__decap_8
XTAP_TAPCELL_ROW_116_2_4452 VGND VPWR sky130_fd_sc_hd__tapvpwrvgnd_1
XFILLER_0_248 VGND VGND VPWR VPWR sky130_fd_sc_hd__decap_4
XFILLER_5_1001 VGND VGND VPWR VPWR sky130_fd_sc_hd__decap_6
XFILLER_131_1511 VGND VGND VPWR VPWR sky130_fd_sc_hd__decap_4
XFILLER_236_309 VPWR VGND VPWR VGND sky130_ef_sc_hd__decap_12
XFILLER_233_1281 VGND VGND VPWR VPWR sky130_fd_sc_hd__decap_6
XFILLER_188_1309 VGND VGND VPWR VPWR sky130_fd_sc_hd__decap_6
XFILLER_243_81 VPWR VGND VPWR VGND sky130_ef_sc_hd__decap_12
XFILLER_229_361 VPWR VGND VPWR VGND sky130_ef_sc_hd__decap_12
XFILLER_245_821 VPWR VGND VPWR VGND sky130_ef_sc_hd__decap_12
XFILLER_40_1427 VPWR VGND VPWR VGND sky130_ef_sc_hd__decap_12
XFILLER_5_1045 VPWR VGND VPWR VGND sky130_ef_sc_hd__decap_12
XFILLER_245_865 VPWR VGND VPWR VGND sky130_ef_sc_hd__decap_12
XFILLER_5_1089 VPWR VGND VPWR VGND sky130_ef_sc_hd__decap_12
X_570_ net666 VGND VGND VPWR VPWR _052_ sky130_fd_sc_hd__inv_2
XFILLER_112_41 VPWR VGND VPWR VGND sky130_ef_sc_hd__decap_12
XFILLER_205_729 VPWR VGND VPWR VGND sky130_ef_sc_hd__decap_12
XTAP_TAPCELL_ROW_238_3310 VGND VPWR sky130_fd_sc_hd__tapvpwrvgnd_1
XFILLER_38_1301 VGND VGND VPWR VPWR sky130_fd_sc_hd__fill_1
XTAP_TAPCELL_ROW_238_3321 VGND VPWR sky130_fd_sc_hd__tapvpwrvgnd_1
XFILLER_241_3 VPWR VGND VPWR VGND sky130_ef_sc_hd__decap_12
XFILLER_227_1063 VGND VGND VPWR VPWR sky130_fd_sc_hd__fill_1
XTAP_TAPCELL_ROW_234_3207 VGND VPWR sky130_fd_sc_hd__tapvpwrvgnd_1
XFILLER_197_441 VGND VGND VPWR VPWR sky130_fd_sc_hd__decap_6
XFILLER_200_401 VPWR VGND VPWR VGND sky130_ef_sc_hd__decap_12
XFILLER_240_581 VGND VGND VPWR VPWR sky130_fd_sc_hd__decap_6
XFILLER_197_485 VPWR VGND VPWR VGND sky130_ef_sc_hd__decap_12
XFILLER_160_1239 VGND VGND VPWR VPWR sky130_fd_sc_hd__decap_6
XFILLER_200_445 VPWR VGND VPWR VGND sky130_ef_sc_hd__decap_12
XFILLER_240_1241 VPWR VGND VPWR VGND sky130_ef_sc_hd__decap_12
XTAP_TAPCELL_ROW_160_1_1295 VGND VPWR sky130_fd_sc_hd__tapvpwrvgnd_1
XFILLER_173_809 VPWR VGND VPWR VGND sky130_ef_sc_hd__decap_12
XFILLER_199_1449 VGND VGND VPWR VPWR sky130_fd_sc_hd__decap_6
XFILLER_12_1507 VGND VGND VPWR VPWR sky130_fd_sc_hd__decap_8
XFILLER_166_861 VGND VGND VPWR VPWR sky130_fd_sc_hd__decap_6
XFILLER_200_489 VPWR VGND VPWR VGND sky130_ef_sc_hd__decap_12
XFILLER_201_1225 VGND VGND VPWR VPWR sky130_fd_sc_hd__decap_6
XFILLER_240_1285 VPWR VGND VPWR VGND sky130_ef_sc_hd__decap_12
XFILLER_201_1269 VPWR VGND VPWR VGND sky130_ef_sc_hd__decap_12
XFILLER_165_393 VPWR VGND VPWR VGND sky130_ef_sc_hd__decap_12
XFILLER_181_853 VPWR VGND VPWR VGND sky130_ef_sc_hd__decap_12
XFILLER_49_1441 VGND VGND VPWR VPWR sky130_fd_sc_hd__fill_1
XFILLER_180_363 VGND VGND VPWR VPWR sky130_fd_sc_hd__fill_1
XFILLER_181_897 VPWR VGND VPWR VGND sky130_ef_sc_hd__decap_12
XTAP_TAPCELL_ROW_210_2550 VGND VPWR sky130_fd_sc_hd__tapvpwrvgnd_1
XTAP_TAPCELL_ROW_210_2561 VGND VPWR sky130_fd_sc_hd__tapvpwrvgnd_1
XFILLER_171_1313 VPWR VGND VPWR VGND sky130_ef_sc_hd__decap_12
XFILLER_175_1493 VPWR VGND VPWR VGND sky130_ef_sc_hd__decap_12
XFILLER_239_125 VPWR VGND VPWR VGND sky130_ef_sc_hd__decap_12
XFILLER_171_1357 VPWR VGND VPWR VGND sky130_ef_sc_hd__decap_12
XFILLER_0_760 VGND VGND VPWR VPWR sky130_fd_sc_hd__decap_6
XFILLER_251_1381 VPWR VGND VPWR VGND sky130_ef_sc_hd__decap_12
XFILLER_239_169 VPWR VGND VPWR VGND sky130_ef_sc_hd__decap_12
XFILLER_255_629 VPWR VGND VPWR VGND sky130_ef_sc_hd__decap_12
XFILLER_208_501 VPWR VGND VPWR VGND sky130_ef_sc_hd__decap_12
XTAP_TAPCELL_ROW_223_2900 VGND VPWR sky130_fd_sc_hd__tapvpwrvgnd_1
XFILLER_248_681 VPWR VGND VPWR VGND sky130_ef_sc_hd__decap_12
XTAP_TAPCELL_ROW_223_2911 VGND VPWR sky130_fd_sc_hd__tapvpwrvgnd_1
XFILLER_212_1365 VGND VGND VPWR VPWR sky130_fd_sc_hd__decap_6
XFILLER_254_139 VGND VGND VPWR VPWR sky130_fd_sc_hd__fill_1
XFILLER_208_545 VPWR VGND VPWR VGND sky130_ef_sc_hd__decap_12
XFILLER_169_1231 VGND VGND VPWR VPWR sky130_fd_sc_hd__fill_1
XTAP_TAPCELL_ROW_208_2490 VGND VPWR sky130_fd_sc_hd__tapvpwrvgnd_1
XFILLER_208_589 VPWR VGND VPWR VGND sky130_ef_sc_hd__decap_12
XFILLER_250_301 VGND VGND VPWR VPWR sky130_fd_sc_hd__decap_6
XFILLER_165_1117 VGND VGND VPWR VPWR sky130_fd_sc_hd__decap_3
XTAP_TAPCELL_ROW_204_2387 VGND VPWR sky130_fd_sc_hd__tapvpwrvgnd_1
XTAP_TAPCELL_ROW_204_2398 VGND VPWR sky130_fd_sc_hd__tapvpwrvgnd_1
XFILLER_223_559 VGND VGND VPWR VPWR sky130_fd_sc_hd__fill_1
XFILLER_250_345 VPWR VGND VPWR VGND sky130_ef_sc_hd__decap_12
XFILLER_189_953 VPWR VGND VPWR VGND sky130_ef_sc_hd__decap_12
XFILLER_182_1453 VPWR VGND VPWR VGND sky130_ef_sc_hd__decap_12
XTAP_TAPCELL_ROW_196_2166 VGND VPWR sky130_fd_sc_hd__tapvpwrvgnd_1
XFILLER_210_209 VPWR VGND VPWR VGND sky130_ef_sc_hd__decap_12
XFILLER_250_389 VPWR VGND VPWR VGND sky130_ef_sc_hd__decap_12
XTAP_TAPCELL_ROW_196_2177 VGND VPWR sky130_fd_sc_hd__tapvpwrvgnd_1
XFILLER_203_261 VPWR VGND VPWR VGND sky130_ef_sc_hd__decap_12
XTAP_TAPCELL_ROW_196_2188 VGND VPWR sky130_fd_sc_hd__tapvpwrvgnd_1
XFILLER_206_1147 VGND VGND VPWR VPWR sky130_fd_sc_hd__fill_1
Xclkbuf_0_clk clk VGND VGND VPWR VPWR clknet_0_clk sky130_fd_sc_hd__clkbuf_16
XFILLER_176_625 VPWR VGND VPWR VGND sky130_ef_sc_hd__decap_12
XFILLER_182_1497 VPWR VGND VPWR VGND sky130_ef_sc_hd__decap_12
XFILLER_248_15 VPWR VGND VPWR VGND sky130_ef_sc_hd__decap_12
XFILLER_87_3 VPWR VGND VPWR VGND sky130_ef_sc_hd__decap_12
XFILLER_175_113 VPWR VGND VPWR VGND sky130_ef_sc_hd__decap_12
XTAP_TAPCELL_ROW_217_2737 VGND VPWR sky130_fd_sc_hd__tapvpwrvgnd_1
XTAP_TAPCELL_ROW_217_2748 VGND VPWR sky130_fd_sc_hd__tapvpwrvgnd_1
XFILLER_176_669 VPWR VGND VPWR VGND sky130_ef_sc_hd__decap_12
XFILLER_54_1191 VPWR VGND VPWR VGND sky130_ef_sc_hd__decap_12
XFILLER_191_617 VPWR VGND VPWR VGND sky130_ef_sc_hd__decap_12
XTAP_TAPCELL_ROW_122_2_4484 VGND VPWR sky130_fd_sc_hd__tapvpwrvgnd_1
XFILLER_89_1243 VPWR VGND VPWR VGND sky130_ef_sc_hd__decap_12
XFILLER_8_893 VPWR VGND VPWR VGND sky130_ef_sc_hd__decap_12
Xwire290 net291 VGND VGND VPWR VPWR net290 sky130_fd_sc_hd__clkbuf_1
XFILLER_89_1287 VPWR VGND VPWR VGND sky130_ef_sc_hd__decap_12
XFILLER_102_1189 VGND VGND VPWR VPWR sky130_fd_sc_hd__fill_1
XTAP_TAPCELL_ROW_90_2_4295 VGND VPWR sky130_fd_sc_hd__tapvpwrvgnd_1
XTAP_TAPCELL_ROW_89_2_4289 VGND VPWR sky130_fd_sc_hd__tapvpwrvgnd_1
XFILLER_137_1219 VPWR VGND VPWR VGND sky130_ef_sc_hd__decap_12
XFILLER_171_385 VGND VGND VPWR VPWR sky130_fd_sc_hd__decap_6
XFILLER_217_1287 VGND VGND VPWR VPWR sky130_fd_sc_hd__fill_1
XFILLER_218_309 VPWR VGND VPWR VGND sky130_ef_sc_hd__decap_12
XFILLER_230_1421 VGND VGND VPWR VPWR sky130_fd_sc_hd__decap_6
XFILLER_26_1271 VPWR VGND VPWR VGND sky130_ef_sc_hd__decap_12
XPHY_EDGE_ROW_0_Left_256 VGND VGND VPWR VPWR sky130_fd_sc_hd__decap_3
XTAP_TAPCELL_ROW_185_1870 VGND VPWR sky130_fd_sc_hd__tapvpwrvgnd_1
XFILLER_227_821 VPWR VGND VPWR VGND sky130_ef_sc_hd__decap_12
XFILLER_6_1365 VGND VGND VPWR VPWR sky130_fd_sc_hd__decap_6
XTAP_TAPCELL_ROW_185_1881 VGND VPWR sky130_fd_sc_hd__tapvpwrvgnd_1
XTAP_TAPCELL_ROW_185_1892 VGND VPWR sky130_fd_sc_hd__tapvpwrvgnd_1
XFILLER_230_1465 VPWR VGND VPWR VGND sky130_ef_sc_hd__decap_12
XFILLER_96_1203 VPWR VGND VPWR VGND sky130_ef_sc_hd__decap_12
XFILLER_213_51 VGND VGND VPWR VPWR sky130_fd_sc_hd__decap_4
XFILLER_2_1229 VPWR VGND VPWR VGND sky130_ef_sc_hd__decap_12
XFILLER_227_865 VPWR VGND VPWR VGND sky130_ef_sc_hd__decap_12
XFILLER_242_813 VPWR VGND VPWR VGND sky130_ef_sc_hd__decap_12
XFILLER_26_27 VGND VGND VPWR VPWR sky130_fd_sc_hd__fill_1
XTAP_TAPCELL_ROW_181_1767 VGND VPWR sky130_fd_sc_hd__tapvpwrvgnd_1
XFILLER_96_1247 VPWR VGND VPWR VGND sky130_ef_sc_hd__decap_12
XFILLER_148_1315 VPWR VGND VPWR VGND sky130_ef_sc_hd__decap_12
XTAP_TAPCELL_ROW_181_1778 VGND VPWR sky130_fd_sc_hd__tapvpwrvgnd_1
XFILLER_253_161 VGND VGND VPWR VPWR sky130_fd_sc_hd__decap_6
XFILLER_148_1359 VPWR VGND VPWR VGND sky130_ef_sc_hd__decap_12
XFILLER_224_1203 VGND VGND VPWR VPWR sky130_fd_sc_hd__fill_1
XFILLER_179_441 VGND VGND VPWR VPWR sky130_fd_sc_hd__decap_6
XFILLER_42_15 VPWR VGND VPWR VGND sky130_ef_sc_hd__decap_12
XFILLER_222_581 VGND VGND VPWR VPWR sky130_fd_sc_hd__decap_6
XFILLER_179_485 VPWR VGND VPWR VGND sky130_ef_sc_hd__decap_12
XFILLER_195_945 VGND VGND VPWR VPWR sky130_fd_sc_hd__decap_6
XFILLER_158_15 VPWR VGND VPWR VGND sky130_ef_sc_hd__decap_12
XFILLER_194_433 VPWR VGND VPWR VGND sky130_ef_sc_hd__decap_12
XFILLER_33_1231 VPWR VGND VPWR VGND sky130_ef_sc_hd__decap_12
XTAP_TAPCELL_ROW_42_2_4006 VGND VPWR sky130_fd_sc_hd__tapvpwrvgnd_1
XFILLER_195_989 VPWR VGND VPWR VGND sky130_ef_sc_hd__decap_12
XFILLER_194_477 VPWR VGND VPWR VGND sky130_ef_sc_hd__decap_12
XFILLER_33_1275 VPWR VGND VPWR VGND sky130_ef_sc_hd__decap_12
XFILLER_181_105 VGND VGND VPWR VPWR sky130_fd_sc_hd__decap_6
XFILLER_120_1245 VGND VGND VPWR VPWR sky130_fd_sc_hd__fill_1
XFILLER_159_1411 VPWR VGND VPWR VGND sky130_ef_sc_hd__decap_12
XFILLER_68_1327 VPWR VGND VPWR VGND sky130_ef_sc_hd__decap_12
XFILLER_181_149 VPWR VGND VPWR VGND sky130_ef_sc_hd__decap_12
XFILLER_159_1455 VPWR VGND VPWR VGND sky130_ef_sc_hd__decap_12
XFILLER_218_1029 VGND VGND VPWR VPWR sky130_fd_sc_hd__decap_6
XFILLER_159_1499 VPWR VGND VPWR VGND sky130_ef_sc_hd__decap_12
XTAP_TAPCELL_ROW_227_3011 VGND VPWR sky130_fd_sc_hd__tapvpwrvgnd_1
XFILLER_235_1343 VGND VGND VPWR VPWR sky130_fd_sc_hd__fill_1
XTAP_TAPCELL_ROW_227_3022 VGND VPWR sky130_fd_sc_hd__tapvpwrvgnd_1
XFILLER_1_568 VGND VGND VPWR VPWR sky130_fd_sc_hd__fill_2
XFILLER_191_3 VPWR VGND VPWR VGND sky130_ef_sc_hd__decap_12
XFILLER_237_629 VPWR VGND VPWR VGND sky130_ef_sc_hd__decap_12
XFILLER_44_1371 VPWR VGND VPWR VGND sky130_ef_sc_hd__decap_12
XFILLER_188_1117 VPWR VGND VPWR VGND sky130_ef_sc_hd__decap_12
XFILLER_236_139 VGND VGND VPWR VPWR sky130_fd_sc_hd__fill_1
XPHY_EDGE_ROW_154_2_Left_656 VGND VGND VPWR VPWR sky130_fd_sc_hd__decap_3
X_622_ clknet_3_4__leaf_clk dout0\[20\] _030_ VGND VGND VPWR VPWR dout0_q\[20\] sky130_fd_sc_hd__dfrtp_1
XFILLER_79_1423 VPWR VGND VPWR VGND sky130_ef_sc_hd__decap_12
XFILLER_123_51 VGND VGND VPWR VPWR sky130_fd_sc_hd__decap_4
XFILLER_131_1385 VGND VGND VPWR VPWR sky130_fd_sc_hd__fill_1
XTAP_TAPCELL_ROW_39_1_1174 VGND VPWR sky130_fd_sc_hd__tapvpwrvgnd_1
XFILLER_245_673 VPWR VGND VPWR VGND sky130_ef_sc_hd__decap_12
XFILLER_79_1467 VPWR VGND VPWR VGND sky130_ef_sc_hd__decap_12
XFILLER_232_301 VGND VGND VPWR VPWR sky130_fd_sc_hd__decap_6
X_553_ net669 VGND VGND VPWR VPWR _035_ sky130_fd_sc_hd__inv_2
XFILLER_83_55 VGND VGND VPWR VPWR sky130_fd_sc_hd__fill_1
XFILLER_189_205 VPWR VGND VPWR VGND sky130_ef_sc_hd__decap_12
XFILLER_199_55 VGND VGND VPWR VPWR sky130_fd_sc_hd__fill_1
XFILLER_205_559 VGND VGND VPWR VPWR sky130_fd_sc_hd__fill_1
XFILLER_229_1169 VGND VGND VPWR VPWR sky130_fd_sc_hd__decap_6
XFILLER_232_345 VPWR VGND VPWR VGND sky130_ef_sc_hd__decap_12
XFILLER_207_1401 VPWR VGND VPWR VGND sky130_ef_sc_hd__decap_12
X_484_ net162 net109 VGND VGND VPWR VPWR acc_core.adder.cla_blocks\[3\].block.sum\[0\]
+ sky130_fd_sc_hd__xor2_1
XFILLER_189_249 VPWR VGND VPWR VGND sky130_ef_sc_hd__decap_12
XFILLER_246_1483 VGND VGND VPWR VPWR sky130_fd_sc_hd__fill_1
XFILLER_232_389 VPWR VGND VPWR VGND sky130_ef_sc_hd__decap_12
XFILLER_186_923 VGND VGND VPWR VPWR sky130_fd_sc_hd__fill_1
XFILLER_201_721 VGND VGND VPWR VPWR sky130_fd_sc_hd__decap_6
XFILLER_197_293 VPWR VGND VPWR VGND sky130_ef_sc_hd__decap_12
XFILLER_199_1213 VPWR VGND VPWR VGND sky130_ef_sc_hd__decap_12
XTAP_TAPCELL_ROW_191_2030 VGND VPWR sky130_fd_sc_hd__tapvpwrvgnd_1
XFILLER_201_765 VPWR VGND VPWR VGND sky130_ef_sc_hd__decap_12
XFILLER_51_1331 VPWR VGND VPWR VGND sky130_ef_sc_hd__decap_12
XFILLER_16_1451 VPWR VGND VPWR VGND sky130_ef_sc_hd__decap_12
XFILLER_9_657 VPWR VGND VPWR VGND sky130_ef_sc_hd__decap_12
XTAP_TAPCELL_ROW_191_2041 VGND VPWR sky130_fd_sc_hd__tapvpwrvgnd_1
XFILLER_200_253 VPWR VGND VPWR VGND sky130_ef_sc_hd__decap_12
XFILLER_125_1189 VPWR VGND VPWR VGND sky130_ef_sc_hd__decap_12
XTAP_TAPCELL_ROW_191_2052 VGND VPWR sky130_fd_sc_hd__tapvpwrvgnd_1
XTAP_TAPCELL_ROW_107_2_4397 VGND VPWR sky130_fd_sc_hd__tapvpwrvgnd_1
XFILLER_173_617 VPWR VGND VPWR VGND sky130_ef_sc_hd__decap_12
XFILLER_199_1257 VPWR VGND VPWR VGND sky130_ef_sc_hd__decap_12
XFILLER_32_70 VGND VGND VPWR VPWR sky130_fd_sc_hd__fill_1
XFILLER_12_1315 VPWR VGND VPWR VGND sky130_ef_sc_hd__decap_12
XFILLER_201_1033 VPWR VGND VPWR VGND sky130_ef_sc_hd__decap_12
XFILLER_16_1495 VPWR VGND VPWR VGND sky130_ef_sc_hd__decap_12
XFILLER_103_1443 VPWR VGND VPWR VGND sky130_ef_sc_hd__decap_12
XFILLER_240_1093 VPWR VGND VPWR VGND sky130_ef_sc_hd__decap_12
XTAP_TAPCELL_ROW_212_2601 VGND VPWR sky130_fd_sc_hd__tapvpwrvgnd_1
XFILLER_177_1511 VGND VGND VPWR VPWR sky130_fd_sc_hd__fill_1
XTAP_TAPCELL_ROW_212_2612 VGND VPWR sky130_fd_sc_hd__tapvpwrvgnd_1
XFILLER_218_29 VPWR VGND VPWR VGND sky130_ef_sc_hd__decap_12
XFILLER_12_1359 VPWR VGND VPWR VGND sky130_ef_sc_hd__decap_12
XFILLER_201_1077 VPWR VGND VPWR VGND sky130_ef_sc_hd__decap_12
XFILLER_86_1427 VPWR VGND VPWR VGND sky130_ef_sc_hd__decap_12
XPHY_EDGE_ROW_79_2_Right_170 VGND VGND VPWR VPWR sky130_fd_sc_hd__decap_3
XFILLER_236_1129 VPWR VGND VPWR VGND sky130_ef_sc_hd__decap_12
XFILLER_4_395 VGND VGND VPWR VPWR sky130_fd_sc_hd__fill_2
XFILLER_171_1121 VPWR VGND VPWR VGND sky130_ef_sc_hd__decap_12
XTAP_TAPCELL_ROW_55_2_4084 VGND VPWR sky130_fd_sc_hd__tapvpwrvgnd_1
XFILLER_214_1427 VGND VGND VPWR VPWR sky130_fd_sc_hd__fill_1
XFILLER_45_1168 VPWR VGND VPWR VGND sky130_ef_sc_hd__decap_12
XPHY_EDGE_ROW_86_2_Left_588 VGND VGND VPWR VPWR sky130_fd_sc_hd__decap_3
XFILLER_23_1411 VPWR VGND VPWR VGND sky130_ef_sc_hd__decap_12
XFILLER_62_1471 VPWR VGND VPWR VGND sky130_ef_sc_hd__decap_12
XFILLER_209_821 VPWR VGND VPWR VGND sky130_ef_sc_hd__decap_12
XFILLER_3_1505 VGND VGND VPWR VPWR sky130_fd_sc_hd__decap_6
XTAP_TAPCELL_ROW_206_2438 VGND VPWR sky130_fd_sc_hd__tapvpwrvgnd_1
XFILLER_23_1455 VPWR VGND VPWR VGND sky130_ef_sc_hd__decap_12
XTAP_TAPCELL_ROW_206_2449 VGND VPWR sky130_fd_sc_hd__tapvpwrvgnd_1
XFILLER_250_27 VGND VGND VPWR VPWR sky130_fd_sc_hd__fill_1
XFILLER_209_865 VPWR VGND VPWR VGND sky130_ef_sc_hd__decap_12
XFILLER_212_1173 VPWR VGND VPWR VGND sky130_ef_sc_hd__decap_12
XFILLER_242_109 VPWR VGND VPWR VGND sky130_ef_sc_hd__decap_12
XFILLER_224_813 VPWR VGND VPWR VGND sky130_ef_sc_hd__decap_12
XFILLER_58_1507 VGND VGND VPWR VPWR sky130_fd_sc_hd__decap_8
XFILLER_23_1499 VPWR VGND VPWR VGND sky130_ef_sc_hd__decap_12
XFILLER_247_1225 VGND VGND VPWR VPWR sky130_fd_sc_hd__decap_6
XFILLER_235_161 VGND VGND VPWR VPWR sky130_fd_sc_hd__decap_6
XTAP_TAPCELL_ROW_198_2228 VGND VPWR sky130_fd_sc_hd__tapvpwrvgnd_1
XFILLER_110_1469 VGND VGND VPWR VPWR sky130_fd_sc_hd__fill_1
XTAP_TAPCELL_ROW_198_2239 VGND VPWR sky130_fd_sc_hd__tapvpwrvgnd_1
XFILLER_247_1269 VPWR VGND VPWR VGND sky130_ef_sc_hd__decap_12
XTAP_TAPCELL_ROW_33_2_3954 VGND VPWR sky130_fd_sc_hd__tapvpwrvgnd_1
XFILLER_251_665 VGND VGND VPWR VPWR sky130_fd_sc_hd__decap_6
XFILLER_250_153 VPWR VGND VPWR VGND sky130_ef_sc_hd__decap_12
XFILLER_211_529 VPWR VGND VPWR VGND sky130_ef_sc_hd__decap_12
XFILLER_143_1201 VPWR VGND VPWR VGND sky130_ef_sc_hd__decap_12
XFILLER_182_1261 VPWR VGND VPWR VGND sky130_ef_sc_hd__decap_12
XFILLER_189_783 VGND VGND VPWR VPWR sky130_fd_sc_hd__fill_1
XFILLER_204_581 VGND VGND VPWR VPWR sky130_fd_sc_hd__decap_6
XFILLER_250_197 VPWR VGND VPWR VGND sky130_ef_sc_hd__decap_12
XFILLER_91_1177 VPWR VGND VPWR VGND sky130_ef_sc_hd__decap_12
XFILLER_177_945 VGND VGND VPWR VPWR sky130_fd_sc_hd__decap_6
XFILLER_176_433 VPWR VGND VPWR VGND sky130_ef_sc_hd__decap_12
XTAP_TAPCELL_ROW_13_2_3830 VGND VPWR sky130_fd_sc_hd__tapvpwrvgnd_1
XFILLER_143_1267 VGND VGND VPWR VPWR sky130_fd_sc_hd__decap_6
XFILLER_177_989 VPWR VGND VPWR VGND sky130_ef_sc_hd__decap_12
XFILLER_12_29 VPWR VGND VPWR VGND sky130_ef_sc_hd__decap_12
XFILLER_176_477 VPWR VGND VPWR VGND sky130_ef_sc_hd__decap_12
XFILLER_30_1415 VPWR VGND VPWR VGND sky130_ef_sc_hd__decap_12
XFILLER_192_937 VPWR VGND VPWR VGND sky130_ef_sc_hd__decap_12
XFILLER_128_29 VPWR VGND VPWR VGND sky130_ef_sc_hd__decap_12
XTAP_TAPCELL_ROW_174_1571 VGND VPWR sky130_fd_sc_hd__tapvpwrvgnd_1
XTAP_TAPCELL_ROW_174_1582 VGND VPWR sky130_fd_sc_hd__tapvpwrvgnd_1
XFILLER_191_447 VGND VGND VPWR VPWR sky130_fd_sc_hd__fill_1
XTAP_TAPCELL_ROW_174_1593 VGND VPWR sky130_fd_sc_hd__tapvpwrvgnd_1
XTAP_TAPCELL_ROW_170_1468 VGND VPWR sky130_fd_sc_hd__tapvpwrvgnd_1
XFILLER_254_1229 VPWR VGND VPWR VGND sky130_ef_sc_hd__decap_12
XTAP_TAPCELL_ROW_170_1479 VGND VPWR sky130_fd_sc_hd__tapvpwrvgnd_1
XFILLER_171_193 VPWR VGND VPWR VGND sky130_ef_sc_hd__decap_12
XFILLER_63_1213 VGND VGND VPWR VPWR sky130_fd_sc_hd__decap_4
XTAP_TAPCELL_ROW_187_1921 VGND VPWR sky130_fd_sc_hd__tapvpwrvgnd_1
XTAP_TAPCELL_ROW_187_1932 VGND VPWR sky130_fd_sc_hd__tapvpwrvgnd_1
XFILLER_8_1427 VGND VGND VPWR VPWR sky130_fd_sc_hd__fill_1
XTAP_TAPCELL_ROW_187_1943 VGND VPWR sky130_fd_sc_hd__tapvpwrvgnd_1
XPHY_EDGE_ROW_10_1_Left_511 VGND VGND VPWR VPWR sky130_fd_sc_hd__decap_3
Xfanout669 net671 VGND VGND VPWR VPWR net669 sky130_fd_sc_hd__buf_4
XFILLER_150_1227 VPWR VGND VPWR VGND sky130_ef_sc_hd__decap_12
XTAP_TAPCELL_ROW_183_1818 VGND VPWR sky130_fd_sc_hd__tapvpwrvgnd_1
XFILLER_219_629 VPWR VGND VPWR VGND sky130_ef_sc_hd__decap_12
XFILLER_41_1511 VGND VGND VPWR VPWR sky130_fd_sc_hd__decap_4
XTAP_TAPCELL_ROW_183_1829 VGND VPWR sky130_fd_sc_hd__tapvpwrvgnd_1
XFILLER_37_15 VPWR VGND VPWR VGND sky130_ef_sc_hd__decap_12
XTAP_TAPCELL_ROW_144_2_4616 VGND VPWR sky130_fd_sc_hd__tapvpwrvgnd_1
XFILLER_189_1437 VPWR VGND VPWR VGND sky130_ef_sc_hd__decap_12
XFILLER_218_139 VGND VGND VPWR VPWR sky130_fd_sc_hd__fill_1
XFILLER_224_83 VGND VGND VPWR VPWR sky130_fd_sc_hd__fill_1
XFILLER_6_1173 VPWR VGND VPWR VGND sky130_ef_sc_hd__decap_12
XFILLER_230_1273 VPWR VGND VPWR VGND sky130_ef_sc_hd__decap_12
XFILLER_160_27 VGND VGND VPWR VPWR sky130_fd_sc_hd__fill_1
XFILLER_2_1037 VPWR VGND VPWR VGND sky130_ef_sc_hd__decap_12
XFILLER_227_673 VPWR VGND VPWR VGND sky130_ef_sc_hd__decap_12
XFILLER_255_993 VPWR VGND VPWR VGND sky130_ef_sc_hd__decap_12
XFILLER_199_503 VGND VGND VPWR VPWR sky130_fd_sc_hd__fill_1
XFILLER_214_301 VGND VGND VPWR VPWR sky130_fd_sc_hd__decap_6
XFILLER_242_643 VGND VGND VPWR VPWR sky130_fd_sc_hd__fill_1
XFILLER_226_1309 VGND VGND VPWR VPWR sky130_fd_sc_hd__decap_6
XFILLER_214_345 VPWR VGND VPWR VGND sky130_ef_sc_hd__decap_12
XFILLER_230_805 VGND VGND VPWR VPWR sky130_fd_sc_hd__decap_6
XFILLER_187_709 VPWR VGND VPWR VGND sky130_ef_sc_hd__decap_12
XFILLER_148_1189 VGND VGND VPWR VPWR sky130_fd_sc_hd__fill_1
XFILLER_214_389 VPWR VGND VPWR VGND sky130_ef_sc_hd__decap_12
XFILLER_230_849 VPWR VGND VPWR VGND sky130_ef_sc_hd__decap_12
XFILLER_165_1481 VGND VGND VPWR VPWR sky130_fd_sc_hd__decap_3
XFILLER_168_923 VGND VGND VPWR VPWR sky130_fd_sc_hd__fill_1
XFILLER_161_1323 VGND VGND VPWR VPWR sky130_fd_sc_hd__decap_6
XFILLER_169_69 VPWR VGND VPWR VGND sky130_ef_sc_hd__decap_12
XFILLER_70_1239 VGND VGND VPWR VPWR sky130_fd_sc_hd__decap_6
XFILLER_179_293 VPWR VGND VPWR VGND sky130_ef_sc_hd__decap_12
XFILLER_195_753 VPWR VGND VPWR VGND sky130_ef_sc_hd__decap_12
XFILLER_161_1367 VPWR VGND VPWR VGND sky130_ef_sc_hd__decap_12
XTAP_TAPCELL_ROW_252_3682 VGND VPWR sky130_fd_sc_hd__tapvpwrvgnd_1
XTAP_TAPCELL_ROW_252_3693 VGND VPWR sky130_fd_sc_hd__tapvpwrvgnd_1
XFILLER_195_797 VPWR VGND VPWR VGND sky130_ef_sc_hd__decap_12
XFILLER_202_1353 VPWR VGND VPWR VGND sky130_ef_sc_hd__decap_12
XFILLER_5_137 VPWR VGND VPWR VGND sky130_ef_sc_hd__decap_12
XFILLER_185_57 VPWR VGND VPWR VGND sky130_ef_sc_hd__decap_12
XFILLER_182_469 VGND VGND VPWR VPWR sky130_fd_sc_hd__decap_6
XFILLER_202_1397 VPWR VGND VPWR VGND sky130_ef_sc_hd__decap_12
XFILLER_204_3 VPWR VGND VPWR VGND sky130_ef_sc_hd__decap_12
XFILLER_237_1449 VGND VGND VPWR VPWR sky130_fd_sc_hd__decap_6
XFILLER_190_1029 VGND VGND VPWR VPWR sky130_fd_sc_hd__decap_6
XTAP_TAPCELL_ROW_155_1_1290 VGND VPWR sky130_fd_sc_hd__tapvpwrvgnd_1
XFILLER_172_1441 VPWR VGND VPWR VGND sky130_ef_sc_hd__decap_12
XFILLER_238_905 VPWR VGND VPWR VGND sky130_ef_sc_hd__decap_12
XFILLER_172_1485 VPWR VGND VPWR VGND sky130_ef_sc_hd__decap_12
XFILLER_81_1379 VGND VGND VPWR VPWR sky130_fd_sc_hd__decap_6
XFILLER_238_949 VPWR VGND VPWR VGND sky130_ef_sc_hd__decap_12
XFILLER_213_1493 VPWR VGND VPWR VGND sky130_ef_sc_hd__decap_12
XFILLER_94_65 VGND VGND VPWR VPWR sky130_fd_sc_hd__decap_6
XFILLER_79_1231 VPWR VGND VPWR VGND sky130_ef_sc_hd__decap_12
XFILLER_224_109 VPWR VGND VPWR VGND sky130_ef_sc_hd__decap_12
XFILLER_206_813 VPWR VGND VPWR VGND sky130_ef_sc_hd__decap_12
XFILLER_246_993 VPWR VGND VPWR VGND sky130_ef_sc_hd__decap_12
XFILLER_217_161 VGND VGND VPWR VPWR sky130_fd_sc_hd__decap_6
X_605_ clknet_3_1__leaf_clk dout0\[3\] _013_ VGND VGND VPWR VPWR dout0_q\[3\] sky130_fd_sc_hd__dfrtp_1
XTAP_TAPCELL_ROW_201_2302 VGND VPWR sky130_fd_sc_hd__tapvpwrvgnd_1
XTAP_TAPCELL_ROW_201_2313 VGND VPWR sky130_fd_sc_hd__tapvpwrvgnd_1
XFILLER_79_1275 VPWR VGND VPWR VGND sky130_ef_sc_hd__decap_12
XTAP_TAPCELL_ROW_201_2324 VGND VPWR sky130_fd_sc_hd__tapvpwrvgnd_1
XFILLER_244_1409 VPWR VGND VPWR VGND sky130_ef_sc_hd__decap_12
XFILLER_233_665 VGND VGND VPWR VPWR sky130_fd_sc_hd__decap_6
X_536_ net666 VGND VGND VPWR VPWR _018_ sky130_fd_sc_hd__inv_2
XFILLER_232_153 VPWR VGND VPWR VGND sky130_ef_sc_hd__decap_12
XTAP_TAPCELL_ROW_193_2103 VGND VPWR sky130_fd_sc_hd__tapvpwrvgnd_1
XFILLER_207_1231 VGND VGND VPWR VPWR sky130_fd_sc_hd__fill_1
X_467_ net154 _241_ VGND VGND VPWR VPWR acc_core.adder.cla_blocks\[1\].block.sum\[3\]
+ sky130_fd_sc_hd__xnor2_1
XFILLER_232_197 VPWR VGND VPWR VGND sky130_ef_sc_hd__decap_12
XTAP_TAPCELL_ROW_157_2_4694 VGND VPWR sky130_fd_sc_hd__tapvpwrvgnd_1
XFILLER_9_421 VGND VGND VPWR VPWR sky130_fd_sc_hd__decap_8
XFILLER_140_1407 VGND VGND VPWR VPWR sky130_fd_sc_hd__decap_6
XFILLER_9_432 VGND VGND VPWR VPWR sky130_fd_sc_hd__fill_1
X_398_ net585 net591 net561 VGND VGND VPWR VPWR _187_ sky130_fd_sc_hd__nand3_1
XFILLER_199_1021 VPWR VGND VPWR VGND sky130_ef_sc_hd__decap_12
XFILLER_201_573 VPWR VGND VPWR VGND sky130_ef_sc_hd__decap_12
XFILLER_229_39 VPWR VGND VPWR VGND sky130_ef_sc_hd__decap_12
XFILLER_174_937 VPWR VGND VPWR VGND sky130_ef_sc_hd__decap_12
XFILLER_199_1065 VPWR VGND VPWR VGND sky130_ef_sc_hd__decap_12
XFILLER_220_1453 VPWR VGND VPWR VGND sky130_ef_sc_hd__decap_12
XFILLER_173_447 VGND VGND VPWR VPWR sky130_fd_sc_hd__fill_1
XFILLER_103_1273 VGND VGND VPWR VPWR sky130_fd_sc_hd__fill_1
XFILLER_220_1497 VPWR VGND VPWR VGND sky130_ef_sc_hd__decap_12
XFILLER_138_1303 VPWR VGND VPWR VGND sky130_ef_sc_hd__decap_12
XFILLER_182_981 VPWR VGND VPWR VGND sky130_ef_sc_hd__decap_12
XFILLER_12_1189 VGND VGND VPWR VPWR sky130_fd_sc_hd__fill_1
XFILLER_245_27 VPWR VGND VPWR VGND sky130_ef_sc_hd__decap_12
XFILLER_47_1219 VPWR VGND VPWR VGND sky130_ef_sc_hd__decap_12
XFILLER_4_41 VPWR VGND VPWR VGND sky130_ef_sc_hd__decap_12
XFILLER_218_1371 VGND VGND VPWR VPWR sky130_fd_sc_hd__fill_1
XFILLER_4_85 VPWR VGND VPWR VGND sky130_ef_sc_hd__decap_12
XTAP_TAPCELL_ROW_130_2_4535 VGND VPWR sky130_fd_sc_hd__tapvpwrvgnd_1
XTAP_TAPCELL_ROW_129_2_4529 VGND VPWR sky130_fd_sc_hd__tapvpwrvgnd_1
XFILLER_3_1313 VPWR VGND VPWR VGND sky130_ef_sc_hd__decap_12
XFILLER_7_1493 VPWR VGND VPWR VGND sky130_ef_sc_hd__decap_12
XFILLER_97_1331 VPWR VGND VPWR VGND sky130_ef_sc_hd__decap_12
XFILLER_167_1009 VPWR VGND VPWR VGND sky130_ef_sc_hd__decap_12
XFILLER_209_673 VPWR VGND VPWR VGND sky130_ef_sc_hd__decap_12
XFILLER_243_429 VPWR VGND VPWR VGND sky130_ef_sc_hd__decap_12
XFILLER_3_1357 VPWR VGND VPWR VGND sky130_ef_sc_hd__decap_12
XFILLER_247_1033 VPWR VGND VPWR VGND sky130_ef_sc_hd__decap_12
XFILLER_58_1315 VPWR VGND VPWR VGND sky130_ef_sc_hd__decap_12
XFILLER_149_1443 VPWR VGND VPWR VGND sky130_ef_sc_hd__decap_12
XFILLER_224_643 VGND VGND VPWR VPWR sky130_fd_sc_hd__fill_1
XFILLER_93_1217 VGND VGND VPWR VPWR sky130_fd_sc_hd__fill_1
XFILLER_212_805 VGND VGND VPWR VPWR sky130_fd_sc_hd__decap_6
XFILLER_58_1359 VPWR VGND VPWR VGND sky130_ef_sc_hd__decap_12
XFILLER_208_1017 VPWR VGND VPWR VGND sky130_ef_sc_hd__decap_12
XFILLER_247_1077 VPWR VGND VPWR VGND sky130_ef_sc_hd__decap_12
XFILLER_169_709 VPWR VGND VPWR VGND sky130_ef_sc_hd__decap_12
XFILLER_251_473 VPWR VGND VPWR VGND sky130_ef_sc_hd__decap_12
XFILLER_145_1329 VGND VGND VPWR VPWR sky130_fd_sc_hd__fill_1
XFILLER_210_41 VPWR VGND VPWR VGND sky130_ef_sc_hd__decap_12
XFILLER_212_849 VPWR VGND VPWR VGND sky130_ef_sc_hd__decap_12
XTAP_TAPCELL_ROW_77_2_4216 VGND VPWR sky130_fd_sc_hd__tapvpwrvgnd_1
XFILLER_211_337 VPWR VGND VPWR VGND sky130_ef_sc_hd__decap_12
XFILLER_210_85 VPWR VGND VPWR VGND sky130_ef_sc_hd__decap_12
XTAP_TAPCELL_ROW_176_1633 VGND VPWR sky130_fd_sc_hd__tapvpwrvgnd_1
XFILLER_177_753 VPWR VGND VPWR VGND sky130_ef_sc_hd__decap_12
XFILLER_182_1091 VGND VGND VPWR VPWR sky130_fd_sc_hd__fill_1
XTAP_TAPCELL_ROW_176_1644 VGND VPWR sky130_fd_sc_hd__tapvpwrvgnd_1
XFILLER_139_39 VPWR VGND VPWR VGND sky130_ef_sc_hd__decap_12
XFILLER_192_701 VPWR VGND VPWR VGND sky130_ef_sc_hd__decap_12
XFILLER_220_893 VPWR VGND VPWR VGND sky130_ef_sc_hd__decap_12
XFILLER_165_937 VPWR VGND VPWR VGND sky130_ef_sc_hd__decap_12
XFILLER_177_797 VPWR VGND VPWR VGND sky130_ef_sc_hd__decap_12
XTAP_TAPCELL_ROW_172_1519 VGND VPWR sky130_fd_sc_hd__tapvpwrvgnd_1
XFILLER_178_1105 VPWR VGND VPWR VGND sky130_ef_sc_hd__decap_12
XFILLER_165_959 VGND VGND VPWR VPWR sky130_fd_sc_hd__fill_1
XFILLER_69_1411 VPWR VGND VPWR VGND sky130_ef_sc_hd__decap_12
XFILLER_30_1245 VGND VGND VPWR VPWR sky130_fd_sc_hd__fill_1
XFILLER_178_1149 VPWR VGND VPWR VGND sky130_ef_sc_hd__decap_12
XFILLER_219_1113 VGND VGND VPWR VPWR sky130_fd_sc_hd__decap_6
XFILLER_69_1455 VPWR VGND VPWR VGND sky130_ef_sc_hd__decap_12
XFILLER_155_27 VPWR VGND VPWR VGND sky130_ef_sc_hd__decap_12
XPHY_EDGE_ROW_224_Left_479 VGND VGND VPWR VPWR sky130_fd_sc_hd__decap_3
XFILLER_254_1037 VPWR VGND VPWR VGND sky130_ef_sc_hd__decap_12
XFILLER_219_1157 VPWR VGND VPWR VGND sky130_ef_sc_hd__decap_12
XFILLER_69_1499 VPWR VGND VPWR VGND sky130_ef_sc_hd__decap_12
XFILLER_156_1469 VGND VGND VPWR VPWR sky130_fd_sc_hd__fill_1
XTAP_TAPCELL_ROW_24_2_3899 VGND VPWR sky130_fd_sc_hd__tapvpwrvgnd_1
XFILLER_235_93 VPWR VGND VPWR VGND sky130_ef_sc_hd__decap_12
XFILLER_171_15 VPWR VGND VPWR VGND sky130_ef_sc_hd__decap_12
XFILLER_189_1201 VPWR VGND VPWR VGND sky130_ef_sc_hd__decap_12
XFILLER_115_1177 VPWR VGND VPWR VGND sky130_ef_sc_hd__decap_12
XFILLER_246_245 VGND VGND VPWR VPWR sky130_fd_sc_hd__decap_6
XFILLER_189_1245 VPWR VGND VPWR VGND sky130_ef_sc_hd__decap_12
XFILLER_104_53 VPWR VGND VPWR VGND sky130_ef_sc_hd__decap_12
XFILLER_206_109 VPWR VGND VPWR VGND sky130_ef_sc_hd__decap_12
XFILLER_246_289 VPWR VGND VPWR VGND sky130_ef_sc_hd__decap_12
XTAP_TAPCELL_ROW_241_3383 VGND VPWR sky130_fd_sc_hd__tapvpwrvgnd_1
XFILLER_251_81 VPWR VGND VPWR VGND sky130_ef_sc_hd__decap_12
XTAP_TAPCELL_ROW_241_3394 VGND VPWR sky130_fd_sc_hd__tapvpwrvgnd_1
XFILLER_41_1385 VGND VGND VPWR VPWR sky130_fd_sc_hd__fill_1
XFILLER_189_1289 VPWR VGND VPWR VGND sky130_ef_sc_hd__decap_12
XFILLER_228_993 VPWR VGND VPWR VGND sky130_ef_sc_hd__decap_12
XFILLER_76_1415 VPWR VGND VPWR VGND sky130_ef_sc_hd__decap_12
XFILLER_64_57 VPWR VGND VPWR VGND sky130_ef_sc_hd__decap_12
XPHY_EDGE_ROW_233_Left_488 VGND VGND VPWR VPWR sky130_fd_sc_hd__decap_3
XFILLER_215_665 VGND VGND VPWR VPWR sky130_fd_sc_hd__decap_6
XFILLER_226_1117 VPWR VGND VPWR VGND sky130_ef_sc_hd__decap_12
XFILLER_214_153 VPWR VGND VPWR VGND sky130_ef_sc_hd__decap_12
XFILLER_154_3 VPWR VGND VPWR VGND sky130_ef_sc_hd__decap_12
XFILLER_230_613 VPWR VGND VPWR VGND sky130_ef_sc_hd__decap_12
X_321_ _102_ net137 _109_ net507 VGND VGND VPWR VPWR _110_ sky130_fd_sc_hd__a211o_1
XFILLER_120_41 VPWR VGND VPWR VGND sky130_ef_sc_hd__decap_12
XFILLER_187_517 VPWR VGND VPWR VGND sky130_ef_sc_hd__decap_12
XTAP_TAPCELL_ROW_254_3733 VGND VPWR sky130_fd_sc_hd__tapvpwrvgnd_1
XFILLER_214_197 VPWR VGND VPWR VGND sky130_ef_sc_hd__decap_12
XTAP_TAPCELL_ROW_254_3744 VGND VPWR sky130_fd_sc_hd__tapvpwrvgnd_1
XFILLER_230_657 VPWR VGND VPWR VGND sky130_ef_sc_hd__decap_12
XTAP_TAPCELL_ROW_254_3755 VGND VPWR sky130_fd_sc_hd__tapvpwrvgnd_1
XFILLER_195_561 VPWR VGND VPWR VGND sky130_ef_sc_hd__decap_12
XFILLER_126_1295 VGND VGND VPWR VPWR sky130_fd_sc_hd__decap_6
XFILLER_35_1189 VPWR VGND VPWR VGND sky130_ef_sc_hd__decap_12
XFILLER_196_1205 VPWR VGND VPWR VGND sky130_ef_sc_hd__decap_12
XFILLER_13_1443 VPWR VGND VPWR VGND sky130_ef_sc_hd__decap_12
XFILLER_182_233 VPWR VGND VPWR VGND sky130_ef_sc_hd__decap_12
XFILLER_202_1161 VPWR VGND VPWR VGND sky130_ef_sc_hd__decap_12
XFILLER_87_1511 VGND VGND VPWR VPWR sky130_fd_sc_hd__decap_4
XFILLER_100_1413 VGND VGND VPWR VPWR sky130_fd_sc_hd__fill_1
XPHY_EDGE_ROW_242_Left_497 VGND VGND VPWR VPWR sky130_fd_sc_hd__decap_3
XFILLER_237_1213 VPWR VGND VPWR VGND sky130_ef_sc_hd__decap_12
XFILLER_182_277 VPWR VGND VPWR VGND sky130_ef_sc_hd__decap_12
XFILLER_237_1257 VPWR VGND VPWR VGND sky130_ef_sc_hd__decap_12
XFILLER_215_1511 VGND VGND VPWR VPWR sky130_fd_sc_hd__fill_1
XFILLER_238_713 VPWR VGND VPWR VGND sky130_ef_sc_hd__decap_12
XFILLER_81_1165 VPWR VGND VPWR VGND sky130_ef_sc_hd__decap_12
XFILLER_133_1255 VPWR VGND VPWR VGND sky130_ef_sc_hd__decap_12
XFILLER_238_757 VPWR VGND VPWR VGND sky130_ef_sc_hd__decap_12
XFILLER_237_223 VGND VGND VPWR VPWR sky130_fd_sc_hd__fill_1
XFILLER_133_1299 VPWR VGND VPWR VGND sky130_ef_sc_hd__decap_12
XFILLER_253_727 VGND VGND VPWR VPWR sky130_fd_sc_hd__fill_1
XFILLER_168_1329 VPWR VGND VPWR VGND sky130_ef_sc_hd__decap_12
XFILLER_225_429 VPWR VGND VPWR VGND sky130_ef_sc_hd__decap_12
XFILLER_248_1353 VPWR VGND VPWR VGND sky130_ef_sc_hd__decap_12
XFILLER_20_1469 VGND VGND VPWR VPWR sky130_fd_sc_hd__fill_1
XFILLER_206_643 VGND VGND VPWR VPWR sky130_fd_sc_hd__fill_1
XPHY_EDGE_ROW_117_2_Left_619 VGND VGND VPWR VPWR sky130_fd_sc_hd__decap_3
XFILLER_244_1217 VPWR VGND VPWR VGND sky130_ef_sc_hd__decap_12
XTAP_TAPCELL_ROW_63_2_4135 VGND VPWR sky130_fd_sc_hd__tapvpwrvgnd_1
XFILLER_209_1337 VGND VGND VPWR VPWR sky130_fd_sc_hd__decap_6
XFILLER_248_1397 VPWR VGND VPWR VGND sky130_ef_sc_hd__decap_12
XFILLER_233_473 VPWR VGND VPWR VGND sky130_ef_sc_hd__decap_12
X_519_ net663 VGND VGND VPWR VPWR _001_ sky130_fd_sc_hd__inv_2
XFILLER_53_1201 VPWR VGND VPWR VGND sky130_ef_sc_hd__decap_12
XFILLER_92_1283 VPWR VGND VPWR VGND sky130_ef_sc_hd__decap_12
XFILLER_144_1351 VGND VGND VPWR VPWR sky130_fd_sc_hd__decap_6
XFILLER_53_1267 VGND VGND VPWR VPWR sky130_fd_sc_hd__decap_6
XTAP_TAPCELL_ROW_43_2_4011 VGND VPWR sky130_fd_sc_hd__tapvpwrvgnd_1
XFILLER_140_1215 VPWR VGND VPWR VGND sky130_ef_sc_hd__decap_12
XFILLER_174_701 VPWR VGND VPWR VGND sky130_ef_sc_hd__decap_12
XFILLER_202_893 VPWR VGND VPWR VGND sky130_ef_sc_hd__decap_12
XFILLER_220_189 VGND VGND VPWR VPWR sky130_fd_sc_hd__decap_6
XFILLER_144_1395 VPWR VGND VPWR VGND sky130_ef_sc_hd__decap_12
XFILLER_179_1425 VPWR VGND VPWR VGND sky130_ef_sc_hd__decap_12
XFILLER_9_284 VGND VGND VPWR VPWR sky130_fd_sc_hd__decap_6
XFILLER_105_1379 VGND VGND VPWR VPWR sky130_fd_sc_hd__decap_6
XFILLER_140_1259 VPWR VGND VPWR VGND sky130_ef_sc_hd__decap_12
XFILLER_220_1261 VPWR VGND VPWR VGND sky130_ef_sc_hd__decap_12
XFILLER_179_1469 VPWR VGND VPWR VGND sky130_ef_sc_hd__decap_12
XFILLER_255_1313 VGND VGND VPWR VPWR sky130_fd_sc_hd__decap_3
XTAP_TAPCELL_ROW_62_1_1197 VGND VPWR sky130_fd_sc_hd__tapvpwrvgnd_1
XFILLER_255_1357 VPWR VGND VPWR VGND sky130_ef_sc_hd__decap_12
XFILLER_170_973 VGND VGND VPWR VPWR sky130_fd_sc_hd__decap_6
XFILLER_138_1177 VPWR VGND VPWR VGND sky130_ef_sc_hd__decap_12
XFILLER_173_1057 VGND VGND VPWR VPWR sky130_fd_sc_hd__decap_6
XFILLER_151_1311 VPWR VGND VPWR VGND sky130_ef_sc_hd__decap_12
XFILLER_190_1371 VGND VGND VPWR VPWR sky130_fd_sc_hd__fill_1
XFILLER_155_1491 VGND VGND VPWR VPWR sky130_fd_sc_hd__decap_6
XTAP_TAPCELL_ROW_165_1301 VGND VPWR sky130_fd_sc_hd__tapvpwrvgnd_1
XFILLER_60_1227 VPWR VGND VPWR VGND sky130_ef_sc_hd__decap_12
XTAP_TAPCELL_ROW_165_1312 VGND VPWR sky130_fd_sc_hd__tapvpwrvgnd_1
XFILLER_151_1355 VPWR VGND VPWR VGND sky130_ef_sc_hd__decap_12
XTAP_TAPCELL_ROW_165_1323 VGND VPWR sky130_fd_sc_hd__tapvpwrvgnd_1
XTAP_TAPCELL_ROW_165_1334 VGND VPWR sky130_fd_sc_hd__tapvpwrvgnd_1
XFILLER_228_245 VGND VGND VPWR VPWR sky130_fd_sc_hd__decap_6
XTAP_TAPCELL_ROW_165_1345 VGND VPWR sky130_fd_sc_hd__tapvpwrvgnd_1
XFILLER_112_1339 VPWR VGND VPWR VGND sky130_ef_sc_hd__decap_12
XFILLER_3_1121 VPWR VGND VPWR VGND sky130_ef_sc_hd__decap_12
XFILLER_151_1399 VPWR VGND VPWR VGND sky130_ef_sc_hd__decap_12
XFILLER_228_289 VPWR VGND VPWR VGND sky130_ef_sc_hd__decap_12
XFILLER_244_749 VGND VGND VPWR VPWR sky130_fd_sc_hd__decap_6
XFILLER_186_1429 VPWR VGND VPWR VGND sky130_ef_sc_hd__decap_12
XFILLER_243_237 VPWR VGND VPWR VGND sky130_ef_sc_hd__decap_12
XFILLER_221_51 VGND VGND VPWR VPWR sky130_fd_sc_hd__decap_4
XFILLER_34_27 VGND VGND VPWR VPWR sky130_fd_sc_hd__fill_1
XFILLER_149_1273 VGND VGND VPWR VPWR sky130_fd_sc_hd__fill_1
XFILLER_212_613 VPWR VGND VPWR VGND sky130_ef_sc_hd__decap_12
XFILLER_227_1437 VPWR VGND VPWR VGND sky130_ef_sc_hd__decap_12
XFILLER_252_793 VPWR VGND VPWR VGND sky130_ef_sc_hd__decap_12
XFILLER_169_517 VPWR VGND VPWR VGND sky130_ef_sc_hd__decap_12
XFILLER_251_281 VPWR VGND VPWR VGND sky130_ef_sc_hd__decap_12
XFILLER_34_49 VGND VGND VPWR VPWR sky130_fd_sc_hd__fill_2
XFILLER_180_1017 VPWR VGND VPWR VGND sky130_ef_sc_hd__decap_12
XFILLER_58_1189 VGND VGND VPWR VPWR sky130_fd_sc_hd__fill_1
XFILLER_184_1197 VGND VGND VPWR VPWR sky130_fd_sc_hd__decap_6
XFILLER_212_657 VPWR VGND VPWR VGND sky130_ef_sc_hd__decap_12
XFILLER_71_1323 VGND VGND VPWR VPWR sky130_fd_sc_hd__decap_6
XFILLER_162_1451 VPWR VGND VPWR VGND sky130_ef_sc_hd__decap_12
XFILLER_211_167 VGND VGND VPWR VPWR sky130_fd_sc_hd__fill_1
Xwire108 _207_ VGND VGND VPWR VPWR net108 sky130_fd_sc_hd__clkbuf_1
XFILLER_165_701 VPWR VGND VPWR VGND sky130_ef_sc_hd__decap_12
XFILLER_177_561 VPWR VGND VPWR VGND sky130_ef_sc_hd__decap_12
Xclkload4 clknet_3_4__leaf_clk VGND VGND VPWR VPWR clkload4/Y sky130_fd_sc_hd__bufinv_16
XFILLER_71_1367 VPWR VGND VPWR VGND sky130_ef_sc_hd__decap_12
XFILLER_123_1435 VGND VGND VPWR VPWR sky130_fd_sc_hd__decap_6
XFILLER_50_15 VPWR VGND VPWR VGND sky130_ef_sc_hd__decap_12
XFILLER_162_1495 VPWR VGND VPWR VGND sky130_ef_sc_hd__decap_12
XFILLER_192_531 VGND VGND VPWR VPWR sky130_fd_sc_hd__fill_1
XFILLER_123_1479 VPWR VGND VPWR VGND sky130_ef_sc_hd__decap_12
XFILLER_166_15 VPWR VGND VPWR VGND sky130_ef_sc_hd__decap_12
XFILLER_203_1481 VPWR VGND VPWR VGND sky130_ef_sc_hd__decap_12
XPHY_EDGE_ROW_163_2_Left_665 VGND VGND VPWR VPWR sky130_fd_sc_hd__decap_3
XFILLER_180_737 VPWR VGND VPWR VGND sky130_ef_sc_hd__decap_12
XTAP_TAPCELL_ROW_230_3084 VGND VPWR sky130_fd_sc_hd__tapvpwrvgnd_1
XTAP_TAPCELL_ROW_230_3095 VGND VPWR sky130_fd_sc_hd__tapvpwrvgnd_1
XFILLER_191_1113 VGND VGND VPWR VPWR sky130_fd_sc_hd__decap_6
XFILLER_117_1217 VGND VGND VPWR VPWR sky130_fd_sc_hd__fill_1
XFILLER_59_57 VPWR VGND VPWR VGND sky130_ef_sc_hd__decap_12
XFILLER_191_1157 VPWR VGND VPWR VGND sky130_ef_sc_hd__decap_12
XFILLER_82_1463 VGND VGND VPWR VPWR sky130_fd_sc_hd__decap_6
XTAP_TAPCELL_ROW_243_3434 VGND VPWR sky130_fd_sc_hd__tapvpwrvgnd_1
XTAP_TAPCELL_ROW_243_3445 VGND VPWR sky130_fd_sc_hd__tapvpwrvgnd_1
XTAP_TAPCELL_ROW_243_3456 VGND VPWR sky130_fd_sc_hd__tapvpwrvgnd_1
XFILLER_219_223 VGND VGND VPWR VPWR sky130_fd_sc_hd__fill_1
XFILLER_130_1439 VPWR VGND VPWR VGND sky130_ef_sc_hd__decap_12
XFILLER_235_727 VGND VGND VPWR VPWR sky130_fd_sc_hd__fill_1
XTAP_TAPCELL_ROW_9_1093 VGND VPWR sky130_fd_sc_hd__tapvpwrvgnd_1
XTAP_TAPCELL_ROW_3_950 VGND VPWR sky130_fd_sc_hd__tapvpwrvgnd_1
XFILLER_207_429 VPWR VGND VPWR VGND sky130_ef_sc_hd__decap_12
XFILLER_210_1441 VPWR VGND VPWR VGND sky130_ef_sc_hd__decap_12
XPHY_EDGE_ROW_100_1_Right_756 VGND VGND VPWR VPWR sky130_fd_sc_hd__decap_3
XPHY_EDGE_ROW_52_1_Left_307 VGND VGND VPWR VPWR sky130_fd_sc_hd__decap_3
XFILLER_210_1485 VPWR VGND VPWR VGND sky130_ef_sc_hd__decap_12
XFILLER_131_51 VGND VGND VPWR VPWR sky130_fd_sc_hd__decap_4
XFILLER_76_1245 VGND VGND VPWR VPWR sky130_fd_sc_hd__fill_1
XFILLER_215_473 VPWR VGND VPWR VGND sky130_ef_sc_hd__decap_12
XFILLER_231_933 VPWR VGND VPWR VGND sky130_ef_sc_hd__decap_12
XFILLER_188_837 VPWR VGND VPWR VGND sky130_ef_sc_hd__decap_12
XFILLER_230_421 VPWR VGND VPWR VGND sky130_ef_sc_hd__decap_12
XFILLER_91_55 VGND VGND VPWR VPWR sky130_fd_sc_hd__fill_1
XFILLER_128_1357 VGND VGND VPWR VPWR sky130_fd_sc_hd__fill_1
XFILLER_231_977 VPWR VGND VPWR VGND sky130_ef_sc_hd__decap_12
X_304_ net596 dout0_q\[28\] net527 VGND VGND VPWR VPWR _093_ sky130_fd_sc_hd__a21oi_1
XFILLER_50_1407 VGND VGND VPWR VPWR sky130_fd_sc_hd__decap_6
XFILLER_202_189 VGND VGND VPWR VPWR sky130_fd_sc_hd__decap_6
XFILLER_196_881 VPWR VGND VPWR VGND sky130_ef_sc_hd__decap_12
XPHY_EDGE_ROW_95_2_Left_597 VGND VGND VPWR VPWR sky130_fd_sc_hd__decap_3
XPHY_EDGE_ROW_250_Left_505 VGND VGND VPWR VPWR sky130_fd_sc_hd__decap_3
Xwire631 net37 VGND VGND VPWR VPWR net631 sky130_fd_sc_hd__buf_1
Xwire642 net28 VGND VGND VPWR VPWR net642 sky130_fd_sc_hd__buf_1
XFILLER_195_391 VGND VGND VPWR VPWR sky130_fd_sc_hd__fill_1
Xwire653 net19 VGND VGND VPWR VPWR net653 sky130_fd_sc_hd__buf_1
XFILLER_183_553 VGND VGND VPWR VPWR sky130_fd_sc_hd__decap_6
XFILLER_196_1035 VGND VGND VPWR VPWR sky130_fd_sc_hd__fill_1
XFILLER_13_1273 VGND VGND VPWR VPWR sky130_fd_sc_hd__fill_1
XFILLER_6_276 VGND VGND VPWR VPWR sky130_fd_sc_hd__decap_4
XFILLER_183_597 VPWR VGND VPWR VGND sky130_ef_sc_hd__decap_12
XFILLER_48_1303 VPWR VGND VPWR VGND sky130_ef_sc_hd__decap_12
XFILLER_237_1021 VPWR VGND VPWR VGND sky130_ef_sc_hd__decap_12
XFILLER_226_29 VPWR VGND VPWR VGND sky130_ef_sc_hd__decap_12
XFILLER_87_1385 VGND VGND VPWR VPWR sky130_fd_sc_hd__fill_1
XFILLER_237_1065 VPWR VGND VPWR VGND sky130_ef_sc_hd__decap_12
XFILLER_139_1497 VGND VGND VPWR VPWR sky130_fd_sc_hd__fill_1
XTAP_TAPCELL_ROW_226_2975 VGND VPWR sky130_fd_sc_hd__tapvpwrvgnd_1
XFILLER_238_587 VGND VGND VPWR VPWR sky130_fd_sc_hd__fill_1
XFILLER_4_1441 VPWR VGND VPWR VGND sky130_ef_sc_hd__decap_12
XTAP_TAPCELL_ROW_226_2986 VGND VPWR sky130_fd_sc_hd__tapvpwrvgnd_1
XTAP_TAPCELL_ROW_226_2997 VGND VPWR sky130_fd_sc_hd__tapvpwrvgnd_1
XFILLER_226_749 VGND VGND VPWR VPWR sky130_fd_sc_hd__decap_6
XFILLER_225_237 VPWR VGND VPWR VGND sky130_ef_sc_hd__decap_12
XFILLER_1_97 VPWR VGND VPWR VGND sky130_ef_sc_hd__decap_12
XFILLER_4_1485 VPWR VGND VPWR VGND sky130_ef_sc_hd__decap_12
XFILLER_94_1301 VGND VGND VPWR VPWR sky130_fd_sc_hd__fill_1
XFILLER_59_1443 VPWR VGND VPWR VGND sky130_ef_sc_hd__decap_12
XFILLER_209_1101 VPWR VGND VPWR VGND sky130_ef_sc_hd__decap_12
XFILLER_248_1161 VPWR VGND VPWR VGND sky130_ef_sc_hd__decap_12
XFILLER_146_1413 VGND VGND VPWR VPWR sky130_fd_sc_hd__fill_1
XFILLER_234_793 VPWR VGND VPWR VGND sky130_ef_sc_hd__decap_12
XFILLER_209_1145 VPWR VGND VPWR VGND sky130_ef_sc_hd__decap_12
XFILLER_55_1329 VGND VGND VPWR VPWR sky130_fd_sc_hd__fill_1
XFILLER_233_281 VPWR VGND VPWR VGND sky130_ef_sc_hd__decap_12
XFILLER_181_1337 VGND VGND VPWR VPWR sky130_fd_sc_hd__decap_6
XFILLER_205_1009 VPWR VGND VPWR VGND sky130_ef_sc_hd__decap_12
XFILLER_209_1189 VPWR VGND VPWR VGND sky130_ef_sc_hd__decap_12
XFILLER_193_317 VPWR VGND VPWR VGND sky130_ef_sc_hd__decap_12
XFILLER_105_1165 VPWR VGND VPWR VGND sky130_ef_sc_hd__decap_12
XFILLER_174_531 VGND VGND VPWR VPWR sky130_fd_sc_hd__fill_1
XFILLER_179_1233 VPWR VGND VPWR VGND sky130_ef_sc_hd__decap_12
XFILLER_20_29 VPWR VGND VPWR VGND sky130_ef_sc_hd__decap_12
XFILLER_220_1091 VGND VGND VPWR VPWR sky130_fd_sc_hd__fill_1
XFILLER_175_1119 VGND VGND VPWR VPWR sky130_fd_sc_hd__fill_1
XFILLER_255_1121 VPWR VGND VPWR VGND sky130_ef_sc_hd__decap_12
XFILLER_136_29 VPWR VGND VPWR VGND sky130_ef_sc_hd__decap_12
XFILLER_216_1105 VPWR VGND VPWR VGND sky130_ef_sc_hd__decap_12
XFILLER_251_1007 VGND VGND VPWR VPWR sky130_fd_sc_hd__fill_1
XFILLER_66_1469 VGND VGND VPWR VPWR sky130_fd_sc_hd__fill_1
XFILLER_170_781 VPWR VGND VPWR VGND sky130_ef_sc_hd__decap_12
XFILLER_192_1477 VGND VGND VPWR VPWR sky130_fd_sc_hd__decap_6
XFILLER_248_307 VGND VGND VPWR VPWR sky130_fd_sc_hd__fill_1
XFILLER_216_1149 VPWR VGND VPWR VGND sky130_ef_sc_hd__decap_12
XTAP_TAPCELL_ROW_167_1407 VGND VPWR sky130_fd_sc_hd__tapvpwrvgnd_1
XFILLER_9_1341 VGND VGND VPWR VPWR sky130_fd_sc_hd__decap_3
XFILLER_29_27 VGND VGND VPWR VPWR sky130_fd_sc_hd__decap_6
XFILLER_9_1385 VPWR VGND VPWR VGND sky130_ef_sc_hd__decap_12
XFILLER_99_1201 VPWR VGND VPWR VGND sky130_ef_sc_hd__decap_12
XFILLER_116_1283 VPWR VGND VPWR VGND sky130_ef_sc_hd__decap_12
XFILLER_25_1177 VPWR VGND VPWR VGND sky130_ef_sc_hd__decap_12
XFILLER_244_513 VPWR VGND VPWR VGND sky130_ef_sc_hd__decap_12
XFILLER_217_727 VGND VGND VPWR VPWR sky130_fd_sc_hd__fill_1
XFILLER_99_1267 VGND VGND VPWR VPWR sky130_fd_sc_hd__decap_6
XFILLER_45_15 VPWR VGND VPWR VGND sky130_ef_sc_hd__decap_12
XFILLER_244_557 VPWR VGND VPWR VGND sky130_ef_sc_hd__decap_12
XFILLER_232_83 VGND VGND VPWR VPWR sky130_fd_sc_hd__fill_1
XFILLER_186_1259 VGND VGND VPWR VPWR sky130_fd_sc_hd__fill_1
XFILLER_227_1201 VPWR VGND VPWR VGND sky130_ef_sc_hd__decap_12
XFILLER_213_933 VPWR VGND VPWR VGND sky130_ef_sc_hd__decap_12
XFILLER_212_421 VPWR VGND VPWR VGND sky130_ef_sc_hd__decap_12
XFILLER_227_1245 VPWR VGND VPWR VGND sky130_ef_sc_hd__decap_12
XFILLER_213_977 VPWR VGND VPWR VGND sky130_ef_sc_hd__decap_12
XFILLER_196_133 VGND VGND VPWR VPWR sky130_fd_sc_hd__decap_6
XFILLER_227_1289 VPWR VGND VPWR VGND sky130_ef_sc_hd__decap_12
XTAP_TAPCELL_ROW_236_3260 VGND VPWR sky130_fd_sc_hd__tapvpwrvgnd_1
XFILLER_178_881 VPWR VGND VPWR VGND sky130_ef_sc_hd__decap_12
XFILLER_196_177 VPWR VGND VPWR VGND sky130_ef_sc_hd__decap_12
XFILLER_36_1295 VGND VGND VPWR VPWR sky130_fd_sc_hd__decap_6
XTAP_TAPCELL_ROW_12_2_3826 VGND VPWR sky130_fd_sc_hd__tapvpwrvgnd_1
XFILLER_123_1243 VPWR VGND VPWR VGND sky130_ef_sc_hd__decap_12
XFILLER_177_391 VGND VGND VPWR VPWR sky130_fd_sc_hd__fill_1
XTAP_TAPCELL_ROW_232_3146 VGND VPWR sky130_fd_sc_hd__tapvpwrvgnd_1
XFILLER_177_69 VPWR VGND VPWR VGND sky130_ef_sc_hd__decap_12
XTAP_TAPCELL_ROW_232_3157 VGND VPWR sky130_fd_sc_hd__tapvpwrvgnd_1
XFILLER_123_1287 VPWR VGND VPWR VGND sky130_ef_sc_hd__decap_12
XFILLER_180_501 VPWR VGND VPWR VGND sky130_ef_sc_hd__decap_12
XFILLER_10_1413 VGND VGND VPWR VPWR sky130_fd_sc_hd__fill_1
XFILLER_117_3 VPWR VGND VPWR VGND sky130_ef_sc_hd__decap_12
XFILLER_193_895 VGND VGND VPWR VPWR sky130_fd_sc_hd__fill_1
XTAP_TAPCELL_ROW_249_3610 VGND VPWR sky130_fd_sc_hd__tapvpwrvgnd_1
XTAP_TAPCELL_ROW_249_3621 VGND VPWR sky130_fd_sc_hd__tapvpwrvgnd_1
XFILLER_158_1339 VPWR VGND VPWR VGND sky130_ef_sc_hd__decap_12
XFILLER_180_545 VPWR VGND VPWR VGND sky130_ef_sc_hd__decap_12
XFILLER_197_1399 VGND VGND VPWR VPWR sky130_fd_sc_hd__fill_1
XFILLER_238_1341 VPWR VGND VPWR VGND sky130_ef_sc_hd__decap_12
XFILLER_193_57 VPWR VGND VPWR VGND sky130_ef_sc_hd__decap_12
XFILLER_234_1205 VPWR VGND VPWR VGND sky130_ef_sc_hd__decap_12
XTAP_TAPCELL_ROW_245_3507 VGND VPWR sky130_fd_sc_hd__tapvpwrvgnd_1
XFILLER_180_589 VPWR VGND VPWR VGND sky130_ef_sc_hd__decap_12
XFILLER_238_1385 VPWR VGND VPWR VGND sky130_ef_sc_hd__decap_12
XFILLER_3_279 VGND VGND VPWR VPWR sky130_fd_sc_hd__fill_1
XFILLER_239_329 VGND VGND VPWR VPWR sky130_fd_sc_hd__decap_6
XFILLER_0_953 VPWR VGND VPWR VGND sky130_ef_sc_hd__decap_12
XFILLER_82_1271 VPWR VGND VPWR VGND sky130_ef_sc_hd__decap_12
XTAP_TAPCELL_ROW_131_2_4540 VGND VPWR sky130_fd_sc_hd__tapvpwrvgnd_1
XFILLER_43_1255 VPWR VGND VPWR VGND sky130_ef_sc_hd__decap_12
XFILLER_130_1203 VPWR VGND VPWR VGND sky130_ef_sc_hd__decap_12
XFILLER_134_1383 VPWR VGND VPWR VGND sky130_ef_sc_hd__decap_12
XFILLER_247_373 VPWR VGND VPWR VGND sky130_ef_sc_hd__decap_12
XFILLER_43_1299 VPWR VGND VPWR VGND sky130_ef_sc_hd__decap_12
XFILLER_130_1247 VPWR VGND VPWR VGND sky130_ef_sc_hd__decap_12
XFILLER_169_1413 VPWR VGND VPWR VGND sky130_ef_sc_hd__decap_12
XTAP_TAPCELL_ROW_98_2_4345 VGND VPWR sky130_fd_sc_hd__tapvpwrvgnd_1
XFILLER_208_749 VGND VGND VPWR VPWR sky130_fd_sc_hd__decap_6
XFILLER_207_237 VPWR VGND VPWR VGND sky130_ef_sc_hd__decap_12
XFILLER_169_1457 VPWR VGND VPWR VGND sky130_ef_sc_hd__decap_12
XPHY_EDGE_ROW_101_1_Right_757 VGND VGND VPWR VPWR sky130_fd_sc_hd__decap_3
XTAP_TAPCELL_ROW_221_2850 VGND VPWR sky130_fd_sc_hd__tapvpwrvgnd_1
XFILLER_245_1301 VPWR VGND VPWR VGND sky130_ef_sc_hd__decap_12
XFILLER_249_1481 VPWR VGND VPWR VGND sky130_ef_sc_hd__decap_12
XTAP_TAPCELL_ROW_221_2861 VGND VPWR sky130_fd_sc_hd__tapvpwrvgnd_1
XFILLER_188_601 VPWR VGND VPWR VGND sky130_ef_sc_hd__decap_12
XFILLER_216_793 VPWR VGND VPWR VGND sky130_ef_sc_hd__decap_12
XFILLER_245_1345 VPWR VGND VPWR VGND sky130_ef_sc_hd__decap_12
XFILLER_215_281 VPWR VGND VPWR VGND sky130_ef_sc_hd__decap_12
XTAP_TAPCELL_ROW_78_2_4221 VGND VPWR sky130_fd_sc_hd__tapvpwrvgnd_1
XFILLER_231_741 VPWR VGND VPWR VGND sky130_ef_sc_hd__decap_12
XFILLER_187_111 VGND VGND VPWR VPWR sky130_fd_sc_hd__fill_1
XFILLER_188_645 VPWR VGND VPWR VGND sky130_ef_sc_hd__decap_12
XFILLER_128_1165 VPWR VGND VPWR VGND sky130_ef_sc_hd__decap_12
XFILLER_206_1329 VPWR VGND VPWR VGND sky130_ef_sc_hd__decap_12
XFILLER_230_251 VGND VGND VPWR VPWR sky130_fd_sc_hd__fill_1
XFILLER_231_785 VPWR VGND VPWR VGND sky130_ef_sc_hd__decap_12
XFILLER_54_1351 VGND VGND VPWR VPWR sky130_fd_sc_hd__decap_6
XFILLER_175_317 VPWR VGND VPWR VGND sky130_ef_sc_hd__decap_12
XFILLER_50_1215 VPWR VGND VPWR VGND sky130_ef_sc_hd__decap_12
XFILLER_54_1395 VPWR VGND VPWR VGND sky130_ef_sc_hd__decap_12
XFILLER_106_1463 VGND VGND VPWR VPWR sky130_fd_sc_hd__decap_6
XFILLER_141_1343 VPWR VGND VPWR VGND sky130_ef_sc_hd__decap_12
XTAP_TAPCELL_ROW_219_2790 VGND VPWR sky130_fd_sc_hd__tapvpwrvgnd_1
XFILLER_50_1259 VPWR VGND VPWR VGND sky130_ef_sc_hd__decap_12
XFILLER_15_1379 VGND VGND VPWR VPWR sky130_fd_sc_hd__decap_6
XFILLER_102_1327 VPWR VGND VPWR VGND sky130_ef_sc_hd__decap_12
Xwire450 net451 VGND VGND VPWR VPWR net450 sky130_fd_sc_hd__clkbuf_1
XFILLER_141_1387 VPWR VGND VPWR VGND sky130_ef_sc_hd__decap_12
XFILLER_190_309 VPWR VGND VPWR VGND sky130_ef_sc_hd__decap_12
Xwire461 net462 VGND VGND VPWR VPWR net461 sky130_fd_sc_hd__clkbuf_1
XFILLER_237_39 VPWR VGND VPWR VGND sky130_ef_sc_hd__decap_12
Xmax_cap205 net206 VGND VGND VPWR VPWR net205 sky130_fd_sc_hd__clkbuf_1
Xwire472 net473 VGND VGND VPWR VPWR net472 sky130_fd_sc_hd__clkbuf_1
XFILLER_183_361 VPWR VGND VPWR VGND sky130_ef_sc_hd__decap_12
Xwire483 net484 VGND VGND VPWR VPWR net483 sky130_fd_sc_hd__clkbuf_1
Xmax_cap216 _167_ VGND VGND VPWR VPWR net216 sky130_fd_sc_hd__clkbuf_1
XTAP_TAPCELL_ROW_215_2687 VGND VPWR sky130_fd_sc_hd__tapvpwrvgnd_1
XTAP_TAPCELL_ROW_215_2698 VGND VPWR sky130_fd_sc_hd__tapvpwrvgnd_1
XFILLER_174_1141 VGND VGND VPWR VPWR sky130_fd_sc_hd__decap_6
XFILLER_217_1425 VPWR VGND VPWR VGND sky130_ef_sc_hd__decap_12
XFILLER_253_27 VPWR VGND VPWR VGND sky130_ef_sc_hd__decap_12
XFILLER_48_1177 VPWR VGND VPWR VGND sky130_ef_sc_hd__decap_12
XFILLER_170_1005 VPWR VGND VPWR VGND sky130_ef_sc_hd__decap_12
XFILLER_32_3 VPWR VGND VPWR VGND sky130_ef_sc_hd__decap_12
XFILLER_174_1185 VPWR VGND VPWR VGND sky130_ef_sc_hd__decap_12
XFILLER_217_1469 VPWR VGND VPWR VGND sky130_ef_sc_hd__decap_12
XFILLER_61_1311 VPWR VGND VPWR VGND sky130_ef_sc_hd__decap_12
XFILLER_239_841 VPWR VGND VPWR VGND sky130_ef_sc_hd__decap_12
XFILLER_65_1491 VGND VGND VPWR VPWR sky130_fd_sc_hd__decap_6
XFILLER_170_1049 VPWR VGND VPWR VGND sky130_ef_sc_hd__decap_12
XFILLER_61_1355 VPWR VGND VPWR VGND sky130_ef_sc_hd__decap_12
XFILLER_113_1423 VPWR VGND VPWR VGND sky130_ef_sc_hd__decap_12
XFILLER_250_1073 VPWR VGND VPWR VGND sky130_ef_sc_hd__decap_12
XFILLER_254_811 VGND VGND VPWR VPWR sky130_fd_sc_hd__fill_1
XFILLER_152_1483 VPWR VGND VPWR VGND sky130_ef_sc_hd__decap_12
XTAP_TAPCELL_ROW_57_1_1192 VGND VPWR sky130_fd_sc_hd__tapvpwrvgnd_1
XFILLER_22_1339 VPWR VGND VPWR VGND sky130_ef_sc_hd__decap_12
XFILLER_187_1513 VGND VGND VPWR VPWR sky130_fd_sc_hd__fill_2
XFILLER_226_513 VPWR VGND VPWR VGND sky130_ef_sc_hd__decap_12
XFILLER_61_1399 VPWR VGND VPWR VGND sky130_ef_sc_hd__decap_12
XFILLER_96_1407 VGND VGND VPWR VPWR sky130_fd_sc_hd__decap_6
XFILLER_113_1467 VPWR VGND VPWR VGND sky130_ef_sc_hd__decap_12
XFILLER_211_1057 VGND VGND VPWR VPWR sky130_fd_sc_hd__decap_6
XFILLER_226_557 VPWR VGND VPWR VGND sky130_ef_sc_hd__decap_12
XFILLER_241_505 VPWR VGND VPWR VGND sky130_ef_sc_hd__decap_12
XFILLER_202_53 VPWR VGND VPWR VGND sky130_ef_sc_hd__decap_12
XFILLER_59_1273 VGND VGND VPWR VPWR sky130_fd_sc_hd__fill_1
XFILLER_15_18 VPWR VGND VPWR VGND sky130_ef_sc_hd__decap_12
XFILLER_181_1101 VPWR VGND VPWR VGND sky130_ef_sc_hd__decap_12
XFILLER_185_1281 VGND VGND VPWR VPWR sky130_fd_sc_hd__decap_6
XFILLER_202_97 VPWR VGND VPWR VGND sky130_ef_sc_hd__decap_12
XFILLER_178_133 VGND VGND VPWR VPWR sky130_fd_sc_hd__decap_6
XFILLER_181_1145 VPWR VGND VPWR VGND sky130_ef_sc_hd__decap_12
XFILLER_224_1429 VPWR VGND VPWR VGND sky130_ef_sc_hd__decap_12
XFILLER_210_925 VPWR VGND VPWR VGND sky130_ef_sc_hd__decap_12
XFILLER_221_273 VGND VGND VPWR VPWR sky130_fd_sc_hd__decap_6
XFILLER_72_1451 VPWR VGND VPWR VGND sky130_ef_sc_hd__decap_12
XFILLER_178_177 VPWR VGND VPWR VGND sky130_ef_sc_hd__decap_12
XFILLER_181_1189 VPWR VGND VPWR VGND sky130_ef_sc_hd__decap_12
XFILLER_194_637 VGND VGND VPWR VPWR sky130_fd_sc_hd__decap_6
XFILLER_33_1435 VGND VGND VPWR VPWR sky130_fd_sc_hd__decap_6
XFILLER_193_125 VPWR VGND VPWR VGND sky130_ef_sc_hd__decap_12
XFILLER_72_1495 VPWR VGND VPWR VGND sky130_ef_sc_hd__decap_12
XFILLER_31_39 VGND VGND VPWR VPWR sky130_fd_sc_hd__decap_4
XFILLER_33_1479 VPWR VGND VPWR VGND sky130_ef_sc_hd__decap_12
XFILLER_120_1427 VPWR VGND VPWR VGND sky130_ef_sc_hd__decap_12
XFILLER_193_169 VPWR VGND VPWR VGND sky130_ef_sc_hd__decap_12
XFILLER_222_1197 VGND VGND VPWR VPWR sky130_fd_sc_hd__decap_6
XFILLER_147_39 VPWR VGND VPWR VGND sky130_ef_sc_hd__decap_12
XFILLER_175_895 VGND VGND VPWR VPWR sky130_fd_sc_hd__fill_1
XFILLER_179_1063 VGND VGND VPWR VPWR sky130_fd_sc_hd__fill_1
XFILLER_118_1301 VGND VGND VPWR VPWR sky130_fd_sc_hd__fill_1
XFILLER_192_1241 VPWR VGND VPWR VGND sky130_ef_sc_hd__decap_12
XFILLER_27_1217 VGND VGND VPWR VPWR sky130_fd_sc_hd__fill_1
XFILLER_163_27 VPWR VGND VPWR VGND sky130_ef_sc_hd__decap_12
XTAP_TAPCELL_ROW_116_2_4453 VGND VPWR sky130_fd_sc_hd__tapvpwrvgnd_1
XFILLER_192_1285 VPWR VGND VPWR VGND sky130_ef_sc_hd__decap_12
XFILLER_243_93 VPWR VGND VPWR VGND sky130_ef_sc_hd__decap_12
XFILLER_229_373 VPWR VGND VPWR VGND sky130_ef_sc_hd__decap_12
XFILLER_245_833 VGND VGND VPWR VPWR sky130_fd_sc_hd__decap_6
XFILLER_40_1439 VPWR VGND VPWR VGND sky130_ef_sc_hd__decap_12
XTAP_TAPCELL_ROW_6_1030 VGND VPWR sky130_fd_sc_hd__tapvpwrvgnd_1
XFILLER_5_1057 VGND VGND VPWR VPWR sky130_fd_sc_hd__decap_6
XFILLER_244_321 VPWR VGND VPWR VGND sky130_ef_sc_hd__decap_12
XPHY_EDGE_ROW_174_Left_429 VGND VGND VPWR VPWR sky130_fd_sc_hd__decap_3
XFILLER_245_877 VPWR VGND VPWR VGND sky130_ef_sc_hd__decap_12
XFILLER_244_365 VPWR VGND VPWR VGND sky130_ef_sc_hd__decap_12
XTAP_TAPCELL_ROW_238_3300 VGND VPWR sky130_fd_sc_hd__tapvpwrvgnd_1
XFILLER_112_53 VPWR VGND VPWR VGND sky130_ef_sc_hd__decap_12
XTAP_TAPCELL_ROW_238_3311 VGND VPWR sky130_fd_sc_hd__tapvpwrvgnd_1
XTAP_TAPCELL_ROW_64_2_4140 VGND VPWR sky130_fd_sc_hd__tapvpwrvgnd_1
XTAP_TAPCELL_ROW_238_3322 VGND VPWR sky130_fd_sc_hd__tapvpwrvgnd_1
XFILLER_129_1441 VGND VGND VPWR VPWR sky130_fd_sc_hd__fill_1
XFILLER_213_741 VPWR VGND VPWR VGND sky130_ef_sc_hd__decap_12
XFILLER_169_111 VGND VGND VPWR VPWR sky130_fd_sc_hd__fill_1
XFILLER_38_1357 VGND VGND VPWR VPWR sky130_fd_sc_hd__fill_1
XTAP_TAPCELL_ROW_234_3208 VGND VPWR sky130_fd_sc_hd__tapvpwrvgnd_1
XFILLER_212_251 VGND VGND VPWR VPWR sky130_fd_sc_hd__fill_1
XFILLER_213_785 VPWR VGND VPWR VGND sky130_ef_sc_hd__decap_12
XFILLER_200_413 VGND VGND VPWR VPWR sky130_fd_sc_hd__decap_6
XFILLER_185_615 VGND VGND VPWR VPWR sky130_fd_sc_hd__fill_1
XFILLER_234_3 VPWR VGND VPWR VGND sky130_ef_sc_hd__decap_12
XFILLER_197_497 VGND VGND VPWR VPWR sky130_fd_sc_hd__decap_6
XFILLER_200_457 VPWR VGND VPWR VGND sky130_ef_sc_hd__decap_12
XFILLER_240_1253 VGND VGND VPWR VPWR sky130_fd_sc_hd__decap_6
XFILLER_172_309 VPWR VGND VPWR VGND sky130_ef_sc_hd__decap_12
XPHY_EDGE_ROW_183_Left_438 VGND VGND VPWR VPWR sky130_fd_sc_hd__decap_3
XFILLER_240_1297 VPWR VGND VPWR VGND sky130_ef_sc_hd__decap_12
XFILLER_165_361 VGND VGND VPWR VPWR sky130_fd_sc_hd__decap_3
XFILLER_181_821 VPWR VGND VPWR VGND sky130_ef_sc_hd__decap_12
XFILLER_4_533 VGND VGND VPWR VPWR sky130_fd_sc_hd__fill_1
XFILLER_181_865 VPWR VGND VPWR VGND sky130_ef_sc_hd__decap_12
XTAP_TAPCELL_ROW_210_2551 VGND VPWR sky130_fd_sc_hd__tapvpwrvgnd_1
XTAP_TAPCELL_ROW_210_2562 VGND VPWR sky130_fd_sc_hd__tapvpwrvgnd_1
XPHY_EDGE_ROW_126_2_Left_628 VGND VGND VPWR VPWR sky130_fd_sc_hd__decap_3
XFILLER_234_1035 VGND VGND VPWR VPWR sky130_fd_sc_hd__fill_1
XFILLER_49_1497 VGND VGND VPWR VPWR sky130_fd_sc_hd__fill_1
XFILLER_171_1325 VPWR VGND VPWR VGND sky130_ef_sc_hd__decap_12
XFILLER_239_137 VPWR VGND VPWR VGND sky130_ef_sc_hd__decap_12
XFILLER_171_1369 VPWR VGND VPWR VGND sky130_ef_sc_hd__decap_12
XFILLER_251_1393 VGND VGND VPWR VPWR sky130_fd_sc_hd__decap_6
XFILLER_236_811 VGND VGND VPWR VPWR sky130_fd_sc_hd__fill_1
XPHY_EDGE_ROW_192_Left_447 VGND VGND VPWR VPWR sky130_fd_sc_hd__decap_3
XTAP_TAPCELL_ROW_223_2901 VGND VPWR sky130_fd_sc_hd__tapvpwrvgnd_1
XFILLER_208_513 VPWR VGND VPWR VGND sky130_ef_sc_hd__decap_12
XTAP_TAPCELL_ROW_223_2912 VGND VPWR sky130_fd_sc_hd__tapvpwrvgnd_1
XFILLER_134_1191 VPWR VGND VPWR VGND sky130_ef_sc_hd__decap_12
XFILLER_248_693 VGND VGND VPWR VPWR sky130_fd_sc_hd__decap_6
XFILLER_247_181 VPWR VGND VPWR VGND sky130_ef_sc_hd__decap_12
XTAP_TAPCELL_ROW_208_2491 VGND VPWR sky130_fd_sc_hd__tapvpwrvgnd_1
XFILLER_208_557 VPWR VGND VPWR VGND sky130_ef_sc_hd__decap_12
XFILLER_223_505 VPWR VGND VPWR VGND sky130_ef_sc_hd__decap_12
XFILLER_1_1455 VGND VGND VPWR VPWR sky130_fd_sc_hd__fill_1
XFILLER_169_1287 VGND VGND VPWR VPWR sky130_fd_sc_hd__fill_1
XTAP_TAPCELL_ROW_204_2388 VGND VPWR sky130_fd_sc_hd__tapvpwrvgnd_1
XPHY_EDGE_ROW_102_1_Right_758 VGND VGND VPWR VPWR sky130_fd_sc_hd__decap_3
XFILLER_189_921 VPWR VGND VPWR VGND sky130_ef_sc_hd__decap_12
XTAP_TAPCELL_ROW_204_2399 VGND VPWR sky130_fd_sc_hd__tapvpwrvgnd_1
XFILLER_56_1413 VGND VGND VPWR VPWR sky130_fd_sc_hd__fill_1
Xmax_cap81 net82 VGND VGND VPWR VPWR net81 sky130_fd_sc_hd__clkbuf_1
Xmax_cap92 _248_ VGND VGND VPWR VPWR net92 sky130_fd_sc_hd__clkbuf_1
XFILLER_182_1421 VGND VGND VPWR VPWR sky130_fd_sc_hd__decap_6
XFILLER_250_357 VGND VGND VPWR VPWR sky130_fd_sc_hd__decap_6
XFILLER_189_965 VPWR VGND VPWR VGND sky130_ef_sc_hd__decap_12
XTAP_TAPCELL_ROW_196_2167 VGND VPWR sky130_fd_sc_hd__tapvpwrvgnd_1
XFILLER_245_1175 VGND VGND VPWR VPWR sky130_fd_sc_hd__fill_1
XFILLER_182_1465 VPWR VGND VPWR VGND sky130_ef_sc_hd__decap_12
XTAP_TAPCELL_ROW_196_2178 VGND VPWR sky130_fd_sc_hd__tapvpwrvgnd_1
XTAP_TAPCELL_ROW_196_2189 VGND VPWR sky130_fd_sc_hd__tapvpwrvgnd_1
XFILLER_188_475 VGND VGND VPWR VPWR sky130_fd_sc_hd__fill_1
XFILLER_203_273 VGND VGND VPWR VPWR sky130_fd_sc_hd__decap_6
XFILLER_176_637 VGND VGND VPWR VPWR sky130_fd_sc_hd__decap_6
XFILLER_248_27 VGND VGND VPWR VPWR sky130_fd_sc_hd__fill_1
XFILLER_175_125 VPWR VGND VPWR VGND sky130_ef_sc_hd__decap_12
XTAP_TAPCELL_ROW_217_2738 VGND VPWR sky130_fd_sc_hd__tapvpwrvgnd_1
XTAP_TAPCELL_ROW_217_2749 VGND VPWR sky130_fd_sc_hd__tapvpwrvgnd_1
XFILLER_106_1271 VPWR VGND VPWR VGND sky130_ef_sc_hd__decap_12
XFILLER_7_30 VPWR VGND VPWR VGND sky130_ef_sc_hd__decap_12
XFILLER_15_1165 VPWR VGND VPWR VGND sky130_ef_sc_hd__decap_12
XFILLER_175_169 VPWR VGND VPWR VGND sky130_ef_sc_hd__decap_12
XTAP_TAPCELL_ROW_122_2_4485 VGND VPWR sky130_fd_sc_hd__tapvpwrvgnd_1
XFILLER_191_629 VPWR VGND VPWR VGND sky130_ef_sc_hd__decap_12
XFILLER_176_1203 VGND VGND VPWR VPWR sky130_fd_sc_hd__fill_1
XFILLER_184_681 VPWR VGND VPWR VGND sky130_ef_sc_hd__decap_12
XFILLER_89_1255 VPWR VGND VPWR VGND sky130_ef_sc_hd__decap_12
Xwire280 net281 VGND VGND VPWR VPWR net280 sky130_fd_sc_hd__clkbuf_1
XFILLER_190_139 VGND VGND VPWR VPWR sky130_fd_sc_hd__fill_1
Xwire291 net292 VGND VGND VPWR VPWR net291 sky130_fd_sc_hd__clkbuf_1
XFILLER_89_1299 VPWR VGND VPWR VGND sky130_ef_sc_hd__decap_12
XTAP_TAPCELL_ROW_90_2_4296 VGND VPWR sky130_fd_sc_hd__tapvpwrvgnd_1
XFILLER_217_1233 VPWR VGND VPWR VGND sky130_ef_sc_hd__decap_12
XFILLER_213_1119 VGND VGND VPWR VPWR sky130_fd_sc_hd__fill_1
XTAP_TAPCELL_ROW_70_2_4172 VGND VPWR sky130_fd_sc_hd__tapvpwrvgnd_1
XTAP_TAPCELL_ROW_69_2_4166 VGND VPWR sky130_fd_sc_hd__tapvpwrvgnd_1
XFILLER_239_671 VGND VGND VPWR VPWR sky130_fd_sc_hd__fill_1
XFILLER_26_1283 VPWR VGND VPWR VGND sky130_ef_sc_hd__decap_12
XFILLER_113_1231 VPWR VGND VPWR VGND sky130_ef_sc_hd__decap_12
XTAP_TAPCELL_ROW_185_1871 VGND VPWR sky130_fd_sc_hd__tapvpwrvgnd_1
XPHY_EDGE_ROW_64_1_Right_720 VGND VGND VPWR VPWR sky130_fd_sc_hd__decap_3
XTAP_TAPCELL_ROW_185_1882 VGND VPWR sky130_fd_sc_hd__tapvpwrvgnd_1
XFILLER_227_833 VGND VGND VPWR VPWR sky130_fd_sc_hd__decap_6
XTAP_TAPCELL_ROW_185_1893 VGND VPWR sky130_fd_sc_hd__tapvpwrvgnd_1
XFILLER_226_321 VPWR VGND VPWR VGND sky130_ef_sc_hd__decap_12
XFILLER_230_1477 VGND VGND VPWR VPWR sky130_fd_sc_hd__decap_6
XFILLER_96_1215 VPWR VGND VPWR VGND sky130_ef_sc_hd__decap_12
XFILLER_113_1275 VPWR VGND VPWR VGND sky130_ef_sc_hd__decap_12
XTAP_TAPCELL_ROW_181_1768 VGND VPWR sky130_fd_sc_hd__tapvpwrvgnd_1
XFILLER_187_1343 VGND VGND VPWR VPWR sky130_fd_sc_hd__fill_1
XFILLER_227_877 VPWR VGND VPWR VGND sky130_ef_sc_hd__decap_12
XFILLER_226_365 VPWR VGND VPWR VGND sky130_ef_sc_hd__decap_12
XFILLER_242_825 VPWR VGND VPWR VGND sky130_ef_sc_hd__decap_12
XTAP_TAPCELL_ROW_181_1779 VGND VPWR sky130_fd_sc_hd__tapvpwrvgnd_1
XFILLER_96_1259 VPWR VGND VPWR VGND sky130_ef_sc_hd__decap_12
XFILLER_148_1327 VPWR VGND VPWR VGND sky130_ef_sc_hd__decap_12
XFILLER_199_729 VPWR VGND VPWR VGND sky130_ef_sc_hd__decap_12
XFILLER_241_335 VGND VGND VPWR VPWR sky130_fd_sc_hd__fill_1
XFILLER_242_869 VPWR VGND VPWR VGND sky130_ef_sc_hd__decap_12
XFILLER_228_1373 VPWR VGND VPWR VGND sky130_ef_sc_hd__decap_12
XFILLER_167_615 VGND VGND VPWR VPWR sky130_fd_sc_hd__fill_1
XFILLER_42_27 VGND VGND VPWR VPWR sky130_fd_sc_hd__fill_1
XFILLER_194_401 VPWR VGND VPWR VGND sky130_ef_sc_hd__decap_12
XFILLER_224_1259 VGND VGND VPWR VPWR sky130_fd_sc_hd__fill_1
XFILLER_179_497 VGND VGND VPWR VPWR sky130_fd_sc_hd__decap_6
XFILLER_158_27 VGND VGND VPWR VPWR sky130_fd_sc_hd__fill_1
XFILLER_210_755 VGND VGND VPWR VPWR sky130_fd_sc_hd__fill_1
XFILLER_194_445 VPWR VGND VPWR VGND sky130_ef_sc_hd__decap_12
XTAP_TAPCELL_ROW_42_2_4007 VGND VPWR sky130_fd_sc_hd__tapvpwrvgnd_1
XFILLER_33_1243 VPWR VGND VPWR VGND sky130_ef_sc_hd__decap_12
XFILLER_124_1371 VPWR VGND VPWR VGND sky130_ef_sc_hd__decap_12
XPHY_EDGE_ROW_124_1_Left_379 VGND VGND VPWR VPWR sky130_fd_sc_hd__decap_3
XFILLER_194_489 VPWR VGND VPWR VGND sky130_ef_sc_hd__decap_12
XFILLER_33_1287 VPWR VGND VPWR VGND sky130_ef_sc_hd__decap_12
XFILLER_159_1423 VPWR VGND VPWR VGND sky130_ef_sc_hd__decap_12
XFILLER_198_1483 VGND VGND VPWR VPWR sky130_fd_sc_hd__fill_1
XFILLER_68_1339 VPWR VGND VPWR VGND sky130_ef_sc_hd__decap_12
XFILLER_174_15 VPWR VGND VPWR VGND sky130_ef_sc_hd__decap_12
XFILLER_159_1467 VPWR VGND VPWR VGND sky130_ef_sc_hd__decap_12
XPHY_EDGE_ROW_61_1_Left_316 VGND VGND VPWR VPWR sky130_fd_sc_hd__decap_3
XFILLER_1_503 VGND VGND VPWR VPWR sky130_fd_sc_hd__fill_1
XTAP_TAPCELL_ROW_227_3001 VGND VPWR sky130_fd_sc_hd__tapvpwrvgnd_1
XTAP_TAPCELL_ROW_227_3012 VGND VPWR sky130_fd_sc_hd__tapvpwrvgnd_1
XTAP_TAPCELL_ROW_227_3023 VGND VPWR sky130_fd_sc_hd__tapvpwrvgnd_1
XFILLER_7_1119 VGND VGND VPWR VPWR sky130_fd_sc_hd__fill_1
XFILLER_192_1093 VPWR VGND VPWR VGND sky130_ef_sc_hd__decap_12
XFILLER_235_1399 VGND VGND VPWR VPWR sky130_fd_sc_hd__fill_1
XFILLER_67_57 VPWR VGND VPWR VGND sky130_ef_sc_hd__decap_12
XFILLER_40_1203 VPWR VGND VPWR VGND sky130_ef_sc_hd__decap_12
XFILLER_218_811 VGND VGND VPWR VPWR sky130_fd_sc_hd__fill_1
XFILLER_44_1383 VPWR VGND VPWR VGND sky130_ef_sc_hd__decap_12
XFILLER_131_1331 VPWR VGND VPWR VGND sky130_ef_sc_hd__decap_12
XFILLER_184_3 VPWR VGND VPWR VGND sky130_ef_sc_hd__decap_12
XFILLER_188_1129 VPWR VGND VPWR VGND sky130_ef_sc_hd__decap_12
XFILLER_40_1247 VPWR VGND VPWR VGND sky130_ef_sc_hd__decap_12
X_621_ clknet_3_4__leaf_clk dout0\[19\] _029_ VGND VGND VPWR VPWR dout0_q\[19\] sky130_fd_sc_hd__dfrtp_1
XFILLER_229_181 VPWR VGND VPWR VGND sky130_ef_sc_hd__decap_12
XFILLER_245_641 VPWR VGND VPWR VGND sky130_ef_sc_hd__decap_12
XFILLER_79_1435 VGND VGND VPWR VPWR sky130_fd_sc_hd__decap_6
XFILLER_205_505 VPWR VGND VPWR VGND sky130_ef_sc_hd__decap_12
XFILLER_245_685 VPWR VGND VPWR VGND sky130_ef_sc_hd__decap_12
X_552_ net669 VGND VGND VPWR VPWR _034_ sky130_fd_sc_hd__inv_2
XFILLER_79_1479 VPWR VGND VPWR VGND sky130_ef_sc_hd__decap_12
XFILLER_166_1427 VGND VGND VPWR VPWR sky130_fd_sc_hd__fill_1
XFILLER_189_217 VGND VGND VPWR VPWR sky130_fd_sc_hd__decap_6
XFILLER_244_195 VGND VGND VPWR VPWR sky130_fd_sc_hd__fill_1
X_483_ net98 _247_ VGND VGND VPWR VPWR acc_core.adder.cla_blocks\[3\].block.sum\[1\]
+ sky130_fd_sc_hd__nor2_1
XFILLER_232_357 VGND VGND VPWR VPWR sky130_fd_sc_hd__decap_6
XFILLER_207_1413 VPWR VGND VPWR VGND sky130_ef_sc_hd__decap_12
XFILLER_242_1315 VGND VGND VPWR VPWR sky130_fd_sc_hd__fill_1
XFILLER_38_1165 VPWR VGND VPWR VGND sky130_ef_sc_hd__decap_12
XFILLER_197_261 VPWR VGND VPWR VGND sky130_ef_sc_hd__decap_12
XFILLER_207_1457 VPWR VGND VPWR VGND sky130_ef_sc_hd__decap_12
XFILLER_200_221 VPWR VGND VPWR VGND sky130_ef_sc_hd__decap_12
XTAP_TAPCELL_ROW_191_2031 VGND VPWR sky130_fd_sc_hd__tapvpwrvgnd_1
XFILLER_199_1225 VGND VGND VPWR VPWR sky130_fd_sc_hd__decap_6
XFILLER_201_777 VGND VGND VPWR VPWR sky130_fd_sc_hd__decap_6
XFILLER_186_979 VGND VGND VPWR VPWR sky130_fd_sc_hd__fill_1
XTAP_TAPCELL_ROW_191_2042 VGND VPWR sky130_fd_sc_hd__tapvpwrvgnd_1
XFILLER_201_1001 VGND VGND VPWR VPWR sky130_fd_sc_hd__decap_6
XFILLER_51_1343 VPWR VGND VPWR VGND sky130_ef_sc_hd__decap_12
XFILLER_16_1463 VGND VGND VPWR VPWR sky130_fd_sc_hd__decap_6
XFILLER_9_669 VGND VGND VPWR VPWR sky130_fd_sc_hd__decap_3
XFILLER_103_1411 VPWR VGND VPWR VGND sky130_ef_sc_hd__decap_12
XTAP_TAPCELL_ROW_107_2_4398 VGND VPWR sky130_fd_sc_hd__tapvpwrvgnd_1
XTAP_TAPCELL_ROW_191_2053 VGND VPWR sky130_fd_sc_hd__tapvpwrvgnd_1
XFILLER_200_265 VPWR VGND VPWR VGND sky130_ef_sc_hd__decap_12
XFILLER_240_1061 VPWR VGND VPWR VGND sky130_ef_sc_hd__decap_12
XFILLER_142_1471 VPWR VGND VPWR VGND sky130_ef_sc_hd__decap_12
XFILLER_173_629 VPWR VGND VPWR VGND sky130_ef_sc_hd__decap_12
XFILLER_12_1327 VPWR VGND VPWR VGND sky130_ef_sc_hd__decap_12
XFILLER_199_1269 VPWR VGND VPWR VGND sky130_ef_sc_hd__decap_12
XFILLER_8_179 VGND VGND VPWR VPWR sky130_fd_sc_hd__fill_1
XFILLER_201_1045 VPWR VGND VPWR VGND sky130_ef_sc_hd__decap_12
XTAP_TAPCELL_ROW_212_2602 VGND VPWR sky130_fd_sc_hd__tapvpwrvgnd_1
XFILLER_51_1387 VPWR VGND VPWR VGND sky130_ef_sc_hd__decap_12
XFILLER_103_1455 VPWR VGND VPWR VGND sky130_ef_sc_hd__decap_12
XFILLER_166_681 VPWR VGND VPWR VGND sky130_ef_sc_hd__decap_12
XTAP_TAPCELL_ROW_212_2613 VGND VPWR sky130_fd_sc_hd__tapvpwrvgnd_1
XFILLER_5_831 VGND VGND VPWR VPWR sky130_fd_sc_hd__decap_6
XFILLER_172_139 VGND VGND VPWR VPWR sky130_fd_sc_hd__fill_1
XFILLER_201_1089 VPWR VGND VPWR VGND sky130_ef_sc_hd__decap_12
XFILLER_86_1439 VPWR VGND VPWR VGND sky130_ef_sc_hd__decap_12
XFILLER_103_1499 VPWR VGND VPWR VGND sky130_ef_sc_hd__decap_12
XFILLER_138_1507 VGND VGND VPWR VPWR sky130_fd_sc_hd__decap_8
XFILLER_181_673 VPWR VGND VPWR VGND sky130_ef_sc_hd__decap_12
XFILLER_5_897 VPWR VGND VPWR VGND sky130_ef_sc_hd__decap_12
XFILLER_4_363 VGND VGND VPWR VPWR sky130_fd_sc_hd__fill_1
XFILLER_253_1455 VGND VGND VPWR VPWR sky130_fd_sc_hd__fill_1
XFILLER_234_29 VPWR VGND VPWR VGND sky130_ef_sc_hd__decap_12
XFILLER_171_1133 VPWR VGND VPWR VGND sky130_ef_sc_hd__decap_12
XTAP_TAPCELL_ROW_55_2_4085 VGND VPWR sky130_fd_sc_hd__tapvpwrvgnd_1
XFILLER_171_1177 VPWR VGND VPWR VGND sky130_ef_sc_hd__decap_12
XFILLER_255_405 VPWR VGND VPWR VGND sky130_ef_sc_hd__decap_12
XFILLER_23_1423 VPWR VGND VPWR VGND sky130_ef_sc_hd__decap_12
XFILLER_62_1483 VPWR VGND VPWR VGND sky130_ef_sc_hd__decap_12
XFILLER_209_833 VGND VGND VPWR VPWR sky130_fd_sc_hd__decap_6
XFILLER_212_1141 VGND VGND VPWR VPWR sky130_fd_sc_hd__decap_6
XFILLER_255_449 VPWR VGND VPWR VGND sky130_ef_sc_hd__decap_12
XTAP_TAPCELL_ROW_206_2439 VGND VPWR sky130_fd_sc_hd__tapvpwrvgnd_1
XFILLER_208_321 VPWR VGND VPWR VGND sky130_ef_sc_hd__decap_12
XFILLER_23_1467 VPWR VGND VPWR VGND sky130_ef_sc_hd__decap_12
XFILLER_110_1415 VPWR VGND VPWR VGND sky130_ef_sc_hd__decap_12
XFILLER_212_1185 VPWR VGND VPWR VGND sky130_ef_sc_hd__decap_12
XFILLER_209_877 VPWR VGND VPWR VGND sky130_ef_sc_hd__decap_12
XFILLER_208_365 VPWR VGND VPWR VGND sky130_ef_sc_hd__decap_12
XTAP_TAPCELL_ROW_198_2218 VGND VPWR sky130_fd_sc_hd__tapvpwrvgnd_1
XFILLER_224_825 VPWR VGND VPWR VGND sky130_ef_sc_hd__decap_12
XTAP_TAPCELL_ROW_198_2229 VGND VPWR sky130_fd_sc_hd__tapvpwrvgnd_1
XFILLER_250_121 VPWR VGND VPWR VGND sky130_ef_sc_hd__decap_12
XFILLER_223_335 VGND VGND VPWR VPWR sky130_fd_sc_hd__fill_1
XFILLER_224_869 VPWR VGND VPWR VGND sky130_ef_sc_hd__decap_12
XTAP_TAPCELL_ROW_33_2_3955 VGND VPWR sky130_fd_sc_hd__tapvpwrvgnd_1
XPHY_EDGE_ROW_103_1_Right_759 VGND VGND VPWR VPWR sky130_fd_sc_hd__decap_3
XFILLER_225_1513 VGND VGND VPWR VPWR sky130_fd_sc_hd__fill_2
XFILLER_250_165 VPWR VGND VPWR VGND sky130_ef_sc_hd__decap_12
XFILLER_143_1213 VGND VGND VPWR VPWR sky130_fd_sc_hd__decap_4
XFILLER_176_401 VPWR VGND VPWR VGND sky130_ef_sc_hd__decap_12
XFILLER_182_1273 VPWR VGND VPWR VGND sky130_ef_sc_hd__decap_12
XFILLER_91_1189 VPWR VGND VPWR VGND sky130_ef_sc_hd__decap_12
XTAP_TAPCELL_ROW_13_2_3831 VGND VPWR sky130_fd_sc_hd__tapvpwrvgnd_1
XFILLER_176_445 VPWR VGND VPWR VGND sky130_ef_sc_hd__decap_12
XFILLER_192_905 VPWR VGND VPWR VGND sky130_ef_sc_hd__decap_12
XFILLER_121_1511 VGND VGND VPWR VPWR sky130_fd_sc_hd__decap_4
XFILLER_178_1309 VGND VGND VPWR VPWR sky130_fd_sc_hd__decap_6
XFILLER_223_1281 VGND VGND VPWR VPWR sky130_fd_sc_hd__decap_6
XFILLER_176_489 VPWR VGND VPWR VGND sky130_ef_sc_hd__decap_12
XFILLER_30_1427 VPWR VGND VPWR VGND sky130_ef_sc_hd__decap_12
XFILLER_192_949 VPWR VGND VPWR VGND sky130_ef_sc_hd__decap_12
XTAP_TAPCELL_ROW_174_1572 VGND VPWR sky130_fd_sc_hd__tapvpwrvgnd_1
XTAP_TAPCELL_ROW_174_1583 VGND VPWR sky130_fd_sc_hd__tapvpwrvgnd_1
XTAP_TAPCELL_ROW_174_1594 VGND VPWR sky130_fd_sc_hd__tapvpwrvgnd_1
XFILLER_208_41 VPWR VGND VPWR VGND sky130_ef_sc_hd__decap_12
XTAP_TAPCELL_ROW_170_1469 VGND VPWR sky130_fd_sc_hd__tapvpwrvgnd_1
XFILLER_171_161 VGND VGND VPWR VPWR sky130_fd_sc_hd__decap_6
XFILLER_28_1301 VGND VGND VPWR VPWR sky130_fd_sc_hd__fill_1
XFILLER_208_85 VPWR VGND VPWR VGND sky130_ef_sc_hd__decap_12
XFILLER_144_29 VPWR VGND VPWR VGND sky130_ef_sc_hd__decap_12
XTAP_TAPCELL_ROW_187_1922 VGND VPWR sky130_fd_sc_hd__tapvpwrvgnd_1
XTAP_TAPCELL_ROW_187_1933 VGND VPWR sky130_fd_sc_hd__tapvpwrvgnd_1
XFILLER_217_1063 VGND VGND VPWR VPWR sky130_fd_sc_hd__fill_1
XTAP_TAPCELL_ROW_187_1944 VGND VPWR sky130_fd_sc_hd__tapvpwrvgnd_1
XTAP_TAPCELL_ROW_183_1819 VGND VPWR sky130_fd_sc_hd__tapvpwrvgnd_1
XFILLER_150_1239 VGND VGND VPWR VPWR sky130_fd_sc_hd__decap_6
XFILLER_6_1141 VGND VGND VPWR VPWR sky130_fd_sc_hd__decap_6
XFILLER_230_1241 VPWR VGND VPWR VGND sky130_ef_sc_hd__decap_12
XFILLER_37_27 VPWR VGND VPWR VGND sky130_ef_sc_hd__decap_12
XTAP_TAPCELL_ROW_144_2_4617 VGND VPWR sky130_fd_sc_hd__tapvpwrvgnd_1
XFILLER_2_1005 VPWR VGND VPWR VGND sky130_ef_sc_hd__decap_12
XTAP_TAPCELL_ROW_99_2_4350 VGND VPWR sky130_fd_sc_hd__tapvpwrvgnd_1
XFILLER_189_1449 VGND VGND VPWR VPWR sky130_fd_sc_hd__decap_6
XFILLER_227_641 VPWR VGND VPWR VGND sky130_ef_sc_hd__decap_12
XFILLER_6_1185 VPWR VGND VPWR VGND sky130_ef_sc_hd__decap_12
XFILLER_230_1285 VPWR VGND VPWR VGND sky130_ef_sc_hd__decap_12
XPHY_EDGE_ROW_65_1_Right_721 VGND VGND VPWR VPWR sky130_fd_sc_hd__decap_3
XFILLER_2_1049 VPWR VGND VPWR VGND sky130_ef_sc_hd__decap_12
XFILLER_227_685 VPWR VGND VPWR VGND sky130_ef_sc_hd__decap_12
XFILLER_226_195 VGND VGND VPWR VPWR sky130_fd_sc_hd__fill_1
XFILLER_53_15 VPWR VGND VPWR VGND sky130_ef_sc_hd__decap_12
XFILLER_240_83 VGND VGND VPWR VPWR sky130_fd_sc_hd__fill_1
XFILLER_199_559 VGND VGND VPWR VPWR sky130_fd_sc_hd__fill_1
XFILLER_214_357 VGND VGND VPWR VPWR sky130_fd_sc_hd__decap_6
XFILLER_39_1441 VGND VGND VPWR VPWR sky130_fd_sc_hd__fill_1
XTAP_TAPCELL_ROW_99_1_1234 VGND VPWR sky130_fd_sc_hd__tapvpwrvgnd_1
XFILLER_169_15 VPWR VGND VPWR VGND sky130_ef_sc_hd__decap_12
XFILLER_242_699 VGND VGND VPWR VPWR sky130_fd_sc_hd__fill_1
XTAP_TAPCELL_ROW_113_1_1248 VGND VPWR sky130_fd_sc_hd__tapvpwrvgnd_1
XFILLER_186_209 VPWR VGND VPWR VGND sky130_ef_sc_hd__decap_12
XFILLER_179_261 VPWR VGND VPWR VGND sky130_ef_sc_hd__decap_12
XTAP_TAPCELL_ROW_92_2_4304 VGND VPWR sky130_fd_sc_hd__tapvpwrvgnd_1
XFILLER_195_721 VGND VGND VPWR VPWR sky130_fd_sc_hd__decap_6
XFILLER_168_979 VGND VGND VPWR VPWR sky130_fd_sc_hd__fill_1
XFILLER_161_1379 VGND VGND VPWR VPWR sky130_fd_sc_hd__decap_6
XFILLER_195_765 VPWR VGND VPWR VGND sky130_ef_sc_hd__decap_12
XFILLER_194_253 VPWR VGND VPWR VGND sky130_ef_sc_hd__decap_12
XFILLER_249_81 VPWR VGND VPWR VGND sky130_ef_sc_hd__decap_12
XFILLER_241_1381 VPWR VGND VPWR VGND sky130_ef_sc_hd__decap_12
XFILLER_6_606 VGND VGND VPWR VPWR sky130_fd_sc_hd__fill_1
XTAP_TAPCELL_ROW_252_3683 VGND VPWR sky130_fd_sc_hd__tapvpwrvgnd_1
XFILLER_196_1409 VPWR VGND VPWR VGND sky130_ef_sc_hd__decap_12
XTAP_TAPCELL_ROW_252_3694 VGND VPWR sky130_fd_sc_hd__tapvpwrvgnd_1
XFILLER_202_1365 VGND VGND VPWR VPWR sky130_fd_sc_hd__decap_6
XFILLER_159_1231 VPWR VGND VPWR VGND sky130_ef_sc_hd__decap_12
XFILLER_5_149 VGND VGND VPWR VPWR sky130_fd_sc_hd__decap_8
XFILLER_185_69 VPWR VGND VPWR VGND sky130_ef_sc_hd__decap_12
XFILLER_118_41 VPWR VGND VPWR VGND sky130_ef_sc_hd__decap_12
XPHY_EDGE_ROW_205_Right_50 VGND VGND VPWR VPWR sky130_fd_sc_hd__decap_3
XFILLER_159_1275 VPWR VGND VPWR VGND sky130_ef_sc_hd__decap_12
XFILLER_2_878 VPWR VGND VPWR VGND sky130_ef_sc_hd__decap_12
XFILLER_172_1453 VPWR VGND VPWR VGND sky130_ef_sc_hd__decap_12
XFILLER_238_917 VGND VGND VPWR VPWR sky130_fd_sc_hd__decap_6
XFILLER_237_405 VPWR VGND VPWR VGND sky130_ef_sc_hd__decap_12
XFILLER_172_1497 VPWR VGND VPWR VGND sky130_ef_sc_hd__decap_12
XFILLER_237_449 VPWR VGND VPWR VGND sky130_ef_sc_hd__decap_12
XFILLER_253_909 VPWR VGND VPWR VGND sky130_ef_sc_hd__decap_12
XFILLER_44_1191 VPWR VGND VPWR VGND sky130_ef_sc_hd__decap_12
XFILLER_246_961 VPWR VGND VPWR VGND sky130_ef_sc_hd__decap_12
XFILLER_252_419 VGND VGND VPWR VPWR sky130_fd_sc_hd__fill_1
X_604_ clknet_3_0__leaf_clk dout0\[2\] _012_ VGND VGND VPWR VPWR dout0_q\[2\] sky130_fd_sc_hd__dfrtp_1
XFILLER_79_1243 VPWR VGND VPWR VGND sky130_ef_sc_hd__decap_12
XFILLER_206_825 VPWR VGND VPWR VGND sky130_ef_sc_hd__decap_12
XTAP_TAPCELL_ROW_201_2303 VGND VPWR sky130_fd_sc_hd__tapvpwrvgnd_1
XTAP_TAPCELL_ROW_201_2314 VGND VPWR sky130_fd_sc_hd__tapvpwrvgnd_1
XTAP_TAPCELL_ROW_201_2325 VGND VPWR sky130_fd_sc_hd__tapvpwrvgnd_1
XFILLER_79_1287 VPWR VGND VPWR VGND sky130_ef_sc_hd__decap_12
XFILLER_205_335 VGND VGND VPWR VPWR sky130_fd_sc_hd__fill_1
XFILLER_206_869 VPWR VGND VPWR VGND sky130_ef_sc_hd__decap_12
XFILLER_232_121 VPWR VGND VPWR VGND sky130_ef_sc_hd__decap_12
X_535_ net666 VGND VGND VPWR VPWR _017_ sky130_fd_sc_hd__inv_2
XFILLER_127_1219 VPWR VGND VPWR VGND sky130_ef_sc_hd__decap_12
XFILLER_221_839 VGND VGND VPWR VPWR sky130_fd_sc_hd__fill_1
XFILLER_232_165 VPWR VGND VPWR VGND sky130_ef_sc_hd__decap_12
XTAP_TAPCELL_ROW_193_2104 VGND VPWR sky130_fd_sc_hd__tapvpwrvgnd_1
X_466_ _173_ _240_ net214 VGND VGND VPWR VPWR _241_ sky130_fd_sc_hd__a21o_1
XFILLER_198_581 VGND VGND VPWR VPWR sky130_fd_sc_hd__decap_6
XTAP_TAPCELL_ROW_157_2_4695 VGND VPWR sky130_fd_sc_hd__tapvpwrvgnd_1
XFILLER_201_541 VPWR VGND VPWR VGND sky130_ef_sc_hd__decap_12
X_397_ net585 net591 net561 VGND VGND VPWR VPWR _186_ sky130_fd_sc_hd__a21oi_1
XFILLER_207_1287 VGND VGND VPWR VPWR sky130_fd_sc_hd__fill_1
XFILLER_174_905 VPWR VGND VPWR VGND sky130_ef_sc_hd__decap_12
XFILLER_199_1033 VPWR VGND VPWR VGND sky130_ef_sc_hd__decap_12
XFILLER_201_585 VPWR VGND VPWR VGND sky130_ef_sc_hd__decap_12
XFILLER_220_1421 VGND VGND VPWR VPWR sky130_fd_sc_hd__decap_6
XFILLER_16_1271 VPWR VGND VPWR VGND sky130_ef_sc_hd__decap_12
XFILLER_174_949 VPWR VGND VPWR VGND sky130_ef_sc_hd__decap_12
XFILLER_199_1077 VPWR VGND VPWR VGND sky130_ef_sc_hd__decap_12
XFILLER_220_1465 VPWR VGND VPWR VGND sky130_ef_sc_hd__decap_12
XFILLER_64_6 VPWR VGND VPWR VGND sky130_ef_sc_hd__decap_12
XFILLER_86_1203 VPWR VGND VPWR VGND sky130_ef_sc_hd__decap_12
XFILLER_86_1247 VPWR VGND VPWR VGND sky130_ef_sc_hd__decap_12
XFILLER_138_1315 VPWR VGND VPWR VGND sky130_ef_sc_hd__decap_12
XFILLER_182_993 VPWR VGND VPWR VGND sky130_ef_sc_hd__decap_12
XFILLER_245_39 VPWR VGND VPWR VGND sky130_ef_sc_hd__decap_12
XFILLER_138_1359 VPWR VGND VPWR VGND sky130_ef_sc_hd__decap_12
XFILLER_4_193 VGND VGND VPWR VPWR sky130_fd_sc_hd__decap_3
XFILLER_4_53 VPWR VGND VPWR VGND sky130_ef_sc_hd__decap_12
XFILLER_214_1203 VGND VGND VPWR VPWR sky130_fd_sc_hd__fill_1
XTAP_TAPCELL_ROW_130_2_4536 VGND VPWR sky130_fd_sc_hd__tapvpwrvgnd_1
XFILLER_23_1231 VPWR VGND VPWR VGND sky130_ef_sc_hd__decap_12
XFILLER_209_641 VPWR VGND VPWR VGND sky130_ef_sc_hd__decap_12
XFILLER_3_1325 VPWR VGND VPWR VGND sky130_ef_sc_hd__decap_12
XFILLER_23_1275 VPWR VGND VPWR VGND sky130_ef_sc_hd__decap_12
XFILLER_247_1001 VGND VGND VPWR VPWR sky130_fd_sc_hd__decap_6
XFILLER_97_1343 VPWR VGND VPWR VGND sky130_ef_sc_hd__decap_12
XFILLER_149_1411 VPWR VGND VPWR VGND sky130_ef_sc_hd__decap_12
XFILLER_209_685 VPWR VGND VPWR VGND sky130_ef_sc_hd__decap_12
XFILLER_3_1369 VPWR VGND VPWR VGND sky130_ef_sc_hd__decap_12
XFILLER_110_1245 VGND VGND VPWR VPWR sky130_fd_sc_hd__fill_1
XTAP_TAPCELL_ROW_110_2_4412 VGND VPWR sky130_fd_sc_hd__tapvpwrvgnd_1
XFILLER_58_1327 VPWR VGND VPWR VGND sky130_ef_sc_hd__decap_12
XTAP_TAPCELL_ROW_109_2_4406 VGND VPWR sky130_fd_sc_hd__tapvpwrvgnd_1
XFILLER_247_1045 VPWR VGND VPWR VGND sky130_ef_sc_hd__decap_12
XFILLER_208_195 VGND VGND VPWR VPWR sky130_fd_sc_hd__fill_1
XFILLER_251_441 VGND VGND VPWR VPWR sky130_fd_sc_hd__decap_6
XFILLER_97_1387 VPWR VGND VPWR VGND sky130_ef_sc_hd__decap_12
XFILLER_149_1455 VPWR VGND VPWR VGND sky130_ef_sc_hd__decap_12
XFILLER_208_1029 VGND VGND VPWR VPWR sky130_fd_sc_hd__decap_6
XFILLER_247_1089 VPWR VGND VPWR VGND sky130_ef_sc_hd__decap_12
XFILLER_211_305 VPWR VGND VPWR VGND sky130_ef_sc_hd__decap_12
XFILLER_251_485 VPWR VGND VPWR VGND sky130_ef_sc_hd__decap_12
XFILLER_149_1499 VPWR VGND VPWR VGND sky130_ef_sc_hd__decap_12
XFILLER_168_209 VPWR VGND VPWR VGND sky130_ef_sc_hd__decap_12
XFILLER_224_699 VGND VGND VPWR VPWR sky130_fd_sc_hd__fill_1
XTAP_TAPCELL_ROW_77_2_4217 VGND VPWR sky130_fd_sc_hd__tapvpwrvgnd_1
XFILLER_210_53 VPWR VGND VPWR VGND sky130_ef_sc_hd__decap_12
XFILLER_177_721 VGND VGND VPWR VPWR sky130_fd_sc_hd__decap_6
XFILLER_225_1343 VGND VGND VPWR VPWR sky130_fd_sc_hd__fill_1
XFILLER_211_349 VPWR VGND VPWR VGND sky130_ef_sc_hd__decap_12
XFILLER_210_97 VPWR VGND VPWR VGND sky130_ef_sc_hd__decap_12
XTAP_TAPCELL_ROW_176_1634 VGND VPWR sky130_fd_sc_hd__tapvpwrvgnd_1
XFILLER_220_861 VGND VGND VPWR VPWR sky130_fd_sc_hd__decap_6
XTAP_TAPCELL_ROW_176_1645 VGND VPWR sky130_fd_sc_hd__tapvpwrvgnd_1
XFILLER_177_765 VPWR VGND VPWR VGND sky130_ef_sc_hd__decap_12
XFILLER_176_253 VPWR VGND VPWR VGND sky130_ef_sc_hd__decap_12
XFILLER_192_713 VPWR VGND VPWR VGND sky130_ef_sc_hd__decap_12
XFILLER_34_1371 VPWR VGND VPWR VGND sky130_ef_sc_hd__decap_12
XFILLER_165_949 VGND VGND VPWR VPWR sky130_fd_sc_hd__decap_3
XFILLER_178_1117 VPWR VGND VPWR VGND sky130_ef_sc_hd__decap_12
XFILLER_191_223 VGND VGND VPWR VPWR sky130_fd_sc_hd__fill_1
XFILLER_192_757 VPWR VGND VPWR VGND sky130_ef_sc_hd__decap_12
XFILLER_219_51 VGND VGND VPWR VPWR sky130_fd_sc_hd__decap_4
XFILLER_69_1423 VPWR VGND VPWR VGND sky130_ef_sc_hd__decap_12
XFILLER_3_609 VGND VGND VPWR VPWR sky130_fd_sc_hd__fill_2
XFILLER_121_1385 VGND VGND VPWR VPWR sky130_fd_sc_hd__fill_1
XFILLER_254_1005 VPWR VGND VPWR VGND sky130_ef_sc_hd__decap_12
XFILLER_69_1467 VPWR VGND VPWR VGND sky130_ef_sc_hd__decap_12
XFILLER_156_1415 VPWR VGND VPWR VGND sky130_ef_sc_hd__decap_12
XFILLER_155_39 VPWR VGND VPWR VGND sky130_ef_sc_hd__decap_12
XFILLER_254_1049 VPWR VGND VPWR VGND sky130_ef_sc_hd__decap_12
XFILLER_219_1169 VGND VGND VPWR VPWR sky130_fd_sc_hd__decap_6
XFILLER_8_1203 VGND VGND VPWR VPWR sky130_fd_sc_hd__fill_1
XFILLER_236_1483 VGND VGND VPWR VPWR sky130_fd_sc_hd__fill_1
XFILLER_48_15 VPWR VGND VPWR VGND sky130_ef_sc_hd__decap_12
XFILLER_219_405 VPWR VGND VPWR VGND sky130_ef_sc_hd__decap_12
XFILLER_171_27 VPWR VGND VPWR VGND sky130_ef_sc_hd__decap_12
XFILLER_189_1213 VPWR VGND VPWR VGND sky130_ef_sc_hd__decap_12
XFILLER_41_1331 VPWR VGND VPWR VGND sky130_ef_sc_hd__decap_12
XFILLER_219_449 VPWR VGND VPWR VGND sky130_ef_sc_hd__decap_12
XFILLER_235_909 VPWR VGND VPWR VGND sky130_ef_sc_hd__decap_12
XFILLER_115_1189 VPWR VGND VPWR VGND sky130_ef_sc_hd__decap_12
XFILLER_189_1257 VPWR VGND VPWR VGND sky130_ef_sc_hd__decap_12
XFILLER_228_961 VPWR VGND VPWR VGND sky130_ef_sc_hd__decap_12
XTAP_TAPCELL_ROW_241_3384 VGND VPWR sky130_fd_sc_hd__tapvpwrvgnd_1
XFILLER_234_419 VGND VGND VPWR VPWR sky130_fd_sc_hd__fill_1
XFILLER_104_65 VGND VGND VPWR VPWR sky130_fd_sc_hd__decap_6
XTAP_TAPCELL_ROW_241_3395 VGND VPWR sky130_fd_sc_hd__tapvpwrvgnd_1
XFILLER_230_1093 VPWR VGND VPWR VGND sky130_ef_sc_hd__decap_12
XFILLER_167_1511 VGND VGND VPWR VPWR sky130_fd_sc_hd__fill_1
XFILLER_251_93 VPWR VGND VPWR VGND sky130_ef_sc_hd__decap_12
XPHY_EDGE_ROW_66_1_Right_722 VGND VGND VPWR VPWR sky130_fd_sc_hd__decap_3
XFILLER_64_47 VGND VGND VPWR VPWR sky130_fd_sc_hd__fill_1
XFILLER_243_953 VPWR VGND VPWR VGND sky130_ef_sc_hd__decap_12
XFILLER_76_1427 VPWR VGND VPWR VGND sky130_ef_sc_hd__decap_12
XFILLER_214_121 VPWR VGND VPWR VGND sky130_ef_sc_hd__decap_12
XFILLER_64_69 VGND VGND VPWR VPWR sky130_fd_sc_hd__fill_2
XFILLER_214_165 VPWR VGND VPWR VGND sky130_ef_sc_hd__decap_12
XFILLER_226_1129 VPWR VGND VPWR VGND sky130_ef_sc_hd__decap_12
X_320_ _101_ _104_ VGND VGND VPWR VPWR _109_ sky130_fd_sc_hd__and2b_1
XFILLER_203_839 VGND VGND VPWR VPWR sky130_fd_sc_hd__fill_1
XFILLER_230_625 VPWR VGND VPWR VGND sky130_ef_sc_hd__decap_12
XFILLER_120_53 VPWR VGND VPWR VGND sky130_ef_sc_hd__decap_12
XFILLER_187_529 VPWR VGND VPWR VGND sky130_ef_sc_hd__decap_12
XTAP_TAPCELL_ROW_254_3734 VGND VPWR sky130_fd_sc_hd__tapvpwrvgnd_1
XTAP_TAPCELL_ROW_254_3745 VGND VPWR sky130_fd_sc_hd__tapvpwrvgnd_1
XFILLER_147_3 VPWR VGND VPWR VGND sky130_ef_sc_hd__decap_12
XTAP_TAPCELL_ROW_254_3756 VGND VPWR sky130_fd_sc_hd__tapvpwrvgnd_1
XPHY_EDGE_ROW_135_2_Left_637 VGND VGND VPWR VPWR sky130_fd_sc_hd__decap_3
XFILLER_230_669 VPWR VGND VPWR VGND sky130_ef_sc_hd__decap_12
XFILLER_204_1427 VGND VGND VPWR VPWR sky130_fd_sc_hd__fill_1
XFILLER_161_1165 VPWR VGND VPWR VGND sky130_ef_sc_hd__decap_12
XFILLER_195_573 VPWR VGND VPWR VGND sky130_ef_sc_hd__decap_12
XFILLER_13_1411 VPWR VGND VPWR VGND sky130_ef_sc_hd__decap_12
XFILLER_13_51 VGND VGND VPWR VPWR sky130_fd_sc_hd__decap_4
XFILLER_52_1471 VPWR VGND VPWR VGND sky130_ef_sc_hd__decap_12
XTAP_TAPCELL_ROW_123_2_4490 VGND VPWR sky130_fd_sc_hd__tapvpwrvgnd_1
XFILLER_196_1217 VPWR VGND VPWR VGND sky130_ef_sc_hd__decap_12
XFILLER_129_51 VGND VGND VPWR VPWR sky130_fd_sc_hd__decap_4
XFILLER_13_1455 VPWR VGND VPWR VGND sky130_ef_sc_hd__decap_12
XFILLER_182_245 VGND VGND VPWR VPWR sky130_fd_sc_hd__decap_6
XFILLER_202_1173 VPWR VGND VPWR VGND sky130_ef_sc_hd__decap_12
XFILLER_48_1507 VGND VGND VPWR VPWR sky130_fd_sc_hd__decap_8
XFILLER_13_1499 VPWR VGND VPWR VGND sky130_ef_sc_hd__decap_12
XFILLER_89_55 VGND VGND VPWR VPWR sky130_fd_sc_hd__fill_1
XFILLER_237_1225 VGND VGND VPWR VPWR sky130_fd_sc_hd__decap_6
XFILLER_182_289 VPWR VGND VPWR VGND sky130_ef_sc_hd__decap_12
XFILLER_100_1469 VGND VGND VPWR VPWR sky130_fd_sc_hd__fill_1
XFILLER_237_1269 VPWR VGND VPWR VGND sky130_ef_sc_hd__decap_12
XFILLER_133_1201 VPWR VGND VPWR VGND sky130_ef_sc_hd__decap_12
XFILLER_172_1261 VPWR VGND VPWR VGND sky130_ef_sc_hd__decap_12
XFILLER_238_725 VPWR VGND VPWR VGND sky130_ef_sc_hd__decap_12
XFILLER_81_1177 VPWR VGND VPWR VGND sky130_ef_sc_hd__decap_12
XFILLER_133_1267 VGND VGND VPWR VPWR sky130_fd_sc_hd__decap_6
XFILLER_238_769 VPWR VGND VPWR VGND sky130_ef_sc_hd__decap_12
XFILLER_237_279 VGND VGND VPWR VPWR sky130_fd_sc_hd__fill_1
XFILLER_20_1415 VPWR VGND VPWR VGND sky130_ef_sc_hd__decap_12
XPHY_EDGE_ROW_149_1_Left_404 VGND VGND VPWR VPWR sky130_fd_sc_hd__decap_3
XFILLER_0_1509 VGND VGND VPWR VPWR sky130_fd_sc_hd__decap_3
XFILLER_248_1365 VGND VGND VPWR VPWR sky130_fd_sc_hd__decap_6
XFILLER_233_441 VGND VGND VPWR VPWR sky130_fd_sc_hd__decap_6
XFILLER_244_1229 VPWR VGND VPWR VGND sky130_ef_sc_hd__decap_12
XFILLER_233_485 VPWR VGND VPWR VGND sky130_ef_sc_hd__decap_12
XPHY_EDGE_ROW_67_2_Left_569 VGND VGND VPWR VPWR sky130_fd_sc_hd__decap_3
X_518_ _265_ net75 VGND VGND VPWR VPWR acc_core.adder.cla_blocks\[7\].block.sum\[2\]
+ sky130_fd_sc_hd__xnor2_1
XFILLER_206_699 VGND VGND VPWR VPWR sky130_fd_sc_hd__fill_1
XFILLER_53_1213 VGND VGND VPWR VPWR sky130_fd_sc_hd__decap_4
X_449_ _090_ net516 net512 net82 VGND VGND VPWR VPWR _238_ sky130_fd_sc_hd__o22ai_1
XFILLER_202_861 VGND VGND VPWR VPWR sky130_fd_sc_hd__decap_6
XFILLER_92_1295 VGND VGND VPWR VPWR sky130_fd_sc_hd__decap_6
XTAP_TAPCELL_ROW_43_2_4012 VGND VPWR sky130_fd_sc_hd__tapvpwrvgnd_1
XFILLER_140_1227 VPWR VGND VPWR VGND sky130_ef_sc_hd__decap_12
XFILLER_174_713 VPWR VGND VPWR VGND sky130_ef_sc_hd__decap_12
XFILLER_31_1511 VGND VGND VPWR VPWR sky130_fd_sc_hd__decap_4
XFILLER_201_393 VPWR VGND VPWR VGND sky130_ef_sc_hd__decap_12
XFILLER_173_223 VGND VGND VPWR VPWR sky130_fd_sc_hd__fill_1
XFILLER_174_757 VPWR VGND VPWR VGND sky130_ef_sc_hd__decap_12
XFILLER_179_1437 VPWR VGND VPWR VGND sky130_ef_sc_hd__decap_12
XFILLER_220_1273 VPWR VGND VPWR VGND sky130_ef_sc_hd__decap_12
XFILLER_6_981 VPWR VGND VPWR VGND sky130_ef_sc_hd__decap_12
XFILLER_216_1309 VGND VGND VPWR VPWR sky130_fd_sc_hd__decap_6
XFILLER_255_1369 VGND VGND VPWR VPWR sky130_fd_sc_hd__decap_3
XFILLER_138_1189 VGND VGND VPWR VPWR sky130_fd_sc_hd__fill_1
XFILLER_151_1323 VGND VGND VPWR VPWR sky130_fd_sc_hd__decap_6
XTAP_TAPCELL_ROW_169_1460 VGND VPWR sky130_fd_sc_hd__tapvpwrvgnd_1
XTAP_TAPCELL_ROW_165_1302 VGND VPWR sky130_fd_sc_hd__tapvpwrvgnd_1
XTAP_TAPCELL_ROW_165_1313 VGND VPWR sky130_fd_sc_hd__tapvpwrvgnd_1
XFILLER_60_1239 VGND VGND VPWR VPWR sky130_fd_sc_hd__decap_6
XTAP_TAPCELL_ROW_165_1324 VGND VPWR sky130_fd_sc_hd__tapvpwrvgnd_1
XFILLER_151_1367 VPWR VGND VPWR VGND sky130_ef_sc_hd__decap_12
XTAP_TAPCELL_ROW_165_1335 VGND VPWR sky130_fd_sc_hd__tapvpwrvgnd_1
XFILLER_217_909 VPWR VGND VPWR VGND sky130_ef_sc_hd__decap_12
XFILLER_18_29 VPWR VGND VPWR VGND sky130_ef_sc_hd__decap_12
XTAP_TAPCELL_ROW_165_1346 VGND VPWR sky130_fd_sc_hd__tapvpwrvgnd_1
XFILLER_216_419 VGND VGND VPWR VPWR sky130_fd_sc_hd__fill_1
XFILLER_243_205 VPWR VGND VPWR VGND sky130_ef_sc_hd__decap_12
XFILLER_3_1133 VPWR VGND VPWR VGND sky130_ef_sc_hd__decap_12
XPHY_EDGE_ROW_133_1_Left_388 VGND VGND VPWR VPWR sky130_fd_sc_hd__decap_3
XFILLER_243_249 VPWR VGND VPWR VGND sky130_ef_sc_hd__decap_12
XFILLER_3_1177 VPWR VGND VPWR VGND sky130_ef_sc_hd__decap_12
XFILLER_225_953 VPWR VGND VPWR VGND sky130_ef_sc_hd__decap_12
XFILLER_240_923 VGND VGND VPWR VPWR sky130_fd_sc_hd__fill_1
XFILLER_212_625 VPWR VGND VPWR VGND sky130_ef_sc_hd__decap_12
XFILLER_227_1449 VGND VGND VPWR VPWR sky130_fd_sc_hd__decap_6
XPHY_EDGE_ROW_70_1_Left_325 VGND VGND VPWR VPWR sky130_fd_sc_hd__decap_3
XFILLER_169_529 VPWR VGND VPWR VGND sky130_ef_sc_hd__decap_12
XFILLER_211_113 VPWR VGND VPWR VGND sky130_ef_sc_hd__decap_12
XFILLER_251_293 VPWR VGND VPWR VGND sky130_ef_sc_hd__decap_12
XFILLER_180_1029 VGND VGND VPWR VPWR sky130_fd_sc_hd__decap_6
XFILLER_212_669 VPWR VGND VPWR VGND sky130_ef_sc_hd__decap_12
XFILLER_162_1463 VGND VGND VPWR VPWR sky130_fd_sc_hd__decap_6
Xwire109 _206_ VGND VGND VPWR VPWR net109 sky130_fd_sc_hd__clkbuf_1
Xclkload5 clknet_3_6__leaf_clk VGND VGND VPWR VPWR clkload5/Y sky130_fd_sc_hd__bufinv_16
XFILLER_165_713 VPWR VGND VPWR VGND sky130_ef_sc_hd__decap_12
XFILLER_177_573 VPWR VGND VPWR VGND sky130_ef_sc_hd__decap_12
XFILLER_71_1379 VGND VGND VPWR VPWR sky130_fd_sc_hd__decap_6
XFILLER_50_27 VGND VGND VPWR VPWR sky130_fd_sc_hd__fill_1
XFILLER_165_757 VPWR VGND VPWR VGND sky130_ef_sc_hd__decap_12
XFILLER_166_27 VGND VGND VPWR VPWR sky130_fd_sc_hd__fill_1
XFILLER_203_1493 VPWR VGND VPWR VGND sky130_ef_sc_hd__decap_12
XFILLER_69_1231 VPWR VGND VPWR VGND sky130_ef_sc_hd__decap_12
XTAP_TAPCELL_ROW_108_1_1243 VGND VPWR sky130_fd_sc_hd__tapvpwrvgnd_1
XFILLER_192_587 VGND VGND VPWR VPWR sky130_fd_sc_hd__fill_1
XTAP_TAPCELL_ROW_230_3085 VGND VPWR sky130_fd_sc_hd__tapvpwrvgnd_1
XFILLER_180_749 VGND VGND VPWR VPWR sky130_fd_sc_hd__decap_6
XTAP_TAPCELL_ROW_230_3096 VGND VPWR sky130_fd_sc_hd__tapvpwrvgnd_1
XFILLER_69_1275 VPWR VGND VPWR VGND sky130_ef_sc_hd__decap_12
XFILLER_234_1409 VPWR VGND VPWR VGND sky130_ef_sc_hd__decap_12
XFILLER_156_1245 VGND VGND VPWR VPWR sky130_fd_sc_hd__fill_1
XFILLER_182_15 VPWR VGND VPWR VGND sky130_ef_sc_hd__decap_12
XTAP_TAPCELL_ROW_247_3560 VGND VPWR sky130_fd_sc_hd__tapvpwrvgnd_1
XTAP_TAPCELL_ROW_56_2_4090 VGND VPWR sky130_fd_sc_hd__tapvpwrvgnd_1
XFILLER_59_69 VGND VGND VPWR VPWR sky130_fd_sc_hd__fill_2
XFILLER_191_1169 VGND VGND VPWR VPWR sky130_fd_sc_hd__decap_6
XTAP_TAPCELL_ROW_243_3435 VGND VPWR sky130_fd_sc_hd__tapvpwrvgnd_1
XTAP_TAPCELL_ROW_243_3446 VGND VPWR sky130_fd_sc_hd__tapvpwrvgnd_1
XTAP_TAPCELL_ROW_243_3457 VGND VPWR sky130_fd_sc_hd__tapvpwrvgnd_1
XFILLER_130_1407 VGND VGND VPWR VPWR sky130_fd_sc_hd__decap_6
XFILLER_189_1021 VPWR VGND VPWR VGND sky130_ef_sc_hd__decap_12
XTAP_TAPCELL_ROW_3_940 VGND VPWR sky130_fd_sc_hd__tapvpwrvgnd_1
XTAP_TAPCELL_ROW_3_951 VGND VPWR sky130_fd_sc_hd__tapvpwrvgnd_1
XFILLER_75_57 VPWR VGND VPWR VGND sky130_ef_sc_hd__decap_12
XTAP_TAPCELL_ROW_9_1094 VGND VPWR sky130_fd_sc_hd__tapvpwrvgnd_1
XFILLER_219_279 VGND VGND VPWR VPWR sky130_fd_sc_hd__fill_1
XFILLER_189_1065 VPWR VGND VPWR VGND sky130_ef_sc_hd__decap_12
XFILLER_210_1453 VPWR VGND VPWR VGND sky130_ef_sc_hd__decap_12
XFILLER_210_1497 VPWR VGND VPWR VGND sky130_ef_sc_hd__decap_12
XFILLER_245_1505 VGND VGND VPWR VPWR sky130_fd_sc_hd__decap_6
XFILLER_215_441 VGND VGND VPWR VPWR sky130_fd_sc_hd__decap_6
XPHY_EDGE_ROW_67_1_Right_723 VGND VGND VPWR VPWR sky130_fd_sc_hd__decap_3
XTAP_TAPCELL_ROW_34_2_3960 VGND VPWR sky130_fd_sc_hd__tapvpwrvgnd_1
XFILLER_128_1303 VPWR VGND VPWR VGND sky130_ef_sc_hd__decap_12
XFILLER_188_805 VGND VGND VPWR VPWR sky130_fd_sc_hd__decap_6
XFILLER_243_783 VGND VGND VPWR VPWR sky130_fd_sc_hd__fill_1
XFILLER_37_1219 VPWR VGND VPWR VGND sky130_ef_sc_hd__decap_12
XFILLER_215_485 VPWR VGND VPWR VGND sky130_ef_sc_hd__decap_12
XFILLER_231_945 VGND VGND VPWR VPWR sky130_fd_sc_hd__decap_6
XFILLER_188_849 VPWR VGND VPWR VGND sky130_ef_sc_hd__decap_12
XFILLER_230_433 VPWR VGND VPWR VGND sky130_ef_sc_hd__decap_12
X_303_ net596 dout0_q\[28\] net527 VGND VGND VPWR VPWR _092_ sky130_fd_sc_hd__and3_1
XFILLER_187_337 VPWR VGND VPWR VGND sky130_ef_sc_hd__decap_12
XFILLER_208_1371 VGND VGND VPWR VPWR sky130_fd_sc_hd__fill_1
XFILLER_231_989 VPWR VGND VPWR VGND sky130_ef_sc_hd__decap_12
XFILLER_230_477 VPWR VGND VPWR VGND sky130_ef_sc_hd__decap_12
Xwire621 net622 VGND VGND VPWR VPWR net621 sky130_fd_sc_hd__buf_1
XFILLER_196_893 VPWR VGND VPWR VGND sky130_ef_sc_hd__decap_12
Xwire632 net36 VGND VGND VPWR VPWR net632 sky130_fd_sc_hd__buf_1
Xwire643 net27 VGND VGND VPWR VPWR net643 sky130_fd_sc_hd__buf_1
XTAP_TAPCELL_ROW_26_2_3908 VGND VPWR sky130_fd_sc_hd__tapvpwrvgnd_1
Xwire654 net18 VGND VGND VPWR VPWR net654 sky130_fd_sc_hd__buf_1
XFILLER_87_1331 VPWR VGND VPWR VGND sky130_ef_sc_hd__decap_12
XFILLER_171_727 VGND VGND VPWR VPWR sky130_fd_sc_hd__fill_1
XFILLER_48_1315 VPWR VGND VPWR VGND sky130_ef_sc_hd__decap_12
XFILLER_237_1033 VPWR VGND VPWR VGND sky130_ef_sc_hd__decap_12
XFILLER_139_1443 VPWR VGND VPWR VGND sky130_ef_sc_hd__decap_12
XFILLER_83_1217 VGND VGND VPWR VPWR sky130_fd_sc_hd__fill_1
XFILLER_252_1509 VGND VGND VPWR VPWR sky130_fd_sc_hd__decap_6
XFILLER_3_951 VGND VGND VPWR VPWR sky130_fd_sc_hd__fill_1
XFILLER_48_1359 VPWR VGND VPWR VGND sky130_ef_sc_hd__decap_12
XFILLER_237_1077 VPWR VGND VPWR VGND sky130_ef_sc_hd__decap_12
XFILLER_135_1329 VGND VGND VPWR VPWR sky130_fd_sc_hd__fill_1
XFILLER_242_29 VPWR VGND VPWR VGND sky130_ef_sc_hd__decap_12
XFILLER_238_533 VPWR VGND VPWR VGND sky130_ef_sc_hd__decap_12
XFILLER_172_1091 VGND VGND VPWR VPWR sky130_fd_sc_hd__fill_1
XTAP_TAPCELL_ROW_145_2_4622 VGND VPWR sky130_fd_sc_hd__tapvpwrvgnd_1
XFILLER_253_503 VGND VGND VPWR VPWR sky130_fd_sc_hd__fill_1
XTAP_TAPCELL_ROW_226_2976 VGND VPWR sky130_fd_sc_hd__tapvpwrvgnd_1
XFILLER_225_205 VPWR VGND VPWR VGND sky130_ef_sc_hd__decap_12
XTAP_TAPCELL_ROW_226_2987 VGND VPWR sky130_fd_sc_hd__tapvpwrvgnd_1
XFILLER_168_1105 VPWR VGND VPWR VGND sky130_ef_sc_hd__decap_12
XFILLER_4_1453 VPWR VGND VPWR VGND sky130_ef_sc_hd__decap_12
XTAP_TAPCELL_ROW_226_2998 VGND VPWR sky130_fd_sc_hd__tapvpwrvgnd_1
XFILLER_59_1411 VPWR VGND VPWR VGND sky130_ef_sc_hd__decap_12
XFILLER_20_1245 VGND VGND VPWR VPWR sky130_fd_sc_hd__fill_1
XFILLER_0_1317 VPWR VGND VPWR VGND sky130_ef_sc_hd__decap_12
XFILLER_98_1471 VPWR VGND VPWR VGND sky130_ef_sc_hd__decap_12
XFILLER_168_1149 VPWR VGND VPWR VGND sky130_ef_sc_hd__decap_12
XFILLER_207_953 VPWR VGND VPWR VGND sky130_ef_sc_hd__decap_12
XFILLER_225_249 VPWR VGND VPWR VGND sky130_ef_sc_hd__decap_12
XFILLER_241_709 VPWR VGND VPWR VGND sky130_ef_sc_hd__decap_12
XFILLER_4_1497 VPWR VGND VPWR VGND sky130_ef_sc_hd__decap_12
XFILLER_59_1455 VPWR VGND VPWR VGND sky130_ef_sc_hd__decap_12
XFILLER_209_1113 VGND VGND VPWR VPWR sky130_fd_sc_hd__decap_6
XFILLER_248_1173 VPWR VGND VPWR VGND sky130_ef_sc_hd__decap_12
XFILLER_222_923 VGND VGND VPWR VPWR sky130_fd_sc_hd__fill_1
XFILLER_94_1357 VGND VGND VPWR VPWR sky130_fd_sc_hd__fill_1
XFILLER_244_1037 VPWR VGND VPWR VGND sky130_ef_sc_hd__decap_12
XFILLER_59_1499 VPWR VGND VPWR VGND sky130_ef_sc_hd__decap_12
XFILLER_209_1157 VPWR VGND VPWR VGND sky130_ef_sc_hd__decap_12
XFILLER_233_293 VPWR VGND VPWR VGND sky130_ef_sc_hd__decap_12
XFILLER_146_1469 VGND VGND VPWR VPWR sky130_fd_sc_hd__fill_1
XFILLER_193_329 VGND VGND VPWR VPWR sky130_fd_sc_hd__decap_6
XFILLER_179_1201 VPWR VGND VPWR VGND sky130_ef_sc_hd__decap_12
XFILLER_105_1177 VPWR VGND VPWR VGND sky130_ef_sc_hd__decap_12
XFILLER_179_1245 VPWR VGND VPWR VGND sky130_ef_sc_hd__decap_12
XFILLER_174_587 VGND VGND VPWR VPWR sky130_fd_sc_hd__fill_1
XFILLER_31_1385 VGND VGND VPWR VPWR sky130_fd_sc_hd__fill_1
XFILLER_179_1289 VPWR VGND VPWR VGND sky130_ef_sc_hd__decap_12
XFILLER_66_1415 VPWR VGND VPWR VGND sky130_ef_sc_hd__decap_12
XFILLER_255_1133 VPWR VGND VPWR VGND sky130_ef_sc_hd__decap_12
XFILLER_216_1117 VPWR VGND VPWR VGND sky130_ef_sc_hd__decap_12
XFILLER_255_1177 VPWR VGND VPWR VGND sky130_ef_sc_hd__decap_12
XFILLER_249_809 VPWR VGND VPWR VGND sky130_ef_sc_hd__decap_12
XFILLER_216_41 VPWR VGND VPWR VGND sky130_ef_sc_hd__decap_12
XFILLER_170_793 VPWR VGND VPWR VGND sky130_ef_sc_hd__decap_12
XTAP_TAPCELL_ROW_40_2_3992 VGND VPWR sky130_fd_sc_hd__tapvpwrvgnd_1
XFILLER_216_85 VPWR VGND VPWR VGND sky130_ef_sc_hd__decap_12
XTAP_TAPCELL_ROW_39_2_3986 VGND VPWR sky130_fd_sc_hd__tapvpwrvgnd_1
XFILLER_152_29 VPWR VGND VPWR VGND sky130_ef_sc_hd__decap_12
XFILLER_9_1397 VGND VGND VPWR VPWR sky130_fd_sc_hd__decap_3
XFILLER_99_1213 VGND VGND VPWR VPWR sky130_fd_sc_hd__decap_4
XFILLER_116_1295 VGND VGND VPWR VPWR sky130_fd_sc_hd__decap_6
XFILLER_25_1189 VPWR VGND VPWR VGND sky130_ef_sc_hd__decap_12
XFILLER_186_1205 VPWR VGND VPWR VGND sky130_ef_sc_hd__decap_12
XFILLER_244_525 VGND VGND VPWR VPWR sky130_fd_sc_hd__decap_6
XFILLER_45_27 VPWR VGND VPWR VGND sky130_ef_sc_hd__decap_12
XFILLER_77_1511 VGND VGND VPWR VPWR sky130_fd_sc_hd__decap_4
XFILLER_244_569 VPWR VGND VPWR VGND sky130_ef_sc_hd__decap_12
XFILLER_227_1213 VPWR VGND VPWR VGND sky130_ef_sc_hd__decap_12
XFILLER_225_783 VGND VGND VPWR VPWR sky130_fd_sc_hd__fill_1
XFILLER_213_945 VGND VGND VPWR VPWR sky130_fd_sc_hd__decap_6
XFILLER_227_1257 VPWR VGND VPWR VGND sky130_ef_sc_hd__decap_12
XFILLER_212_433 VPWR VGND VPWR VGND sky130_ef_sc_hd__decap_12
XFILLER_101_55 VGND VGND VPWR VPWR sky130_fd_sc_hd__fill_1
XFILLER_169_337 VPWR VGND VPWR VGND sky130_ef_sc_hd__decap_12
XFILLER_61_15 VPWR VGND VPWR VGND sky130_ef_sc_hd__decap_12
XFILLER_205_1511 VGND VGND VPWR VPWR sky130_fd_sc_hd__fill_1
XFILLER_213_989 VPWR VGND VPWR VGND sky130_ef_sc_hd__decap_12
XTAP_TAPCELL_ROW_236_3250 VGND VPWR sky130_fd_sc_hd__tapvpwrvgnd_1
XFILLER_212_477 VPWR VGND VPWR VGND sky130_ef_sc_hd__decap_12
XTAP_TAPCELL_ROW_236_3261 VGND VPWR sky130_fd_sc_hd__tapvpwrvgnd_1
XFILLER_177_15 VPWR VGND VPWR VGND sky130_ef_sc_hd__decap_12
XFILLER_184_307 VGND VGND VPWR VPWR sky130_fd_sc_hd__fill_1
XFILLER_162_1271 VPWR VGND VPWR VGND sky130_ef_sc_hd__decap_12
XFILLER_71_1165 VPWR VGND VPWR VGND sky130_ef_sc_hd__decap_12
XFILLER_178_893 VPWR VGND VPWR VGND sky130_ef_sc_hd__decap_12
XFILLER_196_189 VGND VGND VPWR VPWR sky130_fd_sc_hd__decap_6
XTAP_TAPCELL_ROW_232_3136 VGND VPWR sky130_fd_sc_hd__tapvpwrvgnd_1
XTAP_TAPCELL_ROW_12_2_3827 VGND VPWR sky130_fd_sc_hd__tapvpwrvgnd_1
XFILLER_197_1301 VPWR VGND VPWR VGND sky130_ef_sc_hd__decap_12
XTAP_TAPCELL_ROW_232_3147 VGND VPWR sky130_fd_sc_hd__tapvpwrvgnd_1
XFILLER_123_1255 VPWR VGND VPWR VGND sky130_ef_sc_hd__decap_12
XFILLER_193_841 VPWR VGND VPWR VGND sky130_ef_sc_hd__decap_12
XTAP_TAPCELL_ROW_232_3158 VGND VPWR sky130_fd_sc_hd__tapvpwrvgnd_1
XFILLER_123_1299 VPWR VGND VPWR VGND sky130_ef_sc_hd__decap_12
XFILLER_197_1345 VPWR VGND VPWR VGND sky130_ef_sc_hd__decap_12
XFILLER_4_704 VGND VGND VPWR VPWR sky130_fd_sc_hd__fill_2
XTAP_TAPCELL_ROW_249_3600 VGND VPWR sky130_fd_sc_hd__tapvpwrvgnd_1
XFILLER_180_513 VPWR VGND VPWR VGND sky130_ef_sc_hd__decap_12
XTAP_TAPCELL_ROW_249_3611 VGND VPWR sky130_fd_sc_hd__tapvpwrvgnd_1
XFILLER_3_225 VGND VGND VPWR VPWR sky130_fd_sc_hd__decap_8
XFILLER_10_1469 VGND VGND VPWR VPWR sky130_fd_sc_hd__fill_1
XFILLER_180_557 VPWR VGND VPWR VGND sky130_ef_sc_hd__decap_12
XFILLER_238_1353 VPWR VGND VPWR VGND sky130_ef_sc_hd__decap_12
XFILLER_10_41 VPWR VGND VPWR VGND sky130_ef_sc_hd__decap_12
XFILLER_3_247 VGND VGND VPWR VPWR sky130_fd_sc_hd__fill_1
XTAP_TAPCELL_ROW_245_3508 VGND VPWR sky130_fd_sc_hd__tapvpwrvgnd_1
XFILLER_193_69 VPWR VGND VPWR VGND sky130_ef_sc_hd__decap_12
XFILLER_234_1217 VPWR VGND VPWR VGND sky130_ef_sc_hd__decap_12
XFILLER_238_1397 VPWR VGND VPWR VGND sky130_ef_sc_hd__decap_12
XFILLER_126_41 VPWR VGND VPWR VGND sky130_ef_sc_hd__decap_12
XFILLER_0_910 VPWR VGND VPWR VGND sky130_ef_sc_hd__decap_12
XFILLER_43_1201 VPWR VGND VPWR VGND sky130_ef_sc_hd__decap_12
XTAP_TAPCELL_ROW_131_2_4541 VGND VPWR sky130_fd_sc_hd__tapvpwrvgnd_1
XFILLER_0_965 VPWR VGND VPWR VGND sky130_ef_sc_hd__decap_12
XFILLER_82_1283 VPWR VGND VPWR VGND sky130_ef_sc_hd__decap_12
XFILLER_134_1351 VGND VGND VPWR VPWR sky130_fd_sc_hd__decap_6
XFILLER_43_1267 VGND VGND VPWR VPWR sky130_fd_sc_hd__decap_6
XFILLER_130_1215 VPWR VGND VPWR VGND sky130_ef_sc_hd__decap_12
XFILLER_235_503 VGND VGND VPWR VPWR sky130_fd_sc_hd__fill_1
XFILLER_134_1395 VPWR VGND VPWR VGND sky130_ef_sc_hd__decap_12
XFILLER_207_205 VPWR VGND VPWR VGND sky130_ef_sc_hd__decap_12
XFILLER_247_385 VGND VGND VPWR VPWR sky130_fd_sc_hd__decap_6
XFILLER_169_1425 VPWR VGND VPWR VGND sky130_ef_sc_hd__decap_12
XFILLER_130_1259 VPWR VGND VPWR VGND sky130_ef_sc_hd__decap_12
XPHY_EDGE_ROW_130_2_Right_221 VGND VGND VPWR VPWR sky130_fd_sc_hd__decap_3
XFILLER_210_1261 VPWR VGND VPWR VGND sky130_ef_sc_hd__decap_12
XFILLER_207_249 VPWR VGND VPWR VGND sky130_ef_sc_hd__decap_12
XFILLER_169_1469 VPWR VGND VPWR VGND sky130_ef_sc_hd__decap_12
XFILLER_223_709 VPWR VGND VPWR VGND sky130_ef_sc_hd__decap_12
XTAP_TAPCELL_ROW_221_2840 VGND VPWR sky130_fd_sc_hd__tapvpwrvgnd_1
XTAP_TAPCELL_ROW_221_2851 VGND VPWR sky130_fd_sc_hd__tapvpwrvgnd_1
XFILLER_245_1313 VPWR VGND VPWR VGND sky130_ef_sc_hd__decap_12
XTAP_TAPCELL_ROW_221_2862 VGND VPWR sky130_fd_sc_hd__tapvpwrvgnd_1
XFILLER_204_923 VGND VGND VPWR VPWR sky130_fd_sc_hd__fill_1
XFILLER_249_1493 VPWR VGND VPWR VGND sky130_ef_sc_hd__decap_12
XFILLER_188_613 VPWR VGND VPWR VGND sky130_ef_sc_hd__decap_12
XPHY_EDGE_ROW_68_1_Right_724 VGND VGND VPWR VPWR sky130_fd_sc_hd__decap_3
XFILLER_245_1357 VPWR VGND VPWR VGND sky130_ef_sc_hd__decap_12
XTAP_TAPCELL_ROW_78_2_4222 VGND VPWR sky130_fd_sc_hd__tapvpwrvgnd_1
XFILLER_215_293 VPWR VGND VPWR VGND sky130_ef_sc_hd__decap_12
XFILLER_231_753 VPWR VGND VPWR VGND sky130_ef_sc_hd__decap_12
XFILLER_188_657 VPWR VGND VPWR VGND sky130_ef_sc_hd__decap_12
XFILLER_128_1177 VPWR VGND VPWR VGND sky130_ef_sc_hd__decap_12
XFILLER_231_797 VPWR VGND VPWR VGND sky130_ef_sc_hd__decap_12
XFILLER_187_167 VGND VGND VPWR VPWR sky130_fd_sc_hd__fill_1
XFILLER_141_1311 VPWR VGND VPWR VGND sky130_ef_sc_hd__decap_12
XFILLER_145_1491 VGND VGND VPWR VPWR sky130_fd_sc_hd__decap_6
XFILLER_175_329 VGND VGND VPWR VPWR sky130_fd_sc_hd__decap_6
XFILLER_180_1371 VGND VGND VPWR VPWR sky130_fd_sc_hd__fill_1
XFILLER_50_1227 VPWR VGND VPWR VGND sky130_ef_sc_hd__decap_12
XFILLER_141_1355 VPWR VGND VPWR VGND sky130_ef_sc_hd__decap_12
XTAP_TAPCELL_ROW_219_2791 VGND VPWR sky130_fd_sc_hd__tapvpwrvgnd_1
Xwire440 net441 VGND VGND VPWR VPWR net440 sky130_fd_sc_hd__clkbuf_1
Xwire451 net452 VGND VGND VPWR VPWR net451 sky130_fd_sc_hd__clkbuf_1
Xwire462 net463 VGND VGND VPWR VPWR net462 sky130_fd_sc_hd__clkbuf_1
XFILLER_102_1339 VPWR VGND VPWR VGND sky130_ef_sc_hd__decap_12
XFILLER_141_1399 VPWR VGND VPWR VGND sky130_ef_sc_hd__decap_12
Xwire473 net474 VGND VGND VPWR VPWR net473 sky130_fd_sc_hd__clkbuf_1
Xmax_cap206 _183_ VGND VGND VPWR VPWR net206 sky130_fd_sc_hd__clkbuf_1
XTAP_TAPCELL_ROW_215_2677 VGND VPWR sky130_fd_sc_hd__tapvpwrvgnd_1
Xmax_cap217 _165_ VGND VGND VPWR VPWR net217 sky130_fd_sc_hd__clkbuf_1
Xwire484 net485 VGND VGND VPWR VPWR net484 sky130_fd_sc_hd__clkbuf_1
XFILLER_167_81 VPWR VGND VPWR VGND sky130_ef_sc_hd__decap_12
XFILLER_183_373 VPWR VGND VPWR VGND sky130_ef_sc_hd__decap_12
Xwire495 _123_ VGND VGND VPWR VPWR net495 sky130_fd_sc_hd__clkbuf_1
XFILLER_176_1429 VPWR VGND VPWR VGND sky130_ef_sc_hd__decap_12
XTAP_TAPCELL_ROW_215_2688 VGND VPWR sky130_fd_sc_hd__tapvpwrvgnd_1
XTAP_TAPCELL_ROW_215_2699 VGND VPWR sky130_fd_sc_hd__tapvpwrvgnd_1
XFILLER_252_1317 VPWR VGND VPWR VGND sky130_ef_sc_hd__decap_12
XFILLER_139_1273 VGND VGND VPWR VPWR sky130_fd_sc_hd__fill_1
XFILLER_217_1437 VPWR VGND VPWR VGND sky130_ef_sc_hd__decap_12
XFILLER_253_39 VPWR VGND VPWR VGND sky130_ef_sc_hd__decap_12
XFILLER_48_1189 VGND VGND VPWR VPWR sky130_fd_sc_hd__fill_1
XFILLER_170_1017 VPWR VGND VPWR VGND sky130_ef_sc_hd__decap_12
XFILLER_174_1197 VGND VGND VPWR VPWR sky130_fd_sc_hd__decap_6
XFILLER_61_1323 VGND VGND VPWR VPWR sky130_fd_sc_hd__decap_6
XFILLER_25_3 VPWR VGND VPWR VGND sky130_ef_sc_hd__decap_12
XFILLER_239_853 VPWR VGND VPWR VGND sky130_ef_sc_hd__decap_12
XFILLER_152_1451 VPWR VGND VPWR VGND sky130_ef_sc_hd__decap_12
XFILLER_61_1367 VPWR VGND VPWR VGND sky130_ef_sc_hd__decap_12
XFILLER_113_1435 VGND VGND VPWR VPWR sky130_fd_sc_hd__decap_6
XFILLER_250_1085 VGND VGND VPWR VPWR sky130_fd_sc_hd__decap_6
XFILLER_238_363 VGND VGND VPWR VPWR sky130_fd_sc_hd__fill_1
XFILLER_239_897 VPWR VGND VPWR VGND sky130_ef_sc_hd__decap_12
XFILLER_152_1495 VPWR VGND VPWR VGND sky130_ef_sc_hd__decap_12
XTAP_TAPCELL_ROW_70_1_1205 VGND VPWR sky130_fd_sc_hd__tapvpwrvgnd_1
XFILLER_226_525 VGND VGND VPWR VPWR sky130_fd_sc_hd__decap_6
XFILLER_113_1479 VPWR VGND VPWR VGND sky130_ef_sc_hd__decap_12
XFILLER_254_867 VGND VGND VPWR VPWR sky130_fd_sc_hd__fill_1
XFILLER_4_1261 VPWR VGND VPWR VGND sky130_ef_sc_hd__decap_12
XFILLER_226_569 VPWR VGND VPWR VGND sky130_ef_sc_hd__decap_12
XFILLER_241_517 VPWR VGND VPWR VGND sky130_ef_sc_hd__decap_12
XFILLER_202_65 VPWR VGND VPWR VGND sky130_ef_sc_hd__decap_12
XFILLER_207_783 VGND VGND VPWR VPWR sky130_fd_sc_hd__fill_1
XFILLER_94_1165 VPWR VGND VPWR VGND sky130_ef_sc_hd__decap_12
XFILLER_181_1113 VGND VGND VPWR VPWR sky130_fd_sc_hd__decap_6
XFILLER_107_1217 VGND VGND VPWR VPWR sky130_fd_sc_hd__fill_1
XFILLER_181_1157 VPWR VGND VPWR VGND sky130_ef_sc_hd__decap_12
XFILLER_210_937 VPWR VGND VPWR VGND sky130_ef_sc_hd__decap_12
XFILLER_166_307 VGND VGND VPWR VPWR sky130_fd_sc_hd__fill_1
XFILLER_72_1463 VGND VGND VPWR VPWR sky130_fd_sc_hd__decap_6
XFILLER_178_189 VGND VGND VPWR VPWR sky130_fd_sc_hd__decap_6
XFILLER_175_841 VPWR VGND VPWR VGND sky130_ef_sc_hd__decap_12
XFILLER_193_137 VPWR VGND VPWR VGND sky130_ef_sc_hd__decap_12
XFILLER_120_1439 VPWR VGND VPWR VGND sky130_ef_sc_hd__decap_12
XFILLER_190_811 VGND VGND VPWR VPWR sky130_fd_sc_hd__fill_1
XFILLER_200_1441 VPWR VGND VPWR VGND sky130_ef_sc_hd__decap_12
XPHY_EDGE_ROW_30_1_Right_686 VGND VGND VPWR VPWR sky130_fd_sc_hd__decap_3
XFILLER_200_1485 VPWR VGND VPWR VGND sky130_ef_sc_hd__decap_12
XFILLER_227_51 VGND VGND VPWR VPWR sky130_fd_sc_hd__decap_4
XFILLER_66_1245 VGND VGND VPWR VPWR sky130_fd_sc_hd__fill_1
XFILLER_192_1253 VGND VGND VPWR VPWR sky130_fd_sc_hd__decap_6
XFILLER_249_617 VPWR VGND VPWR VGND sky130_ef_sc_hd__decap_12
XFILLER_163_39 VPWR VGND VPWR VGND sky130_ef_sc_hd__decap_12
XFILLER_118_1357 VGND VGND VPWR VPWR sky130_fd_sc_hd__fill_1
XFILLER_192_1297 VPWR VGND VPWR VGND sky130_ef_sc_hd__decap_12
XFILLER_9_1161 VPWR VGND VPWR VGND sky130_ef_sc_hd__decap_12
XPHY_EDGE_ROW_144_2_Left_646 VGND VGND VPWR VPWR sky130_fd_sc_hd__decap_3
XFILLER_56_15 VPWR VGND VPWR VGND sky130_ef_sc_hd__decap_12
XFILLER_40_1407 VGND VGND VPWR VPWR sky130_fd_sc_hd__decap_6
XFILLER_217_503 VGND VGND VPWR VPWR sky130_fd_sc_hd__fill_1
XTAP_TAPCELL_ROW_6_1020 VGND VPWR sky130_fd_sc_hd__tapvpwrvgnd_1
XTAP_TAPCELL_ROW_6_1031 VGND VPWR sky130_fd_sc_hd__tapvpwrvgnd_1
XFILLER_229_385 VGND VGND VPWR VPWR sky130_fd_sc_hd__decap_6
XFILLER_244_333 VPWR VGND VPWR VGND sky130_ef_sc_hd__decap_12
XFILLER_205_709 VPWR VGND VPWR VGND sky130_ef_sc_hd__decap_12
XFILLER_186_1035 VGND VGND VPWR VPWR sky130_fd_sc_hd__fill_1
XFILLER_245_889 VGND VGND VPWR VPWR sky130_fd_sc_hd__decap_6
XFILLER_244_377 VPWR VGND VPWR VGND sky130_ef_sc_hd__decap_12
XTAP_TAPCELL_ROW_238_3301 VGND VPWR sky130_fd_sc_hd__tapvpwrvgnd_1
XTAP_TAPCELL_ROW_238_3312 VGND VPWR sky130_fd_sc_hd__tapvpwrvgnd_1
XTAP_TAPCELL_ROW_64_2_4141 VGND VPWR sky130_fd_sc_hd__tapvpwrvgnd_1
XFILLER_38_1303 VPWR VGND VPWR VGND sky130_ef_sc_hd__decap_12
XFILLER_112_65 VGND VGND VPWR VPWR sky130_fd_sc_hd__decap_6
XFILLER_227_1021 VPWR VGND VPWR VGND sky130_ef_sc_hd__decap_12
XTAP_TAPCELL_ROW_238_3323 VGND VPWR sky130_fd_sc_hd__tapvpwrvgnd_1
XFILLER_77_1385 VGND VGND VPWR VPWR sky130_fd_sc_hd__fill_1
XFILLER_213_753 VPWR VGND VPWR VGND sky130_ef_sc_hd__decap_12
XFILLER_227_1065 VPWR VGND VPWR VGND sky130_ef_sc_hd__decap_12
XTAP_TAPCELL_ROW_234_3209 VGND VPWR sky130_fd_sc_hd__tapvpwrvgnd_1
XFILLER_129_1497 VGND VGND VPWR VPWR sky130_fd_sc_hd__fill_1
XFILLER_169_167 VGND VGND VPWR VPWR sky130_fd_sc_hd__fill_1
XFILLER_213_797 VPWR VGND VPWR VGND sky130_ef_sc_hd__decap_12
XFILLER_200_469 VGND VGND VPWR VPWR sky130_fd_sc_hd__decap_6
XFILLER_227_3 VPWR VGND VPWR VGND sky130_ef_sc_hd__decap_12
XFILLER_193_671 VGND VGND VPWR VPWR sky130_fd_sc_hd__fill_1
XFILLER_181_833 VGND VGND VPWR VPWR sky130_fd_sc_hd__decap_6
XFILLER_21_51 VGND VGND VPWR VPWR sky130_fd_sc_hd__decap_4
XPHY_EDGE_ROW_158_1_Left_413 VGND VGND VPWR VPWR sky130_fd_sc_hd__decap_3
XFILLER_180_321 VPWR VGND VPWR VGND sky130_ef_sc_hd__decap_12
XFILLER_197_1175 VGND VGND VPWR VPWR sky130_fd_sc_hd__fill_1
XFILLER_84_1301 VGND VGND VPWR VPWR sky130_fd_sc_hd__fill_1
XFILLER_137_51 VGND VGND VPWR VPWR sky130_fd_sc_hd__decap_4
XFILLER_181_877 VPWR VGND VPWR VGND sky130_ef_sc_hd__decap_12
XFILLER_49_1443 VPWR VGND VPWR VGND sky130_ef_sc_hd__decap_12
XFILLER_238_1161 VPWR VGND VPWR VGND sky130_ef_sc_hd__decap_12
XFILLER_180_365 VPWR VGND VPWR VGND sky130_ef_sc_hd__decap_12
XTAP_TAPCELL_ROW_210_2552 VGND VPWR sky130_fd_sc_hd__tapvpwrvgnd_1
XFILLER_136_1413 VGND VGND VPWR VPWR sky130_fd_sc_hd__fill_1
XTAP_TAPCELL_ROW_210_2563 VGND VPWR sky130_fd_sc_hd__tapvpwrvgnd_1
XFILLER_97_55 VGND VGND VPWR VPWR sky130_fd_sc_hd__fill_1
XFILLER_45_1329 VGND VGND VPWR VPWR sky130_fd_sc_hd__fill_1
XFILLER_239_105 VGND VGND VPWR VPWR sky130_fd_sc_hd__decap_6
XPHY_EDGE_ROW_76_2_Left_578 VGND VGND VPWR VPWR sky130_fd_sc_hd__decap_3
XFILLER_171_1337 VGND VGND VPWR VPWR sky130_fd_sc_hd__decap_6
XFILLER_239_149 VPWR VGND VPWR VGND sky130_ef_sc_hd__decap_12
XTAP_TAPCELL_ROW_223_2902 VGND VPWR sky130_fd_sc_hd__tapvpwrvgnd_1
XTAP_TAPCELL_ROW_223_2913 VGND VPWR sky130_fd_sc_hd__tapvpwrvgnd_1
XFILLER_208_525 VGND VGND VPWR VPWR sky130_fd_sc_hd__decap_6
XFILLER_247_193 VPWR VGND VPWR VGND sky130_ef_sc_hd__decap_12
XFILLER_1_1401 VPWR VGND VPWR VGND sky130_ef_sc_hd__decap_12
XFILLER_169_1233 VPWR VGND VPWR VGND sky130_ef_sc_hd__decap_12
XTAP_TAPCELL_ROW_208_2492 VGND VPWR sky130_fd_sc_hd__tapvpwrvgnd_1
XFILLER_236_867 VGND VGND VPWR VPWR sky130_fd_sc_hd__fill_1
XFILLER_208_569 VPWR VGND VPWR VGND sky130_ef_sc_hd__decap_12
XPHY_EDGE_ROW_131_2_Right_222 VGND VGND VPWR VPWR sky130_fd_sc_hd__decap_3
XFILLER_210_1091 VGND VGND VPWR VPWR sky130_fd_sc_hd__fill_1
XFILLER_223_517 VPWR VGND VPWR VGND sky130_ef_sc_hd__decap_12
XFILLER_95_1441 VGND VGND VPWR VPWR sky130_fd_sc_hd__fill_1
XTAP_TAPCELL_ROW_204_2389 VGND VPWR sky130_fd_sc_hd__tapvpwrvgnd_1
XFILLER_245_1121 VPWR VGND VPWR VGND sky130_ef_sc_hd__decap_12
XTAP_TAPCELL_ROW_131_1_1266 VGND VPWR sky130_fd_sc_hd__tapvpwrvgnd_1
XFILLER_189_933 VPWR VGND VPWR VGND sky130_ef_sc_hd__decap_12
Xmax_cap93 _245_ VGND VGND VPWR VPWR net93 sky130_fd_sc_hd__clkbuf_1
XFILLER_188_421 VPWR VGND VPWR VGND sky130_ef_sc_hd__decap_12
XFILLER_206_1105 VPWR VGND VPWR VGND sky130_ef_sc_hd__decap_12
XTAP_TAPCELL_ROW_196_2168 VGND VPWR sky130_fd_sc_hd__tapvpwrvgnd_1
XFILLER_241_1007 VGND VGND VPWR VPWR sky130_fd_sc_hd__fill_1
XPHY_EDGE_ROW_69_1_Right_725 VGND VGND VPWR VPWR sky130_fd_sc_hd__decap_3
XFILLER_56_1469 VGND VGND VPWR VPWR sky130_fd_sc_hd__fill_1
XFILLER_189_977 VPWR VGND VPWR VGND sky130_ef_sc_hd__decap_12
XFILLER_231_561 VPWR VGND VPWR VGND sky130_ef_sc_hd__decap_12
XTAP_TAPCELL_ROW_196_2179 VGND VPWR sky130_fd_sc_hd__tapvpwrvgnd_1
XFILLER_182_1477 VGND VGND VPWR VPWR sky130_fd_sc_hd__decap_6
XFILLER_206_1149 VPWR VGND VPWR VGND sky130_ef_sc_hd__decap_12
XTAP_TAPCELL_ROW_217_2739 VGND VPWR sky130_fd_sc_hd__tapvpwrvgnd_1
XFILLER_175_137 VPWR VGND VPWR VGND sky130_ef_sc_hd__decap_12
XFILLER_89_1201 VPWR VGND VPWR VGND sky130_ef_sc_hd__decap_12
XFILLER_106_1283 VPWR VGND VPWR VGND sky130_ef_sc_hd__decap_12
XFILLER_200_981 VPWR VGND VPWR VGND sky130_ef_sc_hd__decap_12
XFILLER_15_1177 VPWR VGND VPWR VGND sky130_ef_sc_hd__decap_12
XFILLER_8_862 VGND VGND VPWR VPWR sky130_fd_sc_hd__decap_6
XFILLER_7_42 VPWR VGND VPWR VGND sky130_ef_sc_hd__decap_12
XTAP_TAPCELL_ROW_122_2_4486 VGND VPWR sky130_fd_sc_hd__tapvpwrvgnd_1
XFILLER_172_811 VGND VGND VPWR VPWR sky130_fd_sc_hd__fill_1
Xwire270 net271 VGND VGND VPWR VPWR net270 sky130_fd_sc_hd__clkbuf_1
Xwire281 net282 VGND VGND VPWR VPWR net281 sky130_fd_sc_hd__clkbuf_1
XFILLER_89_1267 VGND VGND VPWR VPWR sky130_fd_sc_hd__decap_6
XFILLER_184_693 VGND VGND VPWR VPWR sky130_fd_sc_hd__decap_6
XFILLER_183_181 VPWR VGND VPWR VGND sky130_ef_sc_hd__decap_12
Xwire292 net293 VGND VGND VPWR VPWR net292 sky130_fd_sc_hd__clkbuf_1
XPHY_EDGE_ROW_142_1_Left_397 VGND VGND VPWR VPWR sky130_fd_sc_hd__decap_3
XTAP_TAPCELL_ROW_90_2_4297 VGND VPWR sky130_fd_sc_hd__tapvpwrvgnd_1
XFILLER_176_1259 VGND VGND VPWR VPWR sky130_fd_sc_hd__fill_1
XFILLER_217_1201 VPWR VGND VPWR VGND sky130_ef_sc_hd__decap_12
XFILLER_217_1245 VPWR VGND VPWR VGND sky130_ef_sc_hd__decap_12
XFILLER_252_1147 VGND VGND VPWR VPWR sky130_fd_sc_hd__fill_1
XFILLER_217_1289 VPWR VGND VPWR VGND sky130_ef_sc_hd__decap_12
XTAP_TAPCELL_ROW_70_2_4173 VGND VPWR sky130_fd_sc_hd__tapvpwrvgnd_1
XTAP_TAPCELL_ROW_69_2_4167 VGND VPWR sky130_fd_sc_hd__tapvpwrvgnd_1
XTAP_TAPCELL_ROW_185_1872 VGND VPWR sky130_fd_sc_hd__tapvpwrvgnd_1
XFILLER_26_1295 VGND VGND VPWR VPWR sky130_fd_sc_hd__decap_6
XFILLER_113_1243 VPWR VGND VPWR VGND sky130_ef_sc_hd__decap_12
XTAP_TAPCELL_ROW_185_1883 VGND VPWR sky130_fd_sc_hd__tapvpwrvgnd_1
XFILLER_226_333 VPWR VGND VPWR VGND sky130_ef_sc_hd__decap_12
XFILLER_96_1227 VPWR VGND VPWR VGND sky130_ef_sc_hd__decap_12
XFILLER_113_1287 VPWR VGND VPWR VGND sky130_ef_sc_hd__decap_12
XFILLER_26_29 VPWR VGND VPWR VGND sky130_ef_sc_hd__decap_12
XTAP_TAPCELL_ROW_181_1769 VGND VPWR sky130_fd_sc_hd__tapvpwrvgnd_1
XFILLER_227_889 VGND VGND VPWR VPWR sky130_fd_sc_hd__decap_6
XPHY_EDGE_ROW_5_Right_5 VGND VGND VPWR VPWR sky130_fd_sc_hd__decap_3
XFILLER_226_377 VPWR VGND VPWR VGND sky130_ef_sc_hd__decap_12
XFILLER_242_837 VPWR VGND VPWR VGND sky130_ef_sc_hd__decap_12
XFILLER_4_1091 VGND VGND VPWR VPWR sky130_fd_sc_hd__fill_1
XFILLER_148_1339 VPWR VGND VPWR VGND sky130_ef_sc_hd__decap_12
XFILLER_187_1399 VGND VGND VPWR VPWR sky130_fd_sc_hd__fill_1
XFILLER_228_1341 VPWR VGND VPWR VGND sky130_ef_sc_hd__decap_12
XFILLER_224_1205 VPWR VGND VPWR VGND sky130_ef_sc_hd__decap_12
XFILLER_210_701 VPWR VGND VPWR VGND sky130_ef_sc_hd__decap_12
XFILLER_228_1385 VPWR VGND VPWR VGND sky130_ef_sc_hd__decap_12
XFILLER_250_881 VPWR VGND VPWR VGND sky130_ef_sc_hd__decap_12
XFILLER_194_413 VGND VGND VPWR VPWR sky130_fd_sc_hd__decap_6
XFILLER_72_1271 VPWR VGND VPWR VGND sky130_ef_sc_hd__decap_12
XFILLER_194_457 VPWR VGND VPWR VGND sky130_ef_sc_hd__decap_12
XTAP_TAPCELL_ROW_42_2_4008 VGND VPWR sky130_fd_sc_hd__tapvpwrvgnd_1
XFILLER_33_1255 VPWR VGND VPWR VGND sky130_ef_sc_hd__decap_12
XFILLER_120_1203 VPWR VGND VPWR VGND sky130_ef_sc_hd__decap_12
XFILLER_124_1383 VPWR VGND VPWR VGND sky130_ef_sc_hd__decap_12
XFILLER_175_671 VGND VGND VPWR VPWR sky130_fd_sc_hd__fill_1
XFILLER_33_1299 VPWR VGND VPWR VGND sky130_ef_sc_hd__decap_12
XFILLER_120_1247 VPWR VGND VPWR VGND sky130_ef_sc_hd__decap_12
XFILLER_159_1435 VGND VGND VPWR VPWR sky130_fd_sc_hd__decap_6
XFILLER_194_1315 VGND VGND VPWR VPWR sky130_fd_sc_hd__fill_1
XFILLER_238_83 VGND VGND VPWR VPWR sky130_fd_sc_hd__fill_1
XFILLER_174_27 VGND VGND VPWR VPWR sky130_fd_sc_hd__fill_1
XPHY_EDGE_ROW_31_1_Right_687 VGND VGND VPWR VPWR sky130_fd_sc_hd__decap_3
XFILLER_159_1479 VPWR VGND VPWR VGND sky130_ef_sc_hd__decap_12
XFILLER_235_1301 VPWR VGND VPWR VGND sky130_ef_sc_hd__decap_12
XFILLER_239_1481 VPWR VGND VPWR VGND sky130_ef_sc_hd__decap_12
XTAP_TAPCELL_ROW_227_3002 VGND VPWR sky130_fd_sc_hd__tapvpwrvgnd_1
XTAP_TAPCELL_ROW_227_3013 VGND VPWR sky130_fd_sc_hd__tapvpwrvgnd_1
XFILLER_235_1345 VPWR VGND VPWR VGND sky130_ef_sc_hd__decap_12
XFILLER_192_1061 VPWR VGND VPWR VGND sky130_ef_sc_hd__decap_12
XTAP_TAPCELL_ROW_227_3024 VGND VPWR sky130_fd_sc_hd__tapvpwrvgnd_1
XFILLER_249_447 VGND VGND VPWR VPWR sky130_fd_sc_hd__fill_1
XFILLER_118_1165 VPWR VGND VPWR VGND sky130_ef_sc_hd__decap_12
XFILLER_190_15 VPWR VGND VPWR VGND sky130_ef_sc_hd__decap_12
XFILLER_237_609 VGND VGND VPWR VPWR sky130_fd_sc_hd__decap_6
XFILLER_44_1351 VGND VGND VPWR VPWR sky130_fd_sc_hd__decap_6
XFILLER_67_69 VGND VGND VPWR VPWR sky130_fd_sc_hd__fill_2
XFILLER_40_1215 VPWR VGND VPWR VGND sky130_ef_sc_hd__decap_12
XFILLER_44_1395 VPWR VGND VPWR VGND sky130_ef_sc_hd__decap_12
X_620_ clknet_3_4__leaf_clk dout0\[18\] _028_ VGND VGND VPWR VPWR dout0_q\[18\] sky130_fd_sc_hd__dfrtp_1
XFILLER_131_1343 VPWR VGND VPWR VGND sky130_ef_sc_hd__decap_12
XFILLER_40_1259 VPWR VGND VPWR VGND sky130_ef_sc_hd__decap_12
XFILLER_218_867 VGND VGND VPWR VPWR sky130_fd_sc_hd__fill_1
XFILLER_229_193 VPWR VGND VPWR VGND sky130_ef_sc_hd__decap_12
XFILLER_245_653 VPWR VGND VPWR VGND sky130_ef_sc_hd__decap_12
XFILLER_244_141 VPWR VGND VPWR VGND sky130_ef_sc_hd__decap_12
XFILLER_131_1387 VPWR VGND VPWR VGND sky130_ef_sc_hd__decap_12
XFILLER_177_3 VPWR VGND VPWR VGND sky130_ef_sc_hd__decap_12
X_551_ net669 VGND VGND VPWR VPWR _033_ sky130_fd_sc_hd__inv_2
XFILLER_205_517 VPWR VGND VPWR VGND sky130_ef_sc_hd__decap_12
XFILLER_245_697 VPWR VGND VPWR VGND sky130_ef_sc_hd__decap_12
XFILLER_83_57 VPWR VGND VPWR VGND sky130_ef_sc_hd__decap_12
XFILLER_246_1441 VPWR VGND VPWR VGND sky130_ef_sc_hd__decap_12
X_482_ net167 net327 net107 VGND VGND VPWR VPWR _247_ sky130_fd_sc_hd__and3_1
XFILLER_199_57 VPWR VGND VPWR VGND sky130_ef_sc_hd__decap_12
XFILLER_207_1425 VPWR VGND VPWR VGND sky130_ef_sc_hd__decap_12
XFILLER_246_1485 VPWR VGND VPWR VGND sky130_ef_sc_hd__decap_12
XFILLER_213_561 VPWR VGND VPWR VGND sky130_ef_sc_hd__decap_12
XFILLER_38_1177 VPWR VGND VPWR VGND sky130_ef_sc_hd__decap_12
XFILLER_186_925 VPWR VGND VPWR VGND sky130_ef_sc_hd__decap_12
XFILLER_207_1469 VPWR VGND VPWR VGND sky130_ef_sc_hd__decap_12
XFILLER_9_615 VGND VGND VPWR VPWR sky130_fd_sc_hd__fill_1
XFILLER_197_273 VGND VGND VPWR VPWR sky130_fd_sc_hd__decap_6
XFILLER_51_1311 VPWR VGND VPWR VGND sky130_ef_sc_hd__decap_12
XFILLER_200_233 VPWR VGND VPWR VGND sky130_ef_sc_hd__decap_12
XFILLER_55_1491 VGND VGND VPWR VPWR sky130_fd_sc_hd__decap_6
XFILLER_90_1371 VPWR VGND VPWR VGND sky130_ef_sc_hd__decap_12
XTAP_TAPCELL_ROW_191_2032 VGND VPWR sky130_fd_sc_hd__tapvpwrvgnd_1
XTAP_TAPCELL_ROW_191_2043 VGND VPWR sky130_fd_sc_hd__tapvpwrvgnd_1
XTAP_TAPCELL_ROW_107_2_4399 VGND VPWR sky130_fd_sc_hd__tapvpwrvgnd_1
XTAP_TAPCELL_ROW_191_2054 VGND VPWR sky130_fd_sc_hd__tapvpwrvgnd_1
XFILLER_240_1073 VPWR VGND VPWR VGND sky130_ef_sc_hd__decap_12
XFILLER_51_1355 VPWR VGND VPWR VGND sky130_ef_sc_hd__decap_12
XFILLER_103_1423 VPWR VGND VPWR VGND sky130_ef_sc_hd__decap_12
XFILLER_200_277 VPWR VGND VPWR VGND sky130_ef_sc_hd__decap_12
XFILLER_142_1483 VPWR VGND VPWR VGND sky130_ef_sc_hd__decap_12
XFILLER_12_1339 VPWR VGND VPWR VGND sky130_ef_sc_hd__decap_12
XTAP_TAPCELL_ROW_212_2603 VGND VPWR sky130_fd_sc_hd__tapvpwrvgnd_1
XFILLER_51_1399 VPWR VGND VPWR VGND sky130_ef_sc_hd__decap_12
XFILLER_166_693 VGND VGND VPWR VPWR sky130_fd_sc_hd__decap_6
XFILLER_177_1513 VGND VGND VPWR VPWR sky130_fd_sc_hd__fill_2
XFILLER_201_1057 VGND VGND VPWR VPWR sky130_fd_sc_hd__decap_6
XTAP_TAPCELL_ROW_212_2614 VGND VPWR sky130_fd_sc_hd__tapvpwrvgnd_1
XFILLER_86_1407 VGND VGND VPWR VPWR sky130_fd_sc_hd__decap_6
XFILLER_103_1467 VPWR VGND VPWR VGND sky130_ef_sc_hd__decap_12
XFILLER_165_181 VPWR VGND VPWR VGND sky130_ef_sc_hd__decap_12
XFILLER_181_641 VPWR VGND VPWR VGND sky130_ef_sc_hd__decap_12
XFILLER_253_1401 VPWR VGND VPWR VGND sky130_ef_sc_hd__decap_12
XFILLER_181_685 VPWR VGND VPWR VGND sky130_ef_sc_hd__decap_12
XFILLER_171_1101 VPWR VGND VPWR VGND sky130_ef_sc_hd__decap_12
XFILLER_49_1273 VGND VGND VPWR VPWR sky130_fd_sc_hd__fill_1
XFILLER_180_195 VGND VGND VPWR VPWR sky130_fd_sc_hd__fill_1
XFILLER_175_1281 VGND VGND VPWR VPWR sky130_fd_sc_hd__decap_6
XTAP_TAPCELL_ROW_55_2_4086 VGND VPWR sky130_fd_sc_hd__tapvpwrvgnd_1
XFILLER_171_1145 VPWR VGND VPWR VGND sky130_ef_sc_hd__decap_12
XFILLER_214_1429 VPWR VGND VPWR VGND sky130_ef_sc_hd__decap_12
XFILLER_62_1451 VPWR VGND VPWR VGND sky130_ef_sc_hd__decap_12
XFILLER_255_417 VGND VGND VPWR VPWR sky130_fd_sc_hd__decap_3
XFILLER_0_581 VGND VGND VPWR VPWR sky130_fd_sc_hd__fill_1
XFILLER_171_1189 VPWR VGND VPWR VGND sky130_ef_sc_hd__decap_12
XFILLER_23_1435 VGND VGND VPWR VPWR sky130_fd_sc_hd__decap_6
XFILLER_62_1495 VPWR VGND VPWR VGND sky130_ef_sc_hd__decap_12
XFILLER_208_333 VPWR VGND VPWR VGND sky130_ef_sc_hd__decap_12
XFILLER_250_29 VPWR VGND VPWR VGND sky130_ef_sc_hd__decap_12
XFILLER_23_1479 VPWR VGND VPWR VGND sky130_ef_sc_hd__decap_12
XFILLER_110_1427 VPWR VGND VPWR VGND sky130_ef_sc_hd__decap_12
XFILLER_212_1197 VGND VGND VPWR VPWR sky130_fd_sc_hd__decap_6
XFILLER_209_889 VGND VGND VPWR VPWR sky130_fd_sc_hd__decap_6
XTAP_TAPCELL_ROW_198_2219 VGND VPWR sky130_fd_sc_hd__tapvpwrvgnd_1
XFILLER_1_1231 VGND VGND VPWR VPWR sky130_fd_sc_hd__fill_1
XFILLER_169_1063 VGND VGND VPWR VPWR sky130_fd_sc_hd__fill_1
XFILLER_208_377 VPWR VGND VPWR VGND sky130_ef_sc_hd__decap_12
XFILLER_224_837 VPWR VGND VPWR VGND sky130_ef_sc_hd__decap_12
XPHY_EDGE_ROW_132_2_Right_223 VGND VGND VPWR VPWR sky130_fd_sc_hd__decap_3
XFILLER_250_133 VGND VGND VPWR VPWR sky130_fd_sc_hd__decap_6
XFILLER_189_741 VPWR VGND VPWR VGND sky130_ef_sc_hd__decap_12
XFILLER_108_1301 VGND VGND VPWR VPWR sky130_fd_sc_hd__fill_1
XFILLER_182_1241 VPWR VGND VPWR VGND sky130_ef_sc_hd__decap_12
XFILLER_250_177 VPWR VGND VPWR VGND sky130_ef_sc_hd__decap_12
XFILLER_232_881 VPWR VGND VPWR VGND sky130_ef_sc_hd__decap_12
XTAP_TAPCELL_ROW_65_1_1200 VGND VPWR sky130_fd_sc_hd__tapvpwrvgnd_1
XFILLER_17_1217 VGND VGND VPWR VPWR sky130_fd_sc_hd__fill_1
XFILLER_92_3 VPWR VGND VPWR VGND sky130_ef_sc_hd__decap_12
XFILLER_188_251 VGND VGND VPWR VPWR sky130_fd_sc_hd__fill_1
XFILLER_189_785 VPWR VGND VPWR VGND sky130_ef_sc_hd__decap_12
XFILLER_176_413 VGND VGND VPWR VPWR sky130_fd_sc_hd__decap_6
XFILLER_182_1285 VPWR VGND VPWR VGND sky130_ef_sc_hd__decap_12
XFILLER_231_391 VGND VGND VPWR VPWR sky130_fd_sc_hd__fill_1
XTAP_TAPCELL_ROW_13_2_3832 VGND VPWR sky130_fd_sc_hd__tapvpwrvgnd_1
XFILLER_176_457 VPWR VGND VPWR VGND sky130_ef_sc_hd__decap_12
XFILLER_192_917 VGND VGND VPWR VPWR sky130_fd_sc_hd__decap_6
XFILLER_191_405 VPWR VGND VPWR VGND sky130_ef_sc_hd__decap_12
XFILLER_30_1439 VPWR VGND VPWR VGND sky130_ef_sc_hd__decap_12
XTAP_TAPCELL_ROW_174_1573 VGND VPWR sky130_fd_sc_hd__tapvpwrvgnd_1
XFILLER_8_681 VPWR VGND VPWR VGND sky130_ef_sc_hd__decap_12
XTAP_TAPCELL_ROW_174_1584 VGND VPWR sky130_fd_sc_hd__tapvpwrvgnd_1
XFILLER_191_449 VPWR VGND VPWR VGND sky130_ef_sc_hd__decap_12
XTAP_TAPCELL_ROW_174_1595 VGND VPWR sky130_fd_sc_hd__tapvpwrvgnd_1
XFILLER_208_53 VPWR VGND VPWR VGND sky130_ef_sc_hd__decap_12
XFILLER_208_97 VPWR VGND VPWR VGND sky130_ef_sc_hd__decap_12
XFILLER_119_1441 VGND VGND VPWR VPWR sky130_fd_sc_hd__fill_1
XTAP_TAPCELL_ROW_187_1923 VGND VPWR sky130_fd_sc_hd__tapvpwrvgnd_1
XFILLER_193_1381 VPWR VGND VPWR VGND sky130_ef_sc_hd__decap_12
XTAP_TAPCELL_ROW_187_1934 VGND VPWR sky130_fd_sc_hd__tapvpwrvgnd_1
XFILLER_28_1357 VGND VGND VPWR VPWR sky130_fd_sc_hd__fill_1
XFILLER_8_1429 VPWR VGND VPWR VGND sky130_ef_sc_hd__decap_12
XTAP_TAPCELL_ROW_187_1945 VGND VPWR sky130_fd_sc_hd__tapvpwrvgnd_1
XFILLER_219_609 VGND VGND VPWR VPWR sky130_fd_sc_hd__decap_6
XFILLER_224_41 VPWR VGND VPWR VGND sky130_ef_sc_hd__decap_12
XTAP_TAPCELL_ROW_144_2_4618 VGND VPWR sky130_fd_sc_hd__tapvpwrvgnd_1
XFILLER_224_85 VPWR VGND VPWR VGND sky130_ef_sc_hd__decap_12
XFILLER_230_1253 VGND VGND VPWR VPWR sky130_fd_sc_hd__decap_6
XFILLER_37_39 VPWR VGND VPWR VGND sky130_ef_sc_hd__decap_12
XTAP_TAPCELL_ROW_99_2_4351 VGND VPWR sky130_fd_sc_hd__tapvpwrvgnd_1
XFILLER_2_1017 VPWR VGND VPWR VGND sky130_ef_sc_hd__decap_12
XFILLER_160_29 VPWR VGND VPWR VGND sky130_ef_sc_hd__decap_12
XFILLER_227_653 VPWR VGND VPWR VGND sky130_ef_sc_hd__decap_12
XFILLER_6_1197 VGND VGND VPWR VPWR sky130_fd_sc_hd__decap_6
XFILLER_226_141 VPWR VGND VPWR VGND sky130_ef_sc_hd__decap_12
XFILLER_230_1297 VPWR VGND VPWR VGND sky130_ef_sc_hd__decap_12
XFILLER_242_601 VPWR VGND VPWR VGND sky130_ef_sc_hd__decap_12
XFILLER_199_505 VPWR VGND VPWR VGND sky130_ef_sc_hd__decap_12
XFILLER_227_697 VPWR VGND VPWR VGND sky130_ef_sc_hd__decap_12
XFILLER_241_111 VGND VGND VPWR VPWR sky130_fd_sc_hd__fill_1
XFILLER_242_645 VPWR VGND VPWR VGND sky130_ef_sc_hd__decap_12
XFILLER_53_27 VPWR VGND VPWR VGND sky130_ef_sc_hd__decap_12
XFILLER_169_27 VPWR VGND VPWR VGND sky130_ef_sc_hd__decap_12
XFILLER_168_925 VPWR VGND VPWR VGND sky130_ef_sc_hd__decap_12
XFILLER_39_1497 VGND VGND VPWR VPWR sky130_fd_sc_hd__fill_1
XFILLER_224_1035 VGND VGND VPWR VPWR sky130_fd_sc_hd__fill_1
XTAP_TAPCELL_ROW_92_2_4305 VGND VPWR sky130_fd_sc_hd__tapvpwrvgnd_1
XFILLER_179_273 VGND VGND VPWR VPWR sky130_fd_sc_hd__decap_6
XFILLER_210_531 VGND VGND VPWR VPWR sky130_fd_sc_hd__fill_1
XFILLER_194_221 VPWR VGND VPWR VGND sky130_ef_sc_hd__decap_12
XFILLER_195_777 VGND VGND VPWR VPWR sky130_fd_sc_hd__decap_6
XTAP_TAPCELL_ROW_252_3684 VGND VPWR sky130_fd_sc_hd__tapvpwrvgnd_1
XFILLER_194_265 VPWR VGND VPWR VGND sky130_ef_sc_hd__decap_12
XFILLER_249_93 VPWR VGND VPWR VGND sky130_ef_sc_hd__decap_12
XFILLER_241_1393 VGND VGND VPWR VPWR sky130_fd_sc_hd__decap_6
XTAP_TAPCELL_ROW_252_3695 VGND VPWR sky130_fd_sc_hd__tapvpwrvgnd_1
XFILLER_185_15 VPWR VGND VPWR VGND sky130_ef_sc_hd__decap_12
XFILLER_124_1191 VPWR VGND VPWR VGND sky130_ef_sc_hd__decap_12
XFILLER_159_1243 VPWR VGND VPWR VGND sky130_ef_sc_hd__decap_12
XFILLER_118_53 VPWR VGND VPWR VGND sky130_ef_sc_hd__decap_12
XFILLER_2_813 VGND VGND VPWR VPWR sky130_fd_sc_hd__fill_1
XFILLER_159_1287 VPWR VGND VPWR VGND sky130_ef_sc_hd__decap_12
XPHY_EDGE_ROW_32_1_Right_688 VGND VGND VPWR VPWR sky130_fd_sc_hd__decap_3
XFILLER_46_1413 VGND VGND VPWR VPWR sky130_fd_sc_hd__fill_1
XFILLER_172_1421 VGND VGND VPWR VPWR sky130_fd_sc_hd__decap_6
XFILLER_235_1175 VGND VGND VPWR VPWR sky130_fd_sc_hd__fill_1
XFILLER_172_1465 VPWR VGND VPWR VGND sky130_ef_sc_hd__decap_12
XFILLER_134_41 VPWR VGND VPWR VGND sky130_ef_sc_hd__decap_12
XFILLER_237_417 VPWR VGND VPWR VGND sky130_ef_sc_hd__decap_12
XFILLER_246_973 VGND VGND VPWR VPWR sky130_fd_sc_hd__decap_6
X_603_ clknet_3_0__leaf_clk dout0\[1\] _011_ VGND VGND VPWR VPWR dout0_q\[1\] sky130_fd_sc_hd__dfrtp_1
XFILLER_245_461 VPWR VGND VPWR VGND sky130_ef_sc_hd__decap_12
XFILLER_79_1255 VPWR VGND VPWR VGND sky130_ef_sc_hd__decap_12
XPHY_EDGE_ROW_107_2_Left_609 VGND VGND VPWR VPWR sky130_fd_sc_hd__decap_3
XFILLER_166_1203 VGND VGND VPWR VPWR sky130_fd_sc_hd__fill_1
XTAP_TAPCELL_ROW_201_2304 VGND VPWR sky130_fd_sc_hd__tapvpwrvgnd_1
XFILLER_206_837 VPWR VGND VPWR VGND sky130_ef_sc_hd__decap_12
XTAP_TAPCELL_ROW_201_2315 VGND VPWR sky130_fd_sc_hd__tapvpwrvgnd_1
X_534_ net665 VGND VGND VPWR VPWR _016_ sky130_fd_sc_hd__inv_2
XTAP_TAPCELL_ROW_1_890 VGND VPWR sky130_fd_sc_hd__tapvpwrvgnd_1
XFILLER_79_1299 VPWR VGND VPWR VGND sky130_ef_sc_hd__decap_12
XFILLER_232_133 VGND VGND VPWR VPWR sky130_fd_sc_hd__decap_6
X_465_ _180_ _199_ _176_ VGND VGND VPWR VPWR _240_ sky130_fd_sc_hd__a21o_1
XTAP_TAPCELL_ROW_193_2105 VGND VPWR sky130_fd_sc_hd__tapvpwrvgnd_1
XFILLER_207_1233 VPWR VGND VPWR VGND sky130_ef_sc_hd__decap_12
XFILLER_214_881 VPWR VGND VPWR VGND sky130_ef_sc_hd__decap_12
XFILLER_232_177 VPWR VGND VPWR VGND sky130_ef_sc_hd__decap_12
XTAP_TAPCELL_ROW_157_2_4696 VGND VPWR sky130_fd_sc_hd__tapvpwrvgnd_1
XFILLER_213_391 VGND VGND VPWR VPWR sky130_fd_sc_hd__fill_1
X_396_ _183_ _184_ VGND VGND VPWR VPWR _185_ sky130_fd_sc_hd__nand2b_1
XFILLER_186_755 VGND VGND VPWR VPWR sky130_fd_sc_hd__fill_1
XFILLER_199_1001 VGND VGND VPWR VPWR sky130_fd_sc_hd__decap_6
XFILLER_201_553 VGND VGND VPWR VPWR sky130_fd_sc_hd__decap_6
XFILLER_203_1119 VGND VGND VPWR VPWR sky130_fd_sc_hd__fill_1
XFILLER_174_917 VGND VGND VPWR VPWR sky130_fd_sc_hd__decap_6
XFILLER_173_405 VPWR VGND VPWR VGND sky130_ef_sc_hd__decap_12
XFILLER_199_1045 VPWR VGND VPWR VGND sky130_ef_sc_hd__decap_12
XFILLER_201_597 VPWR VGND VPWR VGND sky130_ef_sc_hd__decap_12
XFILLER_16_1283 VPWR VGND VPWR VGND sky130_ef_sc_hd__decap_12
XFILLER_103_1231 VPWR VGND VPWR VGND sky130_ef_sc_hd__decap_12
XTAP_TAPCELL_ROW_126_1_1261 VGND VPWR sky130_fd_sc_hd__tapvpwrvgnd_1
XFILLER_173_449 VPWR VGND VPWR VGND sky130_ef_sc_hd__decap_12
XFILLER_199_1089 VPWR VGND VPWR VGND sky130_ef_sc_hd__decap_12
XFILLER_220_1477 VGND VGND VPWR VPWR sky130_fd_sc_hd__decap_6
XFILLER_86_1215 VPWR VGND VPWR VGND sky130_ef_sc_hd__decap_12
XFILLER_103_1275 VPWR VGND VPWR VGND sky130_ef_sc_hd__decap_12
XFILLER_182_961 VPWR VGND VPWR VGND sky130_ef_sc_hd__decap_12
XFILLER_177_1343 VGND VGND VPWR VPWR sky130_fd_sc_hd__fill_1
XFILLER_5_651 VPWR VGND VPWR VGND sky130_ef_sc_hd__decap_12
XFILLER_5_673 VGND VGND VPWR VPWR sky130_fd_sc_hd__fill_1
XFILLER_86_1259 VPWR VGND VPWR VGND sky130_ef_sc_hd__decap_12
XFILLER_5_684 VGND VGND VPWR VPWR sky130_fd_sc_hd__fill_1
XFILLER_138_1327 VPWR VGND VPWR VGND sky130_ef_sc_hd__decap_12
XFILLER_175_81 VPWR VGND VPWR VGND sky130_ef_sc_hd__decap_12
XFILLER_253_1231 VGND VGND VPWR VPWR sky130_fd_sc_hd__fill_1
XFILLER_4_65 VPWR VGND VPWR VGND sky130_ef_sc_hd__decap_12
XFILLER_218_1373 VPWR VGND VPWR VGND sky130_ef_sc_hd__decap_12
XFILLER_214_1259 VGND VGND VPWR VPWR sky130_fd_sc_hd__fill_1
XTAP_TAPCELL_ROW_130_2_4537 VGND VPWR sky130_fd_sc_hd__tapvpwrvgnd_1
XFILLER_255_225 VPWR VGND VPWR VGND sky130_ef_sc_hd__decap_12
XFILLER_23_1243 VPWR VGND VPWR VGND sky130_ef_sc_hd__decap_12
XFILLER_237_951 VGND VGND VPWR VPWR sky130_fd_sc_hd__fill_1
XFILLER_97_1311 VPWR VGND VPWR VGND sky130_ef_sc_hd__decap_12
XFILLER_114_1371 VPWR VGND VPWR VGND sky130_ef_sc_hd__decap_12
XFILLER_209_653 VPWR VGND VPWR VGND sky130_ef_sc_hd__decap_12
XFILLER_3_1337 VGND VGND VPWR VPWR sky130_fd_sc_hd__decap_6
XFILLER_208_141 VPWR VGND VPWR VGND sky130_ef_sc_hd__decap_12
XFILLER_23_1287 VPWR VGND VPWR VGND sky130_ef_sc_hd__decap_12
XFILLER_224_601 VPWR VGND VPWR VGND sky130_ef_sc_hd__decap_12
XFILLER_97_1355 VPWR VGND VPWR VGND sky130_ef_sc_hd__decap_12
XTAP_TAPCELL_ROW_110_2_4413 VGND VPWR sky130_fd_sc_hd__tapvpwrvgnd_1
XFILLER_149_1423 VPWR VGND VPWR VGND sky130_ef_sc_hd__decap_12
XFILLER_209_697 VPWR VGND VPWR VGND sky130_ef_sc_hd__decap_12
XFILLER_188_1483 VGND VGND VPWR VPWR sky130_fd_sc_hd__fill_1
XTAP_TAPCELL_ROW_109_2_4407 VGND VPWR sky130_fd_sc_hd__tapvpwrvgnd_1
XFILLER_223_111 VGND VGND VPWR VPWR sky130_fd_sc_hd__fill_1
XFILLER_224_645 VPWR VGND VPWR VGND sky130_ef_sc_hd__decap_12
XFILLER_58_1339 VPWR VGND VPWR VGND sky130_ef_sc_hd__decap_12
XFILLER_93_1219 VPWR VGND VPWR VGND sky130_ef_sc_hd__decap_12
XFILLER_247_1057 VGND VGND VPWR VPWR sky130_fd_sc_hd__decap_6
XFILLER_97_1399 VPWR VGND VPWR VGND sky130_ef_sc_hd__decap_12
XFILLER_149_1467 VPWR VGND VPWR VGND sky130_ef_sc_hd__decap_12
XPHY_EDGE_ROW_133_2_Right_224 VGND VGND VPWR VPWR sky130_fd_sc_hd__decap_3
XFILLER_211_317 VPWR VGND VPWR VGND sky130_ef_sc_hd__decap_12
XFILLER_251_497 VGND VGND VPWR VPWR sky130_fd_sc_hd__decap_6
XTAP_TAPCELL_ROW_77_2_4218 VGND VPWR sky130_fd_sc_hd__tapvpwrvgnd_1
XFILLER_210_65 VPWR VGND VPWR VGND sky130_ef_sc_hd__decap_12
XTAP_TAPCELL_ROW_176_1624 VGND VPWR sky130_fd_sc_hd__tapvpwrvgnd_1
XFILLER_176_221 VPWR VGND VPWR VGND sky130_ef_sc_hd__decap_12
XTAP_TAPCELL_ROW_176_1635 VGND VPWR sky130_fd_sc_hd__tapvpwrvgnd_1
XFILLER_182_1093 VPWR VGND VPWR VGND sky130_ef_sc_hd__decap_12
XTAP_TAPCELL_ROW_176_1646 VGND VPWR sky130_fd_sc_hd__tapvpwrvgnd_1
XFILLER_225_1399 VGND VGND VPWR VPWR sky130_fd_sc_hd__fill_1
XFILLER_177_777 VGND VGND VPWR VPWR sky130_fd_sc_hd__decap_6
XFILLER_176_265 VPWR VGND VPWR VGND sky130_ef_sc_hd__decap_12
XFILLER_30_1203 VPWR VGND VPWR VGND sky130_ef_sc_hd__decap_12
XPHY_EDGE_ROW_153_2_Left_655 VGND VGND VPWR VPWR sky130_fd_sc_hd__decap_3
XFILLER_192_725 VPWR VGND VPWR VGND sky130_ef_sc_hd__decap_12
XFILLER_34_1383 VPWR VGND VPWR VGND sky130_ef_sc_hd__decap_12
XFILLER_121_1331 VPWR VGND VPWR VGND sky130_ef_sc_hd__decap_12
XFILLER_178_1129 VPWR VGND VPWR VGND sky130_ef_sc_hd__decap_12
XFILLER_30_1247 VPWR VGND VPWR VGND sky130_ef_sc_hd__decap_12
XFILLER_192_769 VPWR VGND VPWR VGND sky130_ef_sc_hd__decap_12
XFILLER_69_1435 VGND VGND VPWR VPWR sky130_fd_sc_hd__decap_6
XFILLER_191_279 VGND VGND VPWR VPWR sky130_fd_sc_hd__fill_1
XFILLER_2_109 VPWR VGND VPWR VGND sky130_ef_sc_hd__decap_12
XFILLER_254_1017 VPWR VGND VPWR VGND sky130_ef_sc_hd__decap_12
XFILLER_69_1479 VPWR VGND VPWR VGND sky130_ef_sc_hd__decap_12
XFILLER_156_1427 VPWR VGND VPWR VGND sky130_ef_sc_hd__decap_12
XFILLER_235_51 VGND VGND VPWR VPWR sky130_fd_sc_hd__decap_4
XFILLER_232_1315 VGND VGND VPWR VPWR sky130_fd_sc_hd__fill_1
XFILLER_48_27 VGND VGND VPWR VPWR sky130_fd_sc_hd__fill_1
XFILLER_28_1165 VPWR VGND VPWR VGND sky130_ef_sc_hd__decap_12
XFILLER_8_1259 VGND VGND VPWR VPWR sky130_fd_sc_hd__fill_1
XFILLER_219_417 VPWR VGND VPWR VGND sky130_ef_sc_hd__decap_12
XFILLER_171_39 VPWR VGND VPWR VGND sky130_ef_sc_hd__decap_12
XFILLER_189_1225 VGND VGND VPWR VPWR sky130_fd_sc_hd__decap_6
XFILLER_41_1343 VPWR VGND VPWR VGND sky130_ef_sc_hd__decap_12
XFILLER_132_1471 VPWR VGND VPWR VGND sky130_ef_sc_hd__decap_12
XFILLER_230_1061 VPWR VGND VPWR VGND sky130_ef_sc_hd__decap_12
XFILLER_228_973 VGND VGND VPWR VPWR sky130_fd_sc_hd__decap_6
XFILLER_189_1269 VPWR VGND VPWR VGND sky130_ef_sc_hd__decap_12
XTAP_TAPCELL_ROW_241_3385 VGND VPWR sky130_fd_sc_hd__tapvpwrvgnd_1
XFILLER_227_461 VPWR VGND VPWR VGND sky130_ef_sc_hd__decap_12
XFILLER_255_781 VGND VGND VPWR VPWR sky130_fd_sc_hd__decap_3
XFILLER_243_921 VPWR VGND VPWR VGND sky130_ef_sc_hd__decap_12
XTAP_TAPCELL_ROW_241_3396 VGND VPWR sky130_fd_sc_hd__tapvpwrvgnd_1
XFILLER_64_26 VGND VGND VPWR VPWR sky130_fd_sc_hd__fill_2
XFILLER_41_1387 VPWR VGND VPWR VGND sky130_ef_sc_hd__decap_12
XPHY_EDGE_ROW_6_Left_262 VGND VGND VPWR VPWR sky130_fd_sc_hd__decap_3
XFILLER_243_965 VPWR VGND VPWR VGND sky130_ef_sc_hd__decap_12
XFILLER_76_1439 VPWR VGND VPWR VGND sky130_ef_sc_hd__decap_12
XFILLER_128_1507 VGND VGND VPWR VPWR sky130_fd_sc_hd__decap_8
XFILLER_214_133 VGND VGND VPWR VPWR sky130_fd_sc_hd__decap_6
XFILLER_199_335 VGND VGND VPWR VPWR sky130_fd_sc_hd__fill_1
XFILLER_242_475 VGND VGND VPWR VPWR sky130_fd_sc_hd__fill_1
XFILLER_214_177 VPWR VGND VPWR VGND sky130_ef_sc_hd__decap_12
XFILLER_230_637 VGND VGND VPWR VPWR sky130_fd_sc_hd__decap_6
XTAP_TAPCELL_ROW_254_3735 VGND VPWR sky130_fd_sc_hd__tapvpwrvgnd_1
XFILLER_120_65 VGND VGND VPWR VPWR sky130_fd_sc_hd__decap_6
XTAP_TAPCELL_ROW_254_3746 VGND VPWR sky130_fd_sc_hd__tapvpwrvgnd_1
XFILLER_243_1455 VGND VGND VPWR VPWR sky130_fd_sc_hd__fill_1
XFILLER_168_755 VGND VGND VPWR VPWR sky130_fd_sc_hd__fill_1
XFILLER_195_541 VPWR VGND VPWR VGND sky130_ef_sc_hd__decap_12
XPHY_EDGE_ROW_85_2_Left_587 VGND VGND VPWR VPWR sky130_fd_sc_hd__decap_3
XFILLER_211_895 VGND VGND VPWR VPWR sky130_fd_sc_hd__fill_1
XFILLER_161_1177 VPWR VGND VPWR VGND sky130_ef_sc_hd__decap_12
XFILLER_195_585 VPWR VGND VPWR VGND sky130_ef_sc_hd__decap_12
XFILLER_13_1423 VPWR VGND VPWR VGND sky130_ef_sc_hd__decap_12
XTAP_TAPCELL_ROW_123_2_4491 VGND VPWR sky130_fd_sc_hd__tapvpwrvgnd_1
XFILLER_52_1483 VPWR VGND VPWR VGND sky130_ef_sc_hd__decap_12
XFILLER_202_1141 VGND VGND VPWR VPWR sky130_fd_sc_hd__decap_6
XFILLER_196_1229 VPWR VGND VPWR VGND sky130_ef_sc_hd__decap_12
XFILLER_171_909 VPWR VGND VPWR VGND sky130_ef_sc_hd__decap_12
XFILLER_13_1467 VPWR VGND VPWR VGND sky130_ef_sc_hd__decap_12
XFILLER_100_1415 VPWR VGND VPWR VGND sky130_ef_sc_hd__decap_12
XFILLER_202_1185 VPWR VGND VPWR VGND sky130_ef_sc_hd__decap_12
XFILLER_170_419 VGND VGND VPWR VPWR sky130_fd_sc_hd__fill_1
XFILLER_2_632 VGND VGND VPWR VPWR sky130_fd_sc_hd__fill_1
XFILLER_145_51 VGND VGND VPWR VPWR sky130_fd_sc_hd__decap_4
XPHY_EDGE_ROW_33_1_Right_689 VGND VGND VPWR VPWR sky130_fd_sc_hd__decap_3
XFILLER_215_1513 VGND VGND VPWR VPWR sky130_fd_sc_hd__fill_2
XFILLER_133_1213 VGND VGND VPWR VPWR sky130_fd_sc_hd__decap_4
XFILLER_1_186 VPWR VGND VPWR VGND sky130_ef_sc_hd__decap_12
XFILLER_172_1273 VPWR VGND VPWR VGND sky130_ef_sc_hd__decap_12
XFILLER_238_737 VPWR VGND VPWR VGND sky130_ef_sc_hd__decap_12
XFILLER_81_1189 VPWR VGND VPWR VGND sky130_ef_sc_hd__decap_12
XFILLER_237_225 VPWR VGND VPWR VGND sky130_ef_sc_hd__decap_12
XFILLER_219_951 VGND VGND VPWR VPWR sky130_fd_sc_hd__fill_1
XFILLER_111_1511 VGND VGND VPWR VPWR sky130_fd_sc_hd__decap_4
XFILLER_213_1281 VGND VGND VPWR VPWR sky130_fd_sc_hd__decap_6
XFILLER_168_1309 VGND VGND VPWR VPWR sky130_fd_sc_hd__decap_6
XFILLER_253_729 VPWR VGND VPWR VGND sky130_ef_sc_hd__decap_12
XFILLER_20_1427 VPWR VGND VPWR VGND sky130_ef_sc_hd__decap_12
XFILLER_206_601 VPWR VGND VPWR VGND sky130_ef_sc_hd__decap_12
XFILLER_246_781 VPWR VGND VPWR VGND sky130_ef_sc_hd__decap_12
XPHY_EDGE_ROW_99_1_Left_354 VGND VGND VPWR VPWR sky130_fd_sc_hd__decap_3
XFILLER_205_111 VGND VGND VPWR VPWR sky130_fd_sc_hd__fill_1
XFILLER_206_645 VPWR VGND VPWR VGND sky130_ef_sc_hd__decap_12
X_517_ net514 net510 net80 net517 VGND VGND VPWR VPWR _267_ sky130_fd_sc_hd__o31a_1
XFILLER_221_615 VGND VGND VPWR VPWR sky130_fd_sc_hd__fill_1
XFILLER_18_1301 VGND VGND VPWR VPWR sky130_fd_sc_hd__fill_1
XFILLER_233_497 VGND VGND VPWR VPWR sky130_fd_sc_hd__decap_6
X_448_ _090_ net515 net511 net81 VGND VGND VPWR VPWR _237_ sky130_fd_sc_hd__or4_1
XFILLER_207_1063 VGND VGND VPWR VPWR sky130_fd_sc_hd__fill_1
XTAP_TAPCELL_ROW_43_2_4013 VGND VPWR sky130_fd_sc_hd__tapvpwrvgnd_1
XFILLER_201_361 VPWR VGND VPWR VGND sky130_ef_sc_hd__decap_12
X_379_ net591 net578 net552 VGND VGND VPWR VPWR _168_ sky130_fd_sc_hd__a21oi_1
XFILLER_9_253 VPWR VGND VPWR VGND sky130_ef_sc_hd__decap_12
XFILLER_174_725 VPWR VGND VPWR VGND sky130_ef_sc_hd__decap_12
XFILLER_140_1239 VGND VGND VPWR VPWR sky130_fd_sc_hd__decap_6
XFILLER_220_1241 VPWR VGND VPWR VGND sky130_ef_sc_hd__decap_12
XTAP_TAPCELL_ROW_171_1510 VGND VPWR sky130_fd_sc_hd__tapvpwrvgnd_1
XFILLER_174_769 VPWR VGND VPWR VGND sky130_ef_sc_hd__decap_12
XFILLER_179_1449 VGND VGND VPWR VPWR sky130_fd_sc_hd__decap_6
XFILLER_220_1285 VPWR VGND VPWR VGND sky130_ef_sc_hd__decap_12
XFILLER_173_279 VGND VGND VPWR VPWR sky130_fd_sc_hd__fill_1
XFILLER_55_3 VPWR VGND VPWR VGND sky130_ef_sc_hd__decap_12
XFILLER_6_993 VPWR VGND VPWR VGND sky130_ef_sc_hd__decap_12
XFILLER_29_1441 VGND VGND VPWR VPWR sky130_fd_sc_hd__fill_1
XFILLER_9_1513 VGND VGND VPWR VPWR sky130_fd_sc_hd__fill_2
XTAP_TAPCELL_ROW_169_1450 VGND VPWR sky130_fd_sc_hd__tapvpwrvgnd_1
XTAP_TAPCELL_ROW_169_1461 VGND VPWR sky130_fd_sc_hd__tapvpwrvgnd_1
XFILLER_190_1373 VPWR VGND VPWR VGND sky130_ef_sc_hd__decap_12
XPHY_EDGE_ROW_224_Right_69 VGND VGND VPWR VPWR sky130_fd_sc_hd__decap_3
XTAP_TAPCELL_ROW_165_1303 VGND VPWR sky130_fd_sc_hd__tapvpwrvgnd_1
XTAP_TAPCELL_ROW_165_1314 VGND VPWR sky130_fd_sc_hd__tapvpwrvgnd_1
XTAP_TAPCELL_ROW_165_1325 VGND VPWR sky130_fd_sc_hd__tapvpwrvgnd_1
XFILLER_18_19 VGND VGND VPWR VPWR sky130_fd_sc_hd__decap_8
XTAP_TAPCELL_ROW_165_1336 VGND VPWR sky130_fd_sc_hd__tapvpwrvgnd_1
XFILLER_3_1101 VPWR VGND VPWR VGND sky130_ef_sc_hd__decap_12
XFILLER_151_1379 VGND VGND VPWR VPWR sky130_fd_sc_hd__decap_6
XTAP_TAPCELL_ROW_165_1347 VGND VPWR sky130_fd_sc_hd__tapvpwrvgnd_1
XFILLER_7_1281 VGND VGND VPWR VPWR sky130_fd_sc_hd__decap_6
XFILLER_249_1119 VGND VGND VPWR VPWR sky130_fd_sc_hd__fill_1
XFILLER_231_1381 VPWR VGND VPWR VGND sky130_ef_sc_hd__decap_12
XFILLER_186_1409 VPWR VGND VPWR VGND sky130_ef_sc_hd__decap_12
XFILLER_209_461 VPWR VGND VPWR VGND sky130_ef_sc_hd__decap_12
XFILLER_243_217 VGND VGND VPWR VPWR sky130_fd_sc_hd__decap_6
XFILLER_3_1145 VPWR VGND VPWR VGND sky130_ef_sc_hd__decap_12
XFILLER_225_921 VPWR VGND VPWR VGND sky130_ef_sc_hd__decap_12
XFILLER_149_1231 VPWR VGND VPWR VGND sky130_ef_sc_hd__decap_12
XFILLER_3_1189 VPWR VGND VPWR VGND sky130_ef_sc_hd__decap_12
XFILLER_225_965 VPWR VGND VPWR VGND sky130_ef_sc_hd__decap_12
XFILLER_149_1275 VPWR VGND VPWR VGND sky130_ef_sc_hd__decap_12
XFILLER_251_261 VPWR VGND VPWR VGND sky130_ef_sc_hd__decap_12
XFILLER_34_29 VPWR VGND VPWR VGND sky130_ef_sc_hd__decap_12
XFILLER_224_475 VGND VGND VPWR VPWR sky130_fd_sc_hd__fill_1
XFILLER_197_839 VGND VGND VPWR VPWR sky130_fd_sc_hd__fill_1
XFILLER_212_637 VGND VGND VPWR VPWR sky130_fd_sc_hd__decap_6
XFILLER_211_125 VPWR VGND VPWR VGND sky130_ef_sc_hd__decap_12
XFILLER_240_979 VGND VGND VPWR VPWR sky130_fd_sc_hd__fill_1
XPHY_EDGE_ROW_134_2_Right_225 VGND VGND VPWR VPWR sky130_fd_sc_hd__decap_3
XPHY_EDGE_ROW_233_Right_78 VGND VGND VPWR VPWR sky130_fd_sc_hd__decap_3
XFILLER_177_541 VPWR VGND VPWR VGND sky130_ef_sc_hd__decap_12
XFILLER_211_169 VPWR VGND VPWR VGND sky130_ef_sc_hd__decap_12
XFILLER_220_681 VPWR VGND VPWR VGND sky130_ef_sc_hd__decap_12
XTAP_TAPCELL_ROW_33_1_1168 VGND VPWR sky130_fd_sc_hd__tapvpwrvgnd_1
Xclkload6 clknet_3_7__leaf_clk VGND VGND VPWR VPWR clkload6/Y sky130_fd_sc_hd__inv_8
XFILLER_165_725 VGND VGND VPWR VPWR sky130_fd_sc_hd__decap_3
XFILLER_177_585 VPWR VGND VPWR VGND sky130_ef_sc_hd__decap_12
XFILLER_197_1505 VGND VGND VPWR VPWR sky130_fd_sc_hd__decap_6
XFILLER_192_533 VPWR VGND VPWR VGND sky130_ef_sc_hd__decap_12
XFILLER_34_1191 VPWR VGND VPWR VGND sky130_ef_sc_hd__decap_12
XFILLER_165_769 VPWR VGND VPWR VGND sky130_ef_sc_hd__decap_12
XFILLER_69_1243 VPWR VGND VPWR VGND sky130_ef_sc_hd__decap_12
XTAP_TAPCELL_ROW_230_3086 VGND VPWR sky130_fd_sc_hd__tapvpwrvgnd_1
XTAP_TAPCELL_ROW_230_3097 VGND VPWR sky130_fd_sc_hd__tapvpwrvgnd_1
XFILLER_59_15 VPWR VGND VPWR VGND sky130_ef_sc_hd__decap_12
XFILLER_69_1287 VPWR VGND VPWR VGND sky130_ef_sc_hd__decap_12
XFILLER_246_83 VGND VGND VPWR VPWR sky130_fd_sc_hd__fill_1
XTAP_TAPCELL_ROW_101_2_4358 VGND VPWR sky130_fd_sc_hd__tapvpwrvgnd_1
XTAP_TAPCELL_ROW_247_3550 VGND VPWR sky130_fd_sc_hd__tapvpwrvgnd_1
XTAP_TAPCELL_ROW_56_2_4091 VGND VPWR sky130_fd_sc_hd__tapvpwrvgnd_1
XFILLER_117_1219 VPWR VGND VPWR VGND sky130_ef_sc_hd__decap_12
XFILLER_182_27 VGND VGND VPWR VPWR sky130_fd_sc_hd__fill_1
XTAP_TAPCELL_ROW_247_3561 VGND VPWR sky130_fd_sc_hd__tapvpwrvgnd_1
XPHY_EDGE_ROW_242_Right_87 VGND VGND VPWR VPWR sky130_fd_sc_hd__decap_3
XTAP_TAPCELL_ROW_243_3436 VGND VPWR sky130_fd_sc_hd__tapvpwrvgnd_1
XTAP_TAPCELL_ROW_243_3447 VGND VPWR sky130_fd_sc_hd__tapvpwrvgnd_1
XTAP_TAPCELL_ROW_243_3458 VGND VPWR sky130_fd_sc_hd__tapvpwrvgnd_1
XFILLER_219_225 VPWR VGND VPWR VGND sky130_ef_sc_hd__decap_12
XTAP_TAPCELL_ROW_3_930 VGND VPWR sky130_fd_sc_hd__tapvpwrvgnd_1
XFILLER_189_1033 VPWR VGND VPWR VGND sky130_ef_sc_hd__decap_12
XFILLER_210_1421 VGND VGND VPWR VPWR sky130_fd_sc_hd__decap_6
XTAP_TAPCELL_ROW_3_941 VGND VPWR sky130_fd_sc_hd__tapvpwrvgnd_1
XFILLER_235_729 VPWR VGND VPWR VGND sky130_ef_sc_hd__decap_12
XTAP_TAPCELL_ROW_3_952 VGND VPWR sky130_fd_sc_hd__tapvpwrvgnd_1
XTAP_TAPCELL_ROW_9_1095 VGND VPWR sky130_fd_sc_hd__tapvpwrvgnd_1
XFILLER_75_69 VGND VGND VPWR VPWR sky130_fd_sc_hd__fill_2
XFILLER_228_781 VPWR VGND VPWR VGND sky130_ef_sc_hd__decap_12
XFILLER_189_1077 VPWR VGND VPWR VGND sky130_ef_sc_hd__decap_12
XFILLER_210_1465 VPWR VGND VPWR VGND sky130_ef_sc_hd__decap_12
XFILLER_76_1203 VPWR VGND VPWR VGND sky130_ef_sc_hd__decap_12
XTAP_TAPCELL_ROW_34_2_3961 VGND VPWR sky130_fd_sc_hd__tapvpwrvgnd_1
XFILLER_76_1247 VPWR VGND VPWR VGND sky130_ef_sc_hd__decap_12
XFILLER_128_1315 VPWR VGND VPWR VGND sky130_ef_sc_hd__decap_12
XFILLER_203_615 VGND VGND VPWR VPWR sky130_fd_sc_hd__fill_1
XFILLER_230_401 VPWR VGND VPWR VGND sky130_ef_sc_hd__decap_12
XFILLER_163_1217 VGND VGND VPWR VPWR sky130_fd_sc_hd__fill_1
XPHY_EDGE_ROW_251_Right_96 VGND VGND VPWR VPWR sky130_fd_sc_hd__decap_3
XFILLER_187_305 VPWR VGND VPWR VGND sky130_ef_sc_hd__decap_12
XFILLER_215_497 VGND VGND VPWR VPWR sky130_fd_sc_hd__decap_6
XFILLER_91_57 VPWR VGND VPWR VGND sky130_ef_sc_hd__decap_12
X_302_ net595 dout0_q\[29\] net526 VGND VGND VPWR VPWR _091_ sky130_fd_sc_hd__and3_1
XFILLER_128_1359 VPWR VGND VPWR VGND sky130_ef_sc_hd__decap_12
XFILLER_230_445 VPWR VGND VPWR VGND sky130_ef_sc_hd__decap_12
XFILLER_187_349 VPWR VGND VPWR VGND sky130_ef_sc_hd__decap_12
XFILLER_204_1203 VGND VGND VPWR VPWR sky130_fd_sc_hd__fill_1
XFILLER_196_861 VGND VGND VPWR VPWR sky130_fd_sc_hd__decap_6
XFILLER_230_489 VPWR VGND VPWR VGND sky130_ef_sc_hd__decap_12
Xwire600 net601 VGND VGND VPWR VPWR net600 sky130_fd_sc_hd__clkbuf_1
Xwire622 net5 VGND VGND VPWR VPWR net622 sky130_fd_sc_hd__clkbuf_1
Xwire633 net35 VGND VGND VPWR VPWR net633 sky130_fd_sc_hd__buf_1
Xwire644 net26 VGND VGND VPWR VPWR net644 sky130_fd_sc_hd__buf_1
XFILLER_195_393 VPWR VGND VPWR VGND sky130_ef_sc_hd__decap_12
XFILLER_13_1231 VPWR VGND VPWR VGND sky130_ef_sc_hd__decap_12
Xwire655 net17 VGND VGND VPWR VPWR net655 sky130_fd_sc_hd__buf_1
XTAP_TAPCELL_ROW_26_2_3909 VGND VPWR sky130_fd_sc_hd__tapvpwrvgnd_1
XFILLER_196_1037 VPWR VGND VPWR VGND sky130_ef_sc_hd__decap_12
XFILLER_13_1275 VPWR VGND VPWR VGND sky130_ef_sc_hd__decap_12
XFILLER_237_1001 VGND VGND VPWR VPWR sky130_fd_sc_hd__decap_6
XFILLER_87_1343 VPWR VGND VPWR VGND sky130_ef_sc_hd__decap_12
XFILLER_139_1411 VPWR VGND VPWR VGND sky130_ef_sc_hd__decap_12
XFILLER_100_1245 VGND VGND VPWR VPWR sky130_fd_sc_hd__fill_1
XFILLER_48_1327 VPWR VGND VPWR VGND sky130_ef_sc_hd__decap_12
XFILLER_237_1045 VPWR VGND VPWR VGND sky130_ef_sc_hd__decap_12
XFILLER_87_1387 VPWR VGND VPWR VGND sky130_ef_sc_hd__decap_12
XFILLER_139_1455 VPWR VGND VPWR VGND sky130_ef_sc_hd__decap_12
XFILLER_237_1089 VPWR VGND VPWR VGND sky130_ef_sc_hd__decap_12
XFILLER_139_1499 VPWR VGND VPWR VGND sky130_ef_sc_hd__decap_12
XFILLER_238_501 VPWR VGND VPWR VGND sky130_ef_sc_hd__decap_12
XFILLER_215_1343 VGND VGND VPWR VPWR sky130_fd_sc_hd__fill_1
XFILLER_238_545 VPWR VGND VPWR VGND sky130_ef_sc_hd__decap_12
XFILLER_1_11 VPWR VGND VPWR VGND sky130_ef_sc_hd__decap_12
XTAP_TAPCELL_ROW_145_2_4623 VGND VPWR sky130_fd_sc_hd__tapvpwrvgnd_1
XFILLER_4_1421 VGND VGND VPWR VPWR sky130_fd_sc_hd__decap_6
XTAP_TAPCELL_ROW_226_2977 VGND VPWR sky130_fd_sc_hd__tapvpwrvgnd_1
XFILLER_238_589 VPWR VGND VPWR VGND sky130_ef_sc_hd__decap_12
XFILLER_24_1371 VPWR VGND VPWR VGND sky130_ef_sc_hd__decap_12
XFILLER_1_55 VGND VGND VPWR VPWR sky130_fd_sc_hd__fill_1
XTAP_TAPCELL_ROW_226_2988 VGND VPWR sky130_fd_sc_hd__tapvpwrvgnd_1
XFILLER_168_1117 VPWR VGND VPWR VGND sky130_ef_sc_hd__decap_12
XFILLER_207_921 VPWR VGND VPWR VGND sky130_ef_sc_hd__decap_12
XFILLER_225_217 VGND VGND VPWR VPWR sky130_fd_sc_hd__decap_6
XTAP_TAPCELL_ROW_226_2999 VGND VPWR sky130_fd_sc_hd__tapvpwrvgnd_1
XFILLER_4_1465 VPWR VGND VPWR VGND sky130_ef_sc_hd__decap_12
XFILLER_253_559 VGND VGND VPWR VPWR sky130_fd_sc_hd__fill_1
XFILLER_59_1423 VPWR VGND VPWR VGND sky130_ef_sc_hd__decap_12
XFILLER_94_1303 VPWR VGND VPWR VGND sky130_ef_sc_hd__decap_12
XFILLER_248_1141 VGND VGND VPWR VPWR sky130_fd_sc_hd__decap_6
XFILLER_0_1329 VPWR VGND VPWR VGND sky130_ef_sc_hd__decap_12
XFILLER_98_1483 VPWR VGND VPWR VGND sky130_ef_sc_hd__decap_12
XFILLER_207_965 VPWR VGND VPWR VGND sky130_ef_sc_hd__decap_12
XFILLER_111_1385 VGND VGND VPWR VPWR sky130_fd_sc_hd__fill_1
XFILLER_244_1005 VPWR VGND VPWR VGND sky130_ef_sc_hd__decap_12
XFILLER_240_209 VPWR VGND VPWR VGND sky130_ef_sc_hd__decap_12
XFILLER_59_1467 VPWR VGND VPWR VGND sky130_ef_sc_hd__decap_12
XFILLER_146_1415 VPWR VGND VPWR VGND sky130_ef_sc_hd__decap_12
XFILLER_206_475 VGND VGND VPWR VPWR sky130_fd_sc_hd__fill_1
XFILLER_248_1185 VPWR VGND VPWR VGND sky130_ef_sc_hd__decap_12
XFILLER_233_261 VPWR VGND VPWR VGND sky130_ef_sc_hd__decap_12
XFILLER_179_839 VGND VGND VPWR VPWR sky130_fd_sc_hd__fill_1
XFILLER_244_1049 VPWR VGND VPWR VGND sky130_ef_sc_hd__decap_12
XFILLER_209_1169 VGND VGND VPWR VPWR sky130_fd_sc_hd__decap_6
XTAP_TAPCELL_ROW_93_2_4310 VGND VPWR sky130_fd_sc_hd__tapvpwrvgnd_1
XFILLER_222_979 VGND VGND VPWR VPWR sky130_fd_sc_hd__fill_1
XFILLER_226_1483 VGND VGND VPWR VPWR sky130_fd_sc_hd__fill_1
XFILLER_202_681 VPWR VGND VPWR VGND sky130_ef_sc_hd__decap_12
XFILLER_174_533 VPWR VGND VPWR VGND sky130_ef_sc_hd__decap_12
XFILLER_179_1213 VPWR VGND VPWR VGND sky130_ef_sc_hd__decap_12
XFILLER_31_1331 VPWR VGND VPWR VGND sky130_ef_sc_hd__decap_12
XFILLER_105_1189 VPWR VGND VPWR VGND sky130_ef_sc_hd__decap_12
XFILLER_179_1257 VPWR VGND VPWR VGND sky130_ef_sc_hd__decap_12
XFILLER_220_1093 VPWR VGND VPWR VGND sky130_ef_sc_hd__decap_12
XFILLER_157_1511 VGND VGND VPWR VPWR sky130_fd_sc_hd__decap_4
XFILLER_255_1145 VGND VGND VPWR VPWR sky130_fd_sc_hd__decap_3
XFILLER_66_1427 VPWR VGND VPWR VGND sky130_ef_sc_hd__decap_12
XFILLER_251_1009 VPWR VGND VPWR VGND sky130_ef_sc_hd__decap_12
XFILLER_216_1129 VPWR VGND VPWR VGND sky130_ef_sc_hd__decap_12
XFILLER_255_1189 VPWR VGND VPWR VGND sky130_ef_sc_hd__decap_12
XFILLER_216_53 VPWR VGND VPWR VGND sky130_ef_sc_hd__decap_12
XFILLER_248_309 VPWR VGND VPWR VGND sky130_ef_sc_hd__decap_12
XTAP_TAPCELL_ROW_40_2_3993 VGND VPWR sky130_fd_sc_hd__tapvpwrvgnd_1
XFILLER_216_97 VPWR VGND VPWR VGND sky130_ef_sc_hd__decap_12
XTAP_TAPCELL_ROW_39_2_3987 VGND VPWR sky130_fd_sc_hd__tapvpwrvgnd_1
XFILLER_151_1165 VPWR VGND VPWR VGND sky130_ef_sc_hd__decap_12
XFILLER_217_729 VPWR VGND VPWR VGND sky130_ef_sc_hd__decap_12
XFILLER_232_41 VPWR VGND VPWR VGND sky130_ef_sc_hd__decap_12
XFILLER_42_1471 VPWR VGND VPWR VGND sky130_ef_sc_hd__decap_12
XFILLER_186_1217 VPWR VGND VPWR VGND sky130_ef_sc_hd__decap_12
XFILLER_232_85 VPWR VGND VPWR VGND sky130_ef_sc_hd__decap_12
XFILLER_45_39 VPWR VGND VPWR VGND sky130_ef_sc_hd__decap_12
XFILLER_38_1507 VGND VGND VPWR VPWR sky130_fd_sc_hd__decap_8
XFILLER_227_1225 VGND VGND VPWR VPWR sky130_fd_sc_hd__decap_6
XFILLER_212_401 VPWR VGND VPWR VGND sky130_ef_sc_hd__decap_12
XFILLER_252_581 VGND VGND VPWR VPWR sky130_fd_sc_hd__decap_6
XFILLER_169_305 VPWR VGND VPWR VGND sky130_ef_sc_hd__decap_12
XFILLER_227_1269 VPWR VGND VPWR VGND sky130_ef_sc_hd__decap_12
XFILLER_212_445 VPWR VGND VPWR VGND sky130_ef_sc_hd__decap_12
XFILLER_169_349 VPWR VGND VPWR VGND sky130_ef_sc_hd__decap_12
XFILLER_61_27 VPWR VGND VPWR VGND sky130_ef_sc_hd__decap_12
XFILLER_185_809 VPWR VGND VPWR VGND sky130_ef_sc_hd__decap_12
XTAP_TAPCELL_ROW_236_3251 VGND VPWR sky130_fd_sc_hd__tapvpwrvgnd_1
XTAP_TAPCELL_ROW_236_3262 VGND VPWR sky130_fd_sc_hd__tapvpwrvgnd_1
XFILLER_123_1201 VPWR VGND VPWR VGND sky130_ef_sc_hd__decap_12
XFILLER_178_861 VGND VGND VPWR VPWR sky130_fd_sc_hd__decap_6
XFILLER_212_489 VPWR VGND VPWR VGND sky130_ef_sc_hd__decap_12
XPHY_EDGE_ROW_135_2_Right_226 VGND VGND VPWR VPWR sky130_fd_sc_hd__decap_3
XFILLER_177_27 VPWR VGND VPWR VGND sky130_ef_sc_hd__decap_12
XFILLER_162_1283 VPWR VGND VPWR VGND sky130_ef_sc_hd__decap_12
XTAP_TAPCELL_ROW_12_2_3828 VGND VPWR sky130_fd_sc_hd__tapvpwrvgnd_1
XFILLER_71_1177 VPWR VGND VPWR VGND sky130_ef_sc_hd__decap_12
XTAP_TAPCELL_ROW_232_3137 VGND VPWR sky130_fd_sc_hd__tapvpwrvgnd_1
XFILLER_165_533 VPWR VGND VPWR VGND sky130_ef_sc_hd__decap_12
XTAP_TAPCELL_ROW_232_3148 VGND VPWR sky130_fd_sc_hd__tapvpwrvgnd_1
XFILLER_123_1267 VGND VGND VPWR VPWR sky130_fd_sc_hd__decap_6
XFILLER_177_393 VPWR VGND VPWR VGND sky130_ef_sc_hd__decap_12
XFILLER_197_1313 VPWR VGND VPWR VGND sky130_ef_sc_hd__decap_12
XTAP_TAPCELL_ROW_232_3159 VGND VPWR sky130_fd_sc_hd__tapvpwrvgnd_1
XFILLER_193_853 VPWR VGND VPWR VGND sky130_ef_sc_hd__decap_12
XFILLER_197_1357 VPWR VGND VPWR VGND sky130_ef_sc_hd__decap_12
XFILLER_10_1415 VPWR VGND VPWR VGND sky130_ef_sc_hd__decap_12
XFILLER_192_363 VGND VGND VPWR VPWR sky130_fd_sc_hd__fill_1
XFILLER_193_897 VPWR VGND VPWR VGND sky130_ef_sc_hd__decap_12
XTAP_TAPCELL_ROW_249_3601 VGND VPWR sky130_fd_sc_hd__tapvpwrvgnd_1
XTAP_TAPCELL_ROW_249_3612 VGND VPWR sky130_fd_sc_hd__tapvpwrvgnd_1
XFILLER_180_525 VGND VGND VPWR VPWR sky130_fd_sc_hd__decap_6
XFILLER_193_15 VPWR VGND VPWR VGND sky130_ef_sc_hd__decap_12
XFILLER_4_749 VGND VGND VPWR VPWR sky130_fd_sc_hd__decap_4
XPHY_EDGE_ROW_116_2_Left_618 VGND VGND VPWR VPWR sky130_fd_sc_hd__decap_3
XFILLER_238_1365 VGND VGND VPWR VPWR sky130_fd_sc_hd__decap_6
XFILLER_180_569 VPWR VGND VPWR VGND sky130_ef_sc_hd__decap_12
XFILLER_10_53 VPWR VGND VPWR VGND sky130_ef_sc_hd__decap_12
XFILLER_3_259 VGND VGND VPWR VPWR sky130_fd_sc_hd__decap_6
XTAP_TAPCELL_ROW_245_3509 VGND VPWR sky130_fd_sc_hd__tapvpwrvgnd_1
XFILLER_234_1229 VPWR VGND VPWR VGND sky130_ef_sc_hd__decap_12
XFILLER_0_922 VGND VGND VPWR VPWR sky130_fd_sc_hd__fill_2
XFILLER_126_53 VPWR VGND VPWR VGND sky130_ef_sc_hd__decap_12
XFILLER_43_1213 VGND VGND VPWR VPWR sky130_fd_sc_hd__decap_4
XTAP_TAPCELL_ROW_131_2_4542 VGND VPWR sky130_fd_sc_hd__tapvpwrvgnd_1
XFILLER_0_977 VGND VGND VPWR VPWR sky130_fd_sc_hd__decap_3
XFILLER_82_1295 VGND VGND VPWR VPWR sky130_fd_sc_hd__decap_6
XFILLER_19_51 VGND VGND VPWR VPWR sky130_fd_sc_hd__decap_4
XFILLER_130_1227 VPWR VGND VPWR VGND sky130_ef_sc_hd__decap_12
XFILLER_21_1511 VGND VGND VPWR VPWR sky130_fd_sc_hd__decap_4
XFILLER_142_41 VPWR VGND VPWR VGND sky130_ef_sc_hd__decap_12
XFILLER_207_217 VGND VGND VPWR VPWR sky130_fd_sc_hd__decap_6
XFILLER_169_1437 VPWR VGND VPWR VGND sky130_ef_sc_hd__decap_12
XFILLER_235_559 VGND VGND VPWR VPWR sky130_fd_sc_hd__fill_1
XFILLER_210_1273 VPWR VGND VPWR VGND sky130_ef_sc_hd__decap_12
XTAP_TAPCELL_ROW_221_2841 VGND VPWR sky130_fd_sc_hd__tapvpwrvgnd_1
XTAP_TAPCELL_ROW_221_2852 VGND VPWR sky130_fd_sc_hd__tapvpwrvgnd_1
XFILLER_222_209 VPWR VGND VPWR VGND sky130_ef_sc_hd__decap_12
XTAP_TAPCELL_ROW_221_2863 VGND VPWR sky130_fd_sc_hd__tapvpwrvgnd_1
XFILLER_245_1325 VPWR VGND VPWR VGND sky130_ef_sc_hd__decap_12
XFILLER_215_261 VPWR VGND VPWR VGND sky130_ef_sc_hd__decap_12
XFILLER_231_721 VGND VGND VPWR VPWR sky130_fd_sc_hd__decap_6
XTAP_TAPCELL_ROW_78_2_4223 VGND VPWR sky130_fd_sc_hd__tapvpwrvgnd_1
XFILLER_188_625 VPWR VGND VPWR VGND sky130_ef_sc_hd__decap_12
XFILLER_187_113 VPWR VGND VPWR VGND sky130_ef_sc_hd__decap_12
XFILLER_206_1309 VGND VGND VPWR VPWR sky130_fd_sc_hd__decap_6
XFILLER_245_1369 VPWR VGND VPWR VGND sky130_ef_sc_hd__decap_12
XFILLER_204_979 VGND VGND VPWR VPWR sky130_fd_sc_hd__fill_1
XFILLER_231_765 VPWR VGND VPWR VGND sky130_ef_sc_hd__decap_12
XFILLER_188_669 VPWR VGND VPWR VGND sky130_ef_sc_hd__decap_12
XFILLER_230_253 VPWR VGND VPWR VGND sky130_ef_sc_hd__decap_12
XPHY_EDGE_ROW_239_Left_494 VGND VGND VPWR VPWR sky130_fd_sc_hd__decap_3
XFILLER_128_1189 VGND VGND VPWR VPWR sky130_fd_sc_hd__fill_1
XFILLER_141_1323 VGND VGND VPWR VPWR sky130_fd_sc_hd__decap_6
XFILLER_50_1239 VGND VGND VPWR VPWR sky130_fd_sc_hd__decap_6
Xwire430 net431 VGND VGND VPWR VPWR net430 sky130_fd_sc_hd__clkbuf_1
XTAP_TAPCELL_ROW_219_2792 VGND VPWR sky130_fd_sc_hd__tapvpwrvgnd_1
XFILLER_141_1367 VPWR VGND VPWR VGND sky130_ef_sc_hd__decap_12
Xwire441 net442 VGND VGND VPWR VPWR net441 sky130_fd_sc_hd__clkbuf_1
Xwire452 net453 VGND VGND VPWR VPWR net452 sky130_fd_sc_hd__clkbuf_1
Xwire463 net464 VGND VGND VPWR VPWR net463 sky130_fd_sc_hd__clkbuf_1
Xwire474 net475 VGND VGND VPWR VPWR net474 sky130_fd_sc_hd__clkbuf_1
XFILLER_171_503 VGND VGND VPWR VPWR sky130_fd_sc_hd__fill_1
Xwire485 net486 VGND VGND VPWR VPWR net485 sky130_fd_sc_hd__clkbuf_1
Xmax_cap207 _179_ VGND VGND VPWR VPWR net207 sky130_fd_sc_hd__clkbuf_1
XTAP_TAPCELL_ROW_215_2678 VGND VPWR sky130_fd_sc_hd__tapvpwrvgnd_1
Xmax_cap218 _164_ VGND VGND VPWR VPWR net218 sky130_fd_sc_hd__clkbuf_1
XFILLER_167_93 VPWR VGND VPWR VGND sky130_ef_sc_hd__decap_12
XFILLER_183_385 VGND VGND VPWR VPWR sky130_fd_sc_hd__decap_6
XTAP_TAPCELL_ROW_215_2689 VGND VPWR sky130_fd_sc_hd__tapvpwrvgnd_1
XFILLER_3_760 VGND VGND VPWR VPWR sky130_fd_sc_hd__fill_1
XFILLER_252_1329 VPWR VGND VPWR VGND sky130_ef_sc_hd__decap_12
XFILLER_217_1449 VGND VGND VPWR VPWR sky130_fd_sc_hd__decap_6
XFILLER_3_793 VGND VGND VPWR VPWR sky130_fd_sc_hd__decap_3
XFILLER_183_81 VPWR VGND VPWR VGND sky130_ef_sc_hd__decap_12
XFILLER_239_821 VPWR VGND VPWR VGND sky130_ef_sc_hd__decap_12
XFILLER_170_1029 VGND VGND VPWR VPWR sky130_fd_sc_hd__decap_6
XFILLER_2_292 VGND VGND VPWR VPWR sky130_fd_sc_hd__decap_3
XFILLER_152_1463 VGND VGND VPWR VPWR sky130_fd_sc_hd__decap_6
XFILLER_239_865 VPWR VGND VPWR VGND sky130_ef_sc_hd__decap_12
XFILLER_254_813 VPWR VGND VPWR VGND sky130_ef_sc_hd__decap_12
XFILLER_61_1379 VGND VGND VPWR VPWR sky130_fd_sc_hd__decap_6
XFILLER_18_3 VPWR VGND VPWR VGND sky130_ef_sc_hd__decap_12
XPHY_EDGE_ROW_162_2_Left_664 VGND VGND VPWR VPWR sky130_fd_sc_hd__decap_3
XFILLER_4_1273 VPWR VGND VPWR VGND sky130_ef_sc_hd__decap_12
XFILLER_59_1231 VPWR VGND VPWR VGND sky130_ef_sc_hd__decap_12
XFILLER_241_529 VPWR VGND VPWR VGND sky130_ef_sc_hd__decap_12
XFILLER_234_581 VGND VGND VPWR VPWR sky130_fd_sc_hd__decap_6
XFILLER_202_77 VGND VGND VPWR VPWR sky130_fd_sc_hd__decap_6
XFILLER_59_1275 VPWR VGND VPWR VGND sky130_ef_sc_hd__decap_12
XFILLER_94_1177 VPWR VGND VPWR VGND sky130_ef_sc_hd__decap_12
XFILLER_146_1245 VGND VGND VPWR VPWR sky130_fd_sc_hd__fill_1
XFILLER_224_1409 VPWR VGND VPWR VGND sky130_ef_sc_hd__decap_12
XFILLER_210_905 VPWR VGND VPWR VGND sky130_ef_sc_hd__decap_12
XFILLER_167_809 VPWR VGND VPWR VGND sky130_ef_sc_hd__decap_12
XFILLER_181_1169 VGND VGND VPWR VPWR sky130_fd_sc_hd__decap_6
XFILLER_210_949 VPWR VGND VPWR VGND sky130_ef_sc_hd__decap_12
XFILLER_193_105 VGND VGND VPWR VPWR sky130_fd_sc_hd__decap_6
XPHY_EDGE_ROW_114_1_Left_369 VGND VGND VPWR VPWR sky130_fd_sc_hd__decap_3
XFILLER_120_1407 VGND VGND VPWR VPWR sky130_fd_sc_hd__decap_6
XFILLER_175_853 VPWR VGND VPWR VGND sky130_ef_sc_hd__decap_12
XFILLER_193_149 VPWR VGND VPWR VGND sky130_ef_sc_hd__decap_12
XFILLER_179_1021 VPWR VGND VPWR VGND sky130_ef_sc_hd__decap_12
XFILLER_174_363 VGND VGND VPWR VPWR sky130_fd_sc_hd__fill_1
XFILLER_175_897 VPWR VGND VPWR VGND sky130_ef_sc_hd__decap_12
XFILLER_179_1065 VPWR VGND VPWR VGND sky130_ef_sc_hd__decap_12
XPHY_EDGE_ROW_51_1_Left_306 VGND VGND VPWR VPWR sky130_fd_sc_hd__decap_3
XTAP_TAPCELL_ROW_136_2_4568 VGND VPWR sky130_fd_sc_hd__tapvpwrvgnd_1
XFILLER_200_1453 VPWR VGND VPWR VGND sky130_ef_sc_hd__decap_12
XFILLER_190_867 VGND VGND VPWR VPWR sky130_fd_sc_hd__fill_1
XFILLER_235_1505 VGND VGND VPWR VPWR sky130_fd_sc_hd__decap_6
XFILLER_200_1497 VPWR VGND VPWR VGND sky130_ef_sc_hd__decap_12
XFILLER_118_1303 VPWR VGND VPWR VGND sky130_ef_sc_hd__decap_12
XTAP_TAPCELL_ROW_28_1_1163 VGND VPWR sky130_fd_sc_hd__tapvpwrvgnd_1
XFILLER_27_1219 VPWR VGND VPWR VGND sky130_ef_sc_hd__decap_12
XFILLER_157_1385 VGND VGND VPWR VPWR sky130_fd_sc_hd__fill_1
XFILLER_249_629 VPWR VGND VPWR VGND sky130_ef_sc_hd__decap_12
XFILLER_248_139 VGND VGND VPWR VPWR sky130_fd_sc_hd__fill_1
XFILLER_243_51 VGND VGND VPWR VPWR sky130_fd_sc_hd__decap_4
XFILLER_9_1173 VGND VGND VPWR VPWR sky130_fd_sc_hd__decap_3
XFILLER_56_27 VGND VGND VPWR VPWR sky130_fd_sc_hd__fill_1
XPHY_EDGE_ROW_94_2_Left_596 VGND VGND VPWR VPWR sky130_fd_sc_hd__decap_3
XTAP_TAPCELL_ROW_6_1021 VGND VPWR sky130_fd_sc_hd__tapvpwrvgnd_1
XFILLER_244_301 VGND VGND VPWR VPWR sky130_fd_sc_hd__decap_6
XTAP_TAPCELL_ROW_6_1032 VGND VPWR sky130_fd_sc_hd__tapvpwrvgnd_1
XFILLER_244_345 VPWR VGND VPWR VGND sky130_ef_sc_hd__decap_12
XFILLER_217_559 VGND VGND VPWR VPWR sky130_fd_sc_hd__fill_1
XFILLER_77_1331 VPWR VGND VPWR VGND sky130_ef_sc_hd__decap_12
XFILLER_204_209 VPWR VGND VPWR VGND sky130_ef_sc_hd__decap_12
XFILLER_244_389 VPWR VGND VPWR VGND sky130_ef_sc_hd__decap_12
XTAP_TAPCELL_ROW_238_3302 VGND VPWR sky130_fd_sc_hd__tapvpwrvgnd_1
XTAP_TAPCELL_ROW_238_3313 VGND VPWR sky130_fd_sc_hd__tapvpwrvgnd_1
XFILLER_72_15 VPWR VGND VPWR VGND sky130_ef_sc_hd__decap_12
XFILLER_164_1301 VGND VGND VPWR VPWR sky130_fd_sc_hd__fill_1
XTAP_TAPCELL_ROW_238_3324 VGND VPWR sky130_fd_sc_hd__tapvpwrvgnd_1
XFILLER_38_1315 VPWR VGND VPWR VGND sky130_ef_sc_hd__decap_12
XFILLER_198_923 VGND VGND VPWR VPWR sky130_fd_sc_hd__fill_1
XFILLER_213_721 VGND VGND VPWR VPWR sky130_fd_sc_hd__decap_6
XFILLER_227_1033 VPWR VGND VPWR VGND sky130_ef_sc_hd__decap_12
XFILLER_73_1217 VGND VGND VPWR VPWR sky130_fd_sc_hd__fill_1
XFILLER_129_1443 VPWR VGND VPWR VGND sky130_ef_sc_hd__decap_12
XFILLER_242_1509 VGND VGND VPWR VPWR sky130_fd_sc_hd__decap_6
XFILLER_169_113 VPWR VGND VPWR VGND sky130_ef_sc_hd__decap_12
XFILLER_188_15 VPWR VGND VPWR VGND sky130_ef_sc_hd__decap_12
XFILLER_38_1359 VPWR VGND VPWR VGND sky130_ef_sc_hd__decap_12
XFILLER_213_765 VPWR VGND VPWR VGND sky130_ef_sc_hd__decap_12
XFILLER_212_253 VPWR VGND VPWR VGND sky130_ef_sc_hd__decap_12
XFILLER_227_1077 VPWR VGND VPWR VGND sky130_ef_sc_hd__decap_12
XFILLER_125_1329 VGND VGND VPWR VPWR sky130_fd_sc_hd__fill_1
XFILLER_185_617 VPWR VGND VPWR VGND sky130_ef_sc_hd__decap_12
XFILLER_8_307 VGND VGND VPWR VPWR sky130_fd_sc_hd__fill_1
XPHY_EDGE_ROW_136_2_Right_227 VGND VGND VPWR VPWR sky130_fd_sc_hd__decap_3
XFILLER_122_3 VPWR VGND VPWR VGND sky130_ef_sc_hd__decap_12
XFILLER_197_1121 VPWR VGND VPWR VGND sky130_ef_sc_hd__decap_12
XFILLER_4_513 VGND VGND VPWR VPWR sky130_fd_sc_hd__fill_1
XFILLER_193_1007 VGND VGND VPWR VPWR sky130_fd_sc_hd__fill_1
XFILLER_49_1411 VPWR VGND VPWR VGND sky130_ef_sc_hd__decap_12
XFILLER_10_1245 VGND VGND VPWR VPWR sky130_fd_sc_hd__fill_1
XFILLER_180_333 VPWR VGND VPWR VGND sky130_ef_sc_hd__decap_12
XFILLER_88_1471 VPWR VGND VPWR VGND sky130_ef_sc_hd__decap_12
XFILLER_181_889 VGND VGND VPWR VPWR sky130_fd_sc_hd__decap_6
XFILLER_49_1455 VPWR VGND VPWR VGND sky130_ef_sc_hd__decap_12
XFILLER_180_377 VPWR VGND VPWR VGND sky130_ef_sc_hd__decap_12
XTAP_TAPCELL_ROW_210_2542 VGND VPWR sky130_fd_sc_hd__tapvpwrvgnd_1
XFILLER_238_1173 VPWR VGND VPWR VGND sky130_ef_sc_hd__decap_12
XTAP_TAPCELL_ROW_210_2553 VGND VPWR sky130_fd_sc_hd__tapvpwrvgnd_1
XTAP_TAPCELL_ROW_210_2564 VGND VPWR sky130_fd_sc_hd__tapvpwrvgnd_1
XFILLER_84_1357 VGND VGND VPWR VPWR sky130_fd_sc_hd__fill_1
XFILLER_234_1037 VPWR VGND VPWR VGND sky130_ef_sc_hd__decap_12
XFILLER_49_1499 VPWR VGND VPWR VGND sky130_ef_sc_hd__decap_12
XFILLER_136_1469 VGND VGND VPWR VPWR sky130_fd_sc_hd__fill_1
XFILLER_153_51 VGND VGND VPWR VPWR sky130_fd_sc_hd__decap_4
XFILLER_0_785 VPWR VGND VPWR VGND sky130_ef_sc_hd__decap_12
XFILLER_254_109 VPWR VGND VPWR VGND sky130_ef_sc_hd__decap_12
XFILLER_236_813 VPWR VGND VPWR VGND sky130_ef_sc_hd__decap_12
XTAP_TAPCELL_ROW_223_2903 VGND VPWR sky130_fd_sc_hd__tapvpwrvgnd_1
XFILLER_247_161 VGND VGND VPWR VPWR sky130_fd_sc_hd__decap_6
XFILLER_169_1201 VPWR VGND VPWR VGND sky130_ef_sc_hd__decap_12
XTAP_TAPCELL_ROW_223_2914 VGND VPWR sky130_fd_sc_hd__tapvpwrvgnd_1
XTAP_TAPCELL_ROW_208_2493 VGND VPWR sky130_fd_sc_hd__tapvpwrvgnd_1
XFILLER_1_1413 VPWR VGND VPWR VGND sky130_ef_sc_hd__decap_12
XFILLER_169_1245 VPWR VGND VPWR VGND sky130_ef_sc_hd__decap_12
XFILLER_21_1385 VGND VGND VPWR VPWR sky130_fd_sc_hd__fill_1
XFILLER_223_529 VPWR VGND VPWR VGND sky130_ef_sc_hd__decap_12
XFILLER_1_1457 VPWR VGND VPWR VGND sky130_ef_sc_hd__decap_12
XFILLER_169_1289 VPWR VGND VPWR VGND sky130_ef_sc_hd__decap_12
XFILLER_216_581 VGND VGND VPWR VPWR sky130_fd_sc_hd__decap_6
XFILLER_56_1415 VPWR VGND VPWR VGND sky130_ef_sc_hd__decap_12
XPHY_EDGE_ROW_247_Left_502 VGND VGND VPWR VPWR sky130_fd_sc_hd__decap_3
XFILLER_245_1133 VPWR VGND VPWR VGND sky130_ef_sc_hd__decap_12
Xmax_cap94 net95 VGND VGND VPWR VPWR net94 sky130_fd_sc_hd__clkbuf_1
XFILLER_189_945 VGND VGND VPWR VPWR sky130_fd_sc_hd__decap_6
XFILLER_95_1497 VGND VGND VPWR VPWR sky130_fd_sc_hd__fill_1
XFILLER_188_433 VPWR VGND VPWR VGND sky130_ef_sc_hd__decap_12
XTAP_TAPCELL_ROW_196_2169 VGND VPWR sky130_fd_sc_hd__tapvpwrvgnd_1
XFILLER_206_1117 VPWR VGND VPWR VGND sky130_ef_sc_hd__decap_12
XFILLER_245_1177 VPWR VGND VPWR VGND sky130_ef_sc_hd__decap_12
XFILLER_189_989 VPWR VGND VPWR VGND sky130_ef_sc_hd__decap_12
XFILLER_231_573 VPWR VGND VPWR VGND sky130_ef_sc_hd__decap_12
XFILLER_188_477 VPWR VGND VPWR VGND sky130_ef_sc_hd__decap_12
XFILLER_62_70 VGND VGND VPWR VPWR sky130_fd_sc_hd__fill_1
XFILLER_175_105 VGND VGND VPWR VPWR sky130_fd_sc_hd__decap_6
XFILLER_248_29 VPWR VGND VPWR VGND sky130_ef_sc_hd__decap_12
XFILLER_8_841 VGND VGND VPWR VPWR sky130_fd_sc_hd__fill_1
XFILLER_175_149 VPWR VGND VPWR VGND sky130_ef_sc_hd__decap_12
XFILLER_89_1213 VGND VGND VPWR VPWR sky130_fd_sc_hd__decap_4
XFILLER_191_609 VGND VGND VPWR VPWR sky130_fd_sc_hd__decap_6
XFILLER_106_1295 VGND VGND VPWR VPWR sky130_fd_sc_hd__decap_6
XTAP_TAPCELL_ROW_122_2_4487 VGND VPWR sky130_fd_sc_hd__tapvpwrvgnd_1
XFILLER_200_993 VPWR VGND VPWR VGND sky130_ef_sc_hd__decap_12
XFILLER_15_1189 VPWR VGND VPWR VGND sky130_ef_sc_hd__decap_12
XFILLER_7_54 VGND VGND VPWR VPWR sky130_fd_sc_hd__fill_2
Xwire260 net261 VGND VGND VPWR VPWR net260 sky130_fd_sc_hd__clkbuf_1
Xwire271 net272 VGND VGND VPWR VPWR net271 sky130_fd_sc_hd__clkbuf_1
XFILLER_176_1205 VPWR VGND VPWR VGND sky130_ef_sc_hd__decap_12
Xwire282 net283 VGND VGND VPWR VPWR net282 sky130_fd_sc_hd__clkbuf_1
Xwire293 net294 VGND VGND VPWR VPWR net293 sky130_fd_sc_hd__clkbuf_1
XFILLER_67_1511 VGND VGND VPWR VPWR sky130_fd_sc_hd__decap_4
XFILLER_7_98 VPWR VGND VPWR VGND sky130_ef_sc_hd__decap_12
XFILLER_183_193 VPWR VGND VPWR VGND sky130_ef_sc_hd__decap_12
XFILLER_172_867 VGND VGND VPWR VPWR sky130_fd_sc_hd__fill_1
XFILLER_217_1213 VPWR VGND VPWR VGND sky130_ef_sc_hd__decap_12
XFILLER_217_1257 VPWR VGND VPWR VGND sky130_ef_sc_hd__decap_12
XTAP_TAPCELL_ROW_70_2_4174 VGND VPWR sky130_fd_sc_hd__tapvpwrvgnd_1
XTAP_TAPCELL_ROW_69_2_4168 VGND VPWR sky130_fd_sc_hd__tapvpwrvgnd_1
XFILLER_152_1271 VPWR VGND VPWR VGND sky130_ef_sc_hd__decap_12
XFILLER_239_673 VPWR VGND VPWR VGND sky130_ef_sc_hd__decap_12
XFILLER_61_1165 VPWR VGND VPWR VGND sky130_ef_sc_hd__decap_12
XTAP_TAPCELL_ROW_185_1873 VGND VPWR sky130_fd_sc_hd__tapvpwrvgnd_1
XFILLER_226_301 VGND VGND VPWR VPWR sky130_fd_sc_hd__decap_6
XTAP_TAPCELL_ROW_185_1884 VGND VPWR sky130_fd_sc_hd__tapvpwrvgnd_1
XFILLER_187_1301 VPWR VGND VPWR VGND sky130_ef_sc_hd__decap_12
XFILLER_113_1255 VPWR VGND VPWR VGND sky130_ef_sc_hd__decap_12
XFILLER_254_643 VGND VGND VPWR VPWR sky130_fd_sc_hd__fill_1
XTAP_TAPCELL_ROW_181_1759 VGND VPWR sky130_fd_sc_hd__tapvpwrvgnd_1
XFILLER_226_345 VPWR VGND VPWR VGND sky130_ef_sc_hd__decap_12
XFILLER_242_805 VGND VGND VPWR VPWR sky130_fd_sc_hd__decap_6
XFILLER_187_1345 VPWR VGND VPWR VGND sky130_ef_sc_hd__decap_12
XFILLER_96_1239 VGND VGND VPWR VPWR sky130_fd_sc_hd__decap_6
XFILLER_113_1299 VPWR VGND VPWR VGND sky130_ef_sc_hd__decap_12
XFILLER_199_709 VPWR VGND VPWR VGND sky130_ef_sc_hd__decap_12
XFILLER_226_389 VPWR VGND VPWR VGND sky130_ef_sc_hd__decap_12
XFILLER_242_849 VPWR VGND VPWR VGND sky130_ef_sc_hd__decap_12
XFILLER_241_337 VPWR VGND VPWR VGND sky130_ef_sc_hd__decap_12
XPHY_EDGE_ROW_174_Right_19 VGND VGND VPWR VPWR sky130_fd_sc_hd__decap_3
XFILLER_228_1353 VPWR VGND VPWR VGND sky130_ef_sc_hd__decap_12
XPHY_EDGE_ROW_124_1_Right_780 VGND VGND VPWR VPWR sky130_fd_sc_hd__decap_3
XFILLER_224_1217 VPWR VGND VPWR VGND sky130_ef_sc_hd__decap_12
XFILLER_210_713 VPWR VGND VPWR VGND sky130_ef_sc_hd__decap_12
XFILLER_228_1397 VPWR VGND VPWR VGND sky130_ef_sc_hd__decap_12
XFILLER_250_893 VPWR VGND VPWR VGND sky130_ef_sc_hd__decap_12
XFILLER_167_617 VPWR VGND VPWR VGND sky130_ef_sc_hd__decap_12
XFILLER_42_29 VPWR VGND VPWR VGND sky130_ef_sc_hd__decap_12
XFILLER_33_1201 VPWR VGND VPWR VGND sky130_ef_sc_hd__decap_12
XFILLER_210_757 VPWR VGND VPWR VGND sky130_ef_sc_hd__decap_12
XFILLER_158_29 VPWR VGND VPWR VGND sky130_ef_sc_hd__decap_12
XFILLER_72_1283 VPWR VGND VPWR VGND sky130_ef_sc_hd__decap_12
XFILLER_124_1351 VGND VGND VPWR VPWR sky130_fd_sc_hd__decap_6
XTAP_TAPCELL_ROW_42_2_4009 VGND VPWR sky130_fd_sc_hd__tapvpwrvgnd_1
XFILLER_194_469 VGND VGND VPWR VPWR sky130_fd_sc_hd__decap_6
XTAP_TAPCELL_ROW_27_2_3914 VGND VPWR sky130_fd_sc_hd__tapvpwrvgnd_1
XFILLER_33_1267 VGND VGND VPWR VPWR sky130_fd_sc_hd__decap_6
XFILLER_120_1215 VPWR VGND VPWR VGND sky130_ef_sc_hd__decap_12
XFILLER_198_1441 VPWR VGND VPWR VGND sky130_ef_sc_hd__decap_12
XFILLER_124_1395 VPWR VGND VPWR VGND sky130_ef_sc_hd__decap_12
XFILLER_120_1259 VPWR VGND VPWR VGND sky130_ef_sc_hd__decap_12
XFILLER_198_1485 VPWR VGND VPWR VGND sky130_ef_sc_hd__decap_12
XPHY_EDGE_ROW_60_2_Right_151 VGND VGND VPWR VPWR sky130_fd_sc_hd__decap_3
XFILLER_200_1261 VPWR VGND VPWR VGND sky130_ef_sc_hd__decap_12
XPHY_EDGE_ROW_183_Right_28 VGND VGND VPWR VPWR sky130_fd_sc_hd__decap_3
XFILLER_235_1313 VPWR VGND VPWR VGND sky130_ef_sc_hd__decap_12
XFILLER_239_1493 VPWR VGND VPWR VGND sky130_ef_sc_hd__decap_12
XTAP_TAPCELL_ROW_227_3003 VGND VPWR sky130_fd_sc_hd__tapvpwrvgnd_1
XTAP_TAPCELL_ROW_227_3014 VGND VPWR sky130_fd_sc_hd__tapvpwrvgnd_1
XFILLER_235_1357 VPWR VGND VPWR VGND sky130_ef_sc_hd__decap_12
XFILLER_107_55 VGND VGND VPWR VPWR sky130_fd_sc_hd__fill_1
XTAP_TAPCELL_ROW_227_3025 VGND VPWR sky130_fd_sc_hd__tapvpwrvgnd_1
XFILLER_192_1073 VPWR VGND VPWR VGND sky130_ef_sc_hd__decap_12
XFILLER_67_15 VPWR VGND VPWR VGND sky130_ef_sc_hd__decap_12
XFILLER_254_83 VGND VGND VPWR VPWR sky130_fd_sc_hd__fill_1
XFILLER_118_1177 VPWR VGND VPWR VGND sky130_ef_sc_hd__decap_12
XFILLER_190_27 VGND VGND VPWR VPWR sky130_fd_sc_hd__fill_1
XFILLER_131_1311 VPWR VGND VPWR VGND sky130_ef_sc_hd__decap_12
XFILLER_236_109 VPWR VGND VPWR VGND sky130_ef_sc_hd__decap_12
XFILLER_135_1491 VGND VGND VPWR VPWR sky130_fd_sc_hd__decap_6
XFILLER_170_1371 VGND VGND VPWR VPWR sky130_fd_sc_hd__fill_1
XFILLER_218_813 VPWR VGND VPWR VGND sky130_ef_sc_hd__decap_12
XFILLER_40_1227 VPWR VGND VPWR VGND sky130_ef_sc_hd__decap_12
XFILLER_229_161 VGND VGND VPWR VPWR sky130_fd_sc_hd__decap_6
XFILLER_131_1355 VPWR VGND VPWR VGND sky130_ef_sc_hd__decap_12
X_550_ net669 VGND VGND VPWR VPWR _032_ sky130_fd_sc_hd__inv_2
XFILLER_245_665 VGND VGND VPWR VPWR sky130_fd_sc_hd__decap_6
XFILLER_244_153 VPWR VGND VPWR VGND sky130_ef_sc_hd__decap_12
XFILLER_131_1399 VPWR VGND VPWR VGND sky130_ef_sc_hd__decap_12
XFILLER_166_1429 VPWR VGND VPWR VGND sky130_ef_sc_hd__decap_12
XPHY_EDGE_ROW_192_Right_37 VGND VGND VPWR VPWR sky130_fd_sc_hd__decap_3
XFILLER_205_529 VPWR VGND VPWR VGND sky130_ef_sc_hd__decap_12
XFILLER_83_69 VGND VGND VPWR VPWR sky130_fd_sc_hd__fill_2
X_481_ net164 net93 VGND VGND VPWR VPWR acc_core.adder.cla_blocks\[3\].block.sum\[2\]
+ sky130_fd_sc_hd__xnor2_1
XFILLER_244_197 VPWR VGND VPWR VGND sky130_ef_sc_hd__decap_12
XFILLER_16_41 VPWR VGND VPWR VGND sky130_ef_sc_hd__decap_12
XFILLER_246_1453 VPWR VGND VPWR VGND sky130_ef_sc_hd__decap_12
XFILLER_199_69 VPWR VGND VPWR VGND sky130_ef_sc_hd__decap_12
XFILLER_242_1317 VPWR VGND VPWR VGND sky130_ef_sc_hd__decap_12
XFILLER_207_1437 VPWR VGND VPWR VGND sky130_ef_sc_hd__decap_12
XFILLER_129_1273 VGND VGND VPWR VPWR sky130_fd_sc_hd__fill_1
XFILLER_213_573 VPWR VGND VPWR VGND sky130_ef_sc_hd__decap_12
XFILLER_246_1497 VPWR VGND VPWR VGND sky130_ef_sc_hd__decap_12
XFILLER_38_1189 VGND VGND VPWR VPWR sky130_fd_sc_hd__fill_1
XFILLER_186_937 VPWR VGND VPWR VGND sky130_ef_sc_hd__decap_12
XFILLER_51_1323 VGND VGND VPWR VPWR sky130_fd_sc_hd__decap_6
XFILLER_185_447 VGND VGND VPWR VPWR sky130_fd_sc_hd__fill_1
XTAP_TAPCELL_ROW_191_2033 VGND VPWR sky130_fd_sc_hd__tapvpwrvgnd_1
XFILLER_200_245 VGND VGND VPWR VPWR sky130_fd_sc_hd__decap_6
XFILLER_90_1383 VPWR VGND VPWR VGND sky130_ef_sc_hd__decap_12
XFILLER_142_1451 VPWR VGND VPWR VGND sky130_ef_sc_hd__decap_12
XTAP_TAPCELL_ROW_191_2044 VGND VPWR sky130_fd_sc_hd__tapvpwrvgnd_1
XFILLER_173_609 VGND VGND VPWR VPWR sky130_fd_sc_hd__decap_6
XTAP_TAPCELL_ROW_191_2055 VGND VPWR sky130_fd_sc_hd__tapvpwrvgnd_1
XFILLER_51_1367 VPWR VGND VPWR VGND sky130_ef_sc_hd__decap_12
XFILLER_240_1085 VGND VGND VPWR VPWR sky130_fd_sc_hd__decap_6
XFILLER_103_1435 VGND VGND VPWR VPWR sky130_fd_sc_hd__decap_6
XPHY_EDGE_ROW_137_2_Right_228 VGND VGND VPWR VPWR sky130_fd_sc_hd__decap_3
XFILLER_200_289 VPWR VGND VPWR VGND sky130_ef_sc_hd__decap_12
XFILLER_142_1495 VPWR VGND VPWR VGND sky130_ef_sc_hd__decap_12
XFILLER_194_981 VPWR VGND VPWR VGND sky130_ef_sc_hd__decap_12
XTAP_TAPCELL_ROW_212_2604 VGND VPWR sky130_fd_sc_hd__tapvpwrvgnd_1
XTAP_TAPCELL_ROW_212_2615 VGND VPWR sky130_fd_sc_hd__tapvpwrvgnd_1
XFILLER_103_1479 VPWR VGND VPWR VGND sky130_ef_sc_hd__decap_12
XFILLER_165_193 VGND VGND VPWR VPWR sky130_fd_sc_hd__decap_3
XFILLER_181_653 VPWR VGND VPWR VGND sky130_ef_sc_hd__decap_12
XFILLER_180_141 VPWR VGND VPWR VGND sky130_ef_sc_hd__decap_12
XFILLER_253_1413 VPWR VGND VPWR VGND sky130_ef_sc_hd__decap_12
XFILLER_181_697 VPWR VGND VPWR VGND sky130_ef_sc_hd__decap_12
XFILLER_84_1165 VPWR VGND VPWR VGND sky130_ef_sc_hd__decap_12
XFILLER_171_1113 VGND VGND VPWR VPWR sky130_fd_sc_hd__decap_6
XFILLER_253_1457 VPWR VGND VPWR VGND sky130_ef_sc_hd__decap_12
XTAP_TAPCELL_ROW_55_2_4087 VGND VPWR sky130_fd_sc_hd__tapvpwrvgnd_1
XFILLER_171_1157 VPWR VGND VPWR VGND sky130_ef_sc_hd__decap_12
XFILLER_62_1463 VGND VGND VPWR VPWR sky130_fd_sc_hd__decap_6
XFILLER_208_301 VGND VGND VPWR VPWR sky130_fd_sc_hd__decap_6
XFILLER_57_70 VGND VGND VPWR VPWR sky130_fd_sc_hd__fill_1
XFILLER_236_643 VGND VGND VPWR VPWR sky130_fd_sc_hd__fill_1
XFILLER_208_345 VPWR VGND VPWR VGND sky130_ef_sc_hd__decap_12
XFILLER_110_1439 VPWR VGND VPWR VGND sky130_ef_sc_hd__decap_12
XFILLER_224_805 VGND VGND VPWR VPWR sky130_fd_sc_hd__decap_6
XFILLER_208_389 VPWR VGND VPWR VGND sky130_ef_sc_hd__decap_12
XFILLER_224_849 VPWR VGND VPWR VGND sky130_ef_sc_hd__decap_12
XFILLER_223_337 VPWR VGND VPWR VGND sky130_ef_sc_hd__decap_12
XFILLER_1_1287 VGND VGND VPWR VPWR sky130_fd_sc_hd__fill_1
XFILLER_56_1245 VGND VGND VPWR VPWR sky130_fd_sc_hd__fill_1
XFILLER_189_753 VPWR VGND VPWR VGND sky130_ef_sc_hd__decap_12
XFILLER_182_1253 VGND VGND VPWR VPWR sky130_fd_sc_hd__decap_6
XFILLER_250_189 VGND VGND VPWR VPWR sky130_fd_sc_hd__decap_6
XFILLER_232_893 VPWR VGND VPWR VGND sky130_ef_sc_hd__decap_12
XFILLER_108_1357 VGND VGND VPWR VPWR sky130_fd_sc_hd__fill_1
XFILLER_189_797 VPWR VGND VPWR VGND sky130_ef_sc_hd__decap_12
XFILLER_182_1297 VPWR VGND VPWR VGND sky130_ef_sc_hd__decap_12
XFILLER_85_3 VPWR VGND VPWR VGND sky130_ef_sc_hd__decap_12
XTAP_TAPCELL_ROW_13_2_3833 VGND VPWR sky130_fd_sc_hd__tapvpwrvgnd_1
XFILLER_176_469 VGND VGND VPWR VPWR sky130_fd_sc_hd__decap_6
XFILLER_30_1407 VGND VGND VPWR VPWR sky130_fd_sc_hd__decap_6
XFILLER_191_417 VPWR VGND VPWR VGND sky130_ef_sc_hd__decap_12
XTAP_TAPCELL_ROW_174_1574 VGND VPWR sky130_fd_sc_hd__tapvpwrvgnd_1
XTAP_TAPCELL_ROW_174_1585 VGND VPWR sky130_fd_sc_hd__tapvpwrvgnd_1
XFILLER_8_693 VGND VGND VPWR VPWR sky130_fd_sc_hd__decap_6
XTAP_TAPCELL_ROW_174_1596 VGND VPWR sky130_fd_sc_hd__tapvpwrvgnd_1
XFILLER_7_192 VGND VGND VPWR VPWR sky130_fd_sc_hd__fill_1
XFILLER_176_1035 VGND VGND VPWR VPWR sky130_fd_sc_hd__fill_1
XFILLER_208_65 VPWR VGND VPWR VGND sky130_ef_sc_hd__decap_12
XFILLER_28_1303 VPWR VGND VPWR VGND sky130_ef_sc_hd__decap_12
XFILLER_217_1021 VPWR VGND VPWR VGND sky130_ef_sc_hd__decap_12
XFILLER_67_1385 VGND VGND VPWR VPWR sky130_fd_sc_hd__fill_1
XTAP_TAPCELL_ROW_187_1924 VGND VPWR sky130_fd_sc_hd__tapvpwrvgnd_1
XTAP_TAPCELL_ROW_187_1935 VGND VPWR sky130_fd_sc_hd__tapvpwrvgnd_1
XFILLER_193_1393 VGND VGND VPWR VPWR sky130_fd_sc_hd__decap_6
XFILLER_217_1065 VPWR VGND VPWR VGND sky130_ef_sc_hd__decap_12
XTAP_TAPCELL_ROW_187_1946 VGND VPWR sky130_fd_sc_hd__tapvpwrvgnd_1
XFILLER_119_1497 VGND VGND VPWR VPWR sky130_fd_sc_hd__fill_1
XFILLER_218_109 VPWR VGND VPWR VGND sky130_ef_sc_hd__decap_12
XFILLER_224_53 VPWR VGND VPWR VGND sky130_ef_sc_hd__decap_12
XTAP_TAPCELL_ROW_144_2_4619 VGND VPWR sky130_fd_sc_hd__tapvpwrvgnd_1
XFILLER_224_97 VPWR VGND VPWR VGND sky130_ef_sc_hd__decap_12
XFILLER_2_1029 VGND VGND VPWR VPWR sky130_fd_sc_hd__decap_6
XFILLER_227_665 VGND VGND VPWR VPWR sky130_fd_sc_hd__decap_6
XFILLER_226_153 VPWR VGND VPWR VGND sky130_ef_sc_hd__decap_12
XFILLER_242_613 VPWR VGND VPWR VGND sky130_ef_sc_hd__decap_12
XFILLER_240_41 VPWR VGND VPWR VGND sky130_ef_sc_hd__decap_12
XFILLER_199_517 VPWR VGND VPWR VGND sky130_ef_sc_hd__decap_12
XFILLER_187_1175 VGND VGND VPWR VPWR sky130_fd_sc_hd__fill_1
XFILLER_74_1301 VGND VGND VPWR VPWR sky130_fd_sc_hd__fill_1
XFILLER_226_197 VPWR VGND VPWR VGND sky130_ef_sc_hd__decap_12
XFILLER_242_657 VPWR VGND VPWR VGND sky130_ef_sc_hd__decap_12
XFILLER_240_85 VPWR VGND VPWR VGND sky130_ef_sc_hd__decap_12
XFILLER_53_39 VPWR VGND VPWR VGND sky130_ef_sc_hd__decap_12
XFILLER_39_1443 VPWR VGND VPWR VGND sky130_ef_sc_hd__decap_12
XPHY_EDGE_ROW_125_2_Left_627 VGND VGND VPWR VPWR sky130_fd_sc_hd__decap_3
XFILLER_228_1161 VPWR VGND VPWR VGND sky130_ef_sc_hd__decap_12
XFILLER_241_167 VGND VGND VPWR VPWR sky130_fd_sc_hd__fill_1
XFILLER_126_1413 VGND VGND VPWR VPWR sky130_fd_sc_hd__fill_1
XPHY_EDGE_ROW_125_1_Right_781 VGND VGND VPWR VPWR sky130_fd_sc_hd__decap_3
XFILLER_169_39 VPWR VGND VPWR VGND sky130_ef_sc_hd__decap_12
XFILLER_35_1329 VGND VGND VPWR VPWR sky130_fd_sc_hd__fill_1
XTAP_TAPCELL_ROW_92_2_4306 VGND VPWR sky130_fd_sc_hd__tapvpwrvgnd_1
XFILLER_168_937 VPWR VGND VPWR VGND sky130_ef_sc_hd__decap_12
XFILLER_167_447 VGND VGND VPWR VPWR sky130_fd_sc_hd__fill_1
XFILLER_194_233 VPWR VGND VPWR VGND sky130_ef_sc_hd__decap_12
XFILLER_210_587 VGND VGND VPWR VPWR sky130_fd_sc_hd__fill_1
XTAP_TAPCELL_ROW_252_3685 VGND VPWR sky130_fd_sc_hd__tapvpwrvgnd_1
XTAP_TAPCELL_ROW_252_3696 VGND VPWR sky130_fd_sc_hd__tapvpwrvgnd_1
XFILLER_176_981 VPWR VGND VPWR VGND sky130_ef_sc_hd__decap_12
XFILLER_194_277 VPWR VGND VPWR VGND sky130_ef_sc_hd__decap_12
XFILLER_185_27 VPWR VGND VPWR VGND sky130_ef_sc_hd__decap_12
XFILLER_191_951 VGND VGND VPWR VPWR sky130_fd_sc_hd__fill_1
XFILLER_159_1255 VPWR VGND VPWR VGND sky130_ef_sc_hd__decap_12
XPHY_EDGE_ROW_61_2_Right_152 VGND VGND VPWR VPWR sky130_fd_sc_hd__decap_3
XFILLER_118_65 VGND VGND VPWR VPWR sky130_fd_sc_hd__decap_6
XFILLER_85_1441 VGND VGND VPWR VPWR sky130_fd_sc_hd__fill_1
XFILLER_200_1091 VGND VGND VPWR VPWR sky130_fd_sc_hd__fill_1
XFILLER_235_1121 VPWR VGND VPWR VGND sky130_ef_sc_hd__decap_12
XFILLER_159_1299 VPWR VGND VPWR VGND sky130_ef_sc_hd__decap_12
XFILLER_249_223 VGND VGND VPWR VPWR sky130_fd_sc_hd__fill_1
XFILLER_231_1007 VGND VGND VPWR VPWR sky130_fd_sc_hd__fill_1
XFILLER_46_1469 VGND VGND VPWR VPWR sky130_fd_sc_hd__fill_1
XFILLER_172_1477 VGND VGND VPWR VPWR sky130_fd_sc_hd__decap_6
XFILLER_134_53 VPWR VGND VPWR VGND sky130_ef_sc_hd__decap_12
XFILLER_237_429 VPWR VGND VPWR VGND sky130_ef_sc_hd__decap_12
XFILLER_79_1201 VPWR VGND VPWR VGND sky130_ef_sc_hd__decap_12
XFILLER_218_643 VGND VGND VPWR VPWR sky130_fd_sc_hd__fill_1
XTAP_TAPCELL_ROW_205_2430 VGND VPWR sky130_fd_sc_hd__tapvpwrvgnd_1
X_602_ clknet_3_0__leaf_clk dout0\[0\] _010_ VGND VGND VPWR VPWR dout0_q\[0\] sky130_fd_sc_hd__dfrtp_1
XFILLER_206_805 VGND VGND VPWR VPWR sky130_fd_sc_hd__decap_6
XFILLER_27_51 VGND VGND VPWR VPWR sky130_fd_sc_hd__decap_4
XFILLER_245_473 VPWR VGND VPWR VGND sky130_ef_sc_hd__decap_12
XTAP_TAPCELL_ROW_201_2305 VGND VPWR sky130_fd_sc_hd__tapvpwrvgnd_1
XFILLER_79_1267 VGND VGND VPWR VPWR sky130_fd_sc_hd__decap_6
XFILLER_150_41 VPWR VGND VPWR VGND sky130_ef_sc_hd__decap_12
XTAP_TAPCELL_ROW_201_2316 VGND VPWR sky130_fd_sc_hd__tapvpwrvgnd_1
XFILLER_206_849 VPWR VGND VPWR VGND sky130_ef_sc_hd__decap_12
X_533_ net665 VGND VGND VPWR VPWR _015_ sky130_fd_sc_hd__inv_2
XPHY_EDGE_ROW_57_2_Left_559 VGND VGND VPWR VPWR sky130_fd_sc_hd__decap_3
XFILLER_205_337 VPWR VGND VPWR VGND sky130_ef_sc_hd__decap_12
XTAP_TAPCELL_ROW_1_880 VGND VPWR sky130_fd_sc_hd__tapvpwrvgnd_1
XTAP_TAPCELL_ROW_1_891 VGND VPWR sky130_fd_sc_hd__tapvpwrvgnd_1
XFILLER_166_1259 VGND VGND VPWR VPWR sky130_fd_sc_hd__fill_1
XFILLER_207_1201 VPWR VGND VPWR VGND sky130_ef_sc_hd__decap_12
XFILLER_246_1261 VPWR VGND VPWR VGND sky130_ef_sc_hd__decap_12
X_464_ net197 _194_ VGND VGND VPWR VPWR acc_core.adder.cla_blocks\[0\].block.sum\[1\]
+ sky130_fd_sc_hd__xnor2_1
XFILLER_220_307 VGND VGND VPWR VPWR sky130_fd_sc_hd__fill_1
XTAP_TAPCELL_ROW_193_2106 VGND VPWR sky130_fd_sc_hd__tapvpwrvgnd_1
XFILLER_186_701 VPWR VGND VPWR VGND sky130_ef_sc_hd__decap_12
XFILLER_232_189 VGND VGND VPWR VPWR sky130_fd_sc_hd__decap_6
XFILLER_207_1245 VPWR VGND VPWR VGND sky130_ef_sc_hd__decap_12
XFILLER_214_893 VPWR VGND VPWR VGND sky130_ef_sc_hd__decap_12
XFILLER_242_1147 VGND VGND VPWR VPWR sky130_fd_sc_hd__fill_1
X_395_ net591 net584 net559 VGND VGND VPWR VPWR _184_ sky130_fd_sc_hd__a21o_1
XTAP_TAPCELL_ROW_157_2_4697 VGND VPWR sky130_fd_sc_hd__tapvpwrvgnd_1
XTAP_TAPCELL_ROW_51_1_1186 VGND VPWR sky130_fd_sc_hd__tapvpwrvgnd_1
XFILLER_207_1289 VPWR VGND VPWR VGND sky130_ef_sc_hd__decap_12
XFILLER_90_1191 VPWR VGND VPWR VGND sky130_ef_sc_hd__decap_12
XFILLER_173_417 VPWR VGND VPWR VGND sky130_ef_sc_hd__decap_12
XFILLER_199_1057 VGND VGND VPWR VPWR sky130_fd_sc_hd__decap_6
XFILLER_16_1295 VGND VGND VPWR VPWR sky130_fd_sc_hd__decap_6
XFILLER_103_1243 VPWR VGND VPWR VGND sky130_ef_sc_hd__decap_12
XPHY_EDGE_ROW_138_2_Right_229 VGND VGND VPWR VPWR sky130_fd_sc_hd__decap_3
XFILLER_86_1227 VPWR VGND VPWR VGND sky130_ef_sc_hd__decap_12
XFILLER_103_1287 VPWR VGND VPWR VGND sky130_ef_sc_hd__decap_12
XFILLER_182_973 VGND VGND VPWR VPWR sky130_fd_sc_hd__decap_6
XFILLER_5_663 VGND VGND VPWR VPWR sky130_fd_sc_hd__fill_1
XFILLER_181_461 VPWR VGND VPWR VGND sky130_ef_sc_hd__decap_12
XFILLER_138_1339 VPWR VGND VPWR VGND sky130_ef_sc_hd__decap_12
XPHY_EDGE_ROW_189_Left_444 VGND VGND VPWR VPWR sky130_fd_sc_hd__decap_3
XFILLER_175_93 VPWR VGND VPWR VGND sky130_ef_sc_hd__decap_12
XFILLER_177_1399 VGND VGND VPWR VPWR sky130_fd_sc_hd__fill_1
XFILLER_218_1341 VPWR VGND VPWR VGND sky130_ef_sc_hd__decap_12
XFILLER_214_1205 VPWR VGND VPWR VGND sky130_ef_sc_hd__decap_12
XFILLER_4_77 VGND VGND VPWR VPWR sky130_fd_sc_hd__decap_6
XFILLER_218_1385 VPWR VGND VPWR VGND sky130_ef_sc_hd__decap_12
XFILLER_253_1287 VGND VGND VPWR VPWR sky130_fd_sc_hd__fill_1
XFILLER_62_1271 VPWR VGND VPWR VGND sky130_ef_sc_hd__decap_12
XFILLER_191_81 VPWR VGND VPWR VGND sky130_ef_sc_hd__decap_12
XTAP_TAPCELL_ROW_182_1810 VGND VPWR sky130_fd_sc_hd__tapvpwrvgnd_1
XFILLER_255_237 VPWR VGND VPWR VGND sky130_ef_sc_hd__decap_12
XPHY_EDGE_ROW_123_1_Left_378 VGND VGND VPWR VPWR sky130_fd_sc_hd__decap_3
XFILLER_23_1255 VPWR VGND VPWR VGND sky130_ef_sc_hd__decap_12
XFILLER_110_1203 VPWR VGND VPWR VGND sky130_ef_sc_hd__decap_12
XFILLER_114_1383 VPWR VGND VPWR VGND sky130_ef_sc_hd__decap_12
XFILLER_97_1323 VGND VGND VPWR VPWR sky130_fd_sc_hd__decap_6
XFILLER_209_665 VGND VGND VPWR VPWR sky130_fd_sc_hd__decap_6
XFILLER_208_153 VPWR VGND VPWR VGND sky130_ef_sc_hd__decap_12
XFILLER_224_613 VPWR VGND VPWR VGND sky130_ef_sc_hd__decap_12
XFILLER_23_1299 VPWR VGND VPWR VGND sky130_ef_sc_hd__decap_12
XFILLER_110_1247 VPWR VGND VPWR VGND sky130_ef_sc_hd__decap_12
XFILLER_97_1367 VPWR VGND VPWR VGND sky130_ef_sc_hd__decap_12
XTAP_TAPCELL_ROW_110_2_4414 VGND VPWR sky130_fd_sc_hd__tapvpwrvgnd_1
XFILLER_184_1315 VGND VGND VPWR VPWR sky130_fd_sc_hd__fill_1
XTAP_TAPCELL_ROW_109_2_4408 VGND VPWR sky130_fd_sc_hd__tapvpwrvgnd_1
XFILLER_149_1435 VGND VGND VPWR VPWR sky130_fd_sc_hd__decap_6
XPHY_EDGE_ROW_198_Left_453 VGND VGND VPWR VPWR sky130_fd_sc_hd__decap_3
XFILLER_208_197 VPWR VGND VPWR VGND sky130_ef_sc_hd__decap_12
XPHY_EDGE_ROW_60_1_Left_315 VGND VGND VPWR VPWR sky130_fd_sc_hd__decap_3
XFILLER_224_657 VPWR VGND VPWR VGND sky130_ef_sc_hd__decap_12
XFILLER_149_1479 VPWR VGND VPWR VGND sky130_ef_sc_hd__decap_12
XFILLER_225_1301 VPWR VGND VPWR VGND sky130_ef_sc_hd__decap_12
XFILLER_223_167 VGND VGND VPWR VPWR sky130_fd_sc_hd__fill_1
XFILLER_229_1481 VPWR VGND VPWR VGND sky130_ef_sc_hd__decap_12
XFILLER_189_561 VPWR VGND VPWR VGND sky130_ef_sc_hd__decap_12
XTAP_TAPCELL_ROW_77_2_4219 VGND VPWR sky130_fd_sc_hd__tapvpwrvgnd_1
XFILLER_211_329 VGND VGND VPWR VPWR sky130_fd_sc_hd__decap_6
XFILLER_182_1061 VPWR VGND VPWR VGND sky130_ef_sc_hd__decap_12
XFILLER_225_1345 VPWR VGND VPWR VGND sky130_ef_sc_hd__decap_12
XFILLER_210_77 VGND VGND VPWR VPWR sky130_fd_sc_hd__decap_6
XTAP_TAPCELL_ROW_176_1625 VGND VPWR sky130_fd_sc_hd__tapvpwrvgnd_1
XFILLER_108_1165 VPWR VGND VPWR VGND sky130_ef_sc_hd__decap_12
XTAP_TAPCELL_ROW_176_1636 VGND VPWR sky130_fd_sc_hd__tapvpwrvgnd_1
XFILLER_176_233 VPWR VGND VPWR VGND sky130_ef_sc_hd__decap_12
XTAP_TAPCELL_ROW_176_1647 VGND VPWR sky130_fd_sc_hd__tapvpwrvgnd_1
XFILLER_34_1351 VGND VGND VPWR VPWR sky130_fd_sc_hd__decap_6
Xclkbuf_3_2__f_clk clknet_0_clk VGND VGND VPWR VPWR clknet_3_2__leaf_clk sky130_fd_sc_hd__clkbuf_16
XFILLER_176_277 VPWR VGND VPWR VGND sky130_ef_sc_hd__decap_12
XFILLER_30_1215 VPWR VGND VPWR VGND sky130_ef_sc_hd__decap_12
XFILLER_192_737 VPWR VGND VPWR VGND sky130_ef_sc_hd__decap_12
XFILLER_34_1395 VPWR VGND VPWR VGND sky130_ef_sc_hd__decap_12
XFILLER_121_1343 VPWR VGND VPWR VGND sky130_ef_sc_hd__decap_12
XFILLER_191_225 VPWR VGND VPWR VGND sky130_ef_sc_hd__decap_12
XFILLER_173_951 VGND VGND VPWR VPWR sky130_fd_sc_hd__fill_1
XFILLER_30_1259 VPWR VGND VPWR VGND sky130_ef_sc_hd__decap_12
XFILLER_121_1387 VPWR VGND VPWR VGND sky130_ef_sc_hd__decap_12
XFILLER_195_1455 VGND VGND VPWR VPWR sky130_fd_sc_hd__fill_1
XFILLER_254_1029 VGND VGND VPWR VPWR sky130_fd_sc_hd__decap_6
XFILLER_156_1439 VPWR VGND VPWR VGND sky130_ef_sc_hd__decap_12
XFILLER_236_1441 VPWR VGND VPWR VGND sky130_ef_sc_hd__decap_12
XFILLER_8_1205 VPWR VGND VPWR VGND sky130_ef_sc_hd__decap_12
XFILLER_236_1485 VPWR VGND VPWR VGND sky130_ef_sc_hd__decap_12
XFILLER_28_1177 VPWR VGND VPWR VGND sky130_ef_sc_hd__decap_12
XFILLER_247_727 VGND VGND VPWR VPWR sky130_fd_sc_hd__fill_1
XFILLER_219_429 VPWR VGND VPWR VGND sky130_ef_sc_hd__decap_12
XFILLER_41_1311 VPWR VGND VPWR VGND sky130_ef_sc_hd__decap_12
XFILLER_45_1491 VGND VGND VPWR VPWR sky130_fd_sc_hd__decap_6
XFILLER_80_1371 VPWR VGND VPWR VGND sky130_ef_sc_hd__decap_12
XFILLER_41_1355 VPWR VGND VPWR VGND sky130_ef_sc_hd__decap_12
XFILLER_251_51 VGND VGND VPWR VPWR sky130_fd_sc_hd__decap_4
XFILLER_132_1483 VPWR VGND VPWR VGND sky130_ef_sc_hd__decap_12
XFILLER_230_1073 VPWR VGND VPWR VGND sky130_ef_sc_hd__decap_12
XTAP_TAPCELL_ROW_241_3386 VGND VPWR sky130_fd_sc_hd__tapvpwrvgnd_1
XTAP_TAPCELL_ROW_241_3397 VGND VPWR sky130_fd_sc_hd__tapvpwrvgnd_1
XFILLER_167_1513 VGND VGND VPWR VPWR sky130_fd_sc_hd__fill_2
XFILLER_227_473 VPWR VGND VPWR VGND sky130_ef_sc_hd__decap_12
XFILLER_243_933 VPWR VGND VPWR VGND sky130_ef_sc_hd__decap_12
XFILLER_41_1399 VPWR VGND VPWR VGND sky130_ef_sc_hd__decap_12
XFILLER_76_1407 VGND VGND VPWR VPWR sky130_fd_sc_hd__decap_6
XFILLER_242_421 VPWR VGND VPWR VGND sky130_ef_sc_hd__decap_12
XFILLER_243_977 VPWR VGND VPWR VGND sky130_ef_sc_hd__decap_12
XFILLER_243_1401 VPWR VGND VPWR VGND sky130_ef_sc_hd__decap_12
XFILLER_202_307 VGND VGND VPWR VPWR sky130_fd_sc_hd__fill_1
XFILLER_168_701 VPWR VGND VPWR VGND sky130_ef_sc_hd__decap_12
XFILLER_214_189 VGND VGND VPWR VPWR sky130_fd_sc_hd__decap_6
XTAP_TAPCELL_ROW_254_3736 VGND VPWR sky130_fd_sc_hd__tapvpwrvgnd_1
XFILLER_39_1273 VGND VGND VPWR VPWR sky130_fd_sc_hd__fill_1
XTAP_TAPCELL_ROW_254_3747 VGND VPWR sky130_fd_sc_hd__tapvpwrvgnd_1
XFILLER_80_15 VPWR VGND VPWR VGND sky130_ef_sc_hd__decap_12
XFILLER_211_841 VPWR VGND VPWR VGND sky130_ef_sc_hd__decap_12
XPHY_EDGE_ROW_202_Left_457 VGND VGND VPWR VPWR sky130_fd_sc_hd__decap_3
XPHY_EDGE_ROW_126_1_Right_782 VGND VGND VPWR VPWR sky130_fd_sc_hd__decap_3
XFILLER_196_15 VPWR VGND VPWR VGND sky130_ef_sc_hd__decap_12
XFILLER_204_1429 VPWR VGND VPWR VGND sky130_ef_sc_hd__decap_12
XFILLER_195_553 VGND VGND VPWR VPWR sky130_fd_sc_hd__decap_6
XFILLER_52_1451 VPWR VGND VPWR VGND sky130_ef_sc_hd__decap_12
XFILLER_161_1189 VPWR VGND VPWR VGND sky130_ef_sc_hd__decap_12
XTAP_TAPCELL_ROW_123_2_4492 VGND VPWR sky130_fd_sc_hd__tapvpwrvgnd_1
XFILLER_195_597 VPWR VGND VPWR VGND sky130_ef_sc_hd__decap_12
XFILLER_13_1435 VGND VGND VPWR VPWR sky130_fd_sc_hd__decap_6
XFILLER_52_1495 VPWR VGND VPWR VGND sky130_ef_sc_hd__decap_12
XFILLER_13_1479 VPWR VGND VPWR VGND sky130_ef_sc_hd__decap_12
XFILLER_100_1427 VPWR VGND VPWR VGND sky130_ef_sc_hd__decap_12
XFILLER_202_3 VPWR VGND VPWR VGND sky130_ef_sc_hd__decap_12
XFILLER_202_1197 VGND VGND VPWR VPWR sky130_fd_sc_hd__decap_6
XFILLER_89_57 VPWR VGND VPWR VGND sky130_ef_sc_hd__decap_12
XFILLER_2_600 VGND VGND VPWR VPWR sky130_fd_sc_hd__fill_1
XPHY_EDGE_ROW_62_2_Right_153 VGND VGND VPWR VPWR sky130_fd_sc_hd__decap_3
XFILLER_172_1241 VPWR VGND VPWR VGND sky130_ef_sc_hd__decap_12
XPHY_EDGE_ROW_211_Left_466 VGND VGND VPWR VPWR sky130_fd_sc_hd__decap_3
XFILLER_250_1427 VGND VGND VPWR VPWR sky130_fd_sc_hd__fill_1
XFILLER_2_699 VGND VGND VPWR VPWR sky130_fd_sc_hd__fill_1
XFILLER_1_198 VGND VGND VPWR VPWR sky130_fd_sc_hd__decap_6
XFILLER_172_1285 VPWR VGND VPWR VGND sky130_ef_sc_hd__decap_12
XFILLER_238_749 VGND VGND VPWR VPWR sky130_fd_sc_hd__decap_6
XFILLER_237_237 VPWR VGND VPWR VGND sky130_ef_sc_hd__decap_12
XFILLER_161_51 VGND VGND VPWR VPWR sky130_fd_sc_hd__decap_4
XFILLER_20_1439 VPWR VGND VPWR VGND sky130_ef_sc_hd__decap_12
XFILLER_206_613 VPWR VGND VPWR VGND sky130_ef_sc_hd__decap_12
XFILLER_246_793 VPWR VGND VPWR VGND sky130_ef_sc_hd__decap_12
XFILLER_94_1507 VGND VGND VPWR VPWR sky130_fd_sc_hd__decap_8
XFILLER_245_281 VPWR VGND VPWR VGND sky130_ef_sc_hd__decap_12
XFILLER_206_657 VPWR VGND VPWR VGND sky130_ef_sc_hd__decap_12
XFILLER_2_1371 VGND VGND VPWR VPWR sky130_fd_sc_hd__fill_1
X_516_ _260_ _266_ VGND VGND VPWR VPWR acc_core.adder.cla_blocks\[7\].block.sum\[3\]
+ sky130_fd_sc_hd__xnor2_1
XFILLER_205_167 VGND VGND VPWR VPWR sky130_fd_sc_hd__fill_1
XPHY_EDGE_ROW_220_Left_475 VGND VGND VPWR VPWR sky130_fd_sc_hd__decap_3
XFILLER_109_1441 VGND VGND VPWR VPWR sky130_fd_sc_hd__fill_1
XFILLER_246_1091 VGND VGND VPWR VPWR sky130_fd_sc_hd__fill_1
X_447_ net127 net500 net88 net117 _095_ VGND VGND VPWR VPWR _236_ sky130_fd_sc_hd__o311a_1
XFILLER_183_1381 VPWR VGND VPWR VGND sky130_ef_sc_hd__decap_12
XFILLER_18_1357 VGND VGND VPWR VPWR sky130_fd_sc_hd__fill_1
XFILLER_186_531 VGND VGND VPWR VPWR sky130_fd_sc_hd__fill_1
XFILLER_9_221 VGND VGND VPWR VPWR sky130_fd_sc_hd__decap_3
XTAP_TAPCELL_ROW_43_2_4014 VGND VPWR sky130_fd_sc_hd__tapvpwrvgnd_1
X_378_ net591 net578 net552 VGND VGND VPWR VPWR _167_ sky130_fd_sc_hd__and3_1
XFILLER_201_373 VPWR VGND VPWR VGND sky130_ef_sc_hd__decap_12
XFILLER_9_265 VPWR VGND VPWR VGND sky130_ef_sc_hd__decap_12
XFILLER_174_737 VPWR VGND VPWR VGND sky130_ef_sc_hd__decap_12
XTAP_TAPCELL_ROW_171_1500 VGND VPWR sky130_fd_sc_hd__tapvpwrvgnd_1
XFILLER_173_225 VPWR VGND VPWR VGND sky130_ef_sc_hd__decap_12
XFILLER_220_1253 VGND VGND VPWR VPWR sky130_fd_sc_hd__decap_6
XTAP_TAPCELL_ROW_171_1511 VGND VPWR sky130_fd_sc_hd__tapvpwrvgnd_1
XFILLER_6_961 VPWR VGND VPWR VGND sky130_ef_sc_hd__decap_12
XFILLER_220_1297 VPWR VGND VPWR VGND sky130_ef_sc_hd__decap_12
XFILLER_182_781 VPWR VGND VPWR VGND sky130_ef_sc_hd__decap_12
XFILLER_48_3 VPWR VGND VPWR VGND sky130_ef_sc_hd__decap_12
XFILLER_190_1341 VPWR VGND VPWR VGND sky130_ef_sc_hd__decap_12
XTAP_TAPCELL_ROW_169_1440 VGND VPWR sky130_fd_sc_hd__tapvpwrvgnd_1
XTAP_TAPCELL_ROW_169_1451 VGND VPWR sky130_fd_sc_hd__tapvpwrvgnd_1
XFILLER_29_1497 VGND VGND VPWR VPWR sky130_fd_sc_hd__fill_1
XFILLER_214_1035 VGND VGND VPWR VPWR sky130_fd_sc_hd__fill_1
XFILLER_229_727 VGND VGND VPWR VPWR sky130_fd_sc_hd__fill_1
XTAP_TAPCELL_ROW_165_1304 VGND VPWR sky130_fd_sc_hd__tapvpwrvgnd_1
XFILLER_190_1385 VPWR VGND VPWR VGND sky130_ef_sc_hd__decap_12
XTAP_TAPCELL_ROW_165_1315 VGND VPWR sky130_fd_sc_hd__tapvpwrvgnd_1
XFILLER_205_55 VGND VGND VPWR VPWR sky130_fd_sc_hd__fill_1
XTAP_TAPCELL_ROW_165_1326 VGND VPWR sky130_fd_sc_hd__tapvpwrvgnd_1
XTAP_TAPCELL_ROW_165_1337 VGND VPWR sky130_fd_sc_hd__tapvpwrvgnd_1
XTAP_TAPCELL_ROW_165_1348 VGND VPWR sky130_fd_sc_hd__tapvpwrvgnd_1
XFILLER_3_1113 VGND VGND VPWR VPWR sky130_fd_sc_hd__decap_6
XFILLER_231_1393 VGND VGND VPWR VPWR sky130_fd_sc_hd__decap_6
XFILLER_114_1191 VPWR VGND VPWR VGND sky130_ef_sc_hd__decap_12
XFILLER_209_473 VPWR VGND VPWR VGND sky130_ef_sc_hd__decap_12
XFILLER_3_1157 VPWR VGND VPWR VGND sky130_ef_sc_hd__decap_12
XFILLER_225_933 VPWR VGND VPWR VGND sky130_ef_sc_hd__decap_12
XFILLER_224_421 VPWR VGND VPWR VGND sky130_ef_sc_hd__decap_12
XFILLER_149_1243 VPWR VGND VPWR VGND sky130_ef_sc_hd__decap_12
XFILLER_225_977 VPWR VGND VPWR VGND sky130_ef_sc_hd__decap_12
XFILLER_240_925 VPWR VGND VPWR VGND sky130_ef_sc_hd__decap_12
XFILLER_149_1287 VPWR VGND VPWR VGND sky130_ef_sc_hd__decap_12
XFILLER_251_273 VGND VGND VPWR VPWR sky130_fd_sc_hd__decap_6
XFILLER_36_1413 VGND VGND VPWR VPWR sky130_fd_sc_hd__fill_1
XFILLER_211_137 VPWR VGND VPWR VGND sky130_ef_sc_hd__decap_12
XFILLER_189_391 VGND VGND VPWR VPWR sky130_fd_sc_hd__fill_1
XFILLER_225_1175 VGND VGND VPWR VPWR sky130_fd_sc_hd__fill_1
XFILLER_177_553 VGND VGND VPWR VPWR sky130_fd_sc_hd__decap_6
XFILLER_192_501 VPWR VGND VPWR VGND sky130_ef_sc_hd__decap_12
XFILLER_220_693 VGND VGND VPWR VPWR sky130_fd_sc_hd__decap_6
XFILLER_50_29 VPWR VGND VPWR VGND sky130_ef_sc_hd__decap_12
XFILLER_177_597 VPWR VGND VPWR VGND sky130_ef_sc_hd__decap_12
XFILLER_192_545 VPWR VGND VPWR VGND sky130_ef_sc_hd__decap_12
XTAP_TAPCELL_ROW_234_3190 VGND VPWR sky130_fd_sc_hd__tapvpwrvgnd_1
XFILLER_166_29 VPWR VGND VPWR VGND sky130_ef_sc_hd__decap_12
XFILLER_192_589 VPWR VGND VPWR VGND sky130_ef_sc_hd__decap_12
XFILLER_69_1255 VPWR VGND VPWR VGND sky130_ef_sc_hd__decap_12
XFILLER_156_1203 VPWR VGND VPWR VGND sky130_ef_sc_hd__decap_12
XTAP_TAPCELL_ROW_230_3087 VGND VPWR sky130_fd_sc_hd__tapvpwrvgnd_1
XTAP_TAPCELL_ROW_230_3098 VGND VPWR sky130_fd_sc_hd__tapvpwrvgnd_1
XFILLER_59_27 VPWR VGND VPWR VGND sky130_ef_sc_hd__decap_12
XFILLER_69_1299 VPWR VGND VPWR VGND sky130_ef_sc_hd__decap_12
XFILLER_156_1247 VPWR VGND VPWR VGND sky130_ef_sc_hd__decap_12
XTAP_TAPCELL_ROW_247_3551 VGND VPWR sky130_fd_sc_hd__tapvpwrvgnd_1
XTAP_TAPCELL_ROW_101_2_4359 VGND VPWR sky130_fd_sc_hd__tapvpwrvgnd_1
XTAP_TAPCELL_ROW_56_2_4092 VGND VPWR sky130_fd_sc_hd__tapvpwrvgnd_1
XTAP_TAPCELL_ROW_247_3562 VGND VPWR sky130_fd_sc_hd__tapvpwrvgnd_1
XFILLER_8_1035 VGND VGND VPWR VPWR sky130_fd_sc_hd__fill_1
XTAP_TAPCELL_ROW_243_3437 VGND VPWR sky130_fd_sc_hd__tapvpwrvgnd_1
XTAP_TAPCELL_ROW_243_3448 VGND VPWR sky130_fd_sc_hd__tapvpwrvgnd_1
XFILLER_115_55 VGND VGND VPWR VPWR sky130_fd_sc_hd__fill_1
XTAP_TAPCELL_ROW_243_3459 VGND VPWR sky130_fd_sc_hd__tapvpwrvgnd_1
XFILLER_189_1001 VGND VGND VPWR VPWR sky130_fd_sc_hd__decap_6
XFILLER_75_15 VPWR VGND VPWR VGND sky130_ef_sc_hd__decap_12
XFILLER_219_237 VPWR VGND VPWR VGND sky130_ef_sc_hd__decap_12
XTAP_TAPCELL_ROW_3_931 VGND VPWR sky130_fd_sc_hd__tapvpwrvgnd_1
XTAP_TAPCELL_ROW_3_942 VGND VPWR sky130_fd_sc_hd__tapvpwrvgnd_1
XFILLER_189_1045 VPWR VGND VPWR VGND sky130_ef_sc_hd__decap_12
XTAP_TAPCELL_ROW_9_1096 VGND VPWR sky130_fd_sc_hd__tapvpwrvgnd_1
XTAP_TAPCELL_ROW_3_953 VGND VPWR sky130_fd_sc_hd__tapvpwrvgnd_1
XFILLER_228_793 VPWR VGND VPWR VGND sky130_ef_sc_hd__decap_12
XFILLER_189_1089 VPWR VGND VPWR VGND sky130_ef_sc_hd__decap_12
XFILLER_210_1477 VGND VGND VPWR VPWR sky130_fd_sc_hd__decap_6
XFILLER_227_281 VPWR VGND VPWR VGND sky130_ef_sc_hd__decap_12
XFILLER_243_741 VPWR VGND VPWR VGND sky130_ef_sc_hd__decap_12
XFILLER_76_1215 VPWR VGND VPWR VGND sky130_ef_sc_hd__decap_12
XFILLER_199_111 VGND VGND VPWR VPWR sky130_fd_sc_hd__fill_1
XFILLER_167_1343 VGND VGND VPWR VPWR sky130_fd_sc_hd__fill_1
XFILLER_242_251 VGND VGND VPWR VPWR sky130_fd_sc_hd__fill_1
XFILLER_243_785 VPWR VGND VPWR VGND sky130_ef_sc_hd__decap_12
XFILLER_76_1259 VPWR VGND VPWR VGND sky130_ef_sc_hd__decap_12
XFILLER_128_1327 VPWR VGND VPWR VGND sky130_ef_sc_hd__decap_12
XFILLER_230_413 VGND VGND VPWR VPWR sky130_fd_sc_hd__decap_6
XFILLER_152_3 VPWR VGND VPWR VGND sky130_ef_sc_hd__decap_12
XFILLER_187_317 VPWR VGND VPWR VGND sky130_ef_sc_hd__decap_12
X_301_ net518 VGND VGND VPWR VPWR _090_ sky130_fd_sc_hd__inv_2
XFILLER_243_1231 VGND VGND VPWR VPWR sky130_fd_sc_hd__fill_1
XFILLER_91_69 VGND VGND VPWR VPWR sky130_fd_sc_hd__fill_2
XFILLER_24_41 VGND VGND VPWR VPWR sky130_fd_sc_hd__decap_6
XFILLER_230_457 VPWR VGND VPWR VGND sky130_ef_sc_hd__decap_12
XFILLER_168_531 VGND VGND VPWR VPWR sky130_fd_sc_hd__fill_1
XFILLER_208_1373 VPWR VGND VPWR VGND sky130_ef_sc_hd__decap_12
XFILLER_211_671 VGND VGND VPWR VPWR sky130_fd_sc_hd__fill_1
Xwire601 net602 VGND VGND VPWR VPWR net601 sky130_fd_sc_hd__clkbuf_1
XPHY_EDGE_ROW_127_1_Right_783 VGND VGND VPWR VPWR sky130_fd_sc_hd__decap_3
XFILLER_195_361 VPWR VGND VPWR VGND sky130_ef_sc_hd__decap_12
XFILLER_204_1259 VGND VGND VPWR VPWR sky130_fd_sc_hd__fill_1
Xwire634 net34 VGND VGND VPWR VPWR net634 sky130_fd_sc_hd__buf_1
Xwire645 net25 VGND VGND VPWR VPWR net645 sky130_fd_sc_hd__buf_1
XFILLER_196_1005 VPWR VGND VPWR VGND sky130_ef_sc_hd__decap_12
XFILLER_13_1243 VPWR VGND VPWR VGND sky130_ef_sc_hd__decap_12
Xwire656 net16 VGND VGND VPWR VPWR net656 sky130_fd_sc_hd__buf_1
XFILLER_6_246 VGND VGND VPWR VPWR sky130_fd_sc_hd__fill_2
XFILLER_87_1311 VPWR VGND VPWR VGND sky130_ef_sc_hd__decap_12
XFILLER_104_1371 VPWR VGND VPWR VGND sky130_ef_sc_hd__decap_12
XFILLER_196_1049 VPWR VGND VPWR VGND sky130_ef_sc_hd__decap_12
XFILLER_6_257 VGND VGND VPWR VPWR sky130_fd_sc_hd__decap_4
XFILLER_171_729 VPWR VGND VPWR VGND sky130_ef_sc_hd__decap_12
XFILLER_13_1287 VPWR VGND VPWR VGND sky130_ef_sc_hd__decap_12
XFILLER_87_1355 VPWR VGND VPWR VGND sky130_ef_sc_hd__decap_12
XFILLER_139_1423 VPWR VGND VPWR VGND sky130_ef_sc_hd__decap_12
XFILLER_178_1483 VGND VGND VPWR VPWR sky130_fd_sc_hd__fill_1
XTAP_TAPCELL_ROW_46_1_1181 VGND VPWR sky130_fd_sc_hd__tapvpwrvgnd_1
XFILLER_83_1219 VPWR VGND VPWR VGND sky130_ef_sc_hd__decap_12
XFILLER_237_1057 VGND VGND VPWR VPWR sky130_fd_sc_hd__decap_6
XFILLER_48_1339 VPWR VGND VPWR VGND sky130_ef_sc_hd__decap_12
XFILLER_3_953 VPWR VGND VPWR VGND sky130_ef_sc_hd__decap_12
XFILLER_87_1399 VPWR VGND VPWR VGND sky130_ef_sc_hd__decap_12
XFILLER_139_1467 VPWR VGND VPWR VGND sky130_ef_sc_hd__decap_12
XPHY_EDGE_ROW_63_2_Right_154 VGND VGND VPWR VPWR sky130_fd_sc_hd__decap_3
XFILLER_254_1371 VGND VGND VPWR VPWR sky130_fd_sc_hd__fill_1
XFILLER_238_513 VPWR VGND VPWR VGND sky130_ef_sc_hd__decap_12
XFILLER_172_1093 VPWR VGND VPWR VGND sky130_ef_sc_hd__decap_12
XTAP_TAPCELL_ROW_145_2_4624 VGND VPWR sky130_fd_sc_hd__tapvpwrvgnd_1
XFILLER_238_557 VPWR VGND VPWR VGND sky130_ef_sc_hd__decap_12
XFILLER_1_23 VPWR VGND VPWR VGND sky130_ef_sc_hd__decap_12
XFILLER_172_83 VGND VGND VPWR VPWR sky130_fd_sc_hd__fill_1
XFILLER_215_1399 VGND VGND VPWR VPWR sky130_fd_sc_hd__fill_1
XFILLER_253_505 VPWR VGND VPWR VGND sky130_ef_sc_hd__decap_12
XTAP_TAPCELL_ROW_226_2978 VGND VPWR sky130_fd_sc_hd__tapvpwrvgnd_1
XFILLER_20_1203 VPWR VGND VPWR VGND sky130_ef_sc_hd__decap_12
XTAP_TAPCELL_ROW_226_2989 VGND VPWR sky130_fd_sc_hd__tapvpwrvgnd_1
XFILLER_24_1383 VPWR VGND VPWR VGND sky130_ef_sc_hd__decap_12
XFILLER_111_1331 VPWR VGND VPWR VGND sky130_ef_sc_hd__decap_12
XFILLER_98_1451 VPWR VGND VPWR VGND sky130_ef_sc_hd__decap_12
XFILLER_168_1129 VPWR VGND VPWR VGND sky130_ef_sc_hd__decap_12
XFILLER_207_933 VPWR VGND VPWR VGND sky130_ef_sc_hd__decap_12
XFILLER_4_1477 VGND VGND VPWR VPWR sky130_fd_sc_hd__decap_6
XFILLER_20_1247 VPWR VGND VPWR VGND sky130_ef_sc_hd__decap_12
XFILLER_206_421 VPWR VGND VPWR VGND sky130_ef_sc_hd__decap_12
XFILLER_59_1435 VGND VGND VPWR VPWR sky130_fd_sc_hd__decap_6
XFILLER_94_1315 VPWR VGND VPWR VGND sky130_ef_sc_hd__decap_12
XFILLER_98_1495 VPWR VGND VPWR VGND sky130_ef_sc_hd__decap_12
XFILLER_207_977 VPWR VGND VPWR VGND sky130_ef_sc_hd__decap_12
XFILLER_244_1017 VPWR VGND VPWR VGND sky130_ef_sc_hd__decap_12
XFILLER_94_1359 VPWR VGND VPWR VGND sky130_ef_sc_hd__decap_12
XFILLER_222_925 VPWR VGND VPWR VGND sky130_ef_sc_hd__decap_12
XFILLER_59_1479 VPWR VGND VPWR VGND sky130_ef_sc_hd__decap_12
XFILLER_146_1427 VPWR VGND VPWR VGND sky130_ef_sc_hd__decap_12
XFILLER_233_273 VGND VGND VPWR VPWR sky130_fd_sc_hd__decap_6
XFILLER_248_1197 VGND VGND VPWR VPWR sky130_fd_sc_hd__decap_6
XTAP_TAPCELL_ROW_93_2_4311 VGND VPWR sky130_fd_sc_hd__tapvpwrvgnd_1
XFILLER_222_1315 VGND VGND VPWR VPWR sky130_fd_sc_hd__fill_1
XFILLER_18_1165 VPWR VGND VPWR VGND sky130_ef_sc_hd__decap_12
XFILLER_174_501 VPWR VGND VPWR VGND sky130_ef_sc_hd__decap_12
XFILLER_187_895 VGND VGND VPWR VPWR sky130_fd_sc_hd__fill_1
XFILLER_202_693 VGND VGND VPWR VPWR sky130_fd_sc_hd__decap_6
XFILLER_201_181 VPWR VGND VPWR VGND sky130_ef_sc_hd__decap_12
XFILLER_174_545 VPWR VGND VPWR VGND sky130_ef_sc_hd__decap_12
XFILLER_179_1225 VGND VGND VPWR VPWR sky130_fd_sc_hd__decap_6
XFILLER_31_1343 VPWR VGND VPWR VGND sky130_ef_sc_hd__decap_12
XFILLER_220_1061 VPWR VGND VPWR VGND sky130_ef_sc_hd__decap_12
XFILLER_122_1471 VPWR VGND VPWR VGND sky130_ef_sc_hd__decap_12
XFILLER_179_1269 VPWR VGND VPWR VGND sky130_ef_sc_hd__decap_12
XFILLER_174_589 VPWR VGND VPWR VGND sky130_ef_sc_hd__decap_12
XFILLER_31_1387 VPWR VGND VPWR VGND sky130_ef_sc_hd__decap_12
XTAP_TAPCELL_ROW_93_1_1228 VGND VPWR sky130_fd_sc_hd__tapvpwrvgnd_1
XFILLER_66_1439 VPWR VGND VPWR VGND sky130_ef_sc_hd__decap_12
XFILLER_118_1507 VGND VGND VPWR VPWR sky130_fd_sc_hd__decap_8
XFILLER_216_65 VPWR VGND VPWR VGND sky130_ef_sc_hd__decap_12
XPHY_EDGE_ROW_134_2_Left_636 VGND VGND VPWR VPWR sky130_fd_sc_hd__decap_3
XTAP_TAPCELL_ROW_40_2_3994 VGND VPWR sky130_fd_sc_hd__tapvpwrvgnd_1
XFILLER_233_1455 VGND VGND VPWR VPWR sky130_fd_sc_hd__fill_1
XTAP_TAPCELL_ROW_39_2_3988 VGND VPWR sky130_fd_sc_hd__tapvpwrvgnd_1
XFILLER_151_1177 VPWR VGND VPWR VGND sky130_ef_sc_hd__decap_12
XFILLER_42_1483 VPWR VGND VPWR VGND sky130_ef_sc_hd__decap_12
XFILLER_232_53 VPWR VGND VPWR VGND sky130_ef_sc_hd__decap_12
XFILLER_186_1229 VPWR VGND VPWR VGND sky130_ef_sc_hd__decap_12
XFILLER_209_281 VPWR VGND VPWR VGND sky130_ef_sc_hd__decap_12
XFILLER_225_741 VPWR VGND VPWR VGND sky130_ef_sc_hd__decap_12
XFILLER_232_97 VPWR VGND VPWR VGND sky130_ef_sc_hd__decap_12
XFILLER_224_251 VGND VGND VPWR VPWR sky130_fd_sc_hd__fill_1
XFILLER_225_785 VPWR VGND VPWR VGND sky130_ef_sc_hd__decap_12
XFILLER_197_615 VGND VGND VPWR VPWR sky130_fd_sc_hd__fill_1
XFILLER_212_413 VGND VGND VPWR VPWR sky130_fd_sc_hd__decap_6
XFILLER_169_317 VPWR VGND VPWR VGND sky130_ef_sc_hd__decap_12
XFILLER_240_755 VGND VGND VPWR VPWR sky130_fd_sc_hd__fill_1
XFILLER_101_57 VPWR VGND VPWR VGND sky130_ef_sc_hd__decap_12
XFILLER_212_457 VPWR VGND VPWR VGND sky130_ef_sc_hd__decap_12
XFILLER_205_1513 VGND VGND VPWR VPWR sky130_fd_sc_hd__fill_2
XTAP_TAPCELL_ROW_236_3252 VGND VPWR sky130_fd_sc_hd__tapvpwrvgnd_1
XFILLER_61_39 VPWR VGND VPWR VGND sky130_ef_sc_hd__decap_12
XTAP_TAPCELL_ROW_236_3263 VGND VPWR sky130_fd_sc_hd__tapvpwrvgnd_1
XFILLER_123_1213 VGND VGND VPWR VPWR sky130_fd_sc_hd__decap_4
XFILLER_184_309 VPWR VGND VPWR VGND sky130_ef_sc_hd__decap_12
XFILLER_165_501 VGND VGND VPWR VPWR sky130_fd_sc_hd__decap_3
XFILLER_177_39 VPWR VGND VPWR VGND sky130_ef_sc_hd__decap_12
XFILLER_177_361 VPWR VGND VPWR VGND sky130_ef_sc_hd__decap_12
XFILLER_193_821 VPWR VGND VPWR VGND sky130_ef_sc_hd__decap_12
XTAP_TAPCELL_ROW_232_3138 VGND VPWR sky130_fd_sc_hd__tapvpwrvgnd_1
XTAP_TAPCELL_ROW_12_2_3829 VGND VPWR sky130_fd_sc_hd__tapvpwrvgnd_1
XFILLER_162_1295 VGND VGND VPWR VPWR sky130_fd_sc_hd__decap_6
XFILLER_71_1189 VPWR VGND VPWR VGND sky130_ef_sc_hd__decap_12
XTAP_TAPCELL_ROW_232_3149 VGND VPWR sky130_fd_sc_hd__tapvpwrvgnd_1
XFILLER_165_545 VPWR VGND VPWR VGND sky130_ef_sc_hd__decap_12
XFILLER_197_1325 VPWR VGND VPWR VGND sky130_ef_sc_hd__decap_12
XFILLER_193_865 VPWR VGND VPWR VGND sky130_ef_sc_hd__decap_12
XFILLER_101_1511 VGND VGND VPWR VPWR sky130_fd_sc_hd__decap_4
XPHY_EDGE_ROW_148_1_Left_403 VGND VGND VPWR VPWR sky130_fd_sc_hd__decap_3
XFILLER_203_1281 VGND VGND VPWR VPWR sky130_fd_sc_hd__decap_6
XTAP_TAPCELL_ROW_249_3602 VGND VPWR sky130_fd_sc_hd__tapvpwrvgnd_1
XFILLER_165_589 VPWR VGND VPWR VGND sky130_ef_sc_hd__decap_12
XFILLER_197_1369 VPWR VGND VPWR VGND sky130_ef_sc_hd__decap_12
XTAP_TAPCELL_ROW_249_3613 VGND VPWR sky130_fd_sc_hd__tapvpwrvgnd_1
XFILLER_10_1427 VPWR VGND VPWR VGND sky130_ef_sc_hd__decap_12
XFILLER_4_739 VGND VGND VPWR VPWR sky130_fd_sc_hd__fill_2
XFILLER_193_27 VPWR VGND VPWR VGND sky130_ef_sc_hd__decap_12
XPHY_EDGE_ROW_66_2_Left_568 VGND VGND VPWR VPWR sky130_fd_sc_hd__decap_3
XFILLER_10_65 VGND VGND VPWR VPWR sky130_fd_sc_hd__decap_6
XFILLER_251_1511 VGND VGND VPWR VPWR sky130_fd_sc_hd__fill_1
XFILLER_126_65 VGND VGND VPWR VPWR sky130_fd_sc_hd__decap_6
XFILLER_248_811 VGND VGND VPWR VPWR sky130_fd_sc_hd__fill_1
XTAP_TAPCELL_ROW_131_2_4543 VGND VPWR sky130_fd_sc_hd__tapvpwrvgnd_1
XFILLER_235_505 VPWR VGND VPWR VGND sky130_ef_sc_hd__decap_12
XFILLER_130_1239 VGND VGND VPWR VPWR sky130_fd_sc_hd__decap_6
XFILLER_142_53 VPWR VGND VPWR VGND sky130_ef_sc_hd__decap_12
XFILLER_210_1241 VPWR VGND VPWR VGND sky130_ef_sc_hd__decap_12
XFILLER_169_1449 VGND VGND VPWR VPWR sky130_fd_sc_hd__decap_6
XFILLER_210_1285 VPWR VGND VPWR VGND sky130_ef_sc_hd__decap_12
XTAP_TAPCELL_ROW_221_2842 VGND VPWR sky130_fd_sc_hd__tapvpwrvgnd_1
XTAP_TAPCELL_ROW_221_2853 VGND VPWR sky130_fd_sc_hd__tapvpwrvgnd_1
XTAP_TAPCELL_ROW_221_2864 VGND VPWR sky130_fd_sc_hd__tapvpwrvgnd_1
XFILLER_204_925 VPWR VGND VPWR VGND sky130_ef_sc_hd__decap_12
XFILLER_245_1337 VGND VGND VPWR VPWR sky130_fd_sc_hd__decap_6
XFILLER_35_51 VGND VGND VPWR VPWR sky130_fd_sc_hd__fill_1
XFILLER_215_273 VGND VGND VPWR VPWR sky130_fd_sc_hd__decap_6
XTAP_TAPCELL_ROW_78_2_4224 VGND VPWR sky130_fd_sc_hd__tapvpwrvgnd_1
XFILLER_188_637 VGND VGND VPWR VPWR sky130_fd_sc_hd__decap_6
XFILLER_230_221 VPWR VGND VPWR VGND sky130_ef_sc_hd__decap_12
XFILLER_187_125 VPWR VGND VPWR VGND sky130_ef_sc_hd__decap_12
XFILLER_19_1441 VGND VGND VPWR VPWR sky130_fd_sc_hd__fill_1
XFILLER_231_777 VGND VGND VPWR VPWR sky130_fd_sc_hd__decap_6
XFILLER_230_265 VPWR VGND VPWR VGND sky130_ef_sc_hd__decap_12
XFILLER_187_169 VPWR VGND VPWR VGND sky130_ef_sc_hd__decap_12
XFILLER_180_1373 VPWR VGND VPWR VGND sky130_ef_sc_hd__decap_12
XFILLER_7_500 VGND VGND VPWR VPWR sky130_fd_sc_hd__fill_1
XFILLER_169_895 VGND VGND VPWR VPWR sky130_fd_sc_hd__fill_1
XFILLER_196_681 VPWR VGND VPWR VGND sky130_ef_sc_hd__decap_12
XTAP_TAPCELL_ROW_58_2_4100 VGND VPWR sky130_fd_sc_hd__tapvpwrvgnd_1
Xwire420 net421 VGND VGND VPWR VPWR net420 sky130_fd_sc_hd__clkbuf_1
Xwire431 net432 VGND VGND VPWR VPWR net431 sky130_fd_sc_hd__clkbuf_1
XPHY_EDGE_ROW_128_1_Right_784 VGND VGND VPWR VPWR sky130_fd_sc_hd__decap_3
XTAP_TAPCELL_ROW_219_2793 VGND VPWR sky130_fd_sc_hd__tapvpwrvgnd_1
Xwire442 net443 VGND VGND VPWR VPWR net442 sky130_fd_sc_hd__clkbuf_1
Xwire453 net454 VGND VGND VPWR VPWR net453 sky130_fd_sc_hd__clkbuf_1
XFILLER_141_1379 VGND VGND VPWR VPWR sky130_fd_sc_hd__decap_6
XFILLER_239_1119 VGND VGND VPWR VPWR sky130_fd_sc_hd__fill_1
Xwire464 net465 VGND VGND VPWR VPWR net464 sky130_fd_sc_hd__clkbuf_1
XPHY_EDGE_ROW_132_1_Left_387 VGND VGND VPWR VPWR sky130_fd_sc_hd__decap_3
XFILLER_221_1381 VPWR VGND VPWR VGND sky130_ef_sc_hd__decap_12
Xmax_cap208 net209 VGND VGND VPWR VPWR net208 sky130_fd_sc_hd__clkbuf_1
Xwire475 net476 VGND VGND VPWR VPWR net475 sky130_fd_sc_hd__clkbuf_1
XFILLER_176_1409 VPWR VGND VPWR VGND sky130_ef_sc_hd__decap_12
Xwire486 net487 VGND VGND VPWR VPWR net486 sky130_fd_sc_hd__clkbuf_1
XTAP_TAPCELL_ROW_215_2679 VGND VPWR sky130_fd_sc_hd__tapvpwrvgnd_1
XFILLER_7_588 VGND VGND VPWR VPWR sky130_fd_sc_hd__fill_1
XFILLER_171_559 VGND VGND VPWR VPWR sky130_fd_sc_hd__fill_1
XFILLER_139_1231 VPWR VGND VPWR VGND sky130_ef_sc_hd__decap_12
XFILLER_139_1275 VPWR VGND VPWR VGND sky130_ef_sc_hd__decap_12
XTAP_TAPCELL_ROW_154_1_1289 VGND VPWR sky130_fd_sc_hd__tapvpwrvgnd_1
XFILLER_2_282 VGND VGND VPWR VPWR sky130_fd_sc_hd__decap_3
XPHY_EDGE_ROW_64_2_Right_155 VGND VGND VPWR VPWR sky130_fd_sc_hd__decap_3
XFILLER_183_93 VPWR VGND VPWR VGND sky130_ef_sc_hd__decap_12
XFILLER_239_833 VGND VGND VPWR VPWR sky130_fd_sc_hd__decap_6
XFILLER_238_321 VPWR VGND VPWR VGND sky130_ef_sc_hd__decap_12
XFILLER_239_877 VPWR VGND VPWR VGND sky130_ef_sc_hd__decap_12
XFILLER_238_365 VPWR VGND VPWR VGND sky130_ef_sc_hd__decap_12
XFILLER_254_825 VPWR VGND VPWR VGND sky130_ef_sc_hd__decap_12
XFILLER_187_1505 VGND VGND VPWR VPWR sky130_fd_sc_hd__decap_6
XFILLER_4_1241 VPWR VGND VPWR VGND sky130_ef_sc_hd__decap_12
XFILLER_253_335 VGND VGND VPWR VPWR sky130_fd_sc_hd__fill_1
XFILLER_24_1191 VPWR VGND VPWR VGND sky130_ef_sc_hd__decap_12
XFILLER_254_869 VPWR VGND VPWR VGND sky130_ef_sc_hd__decap_12
XFILLER_0_1105 VPWR VGND VPWR VGND sky130_ef_sc_hd__decap_12
XFILLER_207_741 VPWR VGND VPWR VGND sky130_ef_sc_hd__decap_12
XFILLER_4_1285 VPWR VGND VPWR VGND sky130_ef_sc_hd__decap_12
XFILLER_59_1243 VPWR VGND VPWR VGND sky130_ef_sc_hd__decap_12
XFILLER_206_251 VGND VGND VPWR VPWR sky130_fd_sc_hd__fill_1
XFILLER_0_1149 VPWR VGND VPWR VGND sky130_ef_sc_hd__decap_12
XFILLER_207_785 VPWR VGND VPWR VGND sky130_ef_sc_hd__decap_12
XFILLER_179_615 VGND VGND VPWR VPWR sky130_fd_sc_hd__fill_1
XFILLER_59_1287 VPWR VGND VPWR VGND sky130_ef_sc_hd__decap_12
XFILLER_222_755 VGND VGND VPWR VPWR sky130_fd_sc_hd__fill_1
XFILLER_94_1189 VGND VGND VPWR VPWR sky130_fd_sc_hd__fill_1
XFILLER_107_1219 VPWR VGND VPWR VGND sky130_ef_sc_hd__decap_12
XFILLER_210_917 VGND VGND VPWR VPWR sky130_fd_sc_hd__decap_6
XFILLER_166_309 VPWR VGND VPWR VGND sky130_ef_sc_hd__decap_12
XFILLER_175_821 VPWR VGND VPWR VGND sky130_ef_sc_hd__decap_12
XFILLER_175_865 VPWR VGND VPWR VGND sky130_ef_sc_hd__decap_12
XFILLER_179_1033 VPWR VGND VPWR VGND sky130_ef_sc_hd__decap_12
XFILLER_200_1421 VGND VGND VPWR VPWR sky130_fd_sc_hd__decap_6
XFILLER_190_813 VPWR VGND VPWR VGND sky130_ef_sc_hd__decap_12
XFILLER_194_1509 VGND VGND VPWR VPWR sky130_fd_sc_hd__decap_6
XTAP_TAPCELL_ROW_136_2_4569 VGND VPWR sky130_fd_sc_hd__tapvpwrvgnd_1
XFILLER_179_1077 VPWR VGND VPWR VGND sky130_ef_sc_hd__decap_12
XFILLER_200_1465 VPWR VGND VPWR VGND sky130_ef_sc_hd__decap_12
XFILLER_66_1203 VPWR VGND VPWR VGND sky130_ef_sc_hd__decap_12
XFILLER_157_1331 VPWR VGND VPWR VGND sky130_ef_sc_hd__decap_12
XFILLER_66_1247 VPWR VGND VPWR VGND sky130_ef_sc_hd__decap_12
XFILLER_118_1315 VPWR VGND VPWR VGND sky130_ef_sc_hd__decap_12
XFILLER_153_1217 VGND VGND VPWR VPWR sky130_fd_sc_hd__fill_1
XFILLER_170_581 VGND VGND VPWR VPWR sky130_fd_sc_hd__decap_6
XFILLER_118_1359 VPWR VGND VPWR VGND sky130_ef_sc_hd__decap_12
XTAP_TAPCELL_ROW_84_2_4256 VGND VPWR sky130_fd_sc_hd__tapvpwrvgnd_1
XTAP_TAPCELL_ROW_6_1011 VGND VPWR sky130_fd_sc_hd__tapvpwrvgnd_1
XFILLER_217_505 VPWR VGND VPWR VGND sky130_ef_sc_hd__decap_12
XTAP_TAPCELL_ROW_6_1022 VGND VPWR sky130_fd_sc_hd__tapvpwrvgnd_1
XTAP_TAPCELL_ROW_6_1033 VGND VPWR sky130_fd_sc_hd__tapvpwrvgnd_1
XFILLER_244_357 VGND VGND VPWR VPWR sky130_fd_sc_hd__decap_6
XFILLER_186_1037 VPWR VGND VPWR VGND sky130_ef_sc_hd__decap_12
XTAP_TAPCELL_ROW_238_3303 VGND VPWR sky130_fd_sc_hd__tapvpwrvgnd_1
XFILLER_77_1343 VPWR VGND VPWR VGND sky130_ef_sc_hd__decap_12
XFILLER_227_1001 VGND VGND VPWR VPWR sky130_fd_sc_hd__decap_6
XFILLER_129_1411 VPWR VGND VPWR VGND sky130_ef_sc_hd__decap_12
XTAP_TAPCELL_ROW_238_3314 VGND VPWR sky130_fd_sc_hd__tapvpwrvgnd_1
XFILLER_72_27 VGND VGND VPWR VPWR sky130_fd_sc_hd__fill_1
XFILLER_38_1327 VPWR VGND VPWR VGND sky130_ef_sc_hd__decap_12
XFILLER_77_1387 VPWR VGND VPWR VGND sky130_ef_sc_hd__decap_12
XFILLER_129_1455 VPWR VGND VPWR VGND sky130_ef_sc_hd__decap_12
XFILLER_212_221 VPWR VGND VPWR VGND sky130_ef_sc_hd__decap_12
XFILLER_227_1045 VPWR VGND VPWR VGND sky130_ef_sc_hd__decap_12
XFILLER_169_125 VPWR VGND VPWR VGND sky130_ef_sc_hd__decap_12
XFILLER_188_27 VGND VGND VPWR VPWR sky130_fd_sc_hd__fill_1
XFILLER_164_1357 VGND VGND VPWR VPWR sky130_fd_sc_hd__fill_1
XFILLER_198_979 VGND VGND VPWR VPWR sky130_fd_sc_hd__fill_1
XFILLER_213_777 VGND VGND VPWR VPWR sky130_fd_sc_hd__decap_6
XFILLER_9_809 VGND VGND VPWR VPWR sky130_fd_sc_hd__decap_3
XFILLER_129_1499 VPWR VGND VPWR VGND sky130_ef_sc_hd__decap_12
XFILLER_212_265 VPWR VGND VPWR VGND sky130_ef_sc_hd__decap_12
XFILLER_227_1089 VPWR VGND VPWR VGND sky130_ef_sc_hd__decap_12
XFILLER_169_169 VPWR VGND VPWR VGND sky130_ef_sc_hd__decap_12
XFILLER_185_629 VPWR VGND VPWR VGND sky130_ef_sc_hd__decap_12
XFILLER_205_1343 VGND VGND VPWR VPWR sky130_fd_sc_hd__fill_1
XFILLER_178_681 VPWR VGND VPWR VGND sky130_ef_sc_hd__decap_12
XFILLER_184_139 VGND VGND VPWR VPWR sky130_fd_sc_hd__fill_1
XFILLER_197_1133 VPWR VGND VPWR VGND sky130_ef_sc_hd__decap_12
XFILLER_193_673 VPWR VGND VPWR VGND sky130_ef_sc_hd__decap_12
XFILLER_14_1371 VPWR VGND VPWR VGND sky130_ef_sc_hd__decap_12
XFILLER_115_3 VPWR VGND VPWR VGND sky130_ef_sc_hd__decap_12
XFILLER_180_301 VGND VGND VPWR VPWR sky130_fd_sc_hd__decap_6
XFILLER_197_1177 VPWR VGND VPWR VGND sky130_ef_sc_hd__decap_12
XFILLER_49_1423 VPWR VGND VPWR VGND sky130_ef_sc_hd__decap_12
XFILLER_84_1303 VPWR VGND VPWR VGND sky130_ef_sc_hd__decap_12
XFILLER_180_345 VPWR VGND VPWR VGND sky130_ef_sc_hd__decap_12
XFILLER_238_1141 VGND VGND VPWR VPWR sky130_fd_sc_hd__decap_6
XFILLER_88_1483 VPWR VGND VPWR VGND sky130_ef_sc_hd__decap_12
XFILLER_101_1385 VGND VGND VPWR VPWR sky130_fd_sc_hd__fill_1
XTAP_TAPCELL_ROW_210_2543 VGND VPWR sky130_fd_sc_hd__tapvpwrvgnd_1
XTAP_TAPCELL_ROW_210_2554 VGND VPWR sky130_fd_sc_hd__tapvpwrvgnd_1
XFILLER_234_1005 VPWR VGND VPWR VGND sky130_ef_sc_hd__decap_12
XFILLER_49_1467 VPWR VGND VPWR VGND sky130_ef_sc_hd__decap_12
XFILLER_136_1415 VPWR VGND VPWR VGND sky130_ef_sc_hd__decap_12
XFILLER_180_389 VPWR VGND VPWR VGND sky130_ef_sc_hd__decap_12
XFILLER_238_1185 VPWR VGND VPWR VGND sky130_ef_sc_hd__decap_12
XTAP_TAPCELL_ROW_210_2565 VGND VPWR sky130_fd_sc_hd__tapvpwrvgnd_1
XFILLER_97_57 VPWR VGND VPWR VGND sky130_ef_sc_hd__decap_12
XFILLER_234_1049 VPWR VGND VPWR VGND sky130_ef_sc_hd__decap_12
XFILLER_216_1483 VGND VGND VPWR VPWR sky130_fd_sc_hd__fill_1
XFILLER_0_797 VGND VGND VPWR VPWR sky130_fd_sc_hd__decap_4
XTAP_TAPCELL_ROW_223_2904 VGND VPWR sky130_fd_sc_hd__tapvpwrvgnd_1
XFILLER_236_825 VPWR VGND VPWR VGND sky130_ef_sc_hd__decap_12
XTAP_TAPCELL_ROW_223_2915 VGND VPWR sky130_fd_sc_hd__tapvpwrvgnd_1
XFILLER_169_1213 VPWR VGND VPWR VGND sky130_ef_sc_hd__decap_12
XFILLER_235_335 VGND VGND VPWR VPWR sky130_fd_sc_hd__fill_1
XFILLER_21_1331 VPWR VGND VPWR VGND sky130_ef_sc_hd__decap_12
XTAP_TAPCELL_ROW_208_2494 VGND VPWR sky130_fd_sc_hd__tapvpwrvgnd_1
XFILLER_236_869 VPWR VGND VPWR VGND sky130_ef_sc_hd__decap_12
XFILLER_1_1425 VPWR VGND VPWR VGND sky130_ef_sc_hd__decap_12
XFILLER_169_1257 VPWR VGND VPWR VGND sky130_ef_sc_hd__decap_12
XFILLER_251_839 VGND VGND VPWR VPWR sky130_fd_sc_hd__fill_1
XFILLER_245_1101 VPWR VGND VPWR VGND sky130_ef_sc_hd__decap_12
XFILLER_95_1443 VPWR VGND VPWR VGND sky130_ef_sc_hd__decap_12
XFILLER_147_1511 VGND VGND VPWR VPWR sky130_fd_sc_hd__decap_4
XFILLER_210_1093 VPWR VGND VPWR VGND sky130_ef_sc_hd__decap_12
XFILLER_249_1281 VGND VGND VPWR VPWR sky130_fd_sc_hd__decap_6
XFILLER_1_1469 VPWR VGND VPWR VGND sky130_ef_sc_hd__decap_12
Xmax_cap84 net85 VGND VGND VPWR VPWR net84 sky130_fd_sc_hd__clkbuf_1
XFILLER_188_401 VPWR VGND VPWR VGND sky130_ef_sc_hd__decap_12
XFILLER_56_1427 VPWR VGND VPWR VGND sky130_ef_sc_hd__decap_12
XFILLER_245_1145 VPWR VGND VPWR VGND sky130_ef_sc_hd__decap_12
XFILLER_204_755 VGND VGND VPWR VPWR sky130_fd_sc_hd__fill_1
XFILLER_91_1329 VGND VGND VPWR VPWR sky130_fd_sc_hd__fill_1
XFILLER_231_541 VPWR VGND VPWR VGND sky130_ef_sc_hd__decap_12
XFILLER_188_445 VPWR VGND VPWR VGND sky130_ef_sc_hd__decap_12
XFILLER_241_1009 VPWR VGND VPWR VGND sky130_ef_sc_hd__decap_12
XFILLER_206_1129 VPWR VGND VPWR VGND sky130_ef_sc_hd__decap_12
XFILLER_245_1189 VPWR VGND VPWR VGND sky130_ef_sc_hd__decap_12
XFILLER_231_585 VPWR VGND VPWR VGND sky130_ef_sc_hd__decap_12
XFILLER_188_489 VPWR VGND VPWR VGND sky130_ef_sc_hd__decap_12
XFILLER_200_961 VPWR VGND VPWR VGND sky130_ef_sc_hd__decap_12
XFILLER_141_1165 VPWR VGND VPWR VGND sky130_ef_sc_hd__decap_12
Xwire250 net251 VGND VGND VPWR VPWR net250 sky130_fd_sc_hd__clkbuf_1
XTAP_TAPCELL_ROW_122_2_4488 VGND VPWR sky130_fd_sc_hd__tapvpwrvgnd_1
XFILLER_172_813 VPWR VGND VPWR VGND sky130_ef_sc_hd__decap_12
XFILLER_190_109 VPWR VGND VPWR VGND sky130_ef_sc_hd__decap_12
Xwire261 net262 VGND VGND VPWR VPWR net261 sky130_fd_sc_hd__clkbuf_1
XPHY_EDGE_ROW_129_1_Right_785 VGND VGND VPWR VPWR sky130_fd_sc_hd__decap_3
XFILLER_32_1471 VPWR VGND VPWR VGND sky130_ef_sc_hd__decap_12
Xwire272 net273 VGND VGND VPWR VPWR net272 sky130_fd_sc_hd__clkbuf_1
XFILLER_183_161 VGND VGND VPWR VPWR sky130_fd_sc_hd__decap_6
Xwire283 net284 VGND VGND VPWR VPWR net283 sky130_fd_sc_hd__clkbuf_1
XPHY_EDGE_ROW_170_Left_425 VGND VGND VPWR VPWR sky130_fd_sc_hd__decap_3
XFILLER_176_1217 VPWR VGND VPWR VGND sky130_ef_sc_hd__decap_12
Xwire294 net295 VGND VGND VPWR VPWR net294 sky130_fd_sc_hd__clkbuf_1
XFILLER_252_1105 VPWR VGND VPWR VGND sky130_ef_sc_hd__decap_12
XFILLER_28_1507 VGND VGND VPWR VPWR sky130_fd_sc_hd__decap_8
XTAP_TAPCELL_ROW_102_2_4364 VGND VPWR sky130_fd_sc_hd__tapvpwrvgnd_1
XFILLER_217_1225 VGND VGND VPWR VPWR sky130_fd_sc_hd__decap_6
XFILLER_252_1149 VPWR VGND VPWR VGND sky130_ef_sc_hd__decap_12
XFILLER_217_1269 VPWR VGND VPWR VGND sky130_ef_sc_hd__decap_12
XFILLER_30_3 VPWR VGND VPWR VGND sky130_ef_sc_hd__decap_12
XTAP_TAPCELL_ROW_70_2_4175 VGND VPWR sky130_fd_sc_hd__tapvpwrvgnd_1
XFILLER_239_641 VPWR VGND VPWR VGND sky130_ef_sc_hd__decap_12
XTAP_TAPCELL_ROW_69_2_4169 VGND VPWR sky130_fd_sc_hd__tapvpwrvgnd_1
XFILLER_113_1201 VPWR VGND VPWR VGND sky130_ef_sc_hd__decap_12
XPHY_EDGE_ROW_65_2_Right_156 VGND VGND VPWR VPWR sky130_fd_sc_hd__decap_3
XTAP_TAPCELL_ROW_88_1_1223 VGND VPWR sky130_fd_sc_hd__tapvpwrvgnd_1
XTAP_TAPCELL_ROW_102_1_1237 VGND VPWR sky130_fd_sc_hd__tapvpwrvgnd_1
XFILLER_152_1283 VPWR VGND VPWR VGND sky130_ef_sc_hd__decap_12
XTAP_TAPCELL_ROW_185_1874 VGND VPWR sky130_fd_sc_hd__tapvpwrvgnd_1
XFILLER_239_685 VPWR VGND VPWR VGND sky130_ef_sc_hd__decap_12
XFILLER_61_1177 VPWR VGND VPWR VGND sky130_ef_sc_hd__decap_12
XTAP_TAPCELL_ROW_185_1885 VGND VPWR sky130_fd_sc_hd__tapvpwrvgnd_1
XFILLER_187_1313 VPWR VGND VPWR VGND sky130_ef_sc_hd__decap_12
XFILLER_113_1267 VGND VGND VPWR VPWR sky130_fd_sc_hd__decap_6
XFILLER_213_55 VGND VGND VPWR VPWR sky130_fd_sc_hd__fill_1
XFILLER_238_195 VGND VGND VPWR VPWR sky130_fd_sc_hd__fill_1
XFILLER_226_357 VGND VGND VPWR VPWR sky130_fd_sc_hd__decap_6
XFILLER_187_1357 VPWR VGND VPWR VGND sky130_ef_sc_hd__decap_12
XFILLER_241_305 VPWR VGND VPWR VGND sky130_ef_sc_hd__decap_12
XFILLER_254_699 VGND VGND VPWR VPWR sky130_fd_sc_hd__fill_1
XFILLER_4_1093 VPWR VGND VPWR VGND sky130_ef_sc_hd__decap_12
XFILLER_198_209 VPWR VGND VPWR VGND sky130_ef_sc_hd__decap_12
XFILLER_241_349 VPWR VGND VPWR VGND sky130_ef_sc_hd__decap_12
XFILLER_228_1365 VGND VGND VPWR VPWR sky130_fd_sc_hd__decap_6
XFILLER_250_861 VGND VGND VPWR VPWR sky130_fd_sc_hd__decap_6
XFILLER_224_1229 VPWR VGND VPWR VGND sky130_ef_sc_hd__decap_12
XFILLER_210_725 VPWR VGND VPWR VGND sky130_ef_sc_hd__decap_12
XFILLER_167_629 VPWR VGND VPWR VGND sky130_ef_sc_hd__decap_12
XFILLER_33_1213 VGND VGND VPWR VPWR sky130_fd_sc_hd__decap_4
XFILLER_166_139 VGND VGND VPWR VPWR sky130_fd_sc_hd__fill_1
XFILLER_210_769 VPWR VGND VPWR VGND sky130_ef_sc_hd__decap_12
XFILLER_72_1295 VGND VGND VPWR VPWR sky130_fd_sc_hd__decap_6
XTAP_TAPCELL_ROW_27_2_3915 VGND VPWR sky130_fd_sc_hd__tapvpwrvgnd_1
XFILLER_238_41 VPWR VGND VPWR VGND sky130_ef_sc_hd__decap_12
XFILLER_120_1227 VPWR VGND VPWR VGND sky130_ef_sc_hd__decap_12
XFILLER_11_1511 VGND VGND VPWR VPWR sky130_fd_sc_hd__decap_4
XFILLER_175_673 VPWR VGND VPWR VGND sky130_ef_sc_hd__decap_12
XFILLER_198_1453 VPWR VGND VPWR VGND sky130_ef_sc_hd__decap_12
XFILLER_194_1317 VPWR VGND VPWR VGND sky130_ef_sc_hd__decap_12
XFILLER_238_85 VPWR VGND VPWR VGND sky130_ef_sc_hd__decap_12
XFILLER_190_643 VGND VGND VPWR VPWR sky130_fd_sc_hd__fill_1
XFILLER_198_1497 VPWR VGND VPWR VGND sky130_ef_sc_hd__decap_12
XFILLER_200_1273 VPWR VGND VPWR VGND sky130_ef_sc_hd__decap_12
XFILLER_174_29 VPWR VGND VPWR VGND sky130_ef_sc_hd__decap_12
Xmax_cap550 net73 VGND VGND VPWR VPWR net550 sky130_fd_sc_hd__clkbuf_1
Xmax_cap561 net68 VGND VGND VPWR VPWR net561 sky130_fd_sc_hd__clkbuf_1
XFILLER_235_1325 VPWR VGND VPWR VGND sky130_ef_sc_hd__decap_12
XTAP_TAPCELL_ROW_227_3004 VGND VPWR sky130_fd_sc_hd__tapvpwrvgnd_1
XFILLER_249_405 VPWR VGND VPWR VGND sky130_ef_sc_hd__decap_12
XTAP_TAPCELL_ROW_227_3015 VGND VPWR sky130_fd_sc_hd__tapvpwrvgnd_1
XTAP_TAPCELL_ROW_227_3026 VGND VPWR sky130_fd_sc_hd__tapvpwrvgnd_1
XFILLER_235_1369 VPWR VGND VPWR VGND sky130_ef_sc_hd__decap_12
XFILLER_67_27 VPWR VGND VPWR VGND sky130_ef_sc_hd__decap_12
XFILLER_192_1085 VGND VGND VPWR VPWR sky130_fd_sc_hd__decap_6
XFILLER_249_449 VPWR VGND VPWR VGND sky130_ef_sc_hd__decap_12
XFILLER_118_1189 VGND VGND VPWR VPWR sky130_fd_sc_hd__fill_1
XFILLER_131_1323 VGND VGND VPWR VPWR sky130_fd_sc_hd__decap_6
XFILLER_218_825 VPWR VGND VPWR VGND sky130_ef_sc_hd__decap_12
XFILLER_40_1239 VGND VGND VPWR VPWR sky130_fd_sc_hd__decap_6
XFILLER_244_121 VPWR VGND VPWR VGND sky130_ef_sc_hd__decap_12
XFILLER_123_55 VGND VGND VPWR VPWR sky130_fd_sc_hd__fill_1
XFILLER_131_1367 VPWR VGND VPWR VGND sky130_ef_sc_hd__decap_12
XFILLER_217_335 VGND VGND VPWR VPWR sky130_fd_sc_hd__fill_1
XFILLER_83_15 VPWR VGND VPWR VGND sky130_ef_sc_hd__decap_12
XFILLER_218_869 VPWR VGND VPWR VGND sky130_ef_sc_hd__decap_12
XFILLER_244_165 VPWR VGND VPWR VGND sky130_ef_sc_hd__decap_12
XFILLER_199_15 VPWR VGND VPWR VGND sky130_ef_sc_hd__decap_12
XFILLER_233_839 VGND VGND VPWR VPWR sky130_fd_sc_hd__fill_1
XFILLER_246_1421 VGND VGND VPWR VPWR sky130_fd_sc_hd__decap_6
X_480_ net166 _246_ VGND VGND VPWR VPWR acc_core.adder.cla_blocks\[3\].block.sum\[3\]
+ sky130_fd_sc_hd__xnor2_1
XFILLER_16_53 VPWR VGND VPWR VGND sky130_ef_sc_hd__decap_12
XFILLER_213_541 VPWR VGND VPWR VGND sky130_ef_sc_hd__decap_12
XFILLER_246_1465 VPWR VGND VPWR VGND sky130_ef_sc_hd__decap_12
XFILLER_186_905 VPWR VGND VPWR VGND sky130_ef_sc_hd__decap_12
XFILLER_242_1329 VPWR VGND VPWR VGND sky130_ef_sc_hd__decap_12
XFILLER_164_1165 VPWR VGND VPWR VGND sky130_ef_sc_hd__decap_12
XFILLER_207_1449 VGND VGND VPWR VPWR sky130_fd_sc_hd__decap_6
XFILLER_213_585 VPWR VGND VPWR VGND sky130_ef_sc_hd__decap_12
XFILLER_9_617 VPWR VGND VPWR VGND sky130_ef_sc_hd__decap_12
XFILLER_90_1351 VGND VGND VPWR VPWR sky130_fd_sc_hd__decap_6
XFILLER_186_949 VPWR VGND VPWR VGND sky130_ef_sc_hd__decap_12
XFILLER_232_3 VPWR VGND VPWR VGND sky130_ef_sc_hd__decap_12
XTAP_TAPCELL_ROW_191_2034 VGND VPWR sky130_fd_sc_hd__tapvpwrvgnd_1
XFILLER_32_41 VGND VGND VPWR VPWR sky130_fd_sc_hd__decap_8
XTAP_TAPCELL_ROW_191_2045 VGND VPWR sky130_fd_sc_hd__tapvpwrvgnd_1
XFILLER_90_1395 VPWR VGND VPWR VGND sky130_ef_sc_hd__decap_12
XFILLER_142_1463 VGND VGND VPWR VPWR sky130_fd_sc_hd__decap_6
XTAP_TAPCELL_ROW_216_2730 VGND VPWR sky130_fd_sc_hd__tapvpwrvgnd_1
XFILLER_148_41 VPWR VGND VPWR VGND sky130_ef_sc_hd__decap_12
XFILLER_51_1379 VGND VGND VPWR VPWR sky130_fd_sc_hd__decap_6
XFILLER_172_109 VPWR VGND VPWR VGND sky130_ef_sc_hd__decap_12
XFILLER_194_993 VPWR VGND VPWR VGND sky130_ef_sc_hd__decap_12
XTAP_TAPCELL_ROW_212_2605 VGND VPWR sky130_fd_sc_hd__tapvpwrvgnd_1
XFILLER_5_812 VGND VGND VPWR VPWR sky130_fd_sc_hd__fill_1
XTAP_TAPCELL_ROW_212_2616 VGND VPWR sky130_fd_sc_hd__tapvpwrvgnd_1
XFILLER_181_665 VGND VGND VPWR VPWR sky130_fd_sc_hd__decap_6
XFILLER_49_1231 VPWR VGND VPWR VGND sky130_ef_sc_hd__decap_12
XFILLER_180_153 VPWR VGND VPWR VGND sky130_ef_sc_hd__decap_12
XFILLER_253_1425 VPWR VGND VPWR VGND sky130_ef_sc_hd__decap_12
XFILLER_49_1275 VPWR VGND VPWR VGND sky130_ef_sc_hd__decap_12
XFILLER_180_197 VPWR VGND VPWR VGND sky130_ef_sc_hd__decap_12
XFILLER_84_1177 VPWR VGND VPWR VGND sky130_ef_sc_hd__decap_12
XFILLER_136_1245 VGND VGND VPWR VPWR sky130_fd_sc_hd__fill_1
XFILLER_214_1409 VPWR VGND VPWR VGND sky130_ef_sc_hd__decap_12
XFILLER_253_1469 VPWR VGND VPWR VGND sky130_ef_sc_hd__decap_12
XFILLER_0_561 VGND VGND VPWR VPWR sky130_fd_sc_hd__fill_1
XFILLER_171_1169 VGND VGND VPWR VPWR sky130_fd_sc_hd__decap_6
XFILLER_110_1407 VGND VGND VPWR VPWR sky130_fd_sc_hd__decap_6
XFILLER_169_1021 VPWR VGND VPWR VGND sky130_ef_sc_hd__decap_12
XFILLER_208_357 VGND VGND VPWR VPWR sky130_fd_sc_hd__decap_6
XFILLER_180_83 VGND VGND VPWR VPWR sky130_fd_sc_hd__fill_1
XFILLER_1_1233 VPWR VGND VPWR VGND sky130_ef_sc_hd__decap_12
XTAP_TAPCELL_ROW_149_1_1284 VGND VPWR sky130_fd_sc_hd__tapvpwrvgnd_1
XFILLER_223_305 VPWR VGND VPWR VGND sky130_ef_sc_hd__decap_12
XFILLER_236_699 VGND VGND VPWR VPWR sky130_fd_sc_hd__fill_1
XFILLER_169_1065 VPWR VGND VPWR VGND sky130_ef_sc_hd__decap_12
XFILLER_189_721 VGND VGND VPWR VPWR sky130_fd_sc_hd__decap_6
XFILLER_223_349 VPWR VGND VPWR VGND sky130_ef_sc_hd__decap_12
XFILLER_95_1273 VGND VGND VPWR VPWR sky130_fd_sc_hd__fill_1
XFILLER_225_1505 VGND VGND VPWR VPWR sky130_fd_sc_hd__decap_6
XFILLER_108_1303 VPWR VGND VPWR VGND sky130_ef_sc_hd__decap_12
XFILLER_232_861 VGND VGND VPWR VPWR sky130_fd_sc_hd__decap_6
XFILLER_189_765 VPWR VGND VPWR VGND sky130_ef_sc_hd__decap_12
XFILLER_17_1219 VPWR VGND VPWR VGND sky130_ef_sc_hd__decap_12
XFILLER_147_1385 VGND VGND VPWR VPWR sky130_fd_sc_hd__fill_1
XFILLER_188_253 VPWR VGND VPWR VGND sky130_ef_sc_hd__decap_12
XFILLER_189_81 VPWR VGND VPWR VGND sky130_ef_sc_hd__decap_12
XFILLER_231_393 VPWR VGND VPWR VGND sky130_ef_sc_hd__decap_12
XPHY_EDGE_ROW_143_2_Left_645 VGND VGND VPWR VPWR sky130_fd_sc_hd__decap_3
XTAP_TAPCELL_ROW_13_2_3834 VGND VPWR sky130_fd_sc_hd__tapvpwrvgnd_1
XFILLER_78_3 VPWR VGND VPWR VGND sky130_ef_sc_hd__decap_12
XFILLER_191_429 VPWR VGND VPWR VGND sky130_ef_sc_hd__decap_12
XTAP_TAPCELL_ROW_174_1575 VGND VPWR sky130_fd_sc_hd__tapvpwrvgnd_1
XTAP_TAPCELL_ROW_174_1586 VGND VPWR sky130_fd_sc_hd__tapvpwrvgnd_1
XFILLER_172_643 VGND VGND VPWR VPWR sky130_fd_sc_hd__fill_1
XFILLER_67_1331 VPWR VGND VPWR VGND sky130_ef_sc_hd__decap_12
XFILLER_154_1301 VGND VGND VPWR VPWR sky130_fd_sc_hd__fill_1
XFILLER_208_77 VGND VGND VPWR VPWR sky130_fd_sc_hd__decap_6
XFILLER_28_1315 VPWR VGND VPWR VGND sky130_ef_sc_hd__decap_12
XFILLER_217_1033 VPWR VGND VPWR VGND sky130_ef_sc_hd__decap_12
XFILLER_119_1443 VPWR VGND VPWR VGND sky130_ef_sc_hd__decap_12
XFILLER_63_1217 VGND VGND VPWR VPWR sky130_fd_sc_hd__fill_1
XFILLER_8_1409 VPWR VGND VPWR VGND sky130_ef_sc_hd__decap_12
XTAP_TAPCELL_ROW_187_1925 VGND VPWR sky130_fd_sc_hd__tapvpwrvgnd_1
XTAP_TAPCELL_ROW_187_1936 VGND VPWR sky130_fd_sc_hd__tapvpwrvgnd_1
XFILLER_232_1509 VGND VGND VPWR VPWR sky130_fd_sc_hd__decap_6
XFILLER_28_1359 VPWR VGND VPWR VGND sky130_ef_sc_hd__decap_12
XTAP_TAPCELL_ROW_187_1947 VGND VPWR sky130_fd_sc_hd__tapvpwrvgnd_1
XFILLER_217_1077 VPWR VGND VPWR VGND sky130_ef_sc_hd__decap_12
XFILLER_247_909 VPWR VGND VPWR VGND sky130_ef_sc_hd__decap_12
XFILLER_115_1329 VGND VGND VPWR VPWR sky130_fd_sc_hd__fill_1
XFILLER_246_419 VGND VGND VPWR VPWR sky130_fd_sc_hd__fill_1
XFILLER_224_65 VPWR VGND VPWR VGND sky130_ef_sc_hd__decap_12
XPHY_EDGE_ROW_66_2_Right_157 VGND VGND VPWR VPWR sky130_fd_sc_hd__decap_3
XFILLER_255_953 VPWR VGND VPWR VGND sky130_ef_sc_hd__decap_12
XFILLER_226_121 VPWR VGND VPWR VGND sky130_ef_sc_hd__decap_12
XFILLER_187_1121 VPWR VGND VPWR VGND sky130_ef_sc_hd__decap_12
XPHY_EDGE_ROW_157_1_Left_412 VGND VGND VPWR VPWR sky130_fd_sc_hd__decap_3
XFILLER_215_839 VGND VGND VPWR VPWR sky130_fd_sc_hd__fill_1
XFILLER_226_165 VPWR VGND VPWR VGND sky130_ef_sc_hd__decap_12
XFILLER_242_625 VPWR VGND VPWR VGND sky130_ef_sc_hd__decap_12
XFILLER_183_1007 VGND VGND VPWR VPWR sky130_fd_sc_hd__fill_1
XFILLER_241_113 VPWR VGND VPWR VGND sky130_ef_sc_hd__decap_12
XFILLER_240_53 VPWR VGND VPWR VGND sky130_ef_sc_hd__decap_12
XFILLER_199_529 VPWR VGND VPWR VGND sky130_ef_sc_hd__decap_12
XFILLER_39_1411 VPWR VGND VPWR VGND sky130_ef_sc_hd__decap_12
XFILLER_78_1471 VPWR VGND VPWR VGND sky130_ef_sc_hd__decap_12
XFILLER_242_669 VPWR VGND VPWR VGND sky130_ef_sc_hd__decap_12
XFILLER_165_1441 VPWR VGND VPWR VGND sky130_ef_sc_hd__decap_12
XFILLER_240_97 VPWR VGND VPWR VGND sky130_ef_sc_hd__decap_12
XFILLER_39_1455 VPWR VGND VPWR VGND sky130_ef_sc_hd__decap_12
XFILLER_228_1173 VPWR VGND VPWR VGND sky130_ef_sc_hd__decap_12
XFILLER_168_905 VPWR VGND VPWR VGND sky130_ef_sc_hd__decap_12
XFILLER_74_1357 VGND VGND VPWR VPWR sky130_fd_sc_hd__fill_1
XPHY_EDGE_ROW_75_2_Left_577 VGND VGND VPWR VPWR sky130_fd_sc_hd__decap_3
XFILLER_165_1485 VPWR VGND VPWR VGND sky130_ef_sc_hd__decap_12
XFILLER_39_1499 VPWR VGND VPWR VGND sky130_ef_sc_hd__decap_12
XFILLER_224_1037 VPWR VGND VPWR VGND sky130_ef_sc_hd__decap_12
XTAP_TAPCELL_ROW_92_2_4307 VGND VPWR sky130_fd_sc_hd__tapvpwrvgnd_1
XFILLER_168_949 VPWR VGND VPWR VGND sky130_ef_sc_hd__decap_12
XFILLER_210_533 VPWR VGND VPWR VGND sky130_ef_sc_hd__decap_12
XFILLER_126_1469 VGND VGND VPWR VPWR sky130_fd_sc_hd__fill_1
XFILLER_249_51 VGND VGND VPWR VPWR sky130_fd_sc_hd__decap_4
XFILLER_194_245 VGND VGND VPWR VPWR sky130_fd_sc_hd__decap_6
XTAP_TAPCELL_ROW_252_3686 VGND VPWR sky130_fd_sc_hd__tapvpwrvgnd_1
XTAP_TAPCELL_ROW_252_3697 VGND VPWR sky130_fd_sc_hd__tapvpwrvgnd_1
XFILLER_159_1201 VPWR VGND VPWR VGND sky130_ef_sc_hd__decap_12
XFILLER_176_993 VPWR VGND VPWR VGND sky130_ef_sc_hd__decap_12
XFILLER_194_289 VPWR VGND VPWR VGND sky130_ef_sc_hd__decap_12
XFILLER_185_39 VPWR VGND VPWR VGND sky130_ef_sc_hd__decap_12
XFILLER_198_1261 VPWR VGND VPWR VGND sky130_ef_sc_hd__decap_12
XFILLER_159_1267 VGND VGND VPWR VPWR sky130_fd_sc_hd__decap_6
XFILLER_194_1147 VGND VGND VPWR VPWR sky130_fd_sc_hd__fill_1
XFILLER_78_15 VPWR VGND VPWR VGND sky130_ef_sc_hd__decap_12
XFILLER_11_1385 VGND VGND VPWR VPWR sky130_fd_sc_hd__fill_1
XFILLER_2_837 VPWR VGND VPWR VGND sky130_ef_sc_hd__decap_12
XFILLER_46_1415 VPWR VGND VPWR VGND sky130_ef_sc_hd__decap_12
XFILLER_235_1133 VPWR VGND VPWR VGND sky130_ef_sc_hd__decap_12
XFILLER_85_1497 VGND VGND VPWR VPWR sky130_fd_sc_hd__fill_1
XFILLER_235_1177 VPWR VGND VPWR VGND sky130_ef_sc_hd__decap_12
XFILLER_249_279 VGND VGND VPWR VPWR sky130_fd_sc_hd__fill_1
XFILLER_134_65 VGND VGND VPWR VPWR sky130_fd_sc_hd__decap_6
XPHY_EDGE_ROW_89_1_Left_344 VGND VGND VPWR VPWR sky130_fd_sc_hd__decap_3
XFILLER_182_3 VPWR VGND VPWR VGND sky130_ef_sc_hd__decap_12
X_601_ clknet_3_3__leaf_clk net688 _009_ VGND VGND VPWR VPWR valid_d2 sky130_fd_sc_hd__dfrtp_1
XFILLER_79_1213 VGND VGND VPWR VPWR sky130_fd_sc_hd__decap_4
XTAP_TAPCELL_ROW_205_2420 VGND VPWR sky130_fd_sc_hd__tapvpwrvgnd_1
XFILLER_245_441 VGND VGND VPWR VPWR sky130_fd_sc_hd__decap_6
XTAP_TAPCELL_ROW_205_2431 VGND VPWR sky130_fd_sc_hd__tapvpwrvgnd_1
XFILLER_166_1205 VPWR VGND VPWR VGND sky130_ef_sc_hd__decap_12
XFILLER_205_305 VPWR VGND VPWR VGND sky130_ef_sc_hd__decap_12
XFILLER_245_485 VPWR VGND VPWR VGND sky130_ef_sc_hd__decap_12
X_532_ net665 VGND VGND VPWR VPWR _014_ sky130_fd_sc_hd__inv_2
XPHY_EDGE_ROW_141_1_Left_396 VGND VGND VPWR VPWR sky130_fd_sc_hd__decap_3
XTAP_TAPCELL_ROW_201_2306 VGND VPWR sky130_fd_sc_hd__tapvpwrvgnd_1
XFILLER_218_699 VGND VGND VPWR VPWR sky130_fd_sc_hd__fill_1
XFILLER_150_53 VPWR VGND VPWR VGND sky130_ef_sc_hd__decap_12
XTAP_TAPCELL_ROW_201_2317 VGND VPWR sky130_fd_sc_hd__tapvpwrvgnd_1
XTAP_TAPCELL_ROW_197_2210 VGND VPWR sky130_fd_sc_hd__tapvpwrvgnd_1
XFILLER_57_1511 VGND VGND VPWR VPWR sky130_fd_sc_hd__decap_4
XTAP_TAPCELL_ROW_1_881 VGND VPWR sky130_fd_sc_hd__tapvpwrvgnd_1
XFILLER_205_349 VPWR VGND VPWR VGND sky130_ef_sc_hd__decap_12
XTAP_TAPCELL_ROW_1_892 VGND VPWR sky130_fd_sc_hd__tapvpwrvgnd_1
XFILLER_92_1413 VGND VGND VPWR VPWR sky130_fd_sc_hd__fill_1
XFILLER_221_809 VPWR VGND VPWR VGND sky130_ef_sc_hd__decap_12
X_463_ net147 net146 VGND VGND VPWR VPWR acc_core.adder.cla_blocks\[0\].block.sum\[2\]
+ sky130_fd_sc_hd__xnor2_1
XFILLER_207_1213 VPWR VGND VPWR VGND sky130_ef_sc_hd__decap_12
XFILLER_214_861 VGND VGND VPWR VPWR sky130_fd_sc_hd__decap_6
XFILLER_246_1273 VPWR VGND VPWR VGND sky130_ef_sc_hd__decap_12
XTAP_TAPCELL_ROW_193_2107 VGND VPWR sky130_fd_sc_hd__tapvpwrvgnd_1
XFILLER_186_713 VPWR VGND VPWR VGND sky130_ef_sc_hd__decap_12
X_394_ net591 net584 net559 VGND VGND VPWR VPWR _183_ sky130_fd_sc_hd__and3_1
XFILLER_207_1257 VPWR VGND VPWR VGND sky130_ef_sc_hd__decap_12
XTAP_TAPCELL_ROW_157_2_4698 VGND VPWR sky130_fd_sc_hd__tapvpwrvgnd_1
XFILLER_213_393 VPWR VGND VPWR VGND sky130_ef_sc_hd__decap_12
XFILLER_185_223 VGND VGND VPWR VPWR sky130_fd_sc_hd__fill_1
XFILLER_159_51 VGND VGND VPWR VPWR sky130_fd_sc_hd__decap_4
XFILLER_186_757 VPWR VGND VPWR VGND sky130_ef_sc_hd__decap_12
XFILLER_142_1271 VPWR VGND VPWR VGND sky130_ef_sc_hd__decap_12
XFILLER_51_1165 VPWR VGND VPWR VGND sky130_ef_sc_hd__decap_12
XFILLER_173_429 VPWR VGND VPWR VGND sky130_ef_sc_hd__decap_12
XFILLER_177_1301 VPWR VGND VPWR VGND sky130_ef_sc_hd__decap_12
XFILLER_103_1255 VPWR VGND VPWR VGND sky130_ef_sc_hd__decap_12
XTAP_TAPCELL_ROW_137_2_4574 VGND VPWR sky130_fd_sc_hd__tapvpwrvgnd_1
XFILLER_255_1509 VGND VGND VPWR VPWR sky130_fd_sc_hd__decap_3
XFILLER_177_1345 VPWR VGND VPWR VGND sky130_ef_sc_hd__decap_12
XFILLER_86_1239 VGND VGND VPWR VPWR sky130_fd_sc_hd__decap_6
XFILLER_103_1299 VPWR VGND VPWR VGND sky130_ef_sc_hd__decap_12
XFILLER_4_141 VPWR VGND VPWR VGND sky130_ef_sc_hd__decap_12
XFILLER_181_473 VPWR VGND VPWR VGND sky130_ef_sc_hd__decap_12
XFILLER_253_1233 VPWR VGND VPWR VGND sky130_ef_sc_hd__decap_12
XFILLER_218_1353 VPWR VGND VPWR VGND sky130_ef_sc_hd__decap_12
XFILLER_214_1217 VPWR VGND VPWR VGND sky130_ef_sc_hd__decap_12
XFILLER_229_909 VPWR VGND VPWR VGND sky130_ef_sc_hd__decap_12
XFILLER_218_1397 VPWR VGND VPWR VGND sky130_ef_sc_hd__decap_12
XFILLER_23_1201 VPWR VGND VPWR VGND sky130_ef_sc_hd__decap_12
XFILLER_228_419 VGND VGND VPWR VPWR sky130_fd_sc_hd__fill_1
XTAP_TAPCELL_ROW_182_1800 VGND VPWR sky130_fd_sc_hd__tapvpwrvgnd_1
XTAP_TAPCELL_ROW_182_1811 VGND VPWR sky130_fd_sc_hd__tapvpwrvgnd_1
XFILLER_62_1283 VPWR VGND VPWR VGND sky130_ef_sc_hd__decap_12
XFILLER_114_1351 VGND VGND VPWR VPWR sky130_fd_sc_hd__decap_6
XFILLER_191_93 VPWR VGND VPWR VGND sky130_ef_sc_hd__decap_12
XFILLER_255_249 VGND VGND VPWR VPWR sky130_fd_sc_hd__decap_3
XFILLER_237_953 VPWR VGND VPWR VGND sky130_ef_sc_hd__decap_12
XFILLER_208_121 VPWR VGND VPWR VGND sky130_ef_sc_hd__decap_12
XTAP_TAPCELL_ROW_167_1390 VGND VPWR sky130_fd_sc_hd__tapvpwrvgnd_1
XFILLER_23_1267 VGND VGND VPWR VPWR sky130_fd_sc_hd__decap_6
XFILLER_110_1215 VPWR VGND VPWR VGND sky130_ef_sc_hd__decap_12
XFILLER_188_1441 VPWR VGND VPWR VGND sky130_ef_sc_hd__decap_12
XFILLER_114_1395 VPWR VGND VPWR VGND sky130_ef_sc_hd__decap_12
XFILLER_252_923 VGND VGND VPWR VPWR sky130_fd_sc_hd__fill_1
XFILLER_208_165 VPWR VGND VPWR VGND sky130_ef_sc_hd__decap_12
XFILLER_224_625 VPWR VGND VPWR VGND sky130_ef_sc_hd__decap_12
XFILLER_110_1259 VPWR VGND VPWR VGND sky130_ef_sc_hd__decap_12
XTAP_TAPCELL_ROW_110_2_4415 VGND VPWR sky130_fd_sc_hd__tapvpwrvgnd_1
XFILLER_188_1485 VPWR VGND VPWR VGND sky130_ef_sc_hd__decap_12
XFILLER_97_1379 VGND VGND VPWR VPWR sky130_fd_sc_hd__decap_6
XTAP_TAPCELL_ROW_109_2_4409 VGND VPWR sky130_fd_sc_hd__tapvpwrvgnd_1
XFILLER_223_113 VPWR VGND VPWR VGND sky130_ef_sc_hd__decap_12
XFILLER_1_1063 VGND VGND VPWR VPWR sky130_fd_sc_hd__fill_1
XFILLER_224_669 VPWR VGND VPWR VGND sky130_ef_sc_hd__decap_12
XFILLER_225_1313 VPWR VGND VPWR VGND sky130_ef_sc_hd__decap_12
XFILLER_229_1493 VPWR VGND VPWR VGND sky130_ef_sc_hd__decap_12
XFILLER_189_573 VPWR VGND VPWR VGND sky130_ef_sc_hd__decap_12
XFILLER_182_1073 VPWR VGND VPWR VGND sky130_ef_sc_hd__decap_12
XFILLER_225_1357 VPWR VGND VPWR VGND sky130_ef_sc_hd__decap_12
XTAP_TAPCELL_ROW_176_1626 VGND VPWR sky130_fd_sc_hd__tapvpwrvgnd_1
XTAP_TAPCELL_ROW_176_1637 VGND VPWR sky130_fd_sc_hd__tapvpwrvgnd_1
XFILLER_108_1177 VPWR VGND VPWR VGND sky130_ef_sc_hd__decap_12
XTAP_TAPCELL_ROW_176_1648 VGND VPWR sky130_fd_sc_hd__tapvpwrvgnd_1
XFILLER_176_245 VGND VGND VPWR VPWR sky130_fd_sc_hd__decap_6
XFILLER_121_1311 VPWR VGND VPWR VGND sky130_ef_sc_hd__decap_12
XFILLER_160_1371 VPWR VGND VPWR VGND sky130_ef_sc_hd__decap_12
XFILLER_125_1491 VGND VGND VPWR VPWR sky130_fd_sc_hd__decap_6
XFILLER_176_289 VPWR VGND VPWR VGND sky130_ef_sc_hd__decap_12
XFILLER_9_981 VPWR VGND VPWR VGND sky130_ef_sc_hd__decap_12
XFILLER_192_749 VGND VGND VPWR VPWR sky130_fd_sc_hd__decap_6
XFILLER_30_1227 VPWR VGND VPWR VGND sky130_ef_sc_hd__decap_12
XFILLER_195_1401 VPWR VGND VPWR VGND sky130_ef_sc_hd__decap_12
XFILLER_121_1355 VPWR VGND VPWR VGND sky130_ef_sc_hd__decap_12
XFILLER_191_237 VPWR VGND VPWR VGND sky130_ef_sc_hd__decap_12
XFILLER_121_1399 VPWR VGND VPWR VGND sky130_ef_sc_hd__decap_12
XFILLER_156_1407 VGND VGND VPWR VPWR sky130_fd_sc_hd__decap_6
XFILLER_236_1453 VPWR VGND VPWR VGND sky130_ef_sc_hd__decap_12
XFILLER_8_1217 VPWR VGND VPWR VGND sky130_ef_sc_hd__decap_12
XFILLER_232_1317 VPWR VGND VPWR VGND sky130_ef_sc_hd__decap_12
XFILLER_119_1273 VGND VGND VPWR VPWR sky130_fd_sc_hd__fill_1
XFILLER_236_1497 VPWR VGND VPWR VGND sky130_ef_sc_hd__decap_12
XFILLER_48_29 VPWR VGND VPWR VGND sky130_ef_sc_hd__decap_12
XFILLER_28_1189 VGND VGND VPWR VPWR sky130_fd_sc_hd__fill_1
XTAP_TAPCELL_ROW_245_3490 VGND VPWR sky130_fd_sc_hd__tapvpwrvgnd_1
XFILLER_41_1323 VGND VGND VPWR VPWR sky130_fd_sc_hd__decap_6
XFILLER_80_1383 VPWR VGND VPWR VGND sky130_ef_sc_hd__decap_12
XFILLER_132_1451 VPWR VGND VPWR VGND sky130_ef_sc_hd__decap_12
XFILLER_227_441 VGND VGND VPWR VPWR sky130_fd_sc_hd__decap_6
XPHY_EDGE_ROW_67_2_Right_158 VGND VGND VPWR VPWR sky130_fd_sc_hd__decap_3
XFILLER_41_1367 VPWR VGND VPWR VGND sky130_ef_sc_hd__decap_12
XTAP_TAPCELL_ROW_241_3387 VGND VPWR sky130_fd_sc_hd__tapvpwrvgnd_1
XFILLER_132_1495 VPWR VGND VPWR VGND sky130_ef_sc_hd__decap_12
XFILLER_230_1085 VGND VGND VPWR VPWR sky130_fd_sc_hd__decap_6
XTAP_TAPCELL_ROW_241_3398 VGND VPWR sky130_fd_sc_hd__tapvpwrvgnd_1
XFILLER_227_485 VPWR VGND VPWR VGND sky130_ef_sc_hd__decap_12
XFILLER_243_945 VGND VGND VPWR VPWR sky130_fd_sc_hd__decap_6
XFILLER_242_433 VPWR VGND VPWR VGND sky130_ef_sc_hd__decap_12
XFILLER_199_337 VPWR VGND VPWR VGND sky130_ef_sc_hd__decap_12
XFILLER_203_809 VPWR VGND VPWR VGND sky130_ef_sc_hd__decap_12
XFILLER_243_989 VPWR VGND VPWR VGND sky130_ef_sc_hd__decap_12
XFILLER_242_477 VPWR VGND VPWR VGND sky130_ef_sc_hd__decap_12
XFILLER_243_1413 VPWR VGND VPWR VGND sky130_ef_sc_hd__decap_12
XFILLER_168_713 VPWR VGND VPWR VGND sky130_ef_sc_hd__decap_12
XTAP_TAPCELL_ROW_254_3737 VGND VPWR sky130_fd_sc_hd__tapvpwrvgnd_1
XTAP_TAPCELL_ROW_254_3748 VGND VPWR sky130_fd_sc_hd__tapvpwrvgnd_1
XFILLER_74_1165 VPWR VGND VPWR VGND sky130_ef_sc_hd__decap_12
XFILLER_80_27 VGND VGND VPWR VPWR sky130_fd_sc_hd__fill_1
XFILLER_243_1457 VPWR VGND VPWR VGND sky130_ef_sc_hd__decap_12
XFILLER_167_223 VGND VGND VPWR VPWR sky130_fd_sc_hd__fill_1
XFILLER_211_853 VPWR VGND VPWR VGND sky130_ef_sc_hd__decap_12
XFILLER_168_757 VPWR VGND VPWR VGND sky130_ef_sc_hd__decap_12
XFILLER_196_27 VGND VGND VPWR VPWR sky130_fd_sc_hd__fill_1
XFILLER_210_363 VGND VGND VPWR VPWR sky130_fd_sc_hd__fill_1
XFILLER_211_897 VPWR VGND VPWR VGND sky130_ef_sc_hd__decap_12
XFILLER_52_1463 VGND VGND VPWR VPWR sky130_fd_sc_hd__decap_6
XFILLER_183_727 VGND VGND VPWR VPWR sky130_fd_sc_hd__fill_1
XTAP_TAPCELL_ROW_123_2_4493 VGND VPWR sky130_fd_sc_hd__tapvpwrvgnd_1
XFILLER_100_1439 VPWR VGND VPWR VGND sky130_ef_sc_hd__decap_12
XFILLER_198_1091 VGND VGND VPWR VPWR sky130_fd_sc_hd__fill_1
XFILLER_89_69 VGND VGND VPWR VPWR sky130_fd_sc_hd__fill_2
XFILLER_2_612 VGND VGND VPWR VPWR sky130_fd_sc_hd__fill_1
XFILLER_8_3 VPWR VGND VPWR VGND sky130_ef_sc_hd__decap_12
XFILLER_46_1245 VGND VGND VPWR VPWR sky130_fd_sc_hd__fill_1
XTAP_TAPCELL_ROW_71_2_4180 VGND VPWR sky130_fd_sc_hd__tapvpwrvgnd_1
XFILLER_172_1253 VGND VGND VPWR VPWR sky130_fd_sc_hd__decap_6
XFILLER_237_205 VPWR VGND VPWR VGND sky130_ef_sc_hd__decap_12
XFILLER_172_1297 VPWR VGND VPWR VGND sky130_ef_sc_hd__decap_12
XFILLER_237_249 VPWR VGND VPWR VGND sky130_ef_sc_hd__decap_12
XFILLER_253_709 VPWR VGND VPWR VGND sky130_ef_sc_hd__decap_12
XFILLER_219_953 VPWR VGND VPWR VGND sky130_ef_sc_hd__decap_12
XFILLER_20_1407 VGND VGND VPWR VPWR sky130_fd_sc_hd__decap_6
XFILLER_234_923 VGND VGND VPWR VPWR sky130_fd_sc_hd__fill_1
XFILLER_206_625 VPWR VGND VPWR VGND sky130_ef_sc_hd__decap_12
XFILLER_205_113 VPWR VGND VPWR VGND sky130_ef_sc_hd__decap_12
XFILLER_245_293 VPWR VGND VPWR VGND sky130_ef_sc_hd__decap_12
XFILLER_166_1035 VGND VGND VPWR VPWR sky130_fd_sc_hd__fill_1
X_515_ net517 net184 _264_ net79 net186 VGND VGND VPWR VPWR _266_ sky130_fd_sc_hd__o221a_1
XFILLER_206_669 VPWR VGND VPWR VGND sky130_ef_sc_hd__decap_12
XFILLER_221_617 VPWR VGND VPWR VGND sky130_ef_sc_hd__decap_12
XFILLER_18_1303 VPWR VGND VPWR VGND sky130_ef_sc_hd__decap_12
XFILLER_207_1021 VPWR VGND VPWR VGND sky130_ef_sc_hd__decap_12
X_446_ net127 net501 net88 _111_ VGND VGND VPWR VPWR _235_ sky130_fd_sc_hd__o31a_1
XFILLER_57_1385 VGND VGND VPWR VPWR sky130_fd_sc_hd__fill_1
XFILLER_183_1393 VGND VGND VPWR VPWR sky130_fd_sc_hd__decap_6
XFILLER_207_1065 VPWR VGND VPWR VGND sky130_ef_sc_hd__decap_12
X_377_ net218 _165_ VGND VGND VPWR VPWR _166_ sky130_fd_sc_hd__or2_1
XTAP_TAPCELL_ROW_43_2_4015 VGND VPWR sky130_fd_sc_hd__tapvpwrvgnd_1
XPHY_EDGE_ROW_29_2_Right_120 VGND VGND VPWR VPWR sky130_fd_sc_hd__decap_3
XFILLER_109_1497 VGND VGND VPWR VPWR sky130_fd_sc_hd__fill_1
XTAP_TAPCELL_ROW_28_2_3920 VGND VPWR sky130_fd_sc_hd__tapvpwrvgnd_1
XFILLER_201_385 VGND VGND VPWR VPWR sky130_fd_sc_hd__decap_6
XFILLER_186_587 VGND VGND VPWR VPWR sky130_fd_sc_hd__fill_1
XFILLER_9_277 VGND VGND VPWR VPWR sky130_fd_sc_hd__decap_3
XTAP_TAPCELL_ROW_171_1501 VGND VPWR sky130_fd_sc_hd__tapvpwrvgnd_1
XFILLER_174_749 VGND VGND VPWR VPWR sky130_fd_sc_hd__decap_6
XTAP_TAPCELL_ROW_171_1512 VGND VPWR sky130_fd_sc_hd__tapvpwrvgnd_1
XFILLER_173_237 VPWR VGND VPWR VGND sky130_ef_sc_hd__decap_12
XFILLER_62_6 VPWR VGND VPWR VGND sky130_ef_sc_hd__decap_12
XFILLER_255_1317 VPWR VGND VPWR VGND sky130_ef_sc_hd__decap_12
XFILLER_6_973 VGND VGND VPWR VPWR sky130_fd_sc_hd__decap_6
XFILLER_177_1175 VGND VGND VPWR VPWR sky130_fd_sc_hd__fill_1
XFILLER_182_793 VPWR VGND VPWR VGND sky130_ef_sc_hd__decap_12
XFILLER_181_281 VPWR VGND VPWR VGND sky130_ef_sc_hd__decap_12
XFILLER_64_1301 VGND VGND VPWR VPWR sky130_fd_sc_hd__fill_1
XFILLER_29_1443 VPWR VGND VPWR VGND sky130_ef_sc_hd__decap_12
XFILLER_218_1161 VPWR VGND VPWR VGND sky130_ef_sc_hd__decap_12
XFILLER_116_1413 VGND VGND VPWR VPWR sky130_fd_sc_hd__fill_1
XFILLER_253_1063 VGND VGND VPWR VPWR sky130_fd_sc_hd__fill_1
XTAP_TAPCELL_ROW_169_1441 VGND VPWR sky130_fd_sc_hd__tapvpwrvgnd_1
XFILLER_190_1353 VPWR VGND VPWR VGND sky130_ef_sc_hd__decap_12
XTAP_TAPCELL_ROW_169_1452 VGND VPWR sky130_fd_sc_hd__tapvpwrvgnd_1
XFILLER_25_1329 VGND VGND VPWR VPWR sky130_fd_sc_hd__fill_1
XTAP_TAPCELL_ROW_165_1305 VGND VPWR sky130_fd_sc_hd__tapvpwrvgnd_1
XTAP_TAPCELL_ROW_165_1316 VGND VPWR sky130_fd_sc_hd__tapvpwrvgnd_1
XFILLER_190_1397 VPWR VGND VPWR VGND sky130_ef_sc_hd__decap_12
XTAP_TAPCELL_ROW_165_1327 VGND VPWR sky130_fd_sc_hd__tapvpwrvgnd_1
XTAP_TAPCELL_ROW_165_1338 VGND VPWR sky130_fd_sc_hd__tapvpwrvgnd_1
XTAP_TAPCELL_ROW_165_1349 VGND VPWR sky130_fd_sc_hd__tapvpwrvgnd_1
XTAP_TAPCELL_ROW_160_2_4712 VGND VPWR sky130_fd_sc_hd__tapvpwrvgnd_1
XFILLER_209_441 VGND VGND VPWR VPWR sky130_fd_sc_hd__decap_6
XTAP_TAPCELL_ROW_159_2_4706 VGND VPWR sky130_fd_sc_hd__tapvpwrvgnd_1
XFILLER_237_783 VGND VGND VPWR VPWR sky130_fd_sc_hd__fill_1
XFILLER_209_485 VPWR VGND VPWR VGND sky130_ef_sc_hd__decap_12
XFILLER_3_1169 VGND VGND VPWR VPWR sky130_fd_sc_hd__decap_6
XFILLER_225_945 VGND VGND VPWR VPWR sky130_fd_sc_hd__decap_6
XFILLER_97_1165 VPWR VGND VPWR VGND sky130_ef_sc_hd__decap_12
XFILLER_224_433 VPWR VGND VPWR VGND sky130_ef_sc_hd__decap_12
XFILLER_149_1255 VPWR VGND VPWR VGND sky130_ef_sc_hd__decap_12
XFILLER_221_55 VGND VGND VPWR VPWR sky130_fd_sc_hd__fill_1
XFILLER_225_989 VPWR VGND VPWR VGND sky130_ef_sc_hd__decap_12
XFILLER_224_477 VPWR VGND VPWR VGND sky130_ef_sc_hd__decap_12
XFILLER_240_937 VPWR VGND VPWR VGND sky130_ef_sc_hd__decap_12
XFILLER_75_1441 VGND VGND VPWR VPWR sky130_fd_sc_hd__fill_1
XFILLER_211_105 VGND VGND VPWR VPWR sky130_fd_sc_hd__decap_6
XFILLER_149_1299 VPWR VGND VPWR VGND sky130_ef_sc_hd__decap_12
XFILLER_196_307 VGND VGND VPWR VPWR sky130_fd_sc_hd__fill_1
XFILLER_225_1121 VPWR VGND VPWR VGND sky130_ef_sc_hd__decap_12
XFILLER_211_149 VPWR VGND VPWR VGND sky130_ef_sc_hd__decap_12
XFILLER_36_1469 VGND VGND VPWR VPWR sky130_fd_sc_hd__fill_1
XFILLER_221_1007 VGND VGND VPWR VPWR sky130_fd_sc_hd__fill_1
XFILLER_192_513 VPWR VGND VPWR VGND sky130_ef_sc_hd__decap_12
XTAP_TAPCELL_ROW_234_3191 VGND VPWR sky130_fd_sc_hd__tapvpwrvgnd_1
XFILLER_69_1201 VPWR VGND VPWR VGND sky130_ef_sc_hd__decap_12
XFILLER_192_557 VPWR VGND VPWR VGND sky130_ef_sc_hd__decap_12
XPHY_EDGE_ROW_106_2_Left_608 VGND VGND VPWR VPWR sky130_fd_sc_hd__decap_3
XFILLER_195_1231 VGND VGND VPWR VPWR sky130_fd_sc_hd__fill_1
XFILLER_246_41 VPWR VGND VPWR VGND sky130_ef_sc_hd__decap_12
XTAP_TAPCELL_ROW_230_3088 VGND VPWR sky130_fd_sc_hd__tapvpwrvgnd_1
XTAP_TAPCELL_ROW_230_3099 VGND VPWR sky130_fd_sc_hd__tapvpwrvgnd_1
XFILLER_69_1267 VGND VGND VPWR VPWR sky130_fd_sc_hd__decap_6
XFILLER_156_1215 VPWR VGND VPWR VGND sky130_ef_sc_hd__decap_12
XFILLER_246_85 VPWR VGND VPWR VGND sky130_ef_sc_hd__decap_12
XFILLER_59_39 VPWR VGND VPWR VGND sky130_ef_sc_hd__decap_12
XTAP_TAPCELL_ROW_247_3541 VGND VPWR sky130_fd_sc_hd__tapvpwrvgnd_1
XFILLER_156_1259 VPWR VGND VPWR VGND sky130_ef_sc_hd__decap_12
XTAP_TAPCELL_ROW_247_3552 VGND VPWR sky130_fd_sc_hd__tapvpwrvgnd_1
XFILLER_182_29 VPWR VGND VPWR VGND sky130_ef_sc_hd__decap_12
XTAP_TAPCELL_ROW_247_3563 VGND VPWR sky130_fd_sc_hd__tapvpwrvgnd_1
XFILLER_236_1261 VPWR VGND VPWR VGND sky130_ef_sc_hd__decap_12
XTAP_TAPCELL_ROW_56_2_4093 VGND VPWR sky130_fd_sc_hd__tapvpwrvgnd_1
XFILLER_247_503 VGND VGND VPWR VPWR sky130_fd_sc_hd__fill_1
XTAP_TAPCELL_ROW_243_3438 VGND VPWR sky130_fd_sc_hd__tapvpwrvgnd_1
XFILLER_219_205 VPWR VGND VPWR VGND sky130_ef_sc_hd__decap_12
XTAP_TAPCELL_ROW_243_3449 VGND VPWR sky130_fd_sc_hd__tapvpwrvgnd_1
XFILLER_232_1147 VGND VGND VPWR VPWR sky130_fd_sc_hd__fill_1
XFILLER_75_27 VPWR VGND VPWR VGND sky130_ef_sc_hd__decap_12
XFILLER_219_249 VPWR VGND VPWR VGND sky130_ef_sc_hd__decap_12
XFILLER_235_709 VPWR VGND VPWR VGND sky130_ef_sc_hd__decap_12
XTAP_TAPCELL_ROW_3_932 VGND VPWR sky130_fd_sc_hd__tapvpwrvgnd_1
XTAP_TAPCELL_ROW_3_943 VGND VPWR sky130_fd_sc_hd__tapvpwrvgnd_1
XFILLER_80_1191 VPWR VGND VPWR VGND sky130_ef_sc_hd__decap_12
XTAP_TAPCELL_ROW_3_954 VGND VPWR sky130_fd_sc_hd__tapvpwrvgnd_1
XTAP_TAPCELL_ROW_9_1097 VGND VPWR sky130_fd_sc_hd__tapvpwrvgnd_1
XFILLER_189_1057 VGND VGND VPWR VPWR sky130_fd_sc_hd__decap_6
XFILLER_216_923 VGND VGND VPWR VPWR sky130_fd_sc_hd__fill_1
XPHY_EDGE_ROW_68_2_Right_159 VGND VGND VPWR VPWR sky130_fd_sc_hd__decap_3
XFILLER_227_293 VPWR VGND VPWR VGND sky130_ef_sc_hd__decap_12
XFILLER_243_753 VPWR VGND VPWR VGND sky130_ef_sc_hd__decap_12
XFILLER_76_1227 VPWR VGND VPWR VGND sky130_ef_sc_hd__decap_12
XFILLER_131_55 VGND VGND VPWR VPWR sky130_fd_sc_hd__fill_1
XFILLER_91_15 VPWR VGND VPWR VGND sky130_ef_sc_hd__decap_12
XFILLER_203_617 VPWR VGND VPWR VGND sky130_ef_sc_hd__decap_12
XFILLER_243_797 VPWR VGND VPWR VGND sky130_ef_sc_hd__decap_12
XFILLER_163_1219 VPWR VGND VPWR VGND sky130_ef_sc_hd__decap_12
X_300_ net595 dout0_q\[29\] net526 VGND VGND VPWR VPWR _089_ sky130_fd_sc_hd__a21o_1
XFILLER_128_1339 VPWR VGND VPWR VGND sky130_ef_sc_hd__decap_12
XFILLER_199_167 VGND VGND VPWR VPWR sky130_fd_sc_hd__fill_1
XFILLER_167_1399 VGND VGND VPWR VPWR sky130_fd_sc_hd__fill_1
XFILLER_187_329 VGND VGND VPWR VPWR sky130_fd_sc_hd__decap_6
XFILLER_208_1341 VPWR VGND VPWR VGND sky130_ef_sc_hd__decap_12
XFILLER_145_3 VPWR VGND VPWR VGND sky130_ef_sc_hd__decap_12
XFILLER_204_1205 VPWR VGND VPWR VGND sky130_ef_sc_hd__decap_12
XFILLER_230_469 VGND VGND VPWR VPWR sky130_fd_sc_hd__decap_6
XFILLER_208_1385 VPWR VGND VPWR VGND sky130_ef_sc_hd__decap_12
XFILLER_243_1287 VGND VGND VPWR VPWR sky130_fd_sc_hd__fill_1
XFILLER_168_587 VGND VGND VPWR VPWR sky130_fd_sc_hd__fill_1
XFILLER_195_373 VPWR VGND VPWR VGND sky130_ef_sc_hd__decap_12
XFILLER_6_203 VGND VGND VPWR VPWR sky130_fd_sc_hd__fill_1
Xwire635 net33 VGND VGND VPWR VPWR net635 sky130_fd_sc_hd__buf_1
XFILLER_52_1271 VPWR VGND VPWR VGND sky130_ef_sc_hd__decap_12
Xwire646 net24 VGND VGND VPWR VPWR net646 sky130_fd_sc_hd__buf_1
Xwire657 net15 VGND VGND VPWR VPWR net657 sky130_fd_sc_hd__buf_1
XFILLER_196_1017 VPWR VGND VPWR VGND sky130_ef_sc_hd__decap_12
XFILLER_13_1255 VPWR VGND VPWR VGND sky130_ef_sc_hd__decap_12
XFILLER_100_1203 VPWR VGND VPWR VGND sky130_ef_sc_hd__decap_12
XFILLER_40_41 VGND VGND VPWR VPWR sky130_fd_sc_hd__decap_6
XFILLER_87_1323 VGND VGND VPWR VPWR sky130_fd_sc_hd__decap_6
XFILLER_104_1383 VPWR VGND VPWR VGND sky130_ef_sc_hd__decap_12
XFILLER_13_1299 VPWR VGND VPWR VGND sky130_ef_sc_hd__decap_12
XFILLER_100_1247 VPWR VGND VPWR VGND sky130_ef_sc_hd__decap_12
XFILLER_156_41 VPWR VGND VPWR VGND sky130_ef_sc_hd__decap_12
XFILLER_3_921 VPWR VGND VPWR VGND sky130_ef_sc_hd__decap_12
XFILLER_87_1367 VPWR VGND VPWR VGND sky130_ef_sc_hd__decap_12
XFILLER_139_1435 VGND VGND VPWR VPWR sky130_fd_sc_hd__decap_6
XFILLER_174_1315 VGND VGND VPWR VPWR sky130_fd_sc_hd__fill_1
XFILLER_3_965 VPWR VGND VPWR VGND sky130_ef_sc_hd__decap_12
XFILLER_139_1479 VPWR VGND VPWR VGND sky130_ef_sc_hd__decap_12
XFILLER_215_1301 VPWR VGND VPWR VGND sky130_ef_sc_hd__decap_12
XFILLER_219_1481 VPWR VGND VPWR VGND sky130_ef_sc_hd__decap_12
XFILLER_250_1203 VGND VGND VPWR VPWR sky130_fd_sc_hd__fill_1
XFILLER_172_1061 VPWR VGND VPWR VGND sky130_ef_sc_hd__decap_12
XFILLER_215_1345 VPWR VGND VPWR VGND sky130_ef_sc_hd__decap_12
XFILLER_238_525 VGND VGND VPWR VPWR sky130_fd_sc_hd__decap_6
XTAP_TAPCELL_ROW_145_2_4625 VGND VPWR sky130_fd_sc_hd__tapvpwrvgnd_1
XPHY_EDGE_ROW_152_2_Left_654 VGND VGND VPWR VPWR sky130_fd_sc_hd__decap_3
XFILLER_238_569 VPWR VGND VPWR VGND sky130_ef_sc_hd__decap_12
XFILLER_24_1351 VGND VGND VPWR VPWR sky130_fd_sc_hd__decap_6
XFILLER_1_35 VPWR VGND VPWR VGND sky130_ef_sc_hd__decap_12
XTAP_TAPCELL_ROW_226_2979 VGND VPWR sky130_fd_sc_hd__tapvpwrvgnd_1
XFILLER_253_517 VPWR VGND VPWR VGND sky130_ef_sc_hd__decap_12
XFILLER_20_1215 VPWR VGND VPWR VGND sky130_ef_sc_hd__decap_12
XFILLER_1_57 VPWR VGND VPWR VGND sky130_ef_sc_hd__decap_12
XFILLER_24_1395 VPWR VGND VPWR VGND sky130_ef_sc_hd__decap_12
XFILLER_111_1343 VPWR VGND VPWR VGND sky130_ef_sc_hd__decap_12
XFILLER_219_783 VGND VGND VPWR VPWR sky130_fd_sc_hd__fill_1
XFILLER_98_1463 VGND VGND VPWR VPWR sky130_fd_sc_hd__decap_6
XFILLER_207_945 VGND VGND VPWR VPWR sky130_fd_sc_hd__decap_6
XFILLER_20_1259 VPWR VGND VPWR VGND sky130_ef_sc_hd__decap_12
XFILLER_206_433 VPWR VGND VPWR VGND sky130_ef_sc_hd__decap_12
XFILLER_94_1327 VPWR VGND VPWR VGND sky130_ef_sc_hd__decap_12
XFILLER_111_1387 VPWR VGND VPWR VGND sky130_ef_sc_hd__decap_12
XFILLER_185_1455 VGND VGND VPWR VPWR sky130_fd_sc_hd__fill_1
XFILLER_207_989 VPWR VGND VPWR VGND sky130_ef_sc_hd__decap_12
XFILLER_206_477 VPWR VGND VPWR VGND sky130_ef_sc_hd__decap_12
XFILLER_222_937 VPWR VGND VPWR VGND sky130_ef_sc_hd__decap_12
XFILLER_244_1029 VGND VGND VPWR VPWR sky130_fd_sc_hd__decap_6
XFILLER_146_1439 VPWR VGND VPWR VGND sky130_ef_sc_hd__decap_12
XFILLER_178_307 VGND VGND VPWR VPWR sky130_fd_sc_hd__fill_1
XFILLER_226_1441 VPWR VGND VPWR VGND sky130_ef_sc_hd__decap_12
XTAP_TAPCELL_ROW_93_2_4312 VGND VPWR sky130_fd_sc_hd__tapvpwrvgnd_1
XFILLER_221_447 VGND VGND VPWR VPWR sky130_fd_sc_hd__fill_1
XPHY_EDGE_ROW_104_1_Left_359 VGND VGND VPWR VPWR sky130_fd_sc_hd__decap_3
XFILLER_187_841 VPWR VGND VPWR VGND sky130_ef_sc_hd__decap_12
X_429_ net193 net191 VGND VGND VPWR VPWR _218_ sky130_fd_sc_hd__nor2_1
XFILLER_226_1485 VPWR VGND VPWR VGND sky130_ef_sc_hd__decap_12
XFILLER_230_981 VPWR VGND VPWR VGND sky130_ef_sc_hd__decap_12
XFILLER_18_1177 VPWR VGND VPWR VGND sky130_ef_sc_hd__decap_12
XFILLER_174_513 VPWR VGND VPWR VGND sky130_ef_sc_hd__decap_12
XFILLER_197_81 VPWR VGND VPWR VGND sky130_ef_sc_hd__decap_12
XFILLER_31_1311 VPWR VGND VPWR VGND sky130_ef_sc_hd__decap_12
XFILLER_201_193 VPWR VGND VPWR VGND sky130_ef_sc_hd__decap_12
XFILLER_35_1491 VGND VGND VPWR VPWR sky130_fd_sc_hd__decap_6
XFILLER_70_1371 VPWR VGND VPWR VGND sky130_ef_sc_hd__decap_12
XFILLER_174_557 VPWR VGND VPWR VGND sky130_ef_sc_hd__decap_12
XFILLER_31_1355 VPWR VGND VPWR VGND sky130_ef_sc_hd__decap_12
XFILLER_220_1073 VPWR VGND VPWR VGND sky130_ef_sc_hd__decap_12
XFILLER_122_1483 VPWR VGND VPWR VGND sky130_ef_sc_hd__decap_12
XFILLER_66_1407 VGND VGND VPWR VPWR sky130_fd_sc_hd__decap_6
XFILLER_31_1399 VPWR VGND VPWR VGND sky130_ef_sc_hd__decap_12
XFILLER_233_1401 VPWR VGND VPWR VGND sky130_ef_sc_hd__decap_12
XFILLER_9_1301 VPWR VGND VPWR VGND sky130_ef_sc_hd__decap_12
XFILLER_29_1273 VGND VGND VPWR VPWR sky130_fd_sc_hd__fill_1
XFILLER_216_77 VGND VGND VPWR VPWR sky130_fd_sc_hd__decap_6
XFILLER_9_1345 VPWR VGND VPWR VGND sky130_ef_sc_hd__decap_12
XFILLER_190_1161 VPWR VGND VPWR VGND sky130_ef_sc_hd__decap_12
XFILLER_229_503 VGND VGND VPWR VPWR sky130_fd_sc_hd__fill_1
XTAP_TAPCELL_ROW_40_2_3995 VGND VPWR sky130_fd_sc_hd__tapvpwrvgnd_1
XTAP_TAPCELL_ROW_39_2_3989 VGND VPWR sky130_fd_sc_hd__tapvpwrvgnd_1
XPHY_EDGE_ROW_84_2_Left_586 VGND VGND VPWR VPWR sky130_fd_sc_hd__decap_3
XFILLER_42_1451 VPWR VGND VPWR VGND sky130_ef_sc_hd__decap_12
XFILLER_217_709 VPWR VGND VPWR VGND sky130_ef_sc_hd__decap_12
Xinput1 rst VGND VGND VPWR VPWR net1 sky130_fd_sc_hd__clkbuf_1
XFILLER_151_1189 VPWR VGND VPWR VGND sky130_ef_sc_hd__decap_12
XFILLER_42_1495 VPWR VGND VPWR VGND sky130_ef_sc_hd__decap_12
XFILLER_232_65 VPWR VGND VPWR VGND sky130_ef_sc_hd__decap_12
XFILLER_209_293 VPWR VGND VPWR VGND sky130_ef_sc_hd__decap_12
XFILLER_225_753 VPWR VGND VPWR VGND sky130_ef_sc_hd__decap_12
XFILLER_240_701 VPWR VGND VPWR VGND sky130_ef_sc_hd__decap_12
XTAP_TAPCELL_ROW_255_3810 VGND VPWR sky130_fd_sc_hd__tapvpwrvgnd_1
XFILLER_225_797 VPWR VGND VPWR VGND sky130_ef_sc_hd__decap_12
XFILLER_169_329 VGND VGND VPWR VPWR sky130_fd_sc_hd__decap_6
XFILLER_101_69 VGND VGND VPWR VPWR sky130_fd_sc_hd__fill_2
XFILLER_212_469 VGND VGND VPWR VPWR sky130_fd_sc_hd__decap_6
XTAP_TAPCELL_ROW_236_3253 VGND VPWR sky130_fd_sc_hd__tapvpwrvgnd_1
XTAP_TAPCELL_ROW_236_3264 VGND VPWR sky130_fd_sc_hd__tapvpwrvgnd_1
XFILLER_240_1427 VGND VGND VPWR VPWR sky130_fd_sc_hd__fill_1
XFILLER_177_373 VPWR VGND VPWR VGND sky130_ef_sc_hd__decap_12
XFILLER_193_833 VGND VGND VPWR VPWR sky130_fd_sc_hd__decap_6
XTAP_TAPCELL_ROW_232_3139 VGND VPWR sky130_fd_sc_hd__tapvpwrvgnd_1
XFILLER_192_321 VPWR VGND VPWR VGND sky130_ef_sc_hd__decap_12
XFILLER_165_557 VGND VGND VPWR VPWR sky130_fd_sc_hd__decap_3
XFILLER_197_1337 VGND VGND VPWR VPWR sky130_fd_sc_hd__decap_6
XFILLER_193_877 VPWR VGND VPWR VGND sky130_ef_sc_hd__decap_12
XPHY_EDGE_ROW_98_1_Left_353 VGND VGND VPWR VPWR sky130_fd_sc_hd__decap_3
XFILLER_192_365 VPWR VGND VPWR VGND sky130_ef_sc_hd__decap_12
XTAP_TAPCELL_ROW_249_3603 VGND VPWR sky130_fd_sc_hd__tapvpwrvgnd_1
XTAP_TAPCELL_ROW_249_3614 VGND VPWR sky130_fd_sc_hd__tapvpwrvgnd_1
XFILLER_4_729 VGND VGND VPWR VPWR sky130_fd_sc_hd__decap_4
XFILLER_10_1439 VPWR VGND VPWR VGND sky130_ef_sc_hd__decap_12
XFILLER_84_1507 VGND VGND VPWR VPWR sky130_fd_sc_hd__decap_8
XFILLER_193_39 VPWR VGND VPWR VGND sky130_ef_sc_hd__decap_12
XFILLER_86_15 VPWR VGND VPWR VGND sky130_ef_sc_hd__decap_12
XFILLER_236_1091 VGND VGND VPWR VPWR sky130_fd_sc_hd__fill_1
XFILLER_173_1381 VPWR VGND VPWR VGND sky130_ef_sc_hd__decap_12
XTAP_TAPCELL_ROW_120_1_1255 VGND VPWR sky130_fd_sc_hd__tapvpwrvgnd_1
XFILLER_248_867 VGND VGND VPWR VPWR sky130_fd_sc_hd__fill_1
XFILLER_235_517 VPWR VGND VPWR VGND sky130_ef_sc_hd__decap_12
XFILLER_142_65 VGND VGND VPWR VPWR sky130_fd_sc_hd__decap_6
XFILLER_210_1253 VGND VGND VPWR VPWR sky130_fd_sc_hd__decap_6
XTAP_TAPCELL_ROW_111_2_4420 VGND VPWR sky130_fd_sc_hd__tapvpwrvgnd_1
XTAP_TAPCELL_ROW_221_2843 VGND VPWR sky130_fd_sc_hd__tapvpwrvgnd_1
XFILLER_210_1297 VPWR VGND VPWR VGND sky130_ef_sc_hd__decap_12
XTAP_TAPCELL_ROW_221_2854 VGND VPWR sky130_fd_sc_hd__tapvpwrvgnd_1
XFILLER_243_561 VPWR VGND VPWR VGND sky130_ef_sc_hd__decap_12
XTAP_TAPCELL_ROW_221_2865 VGND VPWR sky130_fd_sc_hd__tapvpwrvgnd_1
XFILLER_204_937 VPWR VGND VPWR VGND sky130_ef_sc_hd__decap_12
XTAP_TAPCELL_ROW_78_2_4225 VGND VPWR sky130_fd_sc_hd__tapvpwrvgnd_1
XFILLER_203_447 VGND VGND VPWR VPWR sky130_fd_sc_hd__fill_1
XFILLER_230_233 VPWR VGND VPWR VGND sky130_ef_sc_hd__decap_12
XFILLER_169_841 VPWR VGND VPWR VGND sky130_ef_sc_hd__decap_12
XFILLER_187_137 VPWR VGND VPWR VGND sky130_ef_sc_hd__decap_12
XFILLER_180_1341 VPWR VGND VPWR VGND sky130_ef_sc_hd__decap_12
XFILLER_230_277 VPWR VGND VPWR VGND sky130_ef_sc_hd__decap_12
XFILLER_212_981 VPWR VGND VPWR VGND sky130_ef_sc_hd__decap_12
XFILLER_184_811 VGND VGND VPWR VPWR sky130_fd_sc_hd__fill_1
XFILLER_204_1035 VGND VGND VPWR VPWR sky130_fd_sc_hd__fill_1
XFILLER_19_1497 VGND VGND VPWR VPWR sky130_fd_sc_hd__fill_1
Xwire410 net411 VGND VGND VPWR VPWR net410 sky130_fd_sc_hd__clkbuf_1
XFILLER_180_1385 VPWR VGND VPWR VGND sky130_ef_sc_hd__decap_12
XTAP_TAPCELL_ROW_58_2_4101 VGND VPWR sky130_fd_sc_hd__tapvpwrvgnd_1
Xwire421 net422 VGND VGND VPWR VPWR net421 sky130_fd_sc_hd__clkbuf_1
XFILLER_196_693 VGND VGND VPWR VPWR sky130_fd_sc_hd__decap_6
XTAP_TAPCELL_ROW_219_2794 VGND VPWR sky130_fd_sc_hd__tapvpwrvgnd_1
Xwire432 net433 VGND VGND VPWR VPWR net432 sky130_fd_sc_hd__clkbuf_1
XFILLER_195_181 VPWR VGND VPWR VGND sky130_ef_sc_hd__decap_12
Xwire443 net444 VGND VGND VPWR VPWR net443 sky130_fd_sc_hd__clkbuf_1
Xwire454 net455 VGND VGND VPWR VPWR net454 sky130_fd_sc_hd__clkbuf_1
XFILLER_167_51 VGND VGND VPWR VPWR sky130_fd_sc_hd__decap_4
Xwire465 net466 VGND VGND VPWR VPWR net465 sky130_fd_sc_hd__clkbuf_1
Xwire476 net477 VGND VGND VPWR VPWR net476 sky130_fd_sc_hd__clkbuf_1
XFILLER_171_505 VPWR VGND VPWR VGND sky130_ef_sc_hd__decap_12
Xmax_cap209 _176_ VGND VGND VPWR VPWR net209 sky130_fd_sc_hd__clkbuf_1
XFILLER_221_1393 VGND VGND VPWR VPWR sky130_fd_sc_hd__decap_6
Xwire487 net488 VGND VGND VPWR VPWR net487 sky130_fd_sc_hd__clkbuf_1
XFILLER_104_1191 VPWR VGND VPWR VGND sky130_ef_sc_hd__decap_12
Xwire498 _118_ VGND VGND VPWR VPWR net498 sky130_fd_sc_hd__clkbuf_1
XFILLER_139_1243 VPWR VGND VPWR VGND sky130_ef_sc_hd__decap_12
XFILLER_252_1309 VGND VGND VPWR VPWR sky130_fd_sc_hd__decap_6
XFILLER_139_1287 VPWR VGND VPWR VGND sky130_ef_sc_hd__decap_12
XFILLER_26_1413 VGND VGND VPWR VPWR sky130_fd_sc_hd__fill_1
XFILLER_191_1481 VPWR VGND VPWR VGND sky130_ef_sc_hd__decap_12
XFILLER_238_333 VPWR VGND VPWR VGND sky130_ef_sc_hd__decap_12
XFILLER_215_1175 VGND VGND VPWR VPWR sky130_fd_sc_hd__fill_1
XFILLER_239_889 VGND VGND VPWR VPWR sky130_fd_sc_hd__decap_6
XFILLER_238_377 VPWR VGND VPWR VGND sky130_ef_sc_hd__decap_12
XFILLER_254_837 VPWR VGND VPWR VGND sky130_ef_sc_hd__decap_12
XFILLER_4_1253 VGND VGND VPWR VPWR sky130_fd_sc_hd__decap_6
XFILLER_0_1117 VGND VGND VPWR VPWR sky130_fd_sc_hd__decap_3
XFILLER_98_1271 VPWR VGND VPWR VGND sky130_ef_sc_hd__decap_12
XFILLER_207_753 VPWR VGND VPWR VGND sky130_ef_sc_hd__decap_12
XFILLER_4_1297 VPWR VGND VPWR VGND sky130_ef_sc_hd__decap_12
XFILLER_222_701 VPWR VGND VPWR VGND sky130_ef_sc_hd__decap_12
XFILLER_59_1255 VPWR VGND VPWR VGND sky130_ef_sc_hd__decap_12
XFILLER_146_1203 VPWR VGND VPWR VGND sky130_ef_sc_hd__decap_12
XFILLER_207_797 VPWR VGND VPWR VGND sky130_ef_sc_hd__decap_12
XFILLER_59_1299 VPWR VGND VPWR VGND sky130_ef_sc_hd__decap_12
XFILLER_146_1247 VPWR VGND VPWR VGND sky130_ef_sc_hd__decap_12
XFILLER_187_671 VGND VGND VPWR VPWR sky130_fd_sc_hd__fill_1
XFILLER_175_833 VGND VGND VPWR VPWR sky130_fd_sc_hd__decap_6
XFILLER_179_1001 VGND VGND VPWR VPWR sky130_fd_sc_hd__decap_6
XFILLER_174_321 VPWR VGND VPWR VGND sky130_ef_sc_hd__decap_12
XFILLER_175_877 VPWR VGND VPWR VGND sky130_ef_sc_hd__decap_12
XFILLER_179_1045 VPWR VGND VPWR VGND sky130_ef_sc_hd__decap_12
XFILLER_174_365 VPWR VGND VPWR VGND sky130_ef_sc_hd__decap_12
XFILLER_190_825 VPWR VGND VPWR VGND sky130_ef_sc_hd__decap_12
XFILLER_179_1089 VPWR VGND VPWR VGND sky130_ef_sc_hd__decap_12
XFILLER_200_1477 VGND VGND VPWR VPWR sky130_fd_sc_hd__decap_6
XFILLER_190_869 VPWR VGND VPWR VGND sky130_ef_sc_hd__decap_12
XFILLER_66_1215 VPWR VGND VPWR VGND sky130_ef_sc_hd__decap_12
XFILLER_157_1343 VPWR VGND VPWR VGND sky130_ef_sc_hd__decap_12
XFILLER_249_609 VGND VGND VPWR VPWR sky130_fd_sc_hd__decap_6
XFILLER_66_1259 VPWR VGND VPWR VGND sky130_ef_sc_hd__decap_12
XFILLER_0_209 VPWR VGND VPWR VGND sky130_ef_sc_hd__decap_12
XFILLER_118_1327 VPWR VGND VPWR VGND sky130_ef_sc_hd__decap_12
XFILLER_157_1387 VPWR VGND VPWR VGND sky130_ef_sc_hd__decap_12
XFILLER_233_1231 VGND VGND VPWR VPWR sky130_fd_sc_hd__fill_1
XTAP_TAPCELL_ROW_84_2_4257 VGND VPWR sky130_fd_sc_hd__tapvpwrvgnd_1
XFILLER_56_29 VPWR VGND VPWR VGND sky130_ef_sc_hd__decap_12
XTAP_TAPCELL_ROW_6_1012 VGND VPWR sky130_fd_sc_hd__tapvpwrvgnd_1
XFILLER_217_517 VPWR VGND VPWR VGND sky130_ef_sc_hd__decap_12
XTAP_TAPCELL_ROW_6_1023 VGND VPWR sky130_fd_sc_hd__tapvpwrvgnd_1
XTAP_TAPCELL_ROW_6_1034 VGND VPWR sky130_fd_sc_hd__tapvpwrvgnd_1
XFILLER_186_1005 VPWR VGND VPWR VGND sky130_ef_sc_hd__decap_12
XFILLER_77_1311 VPWR VGND VPWR VGND sky130_ef_sc_hd__decap_12
XFILLER_186_1049 VPWR VGND VPWR VGND sky130_ef_sc_hd__decap_12
XTAP_TAPCELL_ROW_238_3304 VGND VPWR sky130_fd_sc_hd__tapvpwrvgnd_1
XFILLER_225_561 VPWR VGND VPWR VGND sky130_ef_sc_hd__decap_12
XTAP_TAPCELL_ROW_238_3315 VGND VPWR sky130_fd_sc_hd__tapvpwrvgnd_1
XFILLER_77_1355 VPWR VGND VPWR VGND sky130_ef_sc_hd__decap_12
XFILLER_129_1423 VPWR VGND VPWR VGND sky130_ef_sc_hd__decap_12
XFILLER_164_1303 VPWR VGND VPWR VGND sky130_ef_sc_hd__decap_12
XFILLER_198_925 VPWR VGND VPWR VGND sky130_ef_sc_hd__decap_12
XFILLER_168_1483 VGND VGND VPWR VPWR sky130_fd_sc_hd__fill_1
XFILLER_240_531 VGND VGND VPWR VPWR sky130_fd_sc_hd__fill_1
XFILLER_38_1339 VPWR VGND VPWR VGND sky130_ef_sc_hd__decap_12
XFILLER_73_1219 VPWR VGND VPWR VGND sky130_ef_sc_hd__decap_12
XPHY_EDGE_ROW_50_1_Right_706 VGND VGND VPWR VPWR sky130_fd_sc_hd__decap_3
XFILLER_77_1399 VPWR VGND VPWR VGND sky130_ef_sc_hd__decap_12
XFILLER_129_1467 VPWR VGND VPWR VGND sky130_ef_sc_hd__decap_12
XFILLER_212_233 VPWR VGND VPWR VGND sky130_ef_sc_hd__decap_12
XFILLER_227_1057 VGND VGND VPWR VPWR sky130_fd_sc_hd__decap_6
XFILLER_169_137 VPWR VGND VPWR VGND sky130_ef_sc_hd__decap_12
XFILLER_244_1371 VGND VGND VPWR VPWR sky130_fd_sc_hd__fill_1
XFILLER_212_277 VPWR VGND VPWR VGND sky130_ef_sc_hd__decap_12
XTAP_TAPCELL_ROW_44_2_4020 VGND VPWR sky130_fd_sc_hd__tapvpwrvgnd_1
XFILLER_166_811 VGND VGND VPWR VPWR sky130_fd_sc_hd__fill_1
XFILLER_178_693 VGND VGND VPWR VPWR sky130_fd_sc_hd__decap_6
XFILLER_165_321 VPWR VGND VPWR VGND sky130_ef_sc_hd__decap_12
XFILLER_177_181 VPWR VGND VPWR VGND sky130_ef_sc_hd__decap_12
XFILLER_197_1101 VPWR VGND VPWR VGND sky130_ef_sc_hd__decap_12
XFILLER_193_641 VPWR VGND VPWR VGND sky130_ef_sc_hd__decap_12
XFILLER_205_1399 VGND VGND VPWR VPWR sky130_fd_sc_hd__fill_1
XPHY_EDGE_ROW_239_Right_84 VGND VGND VPWR VPWR sky130_fd_sc_hd__decap_3
XFILLER_10_1203 VPWR VGND VPWR VGND sky130_ef_sc_hd__decap_12
XFILLER_165_365 VPWR VGND VPWR VGND sky130_ef_sc_hd__decap_12
XFILLER_197_1145 VPWR VGND VPWR VGND sky130_ef_sc_hd__decap_12
XFILLER_193_685 VPWR VGND VPWR VGND sky130_ef_sc_hd__decap_12
XFILLER_14_1383 VPWR VGND VPWR VGND sky130_ef_sc_hd__decap_12
XFILLER_101_1331 VPWR VGND VPWR VGND sky130_ef_sc_hd__decap_12
XFILLER_88_1451 VPWR VGND VPWR VGND sky130_ef_sc_hd__decap_12
XFILLER_193_1009 VPWR VGND VPWR VGND sky130_ef_sc_hd__decap_12
XFILLER_10_1247 VPWR VGND VPWR VGND sky130_ef_sc_hd__decap_12
XFILLER_192_195 VGND VGND VPWR VPWR sky130_fd_sc_hd__fill_1
XFILLER_197_1189 VPWR VGND VPWR VGND sky130_ef_sc_hd__decap_12
XFILLER_49_1435 VGND VGND VPWR VPWR sky130_fd_sc_hd__decap_6
XFILLER_84_1315 VPWR VGND VPWR VGND sky130_ef_sc_hd__decap_12
XFILLER_108_3 VPWR VGND VPWR VGND sky130_ef_sc_hd__decap_12
XFILLER_180_357 VGND VGND VPWR VPWR sky130_fd_sc_hd__decap_6
XFILLER_88_1495 VPWR VGND VPWR VGND sky130_ef_sc_hd__decap_12
XTAP_TAPCELL_ROW_210_2544 VGND VPWR sky130_fd_sc_hd__tapvpwrvgnd_1
XTAP_TAPCELL_ROW_210_2555 VGND VPWR sky130_fd_sc_hd__tapvpwrvgnd_1
XFILLER_234_1017 VPWR VGND VPWR VGND sky130_ef_sc_hd__decap_12
XTAP_TAPCELL_ROW_210_2566 VGND VPWR sky130_fd_sc_hd__tapvpwrvgnd_1
XFILLER_49_1479 VPWR VGND VPWR VGND sky130_ef_sc_hd__decap_12
XFILLER_84_1359 VPWR VGND VPWR VGND sky130_ef_sc_hd__decap_12
XFILLER_136_1427 VPWR VGND VPWR VGND sky130_ef_sc_hd__decap_12
XFILLER_238_1197 VGND VGND VPWR VPWR sky130_fd_sc_hd__decap_6
XFILLER_97_69 VGND VGND VPWR VPWR sky130_fd_sc_hd__fill_2
XFILLER_0_776 VGND VGND VPWR VPWR sky130_fd_sc_hd__decap_4
XFILLER_212_1315 VGND VGND VPWR VPWR sky130_fd_sc_hd__fill_1
XTAP_TAPCELL_ROW_223_2905 VGND VPWR sky130_fd_sc_hd__tapvpwrvgnd_1
XPHY_EDGE_ROW_248_Right_93 VGND VGND VPWR VPWR sky130_fd_sc_hd__decap_3
XTAP_TAPCELL_ROW_223_2916 VGND VPWR sky130_fd_sc_hd__tapvpwrvgnd_1
XFILLER_236_837 VPWR VGND VPWR VGND sky130_ef_sc_hd__decap_12
XFILLER_169_1225 VGND VGND VPWR VPWR sky130_fd_sc_hd__decap_6
XTAP_TAPCELL_ROW_208_2495 VGND VPWR sky130_fd_sc_hd__tapvpwrvgnd_1
XFILLER_21_1343 VPWR VGND VPWR VGND sky130_ef_sc_hd__decap_12
XFILLER_95_1411 VPWR VGND VPWR VGND sky130_ef_sc_hd__decap_12
XFILLER_112_1471 VPWR VGND VPWR VGND sky130_ef_sc_hd__decap_12
XFILLER_210_1061 VPWR VGND VPWR VGND sky130_ef_sc_hd__decap_12
XFILLER_1_1437 VPWR VGND VPWR VGND sky130_ef_sc_hd__decap_12
XFILLER_169_1269 VPWR VGND VPWR VGND sky130_ef_sc_hd__decap_12
XFILLER_21_1387 VPWR VGND VPWR VGND sky130_ef_sc_hd__decap_12
XFILLER_204_701 VPWR VGND VPWR VGND sky130_ef_sc_hd__decap_12
XFILLER_244_881 VPWR VGND VPWR VGND sky130_ef_sc_hd__decap_12
XFILLER_245_1113 VGND VGND VPWR VPWR sky130_fd_sc_hd__decap_6
XFILLER_95_1455 VPWR VGND VPWR VGND sky130_ef_sc_hd__decap_12
Xmax_cap96 net97 VGND VGND VPWR VPWR net96 sky130_fd_sc_hd__clkbuf_1
XFILLER_188_413 VGND VGND VPWR VPWR sky130_fd_sc_hd__decap_6
XFILLER_243_391 VGND VGND VPWR VPWR sky130_fd_sc_hd__fill_1
XFILLER_56_1439 VPWR VGND VPWR VGND sky130_ef_sc_hd__decap_12
XFILLER_108_1507 VGND VGND VPWR VPWR sky130_fd_sc_hd__decap_8
XFILLER_245_1157 VPWR VGND VPWR VGND sky130_ef_sc_hd__decap_12
XFILLER_95_1499 VPWR VGND VPWR VGND sky130_ef_sc_hd__decap_12
XFILLER_231_553 VGND VGND VPWR VPWR sky130_fd_sc_hd__decap_6
XFILLER_188_457 VPWR VGND VPWR VGND sky130_ef_sc_hd__decap_12
XFILLER_169_671 VGND VGND VPWR VPWR sky130_fd_sc_hd__fill_1
XFILLER_231_597 VPWR VGND VPWR VGND sky130_ef_sc_hd__decap_12
XFILLER_223_1455 VGND VGND VPWR VPWR sky130_fd_sc_hd__fill_1
XFILLER_178_83 VGND VGND VPWR VPWR sky130_fd_sc_hd__fill_1
XFILLER_200_973 VGND VGND VPWR VPWR sky130_fd_sc_hd__decap_6
Xwire240 net241 VGND VGND VPWR VPWR net240 sky130_fd_sc_hd__clkbuf_1
XTAP_TAPCELL_ROW_122_2_4489 VGND VPWR sky130_fd_sc_hd__tapvpwrvgnd_1
XFILLER_141_1177 VPWR VGND VPWR VGND sky130_ef_sc_hd__decap_12
Xwire251 net252 VGND VGND VPWR VPWR net251 sky130_fd_sc_hd__clkbuf_1
Xwire262 net263 VGND VGND VPWR VPWR net262 sky130_fd_sc_hd__clkbuf_1
XFILLER_172_825 VPWR VGND VPWR VGND sky130_ef_sc_hd__decap_12
Xwire273 net274 VGND VGND VPWR VPWR net273 sky130_fd_sc_hd__clkbuf_1
XFILLER_32_1483 VPWR VGND VPWR VGND sky130_ef_sc_hd__decap_12
Xwire284 net285 VGND VGND VPWR VPWR net284 sky130_fd_sc_hd__clkbuf_1
Xwire295 net296 VGND VGND VPWR VPWR net295 sky130_fd_sc_hd__clkbuf_1
XFILLER_176_1229 VPWR VGND VPWR VGND sky130_ef_sc_hd__decap_12
XFILLER_171_335 VGND VGND VPWR VPWR sky130_fd_sc_hd__fill_1
XFILLER_172_869 VPWR VGND VPWR VGND sky130_ef_sc_hd__decap_12
XTAP_TAPCELL_ROW_102_2_4365 VGND VPWR sky130_fd_sc_hd__tapvpwrvgnd_1
XFILLER_252_1117 VPWR VGND VPWR VGND sky130_ef_sc_hd__decap_12
XTAP_TAPCELL_ROW_70_2_4176 VGND VPWR sky130_fd_sc_hd__tapvpwrvgnd_1
XFILLER_6_1315 VGND VGND VPWR VPWR sky130_fd_sc_hd__fill_1
XFILLER_23_3 VPWR VGND VPWR VGND sky130_ef_sc_hd__decap_12
XFILLER_239_653 VPWR VGND VPWR VGND sky130_ef_sc_hd__decap_12
XFILLER_113_1213 VGND VGND VPWR VPWR sky130_fd_sc_hd__decap_4
XFILLER_238_141 VPWR VGND VPWR VGND sky130_ef_sc_hd__decap_12
XFILLER_254_601 VPWR VGND VPWR VGND sky130_ef_sc_hd__decap_12
XTAP_TAPCELL_ROW_185_1875 VGND VPWR sky130_fd_sc_hd__tapvpwrvgnd_1
XFILLER_239_697 VPWR VGND VPWR VGND sky130_ef_sc_hd__decap_12
XFILLER_152_1295 VGND VGND VPWR VPWR sky130_fd_sc_hd__decap_6
XTAP_TAPCELL_ROW_185_1886 VGND VPWR sky130_fd_sc_hd__tapvpwrvgnd_1
XFILLER_61_1189 VPWR VGND VPWR VGND sky130_ef_sc_hd__decap_12
XFILLER_253_111 VGND VGND VPWR VPWR sky130_fd_sc_hd__fill_1
XFILLER_254_645 VPWR VGND VPWR VGND sky130_ef_sc_hd__decap_12
XFILLER_187_1325 VPWR VGND VPWR VGND sky130_ef_sc_hd__decap_12
XTAP_TAPCELL_ROW_50_2_4052 VGND VPWR sky130_fd_sc_hd__tapvpwrvgnd_1
XFILLER_4_1061 VPWR VGND VPWR VGND sky130_ef_sc_hd__decap_12
XTAP_TAPCELL_ROW_49_2_4046 VGND VPWR sky130_fd_sc_hd__tapvpwrvgnd_1
XFILLER_187_1369 VPWR VGND VPWR VGND sky130_ef_sc_hd__decap_12
XFILLER_241_317 VPWR VGND VPWR VGND sky130_ef_sc_hd__decap_12
XFILLER_207_561 VPWR VGND VPWR VGND sky130_ef_sc_hd__decap_12
XPHY_EDGE_ROW_115_2_Left_617 VGND VGND VPWR VPWR sky130_fd_sc_hd__decap_3
XFILLER_222_531 VGND VGND VPWR VPWR sky130_fd_sc_hd__fill_1
XFILLER_241_1511 VGND VGND VPWR VPWR sky130_fd_sc_hd__fill_1
XFILLER_210_737 VPWR VGND VPWR VGND sky130_ef_sc_hd__decap_12
XFILLER_175_641 VPWR VGND VPWR VGND sky130_ef_sc_hd__decap_12
XFILLER_198_1421 VGND VGND VPWR VPWR sky130_fd_sc_hd__decap_6
XTAP_TAPCELL_ROW_27_2_3916 VGND VPWR sky130_fd_sc_hd__tapvpwrvgnd_1
XFILLER_238_53 VPWR VGND VPWR VGND sky130_ef_sc_hd__decap_12
XFILLER_120_1239 VGND VGND VPWR VPWR sky130_fd_sc_hd__decap_6
XFILLER_175_685 VPWR VGND VPWR VGND sky130_ef_sc_hd__decap_12
XFILLER_198_1465 VPWR VGND VPWR VGND sky130_ef_sc_hd__decap_12
XFILLER_200_1241 VPWR VGND VPWR VGND sky130_ef_sc_hd__decap_12
XFILLER_194_1329 VPWR VGND VPWR VGND sky130_ef_sc_hd__decap_12
XFILLER_238_97 VPWR VGND VPWR VGND sky130_ef_sc_hd__decap_12
XFILLER_174_195 VGND VGND VPWR VPWR sky130_fd_sc_hd__fill_1
Xmax_cap540 net49 VGND VGND VPWR VPWR net540 sky130_fd_sc_hd__clkbuf_1
XFILLER_200_1285 VPWR VGND VPWR VGND sky130_ef_sc_hd__decap_12
XFILLER_190_699 VGND VGND VPWR VPWR sky130_fd_sc_hd__fill_1
XTAP_TAPCELL_ROW_227_3005 VGND VPWR sky130_fd_sc_hd__tapvpwrvgnd_1
XFILLER_254_41 VPWR VGND VPWR VGND sky130_ef_sc_hd__decap_12
XFILLER_235_1337 VGND VGND VPWR VPWR sky130_fd_sc_hd__decap_6
XTAP_TAPCELL_ROW_227_3016 VGND VPWR sky130_fd_sc_hd__tapvpwrvgnd_1
XFILLER_249_417 VPWR VGND VPWR VGND sky130_ef_sc_hd__decap_12
XFILLER_107_57 VPWR VGND VPWR VGND sky130_ef_sc_hd__decap_12
XTAP_TAPCELL_ROW_227_3027 VGND VPWR sky130_fd_sc_hd__tapvpwrvgnd_1
XFILLER_254_85 VPWR VGND VPWR VGND sky130_ef_sc_hd__decap_12
XFILLER_67_39 VPWR VGND VPWR VGND sky130_ef_sc_hd__decap_12
XFILLER_190_29 VPWR VGND VPWR VGND sky130_ef_sc_hd__decap_12
XTAP_TAPCELL_ROW_146_2_4630 VGND VPWR sky130_fd_sc_hd__tapvpwrvgnd_1
XFILLER_170_1373 VPWR VGND VPWR VGND sky130_ef_sc_hd__decap_12
XFILLER_218_837 VPWR VGND VPWR VGND sky130_ef_sc_hd__decap_12
XFILLER_131_1379 VGND VGND VPWR VPWR sky130_fd_sc_hd__decap_6
XFILLER_244_133 VGND VGND VPWR VPWR sky130_fd_sc_hd__decap_6
XPHY_EDGE_ROW_47_2_Left_549 VGND VGND VPWR VPWR sky130_fd_sc_hd__decap_3
XFILLER_83_27 VPWR VGND VPWR VGND sky130_ef_sc_hd__decap_12
XFILLER_211_1381 VPWR VGND VPWR VGND sky130_ef_sc_hd__decap_12
XFILLER_166_1409 VPWR VGND VPWR VGND sky130_ef_sc_hd__decap_12
XFILLER_229_1119 VGND VGND VPWR VPWR sky130_fd_sc_hd__fill_1
XFILLER_244_177 VPWR VGND VPWR VGND sky130_ef_sc_hd__decap_12
XFILLER_199_27 VPWR VGND VPWR VGND sky130_ef_sc_hd__decap_12
XFILLER_226_881 VPWR VGND VPWR VGND sky130_ef_sc_hd__decap_12
XTAP_TAPCELL_ROW_115_1_1250 VGND VPWR sky130_fd_sc_hd__tapvpwrvgnd_1
XFILLER_129_1231 VPWR VGND VPWR VGND sky130_ef_sc_hd__decap_12
XTAP_TAPCELL_ROW_203_2370 VGND VPWR sky130_fd_sc_hd__tapvpwrvgnd_1
XFILLER_225_391 VGND VGND VPWR VPWR sky130_fd_sc_hd__fill_1
XFILLER_16_65 VGND VGND VPWR VPWR sky130_fd_sc_hd__decap_6
XFILLER_246_1477 VGND VGND VPWR VPWR sky130_fd_sc_hd__decap_6
XFILLER_213_553 VGND VGND VPWR VPWR sky130_fd_sc_hd__decap_6
XFILLER_0_1481 VGND VGND VPWR VPWR sky130_fd_sc_hd__decap_3
XFILLER_198_755 VGND VGND VPWR VPWR sky130_fd_sc_hd__fill_1
XFILLER_129_1275 VPWR VGND VPWR VGND sky130_ef_sc_hd__decap_12
XFILLER_186_917 VGND VGND VPWR VPWR sky130_fd_sc_hd__decap_6
XFILLER_241_895 VGND VGND VPWR VPWR sky130_fd_sc_hd__fill_1
XPHY_EDGE_ROW_51_1_Right_707 VGND VGND VPWR VPWR sky130_fd_sc_hd__decap_3
XFILLER_9_607 VGND VGND VPWR VPWR sky130_fd_sc_hd__decap_8
XFILLER_164_1177 VPWR VGND VPWR VGND sky130_ef_sc_hd__decap_12
XFILLER_185_405 VPWR VGND VPWR VGND sky130_ef_sc_hd__decap_12
XTAP_TAPCELL_ROW_195_2160 VGND VPWR sky130_fd_sc_hd__tapvpwrvgnd_1
XFILLER_213_597 VPWR VGND VPWR VGND sky130_ef_sc_hd__decap_12
XFILLER_9_629 VPWR VGND VPWR VGND sky130_ef_sc_hd__decap_12
XFILLER_185_449 VPWR VGND VPWR VGND sky130_ef_sc_hd__decap_12
XTAP_TAPCELL_ROW_191_2035 VGND VPWR sky130_fd_sc_hd__tapvpwrvgnd_1
XTAP_TAPCELL_ROW_191_2046 VGND VPWR sky130_fd_sc_hd__tapvpwrvgnd_1
XTAP_TAPCELL_ROW_216_2720 VGND VPWR sky130_fd_sc_hd__tapvpwrvgnd_1
XFILLER_8_139 VGND VGND VPWR VPWR sky130_fd_sc_hd__fill_1
XFILLER_225_3 VPWR VGND VPWR VGND sky130_ef_sc_hd__decap_12
XFILLER_194_961 VPWR VGND VPWR VGND sky130_ef_sc_hd__decap_12
XFILLER_148_53 VPWR VGND VPWR VGND sky130_ef_sc_hd__decap_12
XFILLER_177_1505 VGND VGND VPWR VPWR sky130_fd_sc_hd__decap_6
XPHY_EDGE_ROW_161_2_Left_663 VGND VGND VPWR VPWR sky130_fd_sc_hd__decap_3
XTAP_TAPCELL_ROW_212_2606 VGND VPWR sky130_fd_sc_hd__tapvpwrvgnd_1
XTAP_TAPCELL_ROW_212_2617 VGND VPWR sky130_fd_sc_hd__tapvpwrvgnd_1
XFILLER_14_1191 VPWR VGND VPWR VGND sky130_ef_sc_hd__decap_12
XFILLER_180_121 VPWR VGND VPWR VGND sky130_ef_sc_hd__decap_12
XFILLER_49_1243 VPWR VGND VPWR VGND sky130_ef_sc_hd__decap_12
XFILLER_180_165 VPWR VGND VPWR VGND sky130_ef_sc_hd__decap_12
XFILLER_253_1437 VPWR VGND VPWR VGND sky130_ef_sc_hd__decap_12
XFILLER_164_41 VPWR VGND VPWR VGND sky130_ef_sc_hd__decap_12
XFILLER_49_1287 VPWR VGND VPWR VGND sky130_ef_sc_hd__decap_12
XFILLER_84_1189 VGND VGND VPWR VPWR sky130_fd_sc_hd__fill_1
XFILLER_249_951 VGND VGND VPWR VPWR sky130_fd_sc_hd__fill_1
XPHY_EDGE_ROW_113_1_Left_368 VGND VGND VPWR VPWR sky130_fd_sc_hd__decap_3
XFILLER_236_601 VPWR VGND VPWR VGND sky130_ef_sc_hd__decap_12
XFILLER_235_111 VGND VGND VPWR VPWR sky130_fd_sc_hd__fill_1
XFILLER_236_645 VPWR VGND VPWR VGND sky130_ef_sc_hd__decap_12
XFILLER_1_1201 VPWR VGND VPWR VGND sky130_ef_sc_hd__decap_12
XFILLER_169_1033 VPWR VGND VPWR VGND sky130_ef_sc_hd__decap_12
XPHY_EDGE_ROW_50_1_Left_305 VGND VGND VPWR VPWR sky130_fd_sc_hd__decap_3
XFILLER_5_1381 VPWR VGND VPWR VGND sky130_ef_sc_hd__decap_12
XFILLER_184_1509 VGND VGND VPWR VPWR sky130_fd_sc_hd__decap_6
XFILLER_251_615 VGND VGND VPWR VPWR sky130_fd_sc_hd__fill_1
XTAP_TAPCELL_ROW_180_1750 VGND VPWR sky130_fd_sc_hd__tapvpwrvgnd_1
XFILLER_1_1245 VPWR VGND VPWR VGND sky130_ef_sc_hd__decap_12
XFILLER_169_1077 VPWR VGND VPWR VGND sky130_ef_sc_hd__decap_12
XFILLER_223_317 VPWR VGND VPWR VGND sky130_ef_sc_hd__decap_12
XFILLER_56_1203 VPWR VGND VPWR VGND sky130_ef_sc_hd__decap_12
XFILLER_147_1331 VPWR VGND VPWR VGND sky130_ef_sc_hd__decap_12
XFILLER_204_531 VGND VGND VPWR VPWR sky130_fd_sc_hd__fill_1
XFILLER_1_1289 VPWR VGND VPWR VGND sky130_ef_sc_hd__decap_12
XFILLER_188_221 VPWR VGND VPWR VGND sky130_ef_sc_hd__decap_12
XFILLER_56_1247 VPWR VGND VPWR VGND sky130_ef_sc_hd__decap_12
XFILLER_108_1315 VPWR VGND VPWR VGND sky130_ef_sc_hd__decap_12
XFILLER_189_777 VGND VGND VPWR VPWR sky130_fd_sc_hd__decap_6
XFILLER_231_361 VPWR VGND VPWR VGND sky130_ef_sc_hd__decap_12
XFILLER_143_1217 VGND VGND VPWR VPWR sky130_fd_sc_hd__fill_1
XFILLER_188_265 VPWR VGND VPWR VGND sky130_ef_sc_hd__decap_12
XFILLER_108_1359 VPWR VGND VPWR VGND sky130_ef_sc_hd__decap_12
XFILLER_189_93 VPWR VGND VPWR VGND sky130_ef_sc_hd__decap_12
XTAP_TAPCELL_ROW_13_2_3835 VGND VPWR sky130_fd_sc_hd__tapvpwrvgnd_1
XTAP_TAPCELL_ROW_178_1690 VGND VPWR sky130_fd_sc_hd__tapvpwrvgnd_1
XPHY_EDGE_ROW_93_2_Left_595 VGND VGND VPWR VPWR sky130_fd_sc_hd__decap_3
XFILLER_200_781 VPWR VGND VPWR VGND sky130_ef_sc_hd__decap_12
XPHY_EDGE_ROW_159_2_Right_250 VGND VGND VPWR VPWR sky130_fd_sc_hd__decap_3
XTAP_TAPCELL_ROW_174_1576 VGND VPWR sky130_fd_sc_hd__tapvpwrvgnd_1
XTAP_TAPCELL_ROW_174_1587 VGND VPWR sky130_fd_sc_hd__tapvpwrvgnd_1
XPHY_EDGE_ROW_9_Right_9 VGND VGND VPWR VPWR sky130_fd_sc_hd__decap_3
XFILLER_176_1037 VPWR VGND VPWR VGND sky130_ef_sc_hd__decap_12
XFILLER_217_1001 VGND VGND VPWR VPWR sky130_fd_sc_hd__decap_6
XFILLER_67_1343 VPWR VGND VPWR VGND sky130_ef_sc_hd__decap_12
XFILLER_119_1411 VPWR VGND VPWR VGND sky130_ef_sc_hd__decap_12
XFILLER_172_699 VGND VGND VPWR VPWR sky130_fd_sc_hd__fill_1
XFILLER_158_1471 VPWR VGND VPWR VGND sky130_ef_sc_hd__decap_12
XFILLER_28_1327 VPWR VGND VPWR VGND sky130_ef_sc_hd__decap_12
XFILLER_4_890 VPWR VGND VPWR VGND sky130_ef_sc_hd__decap_12
XFILLER_217_1045 VPWR VGND VPWR VGND sky130_ef_sc_hd__decap_12
XFILLER_67_1387 VPWR VGND VPWR VGND sky130_ef_sc_hd__decap_12
XFILLER_119_1455 VPWR VGND VPWR VGND sky130_ef_sc_hd__decap_12
XTAP_TAPCELL_ROW_187_1926 VGND VPWR sky130_fd_sc_hd__tapvpwrvgnd_1
XTAP_TAPCELL_ROW_187_1937 VGND VPWR sky130_fd_sc_hd__tapvpwrvgnd_1
XFILLER_154_1357 VGND VGND VPWR VPWR sky130_fd_sc_hd__fill_1
XFILLER_217_1089 VPWR VGND VPWR VGND sky130_ef_sc_hd__decap_12
XFILLER_119_1499 VPWR VGND VPWR VGND sky130_ef_sc_hd__decap_12
XFILLER_239_461 VPWR VGND VPWR VGND sky130_ef_sc_hd__decap_12
XFILLER_255_921 VGND VGND VPWR VPWR sky130_fd_sc_hd__decap_3
XFILLER_224_77 VGND VGND VPWR VPWR sky130_fd_sc_hd__decap_6
XFILLER_255_965 VPWR VGND VPWR VGND sky130_ef_sc_hd__decap_12
XFILLER_187_1133 VPWR VGND VPWR VGND sky130_ef_sc_hd__decap_12
XFILLER_226_133 VGND VGND VPWR VPWR sky130_fd_sc_hd__decap_6
XFILLER_254_475 VGND VGND VPWR VPWR sky130_fd_sc_hd__fill_1
XFILLER_226_177 VPWR VGND VPWR VGND sky130_ef_sc_hd__decap_12
XFILLER_242_637 VGND VGND VPWR VPWR sky130_fd_sc_hd__decap_6
XFILLER_187_1177 VPWR VGND VPWR VGND sky130_ef_sc_hd__decap_12
XFILLER_208_881 VPWR VGND VPWR VGND sky130_ef_sc_hd__decap_12
XFILLER_241_125 VPWR VGND VPWR VGND sky130_ef_sc_hd__decap_12
XFILLER_240_65 VPWR VGND VPWR VGND sky130_ef_sc_hd__decap_12
XFILLER_74_1303 VPWR VGND VPWR VGND sky130_ef_sc_hd__decap_12
XFILLER_39_1423 VPWR VGND VPWR VGND sky130_ef_sc_hd__decap_12
XFILLER_228_1141 VGND VGND VPWR VPWR sky130_fd_sc_hd__decap_6
XFILLER_78_1483 VPWR VGND VPWR VGND sky130_ef_sc_hd__decap_12
XTAP_TAPCELL_ROW_79_2_4230 VGND VPWR sky130_fd_sc_hd__tapvpwrvgnd_1
XFILLER_207_391 VGND VGND VPWR VPWR sky130_fd_sc_hd__fill_1
XFILLER_165_1453 VGND VGND VPWR VPWR sky130_fd_sc_hd__decap_3
XFILLER_241_169 VPWR VGND VPWR VGND sky130_ef_sc_hd__decap_12
XFILLER_39_1467 VPWR VGND VPWR VGND sky130_ef_sc_hd__decap_12
XFILLER_126_1415 VPWR VGND VPWR VGND sky130_ef_sc_hd__decap_12
XFILLER_224_1005 VPWR VGND VPWR VGND sky130_ef_sc_hd__decap_12
XFILLER_168_917 VGND VGND VPWR VPWR sky130_fd_sc_hd__decap_6
XFILLER_228_1185 VPWR VGND VPWR VGND sky130_ef_sc_hd__decap_12
XFILLER_210_501 VPWR VGND VPWR VGND sky130_ef_sc_hd__decap_12
XFILLER_250_681 VPWR VGND VPWR VGND sky130_ef_sc_hd__decap_12
XFILLER_167_405 VPWR VGND VPWR VGND sky130_ef_sc_hd__decap_12
XFILLER_223_895 VGND VGND VPWR VPWR sky130_fd_sc_hd__fill_1
XTAP_TAPCELL_ROW_92_2_4308 VGND VPWR sky130_fd_sc_hd__tapvpwrvgnd_1
XFILLER_165_1497 VPWR VGND VPWR VGND sky130_ef_sc_hd__decap_12
XFILLER_224_1049 VPWR VGND VPWR VGND sky130_ef_sc_hd__decap_12
XFILLER_210_545 VPWR VGND VPWR VGND sky130_ef_sc_hd__decap_12
XFILLER_167_449 VPWR VGND VPWR VGND sky130_ef_sc_hd__decap_12
XFILLER_183_909 VPWR VGND VPWR VGND sky130_ef_sc_hd__decap_12
XFILLER_206_1483 VGND VGND VPWR VPWR sky130_fd_sc_hd__fill_1
XTAP_TAPCELL_ROW_252_3676 VGND VPWR sky130_fd_sc_hd__tapvpwrvgnd_1
XFILLER_176_961 VPWR VGND VPWR VGND sky130_ef_sc_hd__decap_12
XFILLER_210_589 VPWR VGND VPWR VGND sky130_ef_sc_hd__decap_12
XTAP_TAPCELL_ROW_252_3687 VGND VPWR sky130_fd_sc_hd__tapvpwrvgnd_1
XFILLER_182_419 VGND VGND VPWR VPWR sky130_fd_sc_hd__fill_1
XTAP_TAPCELL_ROW_252_3698 VGND VPWR sky130_fd_sc_hd__tapvpwrvgnd_1
XFILLER_159_1213 VGND VGND VPWR VPWR sky130_fd_sc_hd__decap_4
XFILLER_11_1331 VPWR VGND VPWR VGND sky130_ef_sc_hd__decap_12
XFILLER_191_953 VPWR VGND VPWR VGND sky130_ef_sc_hd__decap_12
XFILLER_198_1273 VPWR VGND VPWR VGND sky130_ef_sc_hd__decap_12
XFILLER_235_1101 VPWR VGND VPWR VGND sky130_ef_sc_hd__decap_12
XFILLER_85_1443 VPWR VGND VPWR VGND sky130_ef_sc_hd__decap_12
XFILLER_200_1093 VPWR VGND VPWR VGND sky130_ef_sc_hd__decap_12
XFILLER_78_27 VGND VGND VPWR VPWR sky130_fd_sc_hd__fill_1
XFILLER_137_1511 VGND VGND VPWR VPWR sky130_fd_sc_hd__decap_4
XFILLER_239_1281 VGND VGND VPWR VPWR sky130_fd_sc_hd__decap_6
XFILLER_2_849 VGND VGND VPWR VPWR sky130_fd_sc_hd__decap_8
XFILLER_46_1427 VPWR VGND VPWR VGND sky130_ef_sc_hd__decap_12
XFILLER_235_1145 VPWR VGND VPWR VGND sky130_ef_sc_hd__decap_12
XFILLER_81_1329 VGND VGND VPWR VPWR sky130_fd_sc_hd__fill_1
XFILLER_249_225 VPWR VGND VPWR VGND sky130_ef_sc_hd__decap_12
XFILLER_231_1009 VPWR VGND VPWR VGND sky130_ef_sc_hd__decap_12
XFILLER_235_1189 VPWR VGND VPWR VGND sky130_ef_sc_hd__decap_12
XFILLER_218_601 VPWR VGND VPWR VGND sky130_ef_sc_hd__decap_12
XFILLER_94_15 VPWR VGND VPWR VGND sky130_ef_sc_hd__decap_12
XTAP_TAPCELL_ROW_205_2410 VGND VPWR sky130_fd_sc_hd__tapvpwrvgnd_1
XFILLER_217_111 VGND VGND VPWR VPWR sky130_fd_sc_hd__fill_1
X_600_ clknet_3_3__leaf_clk net619 _008_ VGND VGND VPWR VPWR valid_d1 sky130_fd_sc_hd__dfrtp_1
XTAP_TAPCELL_ROW_205_2421 VGND VPWR sky130_fd_sc_hd__tapvpwrvgnd_1
XFILLER_218_645 VPWR VGND VPWR VGND sky130_ef_sc_hd__decap_12
XFILLER_131_1165 VPWR VGND VPWR VGND sky130_ef_sc_hd__decap_12
XTAP_TAPCELL_ROW_205_2432 VGND VPWR sky130_fd_sc_hd__tapvpwrvgnd_1
XFILLER_175_3 VPWR VGND VPWR VGND sky130_ef_sc_hd__decap_12
XFILLER_233_615 VGND VGND VPWR VPWR sky130_fd_sc_hd__fill_1
XFILLER_22_1471 VPWR VGND VPWR VGND sky130_ef_sc_hd__decap_12
X_531_ net665 VGND VGND VPWR VPWR _013_ sky130_fd_sc_hd__inv_2
XTAP_TAPCELL_ROW_201_2307 VGND VPWR sky130_fd_sc_hd__tapvpwrvgnd_1
XFILLER_166_1217 VPWR VGND VPWR VGND sky130_ef_sc_hd__decap_12
XTAP_TAPCELL_ROW_197_2200 VGND VPWR sky130_fd_sc_hd__tapvpwrvgnd_1
XTAP_TAPCELL_ROW_201_2318 VGND VPWR sky130_fd_sc_hd__tapvpwrvgnd_1
XFILLER_205_317 VPWR VGND VPWR VGND sky130_ef_sc_hd__decap_12
XFILLER_245_497 VGND VGND VPWR VPWR sky130_fd_sc_hd__decap_6
XTAP_TAPCELL_ROW_197_2211 VGND VPWR sky130_fd_sc_hd__tapvpwrvgnd_1
XFILLER_150_65 VGND VGND VPWR VPWR sky130_fd_sc_hd__decap_6
XTAP_TAPCELL_ROW_1_882 VGND VPWR sky130_fd_sc_hd__tapvpwrvgnd_1
XFILLER_246_1241 VPWR VGND VPWR VGND sky130_ef_sc_hd__decap_12
XTAP_TAPCELL_ROW_1_893 VGND VPWR sky130_fd_sc_hd__tapvpwrvgnd_1
X_462_ _196_ _197_ VGND VGND VPWR VPWR acc_core.adder.cla_blocks\[0\].block.sum\[3\]
+ sky130_fd_sc_hd__xnor2_1
XFILLER_18_1507 VGND VGND VPWR VPWR sky130_fd_sc_hd__decap_8
XFILLER_220_309 VPWR VGND VPWR VGND sky130_ef_sc_hd__decap_12
XFILLER_242_1105 VPWR VGND VPWR VGND sky130_ef_sc_hd__decap_12
XTAP_TAPCELL_ROW_193_2108 VGND VPWR sky130_fd_sc_hd__tapvpwrvgnd_1
XFILLER_207_1225 VGND VGND VPWR VPWR sky130_fd_sc_hd__decap_6
XFILLER_246_1285 VPWR VGND VPWR VGND sky130_ef_sc_hd__decap_12
XFILLER_213_361 VPWR VGND VPWR VGND sky130_ef_sc_hd__decap_12
X_393_ net151 net150 VGND VGND VPWR VPWR _182_ sky130_fd_sc_hd__or2_1
XFILLER_92_1469 VGND VGND VPWR VPWR sky130_fd_sc_hd__fill_1
XTAP_TAPCELL_ROW_157_2_4699 VGND VPWR sky130_fd_sc_hd__tapvpwrvgnd_1
XFILLER_186_725 VPWR VGND VPWR VGND sky130_ef_sc_hd__decap_12
XFILLER_242_1149 VPWR VGND VPWR VGND sky130_ef_sc_hd__decap_12
XFILLER_207_1269 VPWR VGND VPWR VGND sky130_ef_sc_hd__decap_12
XPHY_EDGE_ROW_52_1_Right_708 VGND VGND VPWR VPWR sky130_fd_sc_hd__decap_3
XFILLER_186_769 VPWR VGND VPWR VGND sky130_ef_sc_hd__decap_12
XFILLER_103_1201 VPWR VGND VPWR VGND sky130_ef_sc_hd__decap_12
XFILLER_185_279 VGND VGND VPWR VPWR sky130_fd_sc_hd__fill_1
XFILLER_142_1283 VPWR VGND VPWR VGND sky130_ef_sc_hd__decap_12
XFILLER_51_1177 VPWR VGND VPWR VGND sky130_ef_sc_hd__decap_12
XTAP_TAPCELL_ROW_137_2_4575 VGND VPWR sky130_fd_sc_hd__tapvpwrvgnd_1
XFILLER_177_1313 VPWR VGND VPWR VGND sky130_ef_sc_hd__decap_12
XFILLER_103_1267 VGND VGND VPWR VPWR sky130_fd_sc_hd__decap_6
XFILLER_181_441 VGND VGND VPWR VPWR sky130_fd_sc_hd__decap_6
XFILLER_175_51 VGND VGND VPWR VPWR sky130_fd_sc_hd__decap_4
XFILLER_177_1357 VPWR VGND VPWR VGND sky130_ef_sc_hd__decap_12
XFILLER_4_153 VPWR VGND VPWR VGND sky130_ef_sc_hd__decap_12
XFILLER_253_1201 VPWR VGND VPWR VGND sky130_ef_sc_hd__decap_12
XFILLER_181_485 VPWR VGND VPWR VGND sky130_ef_sc_hd__decap_12
XFILLER_253_1245 VPWR VGND VPWR VGND sky130_ef_sc_hd__decap_12
XFILLER_218_1365 VGND VGND VPWR VPWR sky130_fd_sc_hd__decap_6
XFILLER_214_1229 VPWR VGND VPWR VGND sky130_ef_sc_hd__decap_12
XFILLER_253_1289 VPWR VGND VPWR VGND sky130_ef_sc_hd__decap_12
XFILLER_1_893 VGND VGND VPWR VPWR sky130_fd_sc_hd__decap_3
XTAP_TAPCELL_ROW_85_2_4262 VGND VPWR sky130_fd_sc_hd__tapvpwrvgnd_1
XFILLER_23_1213 VGND VGND VPWR VPWR sky130_fd_sc_hd__decap_4
XFILLER_237_921 VPWR VGND VPWR VGND sky130_ef_sc_hd__decap_12
XTAP_TAPCELL_ROW_182_1801 VGND VPWR sky130_fd_sc_hd__tapvpwrvgnd_1
XTAP_TAPCELL_ROW_182_1812 VGND VPWR sky130_fd_sc_hd__tapvpwrvgnd_1
XFILLER_62_1295 VGND VGND VPWR VPWR sky130_fd_sc_hd__decap_6
XTAP_TAPCELL_ROW_167_1391 VGND VPWR sky130_fd_sc_hd__tapvpwrvgnd_1
XFILLER_237_965 VPWR VGND VPWR VGND sky130_ef_sc_hd__decap_12
XFILLER_208_133 VGND VGND VPWR VPWR sky130_fd_sc_hd__decap_6
XFILLER_110_1227 VPWR VGND VPWR VGND sky130_ef_sc_hd__decap_12
XFILLER_188_1453 VPWR VGND VPWR VGND sky130_ef_sc_hd__decap_12
XFILLER_236_475 VGND VGND VPWR VPWR sky130_fd_sc_hd__fill_1
XTAP_TAPCELL_ROW_22_1_1157 VGND VPWR sky130_fd_sc_hd__tapvpwrvgnd_1
XTAP_TAPCELL_ROW_110_2_4416 VGND VPWR sky130_fd_sc_hd__tapvpwrvgnd_1
XFILLER_208_177 VPWR VGND VPWR VGND sky130_ef_sc_hd__decap_12
XFILLER_184_1317 VPWR VGND VPWR VGND sky130_ef_sc_hd__decap_12
XFILLER_224_637 VGND VGND VPWR VPWR sky130_fd_sc_hd__decap_6
XFILLER_188_1497 VPWR VGND VPWR VGND sky130_ef_sc_hd__decap_12
XFILLER_223_125 VPWR VGND VPWR VGND sky130_ef_sc_hd__decap_12
XFILLER_252_979 VGND VGND VPWR VPWR sky130_fd_sc_hd__fill_1
XFILLER_189_541 VPWR VGND VPWR VGND sky130_ef_sc_hd__decap_12
XFILLER_223_169 VPWR VGND VPWR VGND sky130_ef_sc_hd__decap_12
XFILLER_225_1325 VPWR VGND VPWR VGND sky130_ef_sc_hd__decap_12
XFILLER_205_895 VGND VGND VPWR VPWR sky130_fd_sc_hd__fill_1
XFILLER_90_3 VPWR VGND VPWR VGND sky130_ef_sc_hd__decap_12
XFILLER_232_681 VPWR VGND VPWR VGND sky130_ef_sc_hd__decap_12
XFILLER_189_585 VPWR VGND VPWR VGND sky130_ef_sc_hd__decap_12
XTAP_TAPCELL_ROW_176_1627 VGND VPWR sky130_fd_sc_hd__tapvpwrvgnd_1
XFILLER_182_1085 VGND VGND VPWR VPWR sky130_fd_sc_hd__decap_6
XFILLER_225_1369 VPWR VGND VPWR VGND sky130_ef_sc_hd__decap_12
XTAP_TAPCELL_ROW_176_1638 VGND VPWR sky130_fd_sc_hd__tapvpwrvgnd_1
XTAP_TAPCELL_ROW_176_1649 VGND VPWR sky130_fd_sc_hd__tapvpwrvgnd_1
XFILLER_165_909 VPWR VGND VPWR VGND sky130_ef_sc_hd__decap_12
XFILLER_108_1189 VGND VGND VPWR VPWR sky130_fd_sc_hd__fill_1
XFILLER_121_1323 VGND VGND VPWR VPWR sky130_fd_sc_hd__decap_6
XFILLER_191_205 VPWR VGND VPWR VGND sky130_ef_sc_hd__decap_12
XFILLER_160_1383 VPWR VGND VPWR VGND sky130_ef_sc_hd__decap_12
XFILLER_30_1239 VGND VGND VPWR VPWR sky130_fd_sc_hd__decap_6
XFILLER_9_993 VGND VGND VPWR VPWR sky130_fd_sc_hd__decap_3
XFILLER_219_55 VGND VGND VPWR VPWR sky130_fd_sc_hd__fill_1
XFILLER_195_1413 VPWR VGND VPWR VGND sky130_ef_sc_hd__decap_12
XFILLER_121_1367 VPWR VGND VPWR VGND sky130_ef_sc_hd__decap_12
XFILLER_173_953 VPWR VGND VPWR VGND sky130_ef_sc_hd__decap_12
XFILLER_191_249 VPWR VGND VPWR VGND sky130_ef_sc_hd__decap_12
XFILLER_195_1457 VPWR VGND VPWR VGND sky130_ef_sc_hd__decap_12
XFILLER_236_1421 VGND VGND VPWR VPWR sky130_fd_sc_hd__decap_6
XFILLER_236_1465 VPWR VGND VPWR VGND sky130_ef_sc_hd__decap_12
XFILLER_8_1229 VPWR VGND VPWR VGND sky130_ef_sc_hd__decap_12
XFILLER_232_1329 VPWR VGND VPWR VGND sky130_ef_sc_hd__decap_12
XFILLER_154_1165 VPWR VGND VPWR VGND sky130_ef_sc_hd__decap_12
XFILLER_247_729 VPWR VGND VPWR VGND sky130_ef_sc_hd__decap_12
XFILLER_80_1351 VGND VGND VPWR VPWR sky130_fd_sc_hd__decap_6
XTAP_TAPCELL_ROW_245_3491 VGND VPWR sky130_fd_sc_hd__tapvpwrvgnd_1
XFILLER_80_1395 VPWR VGND VPWR VGND sky130_ef_sc_hd__decap_12
XFILLER_132_1463 VGND VGND VPWR VPWR sky130_fd_sc_hd__decap_6
XTAP_TAPCELL_ROW_241_3388 VGND VPWR sky130_fd_sc_hd__tapvpwrvgnd_1
XFILLER_64_18 VGND VGND VPWR VPWR sky130_fd_sc_hd__decap_8
XFILLER_41_1379 VGND VGND VPWR VPWR sky130_fd_sc_hd__decap_6
XFILLER_242_401 VPWR VGND VPWR VGND sky130_ef_sc_hd__decap_12
XTAP_TAPCELL_ROW_241_3399 VGND VPWR sky130_fd_sc_hd__tapvpwrvgnd_1
XFILLER_64_29 VPWR VGND VPWR VGND sky130_ef_sc_hd__decap_12
XFILLER_215_615 VGND VGND VPWR VPWR sky130_fd_sc_hd__fill_1
XFILLER_199_305 VPWR VGND VPWR VGND sky130_ef_sc_hd__decap_12
XFILLER_227_497 VGND VGND VPWR VPWR sky130_fd_sc_hd__decap_6
XFILLER_242_445 VPWR VGND VPWR VGND sky130_ef_sc_hd__decap_12
XFILLER_39_1231 VPWR VGND VPWR VGND sky130_ef_sc_hd__decap_12
XFILLER_199_349 VPWR VGND VPWR VGND sky130_ef_sc_hd__decap_12
XFILLER_202_309 VPWR VGND VPWR VGND sky130_ef_sc_hd__decap_12
XFILLER_242_489 VPWR VGND VPWR VGND sky130_ef_sc_hd__decap_12
XFILLER_243_1425 VPWR VGND VPWR VGND sky130_ef_sc_hd__decap_12
XFILLER_165_1261 VPWR VGND VPWR VGND sky130_ef_sc_hd__decap_12
XTAP_TAPCELL_ROW_254_3738 VGND VPWR sky130_fd_sc_hd__tapvpwrvgnd_1
XFILLER_39_1275 VPWR VGND VPWR VGND sky130_ef_sc_hd__decap_12
XFILLER_211_821 VPWR VGND VPWR VGND sky130_ef_sc_hd__decap_12
XTAP_TAPCELL_ROW_254_3749 VGND VPWR sky130_fd_sc_hd__tapvpwrvgnd_1
XFILLER_168_725 VPWR VGND VPWR VGND sky130_ef_sc_hd__decap_12
XFILLER_74_1177 VPWR VGND VPWR VGND sky130_ef_sc_hd__decap_12
XFILLER_204_1409 VPWR VGND VPWR VGND sky130_ef_sc_hd__decap_12
XFILLER_243_1469 VPWR VGND VPWR VGND sky130_ef_sc_hd__decap_12
XFILLER_126_1245 VGND VGND VPWR VPWR sky130_fd_sc_hd__fill_1
XFILLER_211_865 VPWR VGND VPWR VGND sky130_ef_sc_hd__decap_12
XFILLER_168_769 VPWR VGND VPWR VGND sky130_ef_sc_hd__decap_12
XFILLER_91_1491 VGND VGND VPWR VPWR sky130_fd_sc_hd__decap_6
XFILLER_13_55 VGND VGND VPWR VPWR sky130_fd_sc_hd__fill_1
XFILLER_167_279 VGND VGND VPWR VPWR sky130_fd_sc_hd__fill_1
XTAP_TAPCELL_ROW_123_2_4494 VGND VPWR sky130_fd_sc_hd__tapvpwrvgnd_1
XFILLER_100_1407 VGND VGND VPWR VPWR sky130_fd_sc_hd__decap_6
XFILLER_129_55 VGND VGND VPWR VPWR sky130_fd_sc_hd__fill_1
XFILLER_89_15 VPWR VGND VPWR VGND sky130_ef_sc_hd__decap_12
XFILLER_191_783 VGND VGND VPWR VPWR sky130_fd_sc_hd__fill_1
XTAP_TAPCELL_ROW_103_2_4370 VGND VPWR sky130_fd_sc_hd__tapvpwrvgnd_1
XFILLER_215_1505 VGND VGND VPWR VPWR sky130_fd_sc_hd__decap_6
XFILLER_85_1273 VGND VGND VPWR VPWR sky130_fd_sc_hd__fill_1
XFILLER_250_1429 VPWR VGND VPWR VGND sky130_ef_sc_hd__decap_12
XFILLER_1_167 VGND VGND VPWR VPWR sky130_fd_sc_hd__fill_1
XTAP_TAPCELL_ROW_71_2_4181 VGND VPWR sky130_fd_sc_hd__tapvpwrvgnd_1
XFILLER_137_1385 VGND VGND VPWR VPWR sky130_fd_sc_hd__fill_1
XPHY_EDGE_ROW_189_Right_34 VGND VGND VPWR VPWR sky130_fd_sc_hd__decap_3
XFILLER_237_217 VGND VGND VPWR VPWR sky130_fd_sc_hd__decap_6
XFILLER_219_921 VPWR VGND VPWR VGND sky130_ef_sc_hd__decap_12
XFILLER_38_41 VGND VGND VPWR VPWR sky130_fd_sc_hd__decap_8
XFILLER_219_965 VPWR VGND VPWR VGND sky130_ef_sc_hd__decap_12
XFILLER_252_209 VPWR VGND VPWR VGND sky130_ef_sc_hd__decap_12
XFILLER_218_475 VGND VGND VPWR VPWR sky130_fd_sc_hd__fill_1
XFILLER_245_261 VPWR VGND VPWR VGND sky130_ef_sc_hd__decap_12
XFILLER_206_637 VGND VGND VPWR VPWR sky130_fd_sc_hd__decap_6
XFILLER_205_125 VPWR VGND VPWR VGND sky130_ef_sc_hd__decap_12
XFILLER_234_979 VGND VGND VPWR VPWR sky130_fd_sc_hd__fill_1
XFILLER_2_1373 VPWR VGND VPWR VGND sky130_ef_sc_hd__decap_12
X_514_ _261_ _263_ VGND VGND VPWR VPWR _265_ sky130_fd_sc_hd__nand2_1
XFILLER_57_1331 VPWR VGND VPWR VGND sky130_ef_sc_hd__decap_12
XFILLER_205_169 VPWR VGND VPWR VGND sky130_ef_sc_hd__decap_12
XFILLER_221_629 VPWR VGND VPWR VGND sky130_ef_sc_hd__decap_12
XFILLER_144_1301 VGND VGND VPWR VPWR sky130_fd_sc_hd__fill_1
XFILLER_18_1315 VPWR VGND VPWR VGND sky130_ef_sc_hd__decap_12
X_445_ net94 _232_ _114_ VGND VGND VPWR VPWR _234_ sky130_fd_sc_hd__o21ba_1
XFILLER_214_681 VPWR VGND VPWR VGND sky130_ef_sc_hd__decap_12
XFILLER_109_1443 VPWR VGND VPWR VGND sky130_ef_sc_hd__decap_12
XFILLER_207_1033 VPWR VGND VPWR VGND sky130_ef_sc_hd__decap_12
XFILLER_246_1093 VPWR VGND VPWR VGND sky130_ef_sc_hd__decap_12
XFILLER_53_1217 VGND VGND VPWR VPWR sky130_fd_sc_hd__fill_1
XFILLER_220_139 VGND VGND VPWR VPWR sky130_fd_sc_hd__fill_1
XPHY_EDGE_ROW_198_Right_43 VGND VGND VPWR VPWR sky130_fd_sc_hd__decap_3
XFILLER_222_1509 VGND VGND VPWR VPWR sky130_fd_sc_hd__decap_6
XFILLER_186_533 VPWR VGND VPWR VGND sky130_ef_sc_hd__decap_12
XFILLER_18_1359 VPWR VGND VPWR VGND sky130_ef_sc_hd__decap_12
X_376_ net592 net577 net550 VGND VGND VPWR VPWR _165_ sky130_fd_sc_hd__a21oi_1
XFILLER_207_1077 VPWR VGND VPWR VGND sky130_ef_sc_hd__decap_12
XFILLER_105_1329 VGND VGND VPWR VPWR sky130_fd_sc_hd__fill_1
XPHY_EDGE_ROW_53_1_Right_709 VGND VGND VPWR VPWR sky130_fd_sc_hd__decap_3
XTAP_TAPCELL_ROW_28_2_3921 VGND VPWR sky130_fd_sc_hd__tapvpwrvgnd_1
XFILLER_173_205 VPWR VGND VPWR VGND sky130_ef_sc_hd__decap_12
XTAP_TAPCELL_ROW_171_1502 VGND VPWR sky130_fd_sc_hd__tapvpwrvgnd_1
XTAP_TAPCELL_ROW_171_1513 VGND VPWR sky130_fd_sc_hd__tapvpwrvgnd_1
XFILLER_173_249 VPWR VGND VPWR VGND sky130_ef_sc_hd__decap_12
XFILLER_177_1121 VPWR VGND VPWR VGND sky130_ef_sc_hd__decap_12
XFILLER_186_83 VGND VGND VPWR VPWR sky130_fd_sc_hd__fill_1
XFILLER_5_440 VGND VGND VPWR VPWR sky130_fd_sc_hd__fill_2
XFILLER_255_1329 VPWR VGND VPWR VGND sky130_ef_sc_hd__decap_12
XFILLER_170_923 VGND VGND VPWR VPWR sky130_fd_sc_hd__fill_1
XFILLER_173_1007 VGND VGND VPWR VPWR sky130_fd_sc_hd__fill_1
XFILLER_29_1411 VPWR VGND VPWR VGND sky130_ef_sc_hd__decap_12
XFILLER_68_1471 VPWR VGND VPWR VGND sky130_ef_sc_hd__decap_12
XFILLER_181_293 VPWR VGND VPWR VGND sky130_ef_sc_hd__decap_12
XPHY_EDGE_ROW_124_2_Left_626 VGND VGND VPWR VPWR sky130_fd_sc_hd__decap_3
XFILLER_155_1441 VGND VGND VPWR VPWR sky130_fd_sc_hd__fill_1
XFILLER_29_1455 VPWR VGND VPWR VGND sky130_ef_sc_hd__decap_12
XFILLER_218_1173 VPWR VGND VPWR VGND sky130_ef_sc_hd__decap_12
XFILLER_64_1357 VGND VGND VPWR VPWR sky130_fd_sc_hd__fill_1
XTAP_TAPCELL_ROW_169_1442 VGND VPWR sky130_fd_sc_hd__tapvpwrvgnd_1
XFILLER_190_1365 VGND VGND VPWR VPWR sky130_fd_sc_hd__decap_6
XTAP_TAPCELL_ROW_169_1453 VGND VPWR sky130_fd_sc_hd__tapvpwrvgnd_1
XFILLER_214_1037 VPWR VGND VPWR VGND sky130_ef_sc_hd__decap_12
XFILLER_29_1499 VPWR VGND VPWR VGND sky130_ef_sc_hd__decap_12
XFILLER_229_729 VPWR VGND VPWR VGND sky130_ef_sc_hd__decap_12
XTAP_TAPCELL_ROW_165_1306 VGND VPWR sky130_fd_sc_hd__tapvpwrvgnd_1
XFILLER_116_1469 VGND VGND VPWR VPWR sky130_fd_sc_hd__fill_1
XTAP_TAPCELL_ROW_165_1317 VGND VPWR sky130_fd_sc_hd__tapvpwrvgnd_1
XFILLER_205_57 VPWR VGND VPWR VGND sky130_ef_sc_hd__decap_12
XTAP_TAPCELL_ROW_165_1328 VGND VPWR sky130_fd_sc_hd__tapvpwrvgnd_1
XTAP_TAPCELL_ROW_165_1339 VGND VPWR sky130_fd_sc_hd__tapvpwrvgnd_1
XTAP_TAPCELL_ROW_160_2_4713 VGND VPWR sky130_fd_sc_hd__tapvpwrvgnd_1
XTAP_TAPCELL_ROW_159_2_4707 VGND VPWR sky130_fd_sc_hd__tapvpwrvgnd_1
XFILLER_149_1201 VPWR VGND VPWR VGND sky130_ef_sc_hd__decap_12
XFILLER_224_401 VPWR VGND VPWR VGND sky130_ef_sc_hd__decap_12
XFILLER_188_1261 VPWR VGND VPWR VGND sky130_ef_sc_hd__decap_12
XFILLER_209_497 VGND VGND VPWR VPWR sky130_fd_sc_hd__decap_6
XFILLER_97_1177 VPWR VGND VPWR VGND sky130_ef_sc_hd__decap_12
XFILLER_224_445 VPWR VGND VPWR VGND sky130_ef_sc_hd__decap_12
XFILLER_240_905 VPWR VGND VPWR VGND sky130_ef_sc_hd__decap_12
XFILLER_149_1267 VGND VGND VPWR VPWR sky130_fd_sc_hd__decap_6
XFILLER_184_1147 VGND VGND VPWR VPWR sky130_fd_sc_hd__fill_1
XFILLER_197_809 VPWR VGND VPWR VGND sky130_ef_sc_hd__decap_12
XFILLER_224_489 VPWR VGND VPWR VGND sky130_ef_sc_hd__decap_12
XFILLER_240_949 VPWR VGND VPWR VGND sky130_ef_sc_hd__decap_12
XFILLER_36_1415 VPWR VGND VPWR VGND sky130_ef_sc_hd__decap_12
XFILLER_225_1133 VPWR VGND VPWR VGND sky130_ef_sc_hd__decap_12
XFILLER_75_1497 VGND VGND VPWR VPWR sky130_fd_sc_hd__fill_1
XFILLER_189_393 VPWR VGND VPWR VGND sky130_ef_sc_hd__decap_12
XFILLER_225_1177 VPWR VGND VPWR VGND sky130_ef_sc_hd__decap_12
XFILLER_192_525 VGND VGND VPWR VPWR sky130_fd_sc_hd__decap_6
XTAP_TAPCELL_ROW_234_3192 VGND VPWR sky130_fd_sc_hd__tapvpwrvgnd_1
XFILLER_160_1191 VPWR VGND VPWR VGND sky130_ef_sc_hd__decap_12
XPHY_EDGE_ROW_202_Right_47 VGND VGND VPWR VPWR sky130_fd_sc_hd__decap_3
XFILLER_69_1213 VGND VGND VPWR VPWR sky130_fd_sc_hd__decap_4
XFILLER_192_569 VPWR VGND VPWR VGND sky130_ef_sc_hd__decap_12
XFILLER_173_783 VGND VGND VPWR VPWR sky130_fd_sc_hd__fill_1
XTAP_TAPCELL_ROW_230_3089 VGND VPWR sky130_fd_sc_hd__tapvpwrvgnd_1
XFILLER_246_53 VPWR VGND VPWR VGND sky130_ef_sc_hd__decap_12
XPHY_EDGE_ROW_56_2_Left_558 VGND VGND VPWR VPWR sky130_fd_sc_hd__decap_3
XFILLER_156_1227 VPWR VGND VPWR VGND sky130_ef_sc_hd__decap_12
XFILLER_47_1511 VGND VGND VPWR VPWR sky130_fd_sc_hd__decap_4
XFILLER_195_1287 VGND VGND VPWR VPWR sky130_fd_sc_hd__fill_1
XTAP_TAPCELL_ROW_247_3542 VGND VPWR sky130_fd_sc_hd__tapvpwrvgnd_1
XFILLER_246_97 VPWR VGND VPWR VGND sky130_ef_sc_hd__decap_12
XFILLER_82_1413 VGND VGND VPWR VPWR sky130_fd_sc_hd__fill_1
XTAP_TAPCELL_ROW_247_3553 VGND VPWR sky130_fd_sc_hd__tapvpwrvgnd_1
XTAP_TAPCELL_ROW_247_3564 VGND VPWR sky130_fd_sc_hd__tapvpwrvgnd_1
XFILLER_236_1273 VPWR VGND VPWR VGND sky130_ef_sc_hd__decap_12
XTAP_TAPCELL_ROW_243_3439 VGND VPWR sky130_fd_sc_hd__tapvpwrvgnd_1
XFILLER_8_1037 VPWR VGND VPWR VGND sky130_ef_sc_hd__decap_12
XFILLER_219_217 VGND VGND VPWR VPWR sky130_fd_sc_hd__decap_6
XFILLER_115_57 VPWR VGND VPWR VGND sky130_ef_sc_hd__decap_12
XFILLER_247_559 VGND VGND VPWR VPWR sky130_fd_sc_hd__fill_1
XTAP_TAPCELL_ROW_3_933 VGND VPWR sky130_fd_sc_hd__tapvpwrvgnd_1
XFILLER_75_39 VPWR VGND VPWR VGND sky130_ef_sc_hd__decap_12
XPHY_EDGE_ROW_211_Right_56 VGND VGND VPWR VPWR sky130_fd_sc_hd__decap_3
XTAP_TAPCELL_ROW_3_944 VGND VPWR sky130_fd_sc_hd__tapvpwrvgnd_1
XTAP_TAPCELL_ROW_3_955 VGND VPWR sky130_fd_sc_hd__tapvpwrvgnd_1
XFILLER_132_1271 VPWR VGND VPWR VGND sky130_ef_sc_hd__decap_12
XFILLER_234_209 VPWR VGND VPWR VGND sky130_ef_sc_hd__decap_12
XFILLER_41_1165 VPWR VGND VPWR VGND sky130_ef_sc_hd__decap_12
XTAP_TAPCELL_ROW_9_1098 VGND VPWR sky130_fd_sc_hd__tapvpwrvgnd_1
XFILLER_227_261 VPWR VGND VPWR VGND sky130_ef_sc_hd__decap_12
XFILLER_243_721 VGND VGND VPWR VPWR sky130_fd_sc_hd__decap_6
XFILLER_167_1301 VPWR VGND VPWR VGND sky130_ef_sc_hd__decap_12
XFILLER_167_1345 VPWR VGND VPWR VGND sky130_ef_sc_hd__decap_12
XFILLER_199_113 VPWR VGND VPWR VGND sky130_ef_sc_hd__decap_12
XFILLER_243_765 VPWR VGND VPWR VGND sky130_ef_sc_hd__decap_12
XFILLER_76_1239 VGND VGND VPWR VPWR sky130_fd_sc_hd__decap_6
XFILLER_216_979 VGND VGND VPWR VPWR sky130_fd_sc_hd__fill_1
XFILLER_242_253 VPWR VGND VPWR VGND sky130_ef_sc_hd__decap_12
XFILLER_91_27 VPWR VGND VPWR VGND sky130_ef_sc_hd__decap_12
XFILLER_203_629 VPWR VGND VPWR VGND sky130_ef_sc_hd__decap_12
XFILLER_243_1233 VPWR VGND VPWR VGND sky130_ef_sc_hd__decap_12
XFILLER_208_1353 VPWR VGND VPWR VGND sky130_ef_sc_hd__decap_12
XFILLER_202_139 VGND VGND VPWR VPWR sky130_fd_sc_hd__fill_1
XFILLER_165_1091 VGND VGND VPWR VPWR sky130_fd_sc_hd__fill_1
XFILLER_168_533 VPWR VGND VPWR VGND sky130_ef_sc_hd__decap_12
XFILLER_204_1217 VPWR VGND VPWR VGND sky130_ef_sc_hd__decap_12
XTAP_TAPCELL_ROW_14_2_3840 VGND VPWR sky130_fd_sc_hd__tapvpwrvgnd_1
XFILLER_208_1397 VPWR VGND VPWR VGND sky130_ef_sc_hd__decap_12
XFILLER_211_673 VPWR VGND VPWR VGND sky130_ef_sc_hd__decap_12
XFILLER_138_3 VPWR VGND VPWR VGND sky130_ef_sc_hd__decap_12
XFILLER_183_503 VGND VGND VPWR VPWR sky130_fd_sc_hd__fill_1
XFILLER_13_1201 VPWR VGND VPWR VGND sky130_ef_sc_hd__decap_12
Xwire625 net41 VGND VGND VPWR VPWR net625 sky130_fd_sc_hd__buf_1
XPHY_EDGE_ROW_220_Right_65 VGND VGND VPWR VPWR sky130_fd_sc_hd__decap_3
XPHY_EDGE_ROW_122_1_Left_377 VGND VGND VPWR VPWR sky130_fd_sc_hd__decap_3
Xwire636 net32 VGND VGND VPWR VPWR net636 sky130_fd_sc_hd__buf_1
XFILLER_195_385 VGND VGND VPWR VPWR sky130_fd_sc_hd__decap_6
XFILLER_6_215 VGND VGND VPWR VPWR sky130_fd_sc_hd__fill_2
Xwire647 net23 VGND VGND VPWR VPWR net647 sky130_fd_sc_hd__buf_1
XFILLER_52_1283 VPWR VGND VPWR VGND sky130_ef_sc_hd__decap_12
Xwire658 net14 VGND VGND VPWR VPWR net658 sky130_fd_sc_hd__buf_1
XFILLER_104_1351 VGND VGND VPWR VPWR sky130_fd_sc_hd__decap_6
XFILLER_196_1029 VGND VGND VPWR VPWR sky130_fd_sc_hd__decap_6
XFILLER_171_709 VPWR VGND VPWR VGND sky130_ef_sc_hd__decap_12
XFILLER_13_1267 VGND VGND VPWR VPWR sky130_fd_sc_hd__decap_6
XFILLER_100_1215 VPWR VGND VPWR VGND sky130_ef_sc_hd__decap_12
XFILLER_178_1441 VPWR VGND VPWR VGND sky130_ef_sc_hd__decap_12
XFILLER_104_1395 VPWR VGND VPWR VGND sky130_ef_sc_hd__decap_12
XFILLER_156_53 VPWR VGND VPWR VGND sky130_ef_sc_hd__decap_12
XFILLER_100_1259 VPWR VGND VPWR VGND sky130_ef_sc_hd__decap_12
XFILLER_3_933 VPWR VGND VPWR VGND sky130_ef_sc_hd__decap_12
XFILLER_178_1485 VPWR VGND VPWR VGND sky130_ef_sc_hd__decap_12
XFILLER_87_1379 VGND VGND VPWR VPWR sky130_fd_sc_hd__decap_6
XFILLER_2_421 VGND VGND VPWR VPWR sky130_fd_sc_hd__fill_1
XFILLER_3_977 VPWR VGND VPWR VGND sky130_ef_sc_hd__decap_12
XFILLER_215_1313 VPWR VGND VPWR VGND sky130_ef_sc_hd__decap_12
XFILLER_254_1373 VPWR VGND VPWR VGND sky130_ef_sc_hd__decap_12
XFILLER_219_1493 VPWR VGND VPWR VGND sky130_ef_sc_hd__decap_12
XFILLER_49_51 VGND VGND VPWR VPWR sky130_fd_sc_hd__decap_4
XFILLER_172_41 VPWR VGND VPWR VGND sky130_ef_sc_hd__decap_12
XFILLER_172_1073 VPWR VGND VPWR VGND sky130_ef_sc_hd__decap_12
XFILLER_215_1357 VPWR VGND VPWR VGND sky130_ef_sc_hd__decap_12
XFILLER_250_1259 VGND VGND VPWR VPWR sky130_fd_sc_hd__fill_1
XTAP_TAPCELL_ROW_145_2_4626 VGND VPWR sky130_fd_sc_hd__tapvpwrvgnd_1
XFILLER_172_85 VPWR VGND VPWR VGND sky130_ef_sc_hd__decap_12
XFILLER_111_1311 VPWR VGND VPWR VGND sky130_ef_sc_hd__decap_12
XFILLER_1_47 VGND VGND VPWR VPWR sky130_fd_sc_hd__decap_8
XFILLER_115_1491 VGND VGND VPWR VPWR sky130_fd_sc_hd__decap_6
XFILLER_150_1371 VPWR VGND VPWR VGND sky130_ef_sc_hd__decap_12
XFILLER_253_529 VPWR VGND VPWR VGND sky130_ef_sc_hd__decap_12
XFILLER_1_69 VPWR VGND VPWR VGND sky130_ef_sc_hd__decap_12
XFILLER_20_1227 VPWR VGND VPWR VGND sky130_ef_sc_hd__decap_12
XFILLER_185_1401 VPWR VGND VPWR VGND sky130_ef_sc_hd__decap_12
XFILLER_206_401 VPWR VGND VPWR VGND sky130_ef_sc_hd__decap_12
XFILLER_246_581 VGND VGND VPWR VPWR sky130_fd_sc_hd__decap_6
XFILLER_111_1355 VPWR VGND VPWR VGND sky130_ef_sc_hd__decap_12
XFILLER_206_445 VPWR VGND VPWR VGND sky130_ef_sc_hd__decap_12
XTAP_TAPCELL_ROW_125_2_4502 VGND VPWR sky130_fd_sc_hd__tapvpwrvgnd_1
XFILLER_222_905 VPWR VGND VPWR VGND sky130_ef_sc_hd__decap_12
XFILLER_94_1339 VPWR VGND VPWR VGND sky130_ef_sc_hd__decap_12
XFILLER_111_1399 VPWR VGND VPWR VGND sky130_ef_sc_hd__decap_12
XFILLER_146_1407 VGND VGND VPWR VPWR sky130_fd_sc_hd__decap_6
XFILLER_179_809 VPWR VGND VPWR VGND sky130_ef_sc_hd__decap_12
XFILLER_206_489 VPWR VGND VPWR VGND sky130_ef_sc_hd__decap_12
XFILLER_222_949 VPWR VGND VPWR VGND sky130_ef_sc_hd__decap_12
XFILLER_226_1453 VPWR VGND VPWR VGND sky130_ef_sc_hd__decap_12
XTAP_TAPCELL_ROW_93_2_4313 VGND VPWR sky130_fd_sc_hd__tapvpwrvgnd_1
X_428_ net594 dout0_q\[22\] net533 VGND VGND VPWR VPWR _217_ sky130_fd_sc_hd__and3_1
XFILLER_187_853 VPWR VGND VPWR VGND sky130_ef_sc_hd__decap_12
XFILLER_109_1273 VGND VGND VPWR VPWR sky130_fd_sc_hd__fill_1
XFILLER_222_1317 VPWR VGND VPWR VGND sky130_ef_sc_hd__decap_12
XFILLER_226_1497 VPWR VGND VPWR VGND sky130_ef_sc_hd__decap_12
XTAP_TAPCELL_ROW_17_1_1152 VGND VPWR sky130_fd_sc_hd__tapvpwrvgnd_1
XFILLER_201_161 VGND VGND VPWR VPWR sky130_fd_sc_hd__decap_6
XFILLER_230_993 VPWR VGND VPWR VGND sky130_ef_sc_hd__decap_12
XFILLER_18_1189 VGND VGND VPWR VPWR sky130_fd_sc_hd__fill_1
XFILLER_186_363 VGND VGND VPWR VPWR sky130_fd_sc_hd__fill_1
XFILLER_187_897 VPWR VGND VPWR VGND sky130_ef_sc_hd__decap_12
X_359_ net593 net545 net573 VGND VGND VPWR VPWR _148_ sky130_fd_sc_hd__nand3_1
XFILLER_174_525 VGND VGND VPWR VPWR sky130_fd_sc_hd__decap_6
XFILLER_197_93 VPWR VGND VPWR VGND sky130_ef_sc_hd__decap_12
XFILLER_31_1323 VGND VGND VPWR VPWR sky130_fd_sc_hd__decap_6
XFILLER_70_1383 VPWR VGND VPWR VGND sky130_ef_sc_hd__decap_12
XFILLER_122_1451 VPWR VGND VPWR VGND sky130_ef_sc_hd__decap_12
XFILLER_174_569 VPWR VGND VPWR VGND sky130_ef_sc_hd__decap_12
XFILLER_31_1367 VPWR VGND VPWR VGND sky130_ef_sc_hd__decap_12
XFILLER_122_1495 VPWR VGND VPWR VGND sky130_ef_sc_hd__decap_12
XFILLER_220_1085 VGND VGND VPWR VPWR sky130_fd_sc_hd__decap_6
XFILLER_53_3 VPWR VGND VPWR VGND sky130_ef_sc_hd__decap_12
XFILLER_192_1427 VGND VGND VPWR VPWR sky130_fd_sc_hd__fill_1
XFILLER_5_281 VGND VGND VPWR VPWR sky130_fd_sc_hd__decap_8
XFILLER_233_1413 VPWR VGND VPWR VGND sky130_ef_sc_hd__decap_12
XFILLER_9_1313 VGND VGND VPWR VPWR sky130_fd_sc_hd__decap_3
XFILLER_64_1165 VPWR VGND VPWR VGND sky130_ef_sc_hd__decap_12
XFILLER_9_1357 VPWR VGND VPWR VGND sky130_ef_sc_hd__decap_12
XFILLER_233_1457 VPWR VGND VPWR VGND sky130_ef_sc_hd__decap_12
XTAP_TAPCELL_ROW_40_2_3996 VGND VPWR sky130_fd_sc_hd__tapvpwrvgnd_1
XFILLER_190_1173 VPWR VGND VPWR VGND sky130_ef_sc_hd__decap_12
XFILLER_99_1217 VGND VGND VPWR VPWR sky130_fd_sc_hd__fill_1
XFILLER_229_559 VGND VGND VPWR VPWR sky130_fd_sc_hd__fill_1
XFILLER_42_1463 VGND VGND VPWR VPWR sky130_fd_sc_hd__decap_6
Xinput2 wr_addr[0] VGND VGND VPWR VPWR net2 sky130_fd_sc_hd__clkbuf_1
XFILLER_216_209 VPWR VGND VPWR VGND sky130_ef_sc_hd__decap_12
XFILLER_209_261 VPWR VGND VPWR VGND sky130_ef_sc_hd__decap_12
XTAP_TAPCELL_ROW_20_2_3872 VGND VPWR sky130_fd_sc_hd__tapvpwrvgnd_1
XFILLER_225_721 VGND VGND VPWR VPWR sky130_fd_sc_hd__decap_6
XFILLER_232_77 VGND VGND VPWR VPWR sky130_fd_sc_hd__decap_6
XTAP_TAPCELL_ROW_19_2_3866 VGND VPWR sky130_fd_sc_hd__tapvpwrvgnd_1
XFILLER_188_1091 VGND VGND VPWR VPWR sky130_fd_sc_hd__fill_1
XFILLER_225_765 VPWR VGND VPWR VGND sky130_ef_sc_hd__decap_12
XFILLER_164_1507 VGND VGND VPWR VPWR sky130_fd_sc_hd__decap_8
XTAP_TAPCELL_ROW_255_3800 VGND VPWR sky130_fd_sc_hd__tapvpwrvgnd_1
XFILLER_224_253 VPWR VGND VPWR VGND sky130_ef_sc_hd__decap_12
XFILLER_240_713 VPWR VGND VPWR VGND sky130_ef_sc_hd__decap_12
XFILLER_101_15 VPWR VGND VPWR VGND sky130_ef_sc_hd__decap_12
XFILLER_197_617 VPWR VGND VPWR VGND sky130_ef_sc_hd__decap_12
XFILLER_240_757 VPWR VGND VPWR VGND sky130_ef_sc_hd__decap_12
XTAP_TAPCELL_ROW_236_3254 VGND VPWR sky130_fd_sc_hd__tapvpwrvgnd_1
XFILLER_36_1245 VGND VGND VPWR VPWR sky130_fd_sc_hd__fill_1
XTAP_TAPCELL_ROW_236_3265 VGND VPWR sky130_fd_sc_hd__tapvpwrvgnd_1
XFILLER_177_385 VGND VGND VPWR VPWR sky130_fd_sc_hd__decap_6
XTAP_TAPCELL_ROW_138_2_4580 VGND VPWR sky130_fd_sc_hd__tapvpwrvgnd_1
XFILLER_192_333 VPWR VGND VPWR VGND sky130_ef_sc_hd__decap_12
XFILLER_10_1407 VGND VGND VPWR VPWR sky130_fd_sc_hd__decap_6
XFILLER_193_889 VGND VGND VPWR VPWR sky130_fd_sc_hd__decap_6
XTAP_TAPCELL_ROW_249_3604 VGND VPWR sky130_fd_sc_hd__tapvpwrvgnd_1
XFILLER_192_377 VPWR VGND VPWR VGND sky130_ef_sc_hd__decap_12
XTAP_TAPCELL_ROW_249_3615 VGND VPWR sky130_fd_sc_hd__tapvpwrvgnd_1
XTAP_TAPCELL_ROW_151_2_4658 VGND VPWR sky130_fd_sc_hd__tapvpwrvgnd_1
XFILLER_251_1513 VGND VGND VPWR VPWR sky130_fd_sc_hd__fill_2
XFILLER_0_925 VPWR VGND VPWR VGND sky130_ef_sc_hd__decap_12
XFILLER_248_813 VPWR VGND VPWR VGND sky130_ef_sc_hd__decap_12
XFILLER_86_27 VGND VGND VPWR VPWR sky130_fd_sc_hd__fill_1
XFILLER_47_1385 VGND VGND VPWR VPWR sky130_fd_sc_hd__fill_1
XFILLER_173_1393 VGND VGND VPWR VPWR sky130_fd_sc_hd__decap_6
XFILLER_235_529 VPWR VGND VPWR VGND sky130_ef_sc_hd__decap_12
XFILLER_228_581 VGND VGND VPWR VPWR sky130_fd_sc_hd__decap_6
XTAP_TAPCELL_ROW_111_2_4421 VGND VPWR sky130_fd_sc_hd__tapvpwrvgnd_1
XTAP_TAPCELL_ROW_221_2844 VGND VPWR sky130_fd_sc_hd__tapvpwrvgnd_1
XFILLER_204_905 VPWR VGND VPWR VGND sky130_ef_sc_hd__decap_12
XTAP_TAPCELL_ROW_221_2855 VGND VPWR sky130_fd_sc_hd__tapvpwrvgnd_1
XFILLER_255_3 VPWR VGND VPWR VGND sky130_ef_sc_hd__decap_12
XFILLER_243_573 VPWR VGND VPWR VGND sky130_ef_sc_hd__decap_12
XFILLER_167_1175 VGND VGND VPWR VPWR sky130_fd_sc_hd__fill_1
XFILLER_204_949 VPWR VGND VPWR VGND sky130_ef_sc_hd__decap_12
XFILLER_187_105 VGND VGND VPWR VPWR sky130_fd_sc_hd__decap_6
XFILLER_54_1301 VGND VGND VPWR VPWR sky130_fd_sc_hd__fill_1
XFILLER_19_1443 VPWR VGND VPWR VGND sky130_ef_sc_hd__decap_12
XFILLER_230_245 VGND VGND VPWR VPWR sky130_fd_sc_hd__decap_6
XFILLER_208_1161 VPWR VGND VPWR VGND sky130_ef_sc_hd__decap_12
XFILLER_169_853 VPWR VGND VPWR VGND sky130_ef_sc_hd__decap_12
XFILLER_187_149 VPWR VGND VPWR VGND sky130_ef_sc_hd__decap_12
XFILLER_243_1063 VGND VGND VPWR VPWR sky130_fd_sc_hd__fill_1
XFILLER_106_1413 VGND VGND VPWR VPWR sky130_fd_sc_hd__fill_1
XFILLER_180_1353 VPWR VGND VPWR VGND sky130_ef_sc_hd__decap_12
XFILLER_212_993 VPWR VGND VPWR VGND sky130_ef_sc_hd__decap_12
XFILLER_230_289 VPWR VGND VPWR VGND sky130_ef_sc_hd__decap_12
XFILLER_15_1329 VGND VGND VPWR VPWR sky130_fd_sc_hd__fill_1
XFILLER_168_363 VGND VGND VPWR VPWR sky130_fd_sc_hd__fill_1
Xwire400 net401 VGND VGND VPWR VPWR net400 sky130_fd_sc_hd__clkbuf_1
XFILLER_169_897 VPWR VGND VPWR VGND sky130_ef_sc_hd__decap_12
Xwire411 net412 VGND VGND VPWR VPWR net411 sky130_fd_sc_hd__clkbuf_1
XTAP_TAPCELL_ROW_58_2_4102 VGND VPWR sky130_fd_sc_hd__tapvpwrvgnd_1
Xwire422 net423 VGND VGND VPWR VPWR net422 sky130_fd_sc_hd__clkbuf_1
XFILLER_180_1397 VPWR VGND VPWR VGND sky130_ef_sc_hd__decap_12
XFILLER_51_63 VGND VGND VPWR VPWR sky130_fd_sc_hd__decap_8
Xwire433 net434 VGND VGND VPWR VPWR net433 sky130_fd_sc_hd__clkbuf_1
XTAP_TAPCELL_ROW_219_2795 VGND VPWR sky130_fd_sc_hd__tapvpwrvgnd_1
Xwire444 net445 VGND VGND VPWR VPWR net444 sky130_fd_sc_hd__clkbuf_1
XFILLER_195_193 VPWR VGND VPWR VGND sky130_ef_sc_hd__decap_12
XFILLER_184_867 VGND VGND VPWR VPWR sky130_fd_sc_hd__fill_1
Xwire455 net456 VGND VGND VPWR VPWR net455 sky130_fd_sc_hd__clkbuf_1
Xwire466 net467 VGND VGND VPWR VPWR net466 sky130_fd_sc_hd__clkbuf_1
XPHY_EDGE_ROW_208_Left_463 VGND VGND VPWR VPWR sky130_fd_sc_hd__decap_3
Xwire477 net478 VGND VGND VPWR VPWR net477 sky130_fd_sc_hd__clkbuf_1
Xwire488 net489 VGND VGND VPWR VPWR net488 sky130_fd_sc_hd__clkbuf_1
XFILLER_171_517 VPWR VGND VPWR VGND sky130_ef_sc_hd__decap_12
XFILLER_87_1165 VPWR VGND VPWR VGND sky130_ef_sc_hd__decap_12
XFILLER_139_1255 VPWR VGND VPWR VGND sky130_ef_sc_hd__decap_12
XFILLER_183_51 VGND VGND VPWR VPWR sky130_fd_sc_hd__decap_4
XFILLER_65_1441 VGND VGND VPWR VPWR sky130_fd_sc_hd__fill_1
XFILLER_2_251 VGND VGND VPWR VPWR sky130_fd_sc_hd__fill_1
XFILLER_139_1299 VPWR VGND VPWR VGND sky130_ef_sc_hd__decap_12
XFILLER_215_1121 VPWR VGND VPWR VGND sky130_ef_sc_hd__decap_12
XFILLER_238_301 VGND VGND VPWR VPWR sky130_fd_sc_hd__decap_6
XFILLER_191_1493 VPWR VGND VPWR VGND sky130_ef_sc_hd__decap_12
XFILLER_26_1469 VGND VGND VPWR VPWR sky130_fd_sc_hd__fill_1
XFILLER_211_1007 VGND VGND VPWR VPWR sky130_fd_sc_hd__fill_1
XFILLER_238_345 VPWR VGND VPWR VGND sky130_ef_sc_hd__decap_12
XFILLER_254_805 VGND VGND VPWR VPWR sky130_fd_sc_hd__decap_6
XPHY_EDGE_ROW_217_Left_472 VGND VGND VPWR VPWR sky130_fd_sc_hd__decap_3
XFILLER_238_389 VPWR VGND VPWR VGND sky130_ef_sc_hd__decap_12
XFILLER_254_849 VPWR VGND VPWR VGND sky130_ef_sc_hd__decap_12
XFILLER_207_721 VGND VGND VPWR VPWR sky130_fd_sc_hd__decap_6
XFILLER_253_337 VPWR VGND VPWR VGND sky130_ef_sc_hd__decap_12
XFILLER_59_1201 VPWR VGND VPWR VGND sky130_ef_sc_hd__decap_12
XFILLER_98_1283 VPWR VGND VPWR VGND sky130_ef_sc_hd__decap_12
XFILLER_185_1231 VGND VGND VPWR VPWR sky130_fd_sc_hd__fill_1
XFILLER_207_765 VPWR VGND VPWR VGND sky130_ef_sc_hd__decap_12
XFILLER_206_253 VPWR VGND VPWR VGND sky130_ef_sc_hd__decap_12
XFILLER_222_713 VPWR VGND VPWR VGND sky130_ef_sc_hd__decap_12
XFILLER_59_1267 VGND VGND VPWR VPWR sky130_fd_sc_hd__decap_6
XFILLER_146_1215 VPWR VGND VPWR VGND sky130_ef_sc_hd__decap_12
XFILLER_179_617 VPWR VGND VPWR VGND sky130_ef_sc_hd__decap_12
XFILLER_221_223 VGND VGND VPWR VPWR sky130_fd_sc_hd__fill_1
XFILLER_222_757 VPWR VGND VPWR VGND sky130_ef_sc_hd__decap_12
XFILLER_146_1259 VPWR VGND VPWR VGND sky130_ef_sc_hd__decap_12
XFILLER_226_1261 VPWR VGND VPWR VGND sky130_ef_sc_hd__decap_12
XFILLER_222_1147 VGND VGND VPWR VPWR sky130_fd_sc_hd__fill_1
XPHY_EDGE_ROW_226_Left_481 VGND VGND VPWR VPWR sky130_fd_sc_hd__decap_3
XFILLER_174_333 VPWR VGND VPWR VGND sky130_ef_sc_hd__decap_12
XFILLER_70_1191 VPWR VGND VPWR VGND sky130_ef_sc_hd__decap_12
XFILLER_175_889 VGND VGND VPWR VPWR sky130_fd_sc_hd__decap_6
XFILLER_174_377 VPWR VGND VPWR VGND sky130_ef_sc_hd__decap_12
XFILLER_179_1057 VGND VGND VPWR VPWR sky130_fd_sc_hd__decap_6
XFILLER_190_837 VPWR VGND VPWR VGND sky130_ef_sc_hd__decap_12
XFILLER_157_1311 VPWR VGND VPWR VGND sky130_ef_sc_hd__decap_12
XFILLER_196_1371 VGND VGND VPWR VPWR sky130_fd_sc_hd__fill_1
XFILLER_227_55 VGND VGND VPWR VPWR sky130_fd_sc_hd__fill_1
XFILLER_66_1227 VPWR VGND VPWR VGND sky130_ef_sc_hd__decap_12
XFILLER_157_1355 VPWR VGND VPWR VGND sky130_ef_sc_hd__decap_12
XFILLER_118_1339 VPWR VGND VPWR VGND sky130_ef_sc_hd__decap_12
XFILLER_153_1219 VPWR VGND VPWR VGND sky130_ef_sc_hd__decap_12
XFILLER_9_1121 VPWR VGND VPWR VGND sky130_ef_sc_hd__decap_12
XFILLER_157_1399 VPWR VGND VPWR VGND sky130_ef_sc_hd__decap_12
XFILLER_248_109 VPWR VGND VPWR VGND sky130_ef_sc_hd__decap_12
XTAP_TAPCELL_ROW_229_3080 VGND VPWR sky130_fd_sc_hd__tapvpwrvgnd_1
XFILLER_5_1007 VGND VGND VPWR VPWR sky130_fd_sc_hd__fill_1
XPHY_EDGE_ROW_235_Left_490 VGND VGND VPWR VPWR sky130_fd_sc_hd__decap_3
XFILLER_233_1287 VGND VGND VPWR VPWR sky130_fd_sc_hd__fill_1
XTAP_TAPCELL_ROW_84_2_4258 VGND VPWR sky130_fd_sc_hd__tapvpwrvgnd_1
XTAP_TAPCELL_ROW_6_1013 VGND VPWR sky130_fd_sc_hd__tapvpwrvgnd_1
XTAP_TAPCELL_ROW_6_1024 VGND VPWR sky130_fd_sc_hd__tapvpwrvgnd_1
XTAP_TAPCELL_ROW_6_1035 VGND VPWR sky130_fd_sc_hd__tapvpwrvgnd_1
XFILLER_217_529 VPWR VGND VPWR VGND sky130_ef_sc_hd__decap_12
XFILLER_42_1271 VPWR VGND VPWR VGND sky130_ef_sc_hd__decap_12
XFILLER_186_1017 VPWR VGND VPWR VGND sky130_ef_sc_hd__decap_12
XFILLER_77_1323 VGND VGND VPWR VPWR sky130_fd_sc_hd__decap_6
XTAP_TAPCELL_ROW_238_3305 VGND VPWR sky130_fd_sc_hd__tapvpwrvgnd_1
XTAP_TAPCELL_ROW_238_3316 VGND VPWR sky130_fd_sc_hd__tapvpwrvgnd_1
XFILLER_225_573 VPWR VGND VPWR VGND sky130_ef_sc_hd__decap_12
XFILLER_72_29 VPWR VGND VPWR VGND sky130_ef_sc_hd__decap_12
XFILLER_77_1367 VPWR VGND VPWR VGND sky130_ef_sc_hd__decap_12
XFILLER_129_1435 VGND VGND VPWR VPWR sky130_fd_sc_hd__decap_6
XFILLER_164_1315 VPWR VGND VPWR VGND sky130_ef_sc_hd__decap_12
XFILLER_198_937 VPWR VGND VPWR VGND sky130_ef_sc_hd__decap_12
XFILLER_169_105 VGND VGND VPWR VPWR sky130_fd_sc_hd__decap_6
XFILLER_188_29 VPWR VGND VPWR VGND sky130_ef_sc_hd__decap_12
XFILLER_129_1479 VPWR VGND VPWR VGND sky130_ef_sc_hd__decap_12
XFILLER_164_1359 VPWR VGND VPWR VGND sky130_ef_sc_hd__decap_12
XFILLER_197_447 VGND VGND VPWR VPWR sky130_fd_sc_hd__fill_1
XFILLER_212_245 VGND VGND VPWR VPWR sky130_fd_sc_hd__decap_6
XFILLER_169_149 VPWR VGND VPWR VGND sky130_ef_sc_hd__decap_12
XFILLER_205_1301 VPWR VGND VPWR VGND sky130_ef_sc_hd__decap_12
XFILLER_209_1481 VPWR VGND VPWR VGND sky130_ef_sc_hd__decap_12
XFILLER_240_1203 VGND VGND VPWR VPWR sky130_fd_sc_hd__fill_1
XFILLER_185_609 VGND VGND VPWR VPWR sky130_fd_sc_hd__decap_6
XFILLER_240_587 VGND VGND VPWR VPWR sky130_fd_sc_hd__fill_1
XTAP_TAPCELL_ROW_44_2_4021 VGND VPWR sky130_fd_sc_hd__tapvpwrvgnd_1
XFILLER_212_289 VPWR VGND VPWR VGND sky130_ef_sc_hd__decap_12
XFILLER_205_1345 VPWR VGND VPWR VGND sky130_ef_sc_hd__decap_12
XFILLER_165_333 VGND VGND VPWR VPWR sky130_fd_sc_hd__decap_3
XFILLER_177_193 VPWR VGND VPWR VGND sky130_ef_sc_hd__decap_12
XFILLER_197_1113 VGND VGND VPWR VPWR sky130_fd_sc_hd__decap_6
XFILLER_166_867 VGND VGND VPWR VPWR sky130_fd_sc_hd__fill_1
XFILLER_193_653 VPWR VGND VPWR VGND sky130_ef_sc_hd__decap_12
XFILLER_14_1351 VGND VGND VPWR VPWR sky130_fd_sc_hd__decap_6
XFILLER_192_141 VPWR VGND VPWR VGND sky130_ef_sc_hd__decap_12
XFILLER_10_1215 VPWR VGND VPWR VGND sky130_ef_sc_hd__decap_12
XFILLER_4_505 VGND VGND VPWR VPWR sky130_fd_sc_hd__fill_1
XFILLER_165_377 VPWR VGND VPWR VGND sky130_ef_sc_hd__decap_12
XFILLER_197_1157 VPWR VGND VPWR VGND sky130_ef_sc_hd__decap_12
XFILLER_21_55 VGND VGND VPWR VPWR sky130_fd_sc_hd__fill_1
XFILLER_193_697 VPWR VGND VPWR VGND sky130_ef_sc_hd__decap_12
XFILLER_14_1395 VPWR VGND VPWR VGND sky130_ef_sc_hd__decap_12
XFILLER_101_1343 VPWR VGND VPWR VGND sky130_ef_sc_hd__decap_12
XFILLER_88_1463 VGND VGND VPWR VPWR sky130_fd_sc_hd__decap_6
XTAP_TAPCELL_ROW_214_2670 VGND VPWR sky130_fd_sc_hd__tapvpwrvgnd_1
XFILLER_10_1259 VPWR VGND VPWR VGND sky130_ef_sc_hd__decap_12
XFILLER_137_55 VGND VGND VPWR VPWR sky130_fd_sc_hd__fill_1
XFILLER_97_15 VPWR VGND VPWR VGND sky130_ef_sc_hd__decap_12
XFILLER_84_1327 VPWR VGND VPWR VGND sky130_ef_sc_hd__decap_12
XFILLER_101_1387 VPWR VGND VPWR VGND sky130_ef_sc_hd__decap_12
XTAP_TAPCELL_ROW_210_2545 VGND VPWR sky130_fd_sc_hd__tapvpwrvgnd_1
XFILLER_175_1455 VGND VGND VPWR VPWR sky130_fd_sc_hd__fill_1
XTAP_TAPCELL_ROW_210_2556 VGND VPWR sky130_fd_sc_hd__tapvpwrvgnd_1
XTAP_TAPCELL_ROW_210_2567 VGND VPWR sky130_fd_sc_hd__tapvpwrvgnd_1
XFILLER_234_1029 VGND VGND VPWR VPWR sky130_fd_sc_hd__decap_6
XFILLER_136_1439 VPWR VGND VPWR VGND sky130_ef_sc_hd__decap_12
XFILLER_216_1441 VPWR VGND VPWR VGND sky130_ef_sc_hd__decap_12
XFILLER_251_1343 VGND VGND VPWR VPWR sky130_fd_sc_hd__fill_1
XFILLER_248_643 VGND VGND VPWR VPWR sky130_fd_sc_hd__fill_1
XFILLER_216_1485 VPWR VGND VPWR VGND sky130_ef_sc_hd__decap_12
XFILLER_236_805 VGND VGND VPWR VPWR sky130_fd_sc_hd__decap_6
XTAP_TAPCELL_ROW_223_2906 VGND VPWR sky130_fd_sc_hd__tapvpwrvgnd_1
XTAP_TAPCELL_ROW_223_2917 VGND VPWR sky130_fd_sc_hd__tapvpwrvgnd_1
XFILLER_21_1311 VPWR VGND VPWR VGND sky130_ef_sc_hd__decap_12
XFILLER_236_849 VPWR VGND VPWR VGND sky130_ef_sc_hd__decap_12
XFILLER_60_1371 VPWR VGND VPWR VGND sky130_ef_sc_hd__decap_12
XFILLER_25_1491 VGND VGND VPWR VPWR sky130_fd_sc_hd__decap_6
XFILLER_235_337 VPWR VGND VPWR VGND sky130_ef_sc_hd__decap_12
XTAP_TAPCELL_ROW_208_2496 VGND VPWR sky130_fd_sc_hd__tapvpwrvgnd_1
XFILLER_46_41 VGND VGND VPWR VPWR sky130_fd_sc_hd__decap_6
XFILLER_21_1355 VPWR VGND VPWR VGND sky130_ef_sc_hd__decap_12
XFILLER_210_1073 VPWR VGND VPWR VGND sky130_ef_sc_hd__decap_12
XFILLER_95_1423 VPWR VGND VPWR VGND sky130_ef_sc_hd__decap_12
XFILLER_112_1483 VPWR VGND VPWR VGND sky130_ef_sc_hd__decap_12
XFILLER_250_307 VGND VGND VPWR VPWR sky130_fd_sc_hd__fill_1
XFILLER_1_1449 VGND VGND VPWR VPWR sky130_fd_sc_hd__decap_6
XFILLER_21_1399 VPWR VGND VPWR VGND sky130_ef_sc_hd__decap_12
XFILLER_204_713 VPWR VGND VPWR VGND sky130_ef_sc_hd__decap_12
XFILLER_244_893 VPWR VGND VPWR VGND sky130_ef_sc_hd__decap_12
XFILLER_56_1407 VGND VGND VPWR VPWR sky130_fd_sc_hd__decap_6
XFILLER_95_1467 VPWR VGND VPWR VGND sky130_ef_sc_hd__decap_12
XFILLER_203_223 VGND VGND VPWR VPWR sky130_fd_sc_hd__fill_1
XFILLER_204_757 VPWR VGND VPWR VGND sky130_ef_sc_hd__decap_12
XFILLER_245_1169 VGND VGND VPWR VPWR sky130_fd_sc_hd__decap_6
XFILLER_223_1401 VPWR VGND VPWR VGND sky130_ef_sc_hd__decap_12
XPHY_EDGE_ROW_133_2_Left_635 VGND VGND VPWR VPWR sky130_fd_sc_hd__decap_3
XFILLER_188_469 VGND VGND VPWR VPWR sky130_fd_sc_hd__decap_6
XFILLER_19_1273 VGND VGND VPWR VPWR sky130_fd_sc_hd__fill_1
XFILLER_8_811 VGND VGND VPWR VPWR sky130_fd_sc_hd__fill_1
XFILLER_180_1161 VPWR VGND VPWR VGND sky130_ef_sc_hd__decap_12
Xwire230 net231 VGND VGND VPWR VPWR net230 sky130_fd_sc_hd__clkbuf_1
Xwire241 net242 VGND VGND VPWR VPWR net241 sky130_fd_sc_hd__clkbuf_1
XFILLER_32_1451 VPWR VGND VPWR VGND sky130_ef_sc_hd__decap_12
Xwire252 net253 VGND VGND VPWR VPWR net252 sky130_fd_sc_hd__clkbuf_1
XFILLER_7_57 VPWR VGND VPWR VGND sky130_ef_sc_hd__decap_12
Xwire263 net264 VGND VGND VPWR VPWR net263 sky130_fd_sc_hd__clkbuf_1
XFILLER_141_1189 VPWR VGND VPWR VGND sky130_ef_sc_hd__decap_12
Xwire274 net275 VGND VGND VPWR VPWR net274 sky130_fd_sc_hd__clkbuf_1
XFILLER_172_837 VPWR VGND VPWR VGND sky130_ef_sc_hd__decap_12
Xwire285 net286 VGND VGND VPWR VPWR net285 sky130_fd_sc_hd__clkbuf_1
XFILLER_32_1495 VPWR VGND VPWR VGND sky130_ef_sc_hd__decap_12
Xwire296 net297 VGND VGND VPWR VPWR net296 sky130_fd_sc_hd__clkbuf_1
XFILLER_193_1511 VGND VGND VPWR VPWR sky130_fd_sc_hd__fill_1
XFILLER_194_83 VGND VGND VPWR VPWR sky130_fd_sc_hd__fill_1
XTAP_TAPCELL_ROW_102_2_4366 VGND VPWR sky130_fd_sc_hd__tapvpwrvgnd_1
XFILLER_180_881 VPWR VGND VPWR VGND sky130_ef_sc_hd__decap_12
XFILLER_252_1129 VPWR VGND VPWR VGND sky130_ef_sc_hd__decap_12
XTAP_TAPCELL_ROW_70_2_4177 VGND VPWR sky130_fd_sc_hd__tapvpwrvgnd_1
XTAP_TAPCELL_ROW_189_1990 VGND VPWR sky130_fd_sc_hd__tapvpwrvgnd_1
XFILLER_230_1427 VGND VGND VPWR VPWR sky130_fd_sc_hd__fill_1
XFILLER_239_665 VGND VGND VPWR VPWR sky130_fd_sc_hd__decap_6
XFILLER_238_153 VPWR VGND VPWR VGND sky130_ef_sc_hd__decap_12
XTAP_TAPCELL_ROW_185_1876 VGND VPWR sky130_fd_sc_hd__tapvpwrvgnd_1
XFILLER_254_613 VPWR VGND VPWR VGND sky130_ef_sc_hd__decap_12
XFILLER_16_3 VPWR VGND VPWR VGND sky130_ef_sc_hd__decap_12
XTAP_TAPCELL_ROW_185_1887 VGND VPWR sky130_fd_sc_hd__tapvpwrvgnd_1
XPHY_EDGE_ROW_147_1_Left_402 VGND VGND VPWR VPWR sky130_fd_sc_hd__decap_3
XFILLER_238_197 VPWR VGND VPWR VGND sky130_ef_sc_hd__decap_12
XFILLER_187_1337 VGND VGND VPWR VPWR sky130_fd_sc_hd__decap_6
XFILLER_213_57 VPWR VGND VPWR VGND sky130_ef_sc_hd__decap_12
XFILLER_254_657 VPWR VGND VPWR VGND sky130_ef_sc_hd__decap_12
XTAP_TAPCELL_ROW_50_2_4053 VGND VPWR sky130_fd_sc_hd__tapvpwrvgnd_1
XTAP_TAPCELL_ROW_49_2_4047 VGND VPWR sky130_fd_sc_hd__tapvpwrvgnd_1
XFILLER_4_1073 VPWR VGND VPWR VGND sky130_ef_sc_hd__decap_12
XFILLER_253_167 VGND VGND VPWR VPWR sky130_fd_sc_hd__fill_1
XFILLER_207_573 VPWR VGND VPWR VGND sky130_ef_sc_hd__decap_12
XFILLER_241_329 VGND VGND VPWR VPWR sky130_fd_sc_hd__decap_6
XFILLER_74_1507 VGND VGND VPWR VPWR sky130_fd_sc_hd__decap_8
XPHY_EDGE_ROW_65_2_Left_567 VGND VGND VPWR VPWR sky130_fd_sc_hd__decap_3
XFILLER_179_447 VGND VGND VPWR VPWR sky130_fd_sc_hd__fill_1
XFILLER_167_609 VGND VGND VPWR VPWR sky130_fd_sc_hd__decap_6
XFILLER_222_587 VGND VGND VPWR VPWR sky130_fd_sc_hd__fill_1
XFILLER_188_981 VPWR VGND VPWR VGND sky130_ef_sc_hd__decap_12
XFILLER_210_749 VGND VGND VPWR VPWR sky130_fd_sc_hd__decap_6
XFILLER_226_1091 VGND VGND VPWR VPWR sky130_fd_sc_hd__fill_1
XTAP_TAPCELL_ROW_27_2_3917 VGND VPWR sky130_fd_sc_hd__tapvpwrvgnd_1
XFILLER_175_653 VPWR VGND VPWR VGND sky130_ef_sc_hd__decap_12
XFILLER_174_141 VPWR VGND VPWR VGND sky130_ef_sc_hd__decap_12
XFILLER_190_601 VPWR VGND VPWR VGND sky130_ef_sc_hd__decap_12
XFILLER_238_65 VPWR VGND VPWR VGND sky130_ef_sc_hd__decap_12
XFILLER_175_697 VPWR VGND VPWR VGND sky130_ef_sc_hd__decap_12
XFILLER_198_1477 VGND VGND VPWR VPWR sky130_fd_sc_hd__decap_6
XFILLER_200_1253 VGND VGND VPWR VPWR sky130_fd_sc_hd__decap_6
XFILLER_190_645 VPWR VGND VPWR VGND sky130_ef_sc_hd__decap_12
Xmax_cap530 net60 VGND VGND VPWR VPWR net530 sky130_fd_sc_hd__clkbuf_1
Xmax_cap541 net542 VGND VGND VPWR VPWR net541 sky130_fd_sc_hd__clkbuf_1
Xmax_cap552 net72 VGND VGND VPWR VPWR net552 sky130_fd_sc_hd__buf_1
XFILLER_200_1297 VPWR VGND VPWR VGND sky130_ef_sc_hd__decap_12
XTAP_TAPCELL_ROW_227_3006 VGND VPWR sky130_fd_sc_hd__tapvpwrvgnd_1
XTAP_TAPCELL_ROW_227_3017 VGND VPWR sky130_fd_sc_hd__tapvpwrvgnd_1
XFILLER_254_53 VPWR VGND VPWR VGND sky130_ef_sc_hd__decap_12
XFILLER_249_429 VPWR VGND VPWR VGND sky130_ef_sc_hd__decap_12
XFILLER_107_69 VGND VGND VPWR VPWR sky130_fd_sc_hd__fill_2
XFILLER_254_97 VPWR VGND VPWR VGND sky130_ef_sc_hd__decap_12
XFILLER_170_1341 VPWR VGND VPWR VGND sky130_ef_sc_hd__decap_12
XPHY_EDGE_ROW_79_1_Left_334 VGND VGND VPWR VPWR sky130_fd_sc_hd__decap_3
XPHY_EDGE_ROW_144_1_Right_800 VGND VGND VPWR VPWR sky130_fd_sc_hd__decap_3
XTAP_TAPCELL_ROW_146_2_4631 VGND VPWR sky130_fd_sc_hd__tapvpwrvgnd_1
XFILLER_218_805 VGND VGND VPWR VPWR sky130_fd_sc_hd__decap_6
XFILLER_170_1385 VPWR VGND VPWR VGND sky130_ef_sc_hd__decap_12
XFILLER_218_849 VPWR VGND VPWR VGND sky130_ef_sc_hd__decap_12
XTAP_TAPCELL_ROW_40_1_1175 VGND VPWR sky130_fd_sc_hd__tapvpwrvgnd_1
XFILLER_123_57 VPWR VGND VPWR VGND sky130_ef_sc_hd__decap_12
XPHY_EDGE_ROW_131_1_Left_386 VGND VGND VPWR VPWR sky130_fd_sc_hd__decap_3
XFILLER_217_337 VPWR VGND VPWR VGND sky130_ef_sc_hd__decap_12
XFILLER_83_39 VPWR VGND VPWR VGND sky130_ef_sc_hd__decap_12
XFILLER_211_1393 VGND VGND VPWR VPWR sky130_fd_sc_hd__decap_6
XFILLER_232_307 VGND VGND VPWR VPWR sky130_fd_sc_hd__fill_1
XFILLER_198_701 VPWR VGND VPWR VGND sky130_ef_sc_hd__decap_12
XFILLER_199_39 VPWR VGND VPWR VGND sky130_ef_sc_hd__decap_12
XFILLER_244_189 VGND VGND VPWR VPWR sky130_fd_sc_hd__decap_6
XTAP_TAPCELL_ROW_203_2360 VGND VPWR sky130_fd_sc_hd__tapvpwrvgnd_1
XFILLER_226_893 VPWR VGND VPWR VGND sky130_ef_sc_hd__decap_12
XTAP_TAPCELL_ROW_203_2371 VGND VPWR sky130_fd_sc_hd__tapvpwrvgnd_1
XFILLER_241_841 VPWR VGND VPWR VGND sky130_ef_sc_hd__decap_12
XFILLER_129_1243 VPWR VGND VPWR VGND sky130_ef_sc_hd__decap_12
XFILLER_242_1309 VGND VGND VPWR VPWR sky130_fd_sc_hd__decap_6
XFILLER_129_1287 VPWR VGND VPWR VGND sky130_ef_sc_hd__decap_12
XTAP_TAPCELL_ROW_195_2150 VGND VPWR sky130_fd_sc_hd__tapvpwrvgnd_1
XFILLER_201_727 VGND VGND VPWR VPWR sky130_fd_sc_hd__fill_1
XTAP_TAPCELL_ROW_195_2161 VGND VPWR sky130_fd_sc_hd__tapvpwrvgnd_1
XFILLER_16_1413 VGND VGND VPWR VPWR sky130_fd_sc_hd__fill_1
XFILLER_164_1189 VGND VGND VPWR VPWR sky130_fd_sc_hd__fill_1
XFILLER_185_417 VPWR VGND VPWR VGND sky130_ef_sc_hd__decap_12
XFILLER_181_1481 VPWR VGND VPWR VGND sky130_ef_sc_hd__decap_12
XTAP_TAPCELL_ROW_216_2710 VGND VPWR sky130_fd_sc_hd__tapvpwrvgnd_1
XTAP_TAPCELL_ROW_191_2036 VGND VPWR sky130_fd_sc_hd__tapvpwrvgnd_1
XTAP_TAPCELL_ROW_191_2047 VGND VPWR sky130_fd_sc_hd__tapvpwrvgnd_1
XTAP_TAPCELL_ROW_216_2721 VGND VPWR sky130_fd_sc_hd__tapvpwrvgnd_1
XFILLER_205_1175 VGND VGND VPWR VPWR sky130_fd_sc_hd__fill_1
XFILLER_120_3 VPWR VGND VPWR VGND sky130_ef_sc_hd__decap_12
XFILLER_194_973 VGND VGND VPWR VPWR sky130_fd_sc_hd__decap_6
XFILLER_165_141 VPWR VGND VPWR VGND sky130_ef_sc_hd__decap_12
XFILLER_193_461 VPWR VGND VPWR VGND sky130_ef_sc_hd__decap_12
XFILLER_218_3 VPWR VGND VPWR VGND sky130_ef_sc_hd__decap_12
XFILLER_148_65 VGND VGND VPWR VPWR sky130_fd_sc_hd__decap_6
XTAP_TAPCELL_ROW_212_2607 VGND VPWR sky130_fd_sc_hd__tapvpwrvgnd_1
XFILLER_5_825 VGND VGND VPWR VPWR sky130_fd_sc_hd__fill_1
XTAP_TAPCELL_ROW_212_2618 VGND VPWR sky130_fd_sc_hd__tapvpwrvgnd_1
XFILLER_4_313 VGND VGND VPWR VPWR sky130_fd_sc_hd__fill_1
XFILLER_180_133 VGND VGND VPWR VPWR sky130_fd_sc_hd__decap_6
XFILLER_88_1271 VPWR VGND VPWR VGND sky130_ef_sc_hd__decap_12
XFILLER_49_1255 VPWR VGND VPWR VGND sky130_ef_sc_hd__decap_12
XFILLER_136_1203 VPWR VGND VPWR VGND sky130_ef_sc_hd__decap_12
XFILLER_180_177 VPWR VGND VPWR VGND sky130_ef_sc_hd__decap_12
XFILLER_253_1449 VGND VGND VPWR VPWR sky130_fd_sc_hd__decap_6
XFILLER_164_53 VPWR VGND VPWR VGND sky130_ef_sc_hd__decap_12
XPHY_EDGE_ROW_170_Right_15 VGND VGND VPWR VPWR sky130_fd_sc_hd__decap_3
XFILLER_49_1299 VPWR VGND VPWR VGND sky130_ef_sc_hd__decap_12
XFILLER_136_1247 VPWR VGND VPWR VGND sky130_ef_sc_hd__decap_12
XFILLER_57_51 VGND VGND VPWR VPWR sky130_fd_sc_hd__decap_4
XFILLER_236_613 VPWR VGND VPWR VGND sky130_ef_sc_hd__decap_12
XFILLER_180_41 VPWR VGND VPWR VGND sky130_ef_sc_hd__decap_12
XFILLER_169_1001 VGND VGND VPWR VPWR sky130_fd_sc_hd__decap_6
XFILLER_236_657 VPWR VGND VPWR VGND sky130_ef_sc_hd__decap_12
XFILLER_1_1213 VPWR VGND VPWR VGND sky130_ef_sc_hd__decap_12
XFILLER_169_1045 VPWR VGND VPWR VGND sky130_ef_sc_hd__decap_12
XFILLER_180_85 VPWR VGND VPWR VGND sky130_ef_sc_hd__decap_12
XTAP_TAPCELL_ROW_180_1740 VGND VPWR sky130_fd_sc_hd__tapvpwrvgnd_1
XFILLER_5_1393 VGND VGND VPWR VPWR sky130_fd_sc_hd__decap_6
XTAP_TAPCELL_ROW_180_1751 VGND VPWR sky130_fd_sc_hd__tapvpwrvgnd_1
XFILLER_235_167 VGND VGND VPWR VPWR sky130_fd_sc_hd__fill_1
XFILLER_95_1231 VPWR VGND VPWR VGND sky130_ef_sc_hd__decap_12
XFILLER_1_1257 VPWR VGND VPWR VGND sky130_ef_sc_hd__decap_12
XFILLER_169_1089 VPWR VGND VPWR VGND sky130_ef_sc_hd__decap_12
XFILLER_223_329 VGND VGND VPWR VPWR sky130_fd_sc_hd__decap_6
XFILLER_56_1215 VPWR VGND VPWR VGND sky130_ef_sc_hd__decap_12
XFILLER_95_1275 VPWR VGND VPWR VGND sky130_ef_sc_hd__decap_12
XFILLER_147_1343 VPWR VGND VPWR VGND sky130_ef_sc_hd__decap_12
XFILLER_188_233 VPWR VGND VPWR VGND sky130_ef_sc_hd__decap_12
XFILLER_56_1259 VPWR VGND VPWR VGND sky130_ef_sc_hd__decap_12
XFILLER_108_1327 VPWR VGND VPWR VGND sky130_ef_sc_hd__decap_12
XFILLER_147_1387 VPWR VGND VPWR VGND sky130_ef_sc_hd__decap_12
XFILLER_204_587 VGND VGND VPWR VPWR sky130_fd_sc_hd__fill_1
XFILLER_231_373 VPWR VGND VPWR VGND sky130_ef_sc_hd__decap_12
XFILLER_188_277 VPWR VGND VPWR VGND sky130_ef_sc_hd__decap_12
XFILLER_223_1231 VGND VGND VPWR VPWR sky130_fd_sc_hd__fill_1
XTAP_TAPCELL_ROW_178_1680 VGND VPWR sky130_fd_sc_hd__tapvpwrvgnd_1
XTAP_TAPCELL_ROW_178_1691 VGND VPWR sky130_fd_sc_hd__tapvpwrvgnd_1
XFILLER_185_951 VGND VGND VPWR VPWR sky130_fd_sc_hd__fill_1
XFILLER_172_601 VPWR VGND VPWR VGND sky130_ef_sc_hd__decap_12
XFILLER_200_793 VPWR VGND VPWR VGND sky130_ef_sc_hd__decap_12
XTAP_TAPCELL_ROW_174_1577 VGND VPWR sky130_fd_sc_hd__tapvpwrvgnd_1
XTAP_TAPCELL_ROW_174_1588 VGND VPWR sky130_fd_sc_hd__tapvpwrvgnd_1
XFILLER_176_1005 VPWR VGND VPWR VGND sky130_ef_sc_hd__decap_12
XFILLER_171_111 VGND VGND VPWR VPWR sky130_fd_sc_hd__fill_1
XFILLER_7_184 VGND VGND VPWR VPWR sky130_fd_sc_hd__fill_1
XFILLER_172_645 VPWR VGND VPWR VGND sky130_ef_sc_hd__decap_12
XFILLER_67_1311 VPWR VGND VPWR VGND sky130_ef_sc_hd__decap_12
XFILLER_176_1049 VPWR VGND VPWR VGND sky130_ef_sc_hd__decap_12
XFILLER_67_1355 VPWR VGND VPWR VGND sky130_ef_sc_hd__decap_12
XFILLER_154_1303 VPWR VGND VPWR VGND sky130_ef_sc_hd__decap_12
XFILLER_119_1423 VPWR VGND VPWR VGND sky130_ef_sc_hd__decap_12
XFILLER_158_1483 VPWR VGND VPWR VGND sky130_ef_sc_hd__decap_12
XFILLER_63_1219 VPWR VGND VPWR VGND sky130_ef_sc_hd__decap_12
XFILLER_28_1339 VPWR VGND VPWR VGND sky130_ef_sc_hd__decap_12
XTAP_TAPCELL_ROW_187_1927 VGND VPWR sky130_fd_sc_hd__tapvpwrvgnd_1
XFILLER_67_1399 VPWR VGND VPWR VGND sky130_ef_sc_hd__decap_12
XTAP_TAPCELL_ROW_187_1938 VGND VPWR sky130_fd_sc_hd__tapvpwrvgnd_1
XFILLER_217_1057 VGND VGND VPWR VPWR sky130_fd_sc_hd__decap_6
XFILLER_119_1467 VPWR VGND VPWR VGND sky130_ef_sc_hd__decap_12
XFILLER_234_1371 VGND VGND VPWR VPWR sky130_fd_sc_hd__fill_1
XFILLER_239_473 VPWR VGND VPWR VGND sky130_ef_sc_hd__decap_12
XFILLER_187_1101 VPWR VGND VPWR VGND sky130_ef_sc_hd__decap_12
XFILLER_254_421 VPWR VGND VPWR VGND sky130_ef_sc_hd__decap_12
XFILLER_255_977 VGND VGND VPWR VPWR sky130_fd_sc_hd__decap_3
XFILLER_187_1145 VPWR VGND VPWR VGND sky130_ef_sc_hd__decap_12
XFILLER_214_307 VGND VGND VPWR VPWR sky130_fd_sc_hd__fill_1
XFILLER_78_1451 VPWR VGND VPWR VGND sky130_ef_sc_hd__decap_12
XFILLER_183_1009 VPWR VGND VPWR VGND sky130_ef_sc_hd__decap_12
XFILLER_208_893 VPWR VGND VPWR VGND sky130_ef_sc_hd__decap_12
XFILLER_226_189 VGND VGND VPWR VPWR sky130_fd_sc_hd__decap_6
XFILLER_187_1189 VPWR VGND VPWR VGND sky130_ef_sc_hd__decap_12
XFILLER_241_137 VPWR VGND VPWR VGND sky130_ef_sc_hd__decap_12
XFILLER_240_77 VGND VGND VPWR VPWR sky130_fd_sc_hd__decap_6
XFILLER_39_1435 VGND VGND VPWR VPWR sky130_fd_sc_hd__decap_6
XFILLER_74_1315 VPWR VGND VPWR VGND sky130_ef_sc_hd__decap_12
XFILLER_223_841 VPWR VGND VPWR VGND sky130_ef_sc_hd__decap_12
XTAP_TAPCELL_ROW_79_2_4231 VGND VPWR sky130_fd_sc_hd__tapvpwrvgnd_1
XFILLER_78_1495 VPWR VGND VPWR VGND sky130_ef_sc_hd__decap_12
XFILLER_39_1479 VPWR VGND VPWR VGND sky130_ef_sc_hd__decap_12
XFILLER_74_1359 VPWR VGND VPWR VGND sky130_ef_sc_hd__decap_12
XFILLER_126_1427 VPWR VGND VPWR VGND sky130_ef_sc_hd__decap_12
XFILLER_224_1017 VPWR VGND VPWR VGND sky130_ef_sc_hd__decap_12
XFILLER_210_513 VPWR VGND VPWR VGND sky130_ef_sc_hd__decap_12
XFILLER_228_1197 VGND VGND VPWR VPWR sky130_fd_sc_hd__decap_6
XFILLER_161_1329 VGND VGND VPWR VPWR sky130_fd_sc_hd__fill_1
XFILLER_250_693 VGND VGND VPWR VPWR sky130_fd_sc_hd__decap_6
XTAP_TAPCELL_ROW_92_2_4309 VGND VPWR sky130_fd_sc_hd__tapvpwrvgnd_1
XFILLER_167_417 VPWR VGND VPWR VGND sky130_ef_sc_hd__decap_12
XFILLER_210_557 VPWR VGND VPWR VGND sky130_ef_sc_hd__decap_12
XFILLER_202_1315 VGND VGND VPWR VPWR sky130_fd_sc_hd__fill_1
XTAP_TAPCELL_ROW_252_3677 VGND VPWR sky130_fd_sc_hd__tapvpwrvgnd_1
XTAP_TAPCELL_ROW_252_3688 VGND VPWR sky130_fd_sc_hd__tapvpwrvgnd_1
XFILLER_176_973 VGND VGND VPWR VPWR sky130_fd_sc_hd__decap_6
XTAP_TAPCELL_ROW_252_3699 VGND VPWR sky130_fd_sc_hd__tapvpwrvgnd_1
XFILLER_175_461 VPWR VGND VPWR VGND sky130_ef_sc_hd__decap_12
XFILLER_198_1241 VPWR VGND VPWR VGND sky130_ef_sc_hd__decap_12
XFILLER_191_921 VPWR VGND VPWR VGND sky130_ef_sc_hd__decap_12
XFILLER_194_1105 VPWR VGND VPWR VGND sky130_ef_sc_hd__decap_12
XFILLER_198_1285 VPWR VGND VPWR VGND sky130_ef_sc_hd__decap_12
XFILLER_11_1343 VPWR VGND VPWR VGND sky130_ef_sc_hd__decap_12
XFILLER_191_965 VPWR VGND VPWR VGND sky130_ef_sc_hd__decap_12
XFILLER_85_1411 VPWR VGND VPWR VGND sky130_ef_sc_hd__decap_12
XFILLER_102_1471 VPWR VGND VPWR VGND sky130_ef_sc_hd__decap_12
XFILLER_200_1061 VPWR VGND VPWR VGND sky130_ef_sc_hd__decap_12
XFILLER_194_1149 VPWR VGND VPWR VGND sky130_ef_sc_hd__decap_12
XFILLER_190_475 VGND VGND VPWR VPWR sky130_fd_sc_hd__fill_1
XFILLER_11_1387 VPWR VGND VPWR VGND sky130_ef_sc_hd__decap_12
XFILLER_235_1113 VGND VGND VPWR VPWR sky130_fd_sc_hd__decap_6
XFILLER_85_1455 VPWR VGND VPWR VGND sky130_ef_sc_hd__decap_12
XFILLER_46_1439 VPWR VGND VPWR VGND sky130_ef_sc_hd__decap_12
XFILLER_235_1157 VPWR VGND VPWR VGND sky130_ef_sc_hd__decap_12
XFILLER_85_1499 VPWR VGND VPWR VGND sky130_ef_sc_hd__decap_12
XFILLER_249_237 VPWR VGND VPWR VGND sky130_ef_sc_hd__decap_12
XFILLER_94_27 VGND VGND VPWR VPWR sky130_fd_sc_hd__fill_1
XFILLER_213_1455 VGND VGND VPWR VPWR sky130_fd_sc_hd__fill_1
XFILLER_218_613 VPWR VGND VPWR VGND sky130_ef_sc_hd__decap_12
XPHY_EDGE_ROW_145_1_Right_801 VGND VGND VPWR VPWR sky130_fd_sc_hd__decap_3
XTAP_TAPCELL_ROW_205_2411 VGND VPWR sky130_fd_sc_hd__tapvpwrvgnd_1
XTAP_TAPCELL_ROW_205_2422 VGND VPWR sky130_fd_sc_hd__tapvpwrvgnd_1
XTAP_TAPCELL_ROW_205_2433 VGND VPWR sky130_fd_sc_hd__tapvpwrvgnd_1
XFILLER_218_657 VPWR VGND VPWR VGND sky130_ef_sc_hd__decap_12
XFILLER_131_1177 VPWR VGND VPWR VGND sky130_ef_sc_hd__decap_12
X_530_ net665 VGND VGND VPWR VPWR _012_ sky130_fd_sc_hd__inv_2
XFILLER_217_167 VGND VGND VPWR VPWR sky130_fd_sc_hd__fill_1
XFILLER_22_1483 VPWR VGND VPWR VGND sky130_ef_sc_hd__decap_12
XTAP_TAPCELL_ROW_201_2308 VGND VPWR sky130_fd_sc_hd__tapvpwrvgnd_1
XTAP_TAPCELL_ROW_197_2201 VGND VPWR sky130_fd_sc_hd__tapvpwrvgnd_1
XTAP_TAPCELL_ROW_201_2319 VGND VPWR sky130_fd_sc_hd__tapvpwrvgnd_1
XFILLER_205_329 VGND VGND VPWR VPWR sky130_fd_sc_hd__decap_6
XFILLER_166_1229 VPWR VGND VPWR VGND sky130_ef_sc_hd__decap_12
XTAP_TAPCELL_ROW_197_2212 VGND VPWR sky130_fd_sc_hd__tapvpwrvgnd_1
XFILLER_168_3 VPWR VGND VPWR VGND sky130_ef_sc_hd__decap_12
X_461_ net605 net9 net42 VGND VGND VPWR VPWR addr0\[7\] sky130_fd_sc_hd__mux2_1
XTAP_TAPCELL_ROW_1_883 VGND VPWR sky130_fd_sc_hd__tapvpwrvgnd_1
XTAP_TAPCELL_ROW_1_894 VGND VPWR sky130_fd_sc_hd__tapvpwrvgnd_1
XFILLER_92_1415 VPWR VGND VPWR VGND sky130_ef_sc_hd__decap_12
XFILLER_246_1253 VGND VGND VPWR VPWR sky130_fd_sc_hd__decap_6
XFILLER_198_531 VGND VGND VPWR VPWR sky130_fd_sc_hd__fill_1
XTAP_TAPCELL_ROW_193_2109 VGND VPWR sky130_fd_sc_hd__tapvpwrvgnd_1
XFILLER_242_1117 VPWR VGND VPWR VGND sky130_ef_sc_hd__decap_12
XFILLER_241_671 VGND VGND VPWR VPWR sky130_fd_sc_hd__fill_1
X_392_ net208 _179_ VGND VGND VPWR VPWR _181_ sky130_fd_sc_hd__or2_1
XFILLER_246_1297 VPWR VGND VPWR VGND sky130_ef_sc_hd__decap_12
XFILLER_213_373 VPWR VGND VPWR VGND sky130_ef_sc_hd__decap_12
XFILLER_9_405 VPWR VGND VPWR VGND sky130_ef_sc_hd__decap_12
XFILLER_186_737 VPWR VGND VPWR VGND sky130_ef_sc_hd__decap_12
XFILLER_185_225 VPWR VGND VPWR VGND sky130_ef_sc_hd__decap_12
XFILLER_9_449 VGND VGND VPWR VPWR sky130_fd_sc_hd__fill_1
XFILLER_167_951 VGND VGND VPWR VPWR sky130_fd_sc_hd__fill_1
XFILLER_103_1213 VGND VGND VPWR VPWR sky130_fd_sc_hd__decap_4
XFILLER_142_1295 VGND VGND VPWR VPWR sky130_fd_sc_hd__decap_6
XFILLER_194_781 VPWR VGND VPWR VGND sky130_ef_sc_hd__decap_12
XFILLER_51_1189 VPWR VGND VPWR VGND sky130_ef_sc_hd__decap_12
XTAP_TAPCELL_ROW_137_2_4576 VGND VPWR sky130_fd_sc_hd__tapvpwrvgnd_1
XFILLER_177_1325 VPWR VGND VPWR VGND sky130_ef_sc_hd__decap_12
XFILLER_177_1369 VPWR VGND VPWR VGND sky130_ef_sc_hd__decap_12
XFILLER_5_688 VGND VGND VPWR VPWR sky130_fd_sc_hd__decap_3
XFILLER_4_165 VGND VGND VPWR VPWR sky130_fd_sc_hd__decap_4
XFILLER_253_1213 VPWR VGND VPWR VGND sky130_ef_sc_hd__decap_12
XFILLER_5_699 VGND VGND VPWR VPWR sky130_fd_sc_hd__decap_8
XFILLER_181_497 VGND VGND VPWR VPWR sky130_fd_sc_hd__decap_6
XFILLER_253_1257 VPWR VGND VPWR VGND sky130_ef_sc_hd__decap_12
XFILLER_231_1511 VGND VGND VPWR VPWR sky130_fd_sc_hd__fill_1
XFILLER_191_51 VGND VGND VPWR VPWR sky130_fd_sc_hd__decap_4
XTAP_TAPCELL_ROW_85_2_4263 VGND VPWR sky130_fd_sc_hd__tapvpwrvgnd_1
XTAP_TAPCELL_ROW_182_1802 VGND VPWR sky130_fd_sc_hd__tapvpwrvgnd_1
XFILLER_7_1455 VGND VGND VPWR VPWR sky130_fd_sc_hd__fill_1
XFILLER_0_393 VGND VGND VPWR VPWR sky130_fd_sc_hd__fill_1
XFILLER_237_933 VPWR VGND VPWR VGND sky130_ef_sc_hd__decap_12
XFILLER_236_421 VPWR VGND VPWR VGND sky130_ef_sc_hd__decap_12
XTAP_TAPCELL_ROW_167_1381 VGND VPWR sky130_fd_sc_hd__tapvpwrvgnd_1
XFILLER_188_1421 VGND VGND VPWR VPWR sky130_fd_sc_hd__decap_6
XTAP_TAPCELL_ROW_167_1392 VGND VPWR sky130_fd_sc_hd__tapvpwrvgnd_1
XFILLER_237_977 VPWR VGND VPWR VGND sky130_ef_sc_hd__decap_12
XFILLER_110_1239 VGND VGND VPWR VPWR sky130_fd_sc_hd__decap_6
XFILLER_252_925 VPWR VGND VPWR VGND sky130_ef_sc_hd__decap_12
XFILLER_188_1465 VPWR VGND VPWR VGND sky130_ef_sc_hd__decap_12
XFILLER_1_1021 VPWR VGND VPWR VGND sky130_ef_sc_hd__decap_12
XTAP_TAPCELL_ROW_110_2_4417 VGND VPWR sky130_fd_sc_hd__tapvpwrvgnd_1
XFILLER_184_1329 VPWR VGND VPWR VGND sky130_ef_sc_hd__decap_12
XFILLER_208_189 VGND VGND VPWR VPWR sky130_fd_sc_hd__decap_6
XFILLER_223_137 VPWR VGND VPWR VGND sky130_ef_sc_hd__decap_12
X_659_ clknet_3_5__leaf_clk acc_core.adder.cla_blocks\[6\].block.sum\[1\] _067_ VGND
+ VGND VPWR VPWR net60 sky130_fd_sc_hd__dfrtp_1
XFILLER_1_1065 VPWR VGND VPWR VGND sky130_ef_sc_hd__decap_12
XFILLER_205_841 VPWR VGND VPWR VGND sky130_ef_sc_hd__decap_12
XFILLER_189_553 VGND VGND VPWR VPWR sky130_fd_sc_hd__decap_6
XFILLER_220_811 VGND VGND VPWR VPWR sky130_fd_sc_hd__fill_1
XFILLER_225_1337 VGND VGND VPWR VPWR sky130_fd_sc_hd__decap_6
XFILLER_232_693 VGND VGND VPWR VPWR sky130_fd_sc_hd__decap_6
XPHY_EDGE_ROW_167_Left_422 VGND VGND VPWR VPWR sky130_fd_sc_hd__decap_3
XFILLER_189_597 VPWR VGND VPWR VGND sky130_ef_sc_hd__decap_12
XFILLER_231_181 VPWR VGND VPWR VGND sky130_ef_sc_hd__decap_12
XTAP_TAPCELL_ROW_176_1628 VGND VPWR sky130_fd_sc_hd__tapvpwrvgnd_1
XTAP_TAPCELL_ROW_176_1639 VGND VPWR sky130_fd_sc_hd__tapvpwrvgnd_1
XFILLER_83_3 VPWR VGND VPWR VGND sky130_ef_sc_hd__decap_12
XFILLER_160_1351 VGND VGND VPWR VPWR sky130_fd_sc_hd__decap_6
XFILLER_173_921 VPWR VGND VPWR VGND sky130_ef_sc_hd__decap_12
XFILLER_191_217 VGND VGND VPWR VPWR sky130_fd_sc_hd__decap_6
XFILLER_160_1395 VPWR VGND VPWR VGND sky130_ef_sc_hd__decap_12
XFILLER_195_1425 VPWR VGND VPWR VGND sky130_ef_sc_hd__decap_12
XFILLER_121_1379 VGND VGND VPWR VPWR sky130_fd_sc_hd__decap_6
XFILLER_173_965 VPWR VGND VPWR VGND sky130_ef_sc_hd__decap_12
XFILLER_201_1381 VPWR VGND VPWR VGND sky130_ef_sc_hd__decap_12
XFILLER_219_1119 VGND VGND VPWR VPWR sky130_fd_sc_hd__fill_1
XFILLER_172_475 VGND VGND VPWR VPWR sky130_fd_sc_hd__fill_1
XFILLER_195_1469 VPWR VGND VPWR VGND sky130_ef_sc_hd__decap_12
XFILLER_119_1231 VPWR VGND VPWR VGND sky130_ef_sc_hd__decap_12
XFILLER_235_55 VGND VGND VPWR VPWR sky130_fd_sc_hd__fill_1
XPHY_EDGE_ROW_176_Left_431 VGND VGND VPWR VPWR sky130_fd_sc_hd__decap_3
XFILLER_236_1477 VGND VGND VPWR VPWR sky130_fd_sc_hd__decap_6
XFILLER_119_1275 VPWR VGND VPWR VGND sky130_ef_sc_hd__decap_12
XFILLER_154_1177 VPWR VGND VPWR VGND sky130_ef_sc_hd__decap_12
XTAP_TAPCELL_ROW_245_3492 VGND VPWR sky130_fd_sc_hd__tapvpwrvgnd_1
XFILLER_104_15 VPWR VGND VPWR VGND sky130_ef_sc_hd__decap_12
XFILLER_239_281 VPWR VGND VPWR VGND sky130_ef_sc_hd__decap_12
XFILLER_255_741 VPWR VGND VPWR VGND sky130_ef_sc_hd__decap_12
XTAP_TAPCELL_ROW_241_3389 VGND VPWR sky130_fd_sc_hd__tapvpwrvgnd_1
XFILLER_254_251 VGND VGND VPWR VPWR sky130_fd_sc_hd__fill_1
XFILLER_167_1505 VGND VGND VPWR VPWR sky130_fd_sc_hd__decap_6
XFILLER_255_785 VPWR VGND VPWR VGND sky130_ef_sc_hd__decap_12
XFILLER_242_413 VGND VGND VPWR VPWR sky130_fd_sc_hd__decap_6
XFILLER_199_317 VPWR VGND VPWR VGND sky130_ef_sc_hd__decap_12
XFILLER_242_457 VPWR VGND VPWR VGND sky130_ef_sc_hd__decap_12
XFILLER_39_1243 VPWR VGND VPWR VGND sky130_ef_sc_hd__decap_12
XPHY_EDGE_ROW_185_Left_440 VGND VGND VPWR VPWR sky130_fd_sc_hd__decap_3
XFILLER_223_671 VGND VGND VPWR VPWR sky130_fd_sc_hd__fill_1
XFILLER_243_1437 VPWR VGND VPWR VGND sky130_ef_sc_hd__decap_12
XTAP_TAPCELL_ROW_254_3739 VGND VPWR sky130_fd_sc_hd__tapvpwrvgnd_1
XFILLER_165_1273 VPWR VGND VPWR VGND sky130_ef_sc_hd__decap_12
XFILLER_39_1287 VPWR VGND VPWR VGND sky130_ef_sc_hd__decap_12
XFILLER_211_833 VGND VGND VPWR VPWR sky130_fd_sc_hd__decap_6
XTAP_TAPCELL_ROW_35_1_1170 VGND VPWR sky130_fd_sc_hd__tapvpwrvgnd_1
XFILLER_80_29 VPWR VGND VPWR VGND sky130_ef_sc_hd__decap_12
XFILLER_168_737 VPWR VGND VPWR VGND sky130_ef_sc_hd__decap_12
XFILLER_210_321 VPWR VGND VPWR VGND sky130_ef_sc_hd__decap_12
XFILLER_74_1189 VGND VGND VPWR VPWR sky130_fd_sc_hd__fill_1
XFILLER_167_225 VPWR VGND VPWR VGND sky130_ef_sc_hd__decap_12
XFILLER_196_29 VPWR VGND VPWR VGND sky130_ef_sc_hd__decap_12
XFILLER_211_877 VPWR VGND VPWR VGND sky130_ef_sc_hd__decap_12
XFILLER_7_909 VPWR VGND VPWR VGND sky130_ef_sc_hd__decap_12
XFILLER_210_365 VPWR VGND VPWR VGND sky130_ef_sc_hd__decap_12
XFILLER_183_729 VPWR VGND VPWR VGND sky130_ef_sc_hd__decap_12
XTAP_TAPCELL_ROW_123_2_4495 VGND VPWR sky130_fd_sc_hd__tapvpwrvgnd_1
XFILLER_6_419 VGND VGND VPWR VPWR sky130_fd_sc_hd__fill_1
XFILLER_176_781 VPWR VGND VPWR VGND sky130_ef_sc_hd__decap_12
XFILLER_89_27 VPWR VGND VPWR VGND sky130_ef_sc_hd__decap_12
XFILLER_198_1093 VPWR VGND VPWR VGND sky130_ef_sc_hd__decap_12
XFILLER_174_1509 VGND VGND VPWR VPWR sky130_fd_sc_hd__decap_6
XTAP_TAPCELL_ROW_103_2_4371 VGND VPWR sky130_fd_sc_hd__tapvpwrvgnd_1
XFILLER_46_1203 VPWR VGND VPWR VGND sky130_ef_sc_hd__decap_12
XFILLER_1_113 VPWR VGND VPWR VGND sky130_ef_sc_hd__decap_12
XFILLER_137_1331 VPWR VGND VPWR VGND sky130_ef_sc_hd__decap_12
Xmax_cap190 _222_ VGND VGND VPWR VPWR net190 sky130_fd_sc_hd__clkbuf_1
XFILLER_145_55 VGND VGND VPWR VPWR sky130_fd_sc_hd__fill_1
XFILLER_46_1247 VPWR VGND VPWR VGND sky130_ef_sc_hd__decap_12
XTAP_TAPCELL_ROW_71_2_4182 VGND VPWR sky130_fd_sc_hd__tapvpwrvgnd_1
XFILLER_133_1217 VGND VGND VPWR VPWR sky130_fd_sc_hd__fill_1
XPHY_EDGE_ROW_142_2_Left_644 VGND VGND VPWR VPWR sky130_fd_sc_hd__decap_3
XFILLER_219_933 VPWR VGND VPWR VGND sky130_ef_sc_hd__decap_12
XFILLER_218_421 VPWR VGND VPWR VGND sky130_ef_sc_hd__decap_12
XPHY_EDGE_ROW_146_1_Right_802 VGND VGND VPWR VPWR sky130_fd_sc_hd__decap_3
XFILLER_219_977 VPWR VGND VPWR VGND sky130_ef_sc_hd__decap_12
XFILLER_248_1315 VGND VGND VPWR VPWR sky130_fd_sc_hd__fill_1
XFILLER_234_925 VPWR VGND VPWR VGND sky130_ef_sc_hd__decap_12
XPHY_EDGE_ROW_89_2_Right_180 VGND VGND VPWR VPWR sky130_fd_sc_hd__decap_3
XFILLER_245_273 VGND VGND VPWR VPWR sky130_fd_sc_hd__decap_6
XFILLER_2_1341 VPWR VGND VPWR VGND sky130_ef_sc_hd__decap_12
X_513_ net513 net186 net185 net509 VGND VGND VPWR VPWR _264_ sky130_fd_sc_hd__a211o_1
XFILLER_166_1037 VPWR VGND VPWR VGND sky130_ef_sc_hd__decap_12
XFILLER_205_137 VPWR VGND VPWR VGND sky130_ef_sc_hd__decap_12
XFILLER_54_41 VPWR VGND VPWR VGND sky130_ef_sc_hd__decap_12
XFILLER_2_1385 VPWR VGND VPWR VGND sky130_ef_sc_hd__decap_12
XFILLER_57_1343 VPWR VGND VPWR VGND sky130_ef_sc_hd__decap_12
XFILLER_109_1411 VPWR VGND VPWR VGND sky130_ef_sc_hd__decap_12
XFILLER_207_1001 VGND VGND VPWR VPWR sky130_fd_sc_hd__decap_6
XFILLER_246_1061 VPWR VGND VPWR VGND sky130_ef_sc_hd__decap_12
X_444_ net95 _232_ VGND VGND VPWR VPWR _233_ sky130_fd_sc_hd__or2_1
XFILLER_148_1471 VPWR VGND VPWR VGND sky130_ef_sc_hd__decap_12
XFILLER_202_811 VGND VGND VPWR VPWR sky130_fd_sc_hd__fill_1
XTAP_TAPCELL_ROW_82_1_1217 VGND VPWR sky130_fd_sc_hd__tapvpwrvgnd_1
XFILLER_92_1245 VGND VGND VPWR VPWR sky130_fd_sc_hd__fill_1
XFILLER_186_501 VPWR VGND VPWR VGND sky130_ef_sc_hd__decap_12
XFILLER_18_1327 VPWR VGND VPWR VGND sky130_ef_sc_hd__decap_12
XFILLER_199_895 VGND VGND VPWR VPWR sky130_fd_sc_hd__fill_1
XFILLER_207_1045 VPWR VGND VPWR VGND sky130_ef_sc_hd__decap_12
XFILLER_214_693 VGND VGND VPWR VPWR sky130_fd_sc_hd__decap_6
XFILLER_57_1387 VPWR VGND VPWR VGND sky130_ef_sc_hd__decap_12
XFILLER_109_1455 VPWR VGND VPWR VGND sky130_ef_sc_hd__decap_12
XFILLER_213_181 VPWR VGND VPWR VGND sky130_ef_sc_hd__decap_12
X_375_ net592 net550 net577 VGND VGND VPWR VPWR _164_ sky130_fd_sc_hd__and3_1
XFILLER_144_1357 VGND VGND VPWR VPWR sky130_fd_sc_hd__fill_1
XFILLER_186_545 VPWR VGND VPWR VGND sky130_ef_sc_hd__decap_12
XFILLER_207_1089 VPWR VGND VPWR VGND sky130_ef_sc_hd__decap_12
XFILLER_109_1499 VPWR VGND VPWR VGND sky130_ef_sc_hd__decap_12
XTAP_TAPCELL_ROW_28_2_3922 VGND VPWR sky130_fd_sc_hd__tapvpwrvgnd_1
XFILLER_186_589 VPWR VGND VPWR VGND sky130_ef_sc_hd__decap_12
XFILLER_173_217 VGND VGND VPWR VPWR sky130_fd_sc_hd__decap_6
XTAP_TAPCELL_ROW_171_1503 VGND VPWR sky130_fd_sc_hd__tapvpwrvgnd_1
XFILLER_6_920 VGND VGND VPWR VPWR sky130_fd_sc_hd__decap_4
XTAP_TAPCELL_ROW_171_1514 VGND VPWR sky130_fd_sc_hd__tapvpwrvgnd_1
XPHY_EDGE_ROW_156_1_Left_411 VGND VGND VPWR VPWR sky130_fd_sc_hd__decap_3
XFILLER_177_1133 VPWR VGND VPWR VGND sky130_ef_sc_hd__decap_12
XFILLER_181_261 VPWR VGND VPWR VGND sky130_ef_sc_hd__decap_12
XFILLER_177_1177 VPWR VGND VPWR VGND sky130_ef_sc_hd__decap_12
XFILLER_64_1303 VPWR VGND VPWR VGND sky130_ef_sc_hd__decap_12
XFILLER_29_1423 VPWR VGND VPWR VGND sky130_ef_sc_hd__decap_12
XFILLER_5_496 VGND VGND VPWR VPWR sky130_fd_sc_hd__fill_2
XFILLER_253_1021 VPWR VGND VPWR VGND sky130_ef_sc_hd__decap_12
XFILLER_68_1483 VPWR VGND VPWR VGND sky130_ef_sc_hd__decap_12
XFILLER_170_979 VGND VGND VPWR VPWR sky130_fd_sc_hd__fill_1
XFILLER_218_1141 VGND VGND VPWR VPWR sky130_fd_sc_hd__decap_6
XPHY_EDGE_ROW_74_2_Left_576 VGND VGND VPWR VPWR sky130_fd_sc_hd__decap_3
XFILLER_214_1005 VPWR VGND VPWR VGND sky130_ef_sc_hd__decap_12
XFILLER_253_1065 VPWR VGND VPWR VGND sky130_ef_sc_hd__decap_12
XFILLER_29_1467 VPWR VGND VPWR VGND sky130_ef_sc_hd__decap_12
XFILLER_116_1415 VPWR VGND VPWR VGND sky130_ef_sc_hd__decap_12
XTAP_TAPCELL_ROW_169_1443 VGND VPWR sky130_fd_sc_hd__tapvpwrvgnd_1
XFILLER_218_1185 VPWR VGND VPWR VGND sky130_ef_sc_hd__decap_12
XTAP_TAPCELL_ROW_169_1454 VGND VPWR sky130_fd_sc_hd__tapvpwrvgnd_1
XFILLER_155_1497 VGND VGND VPWR VPWR sky130_fd_sc_hd__fill_1
XTAP_TAPCELL_ROW_165_1307 VGND VPWR sky130_fd_sc_hd__tapvpwrvgnd_1
XFILLER_214_1049 VPWR VGND VPWR VGND sky130_ef_sc_hd__decap_12
XTAP_TAPCELL_ROW_165_1318 VGND VPWR sky130_fd_sc_hd__tapvpwrvgnd_1
XTAP_TAPCELL_ROW_165_1329 VGND VPWR sky130_fd_sc_hd__tapvpwrvgnd_1
XFILLER_205_69 VPWR VGND VPWR VGND sky130_ef_sc_hd__decap_12
XFILLER_237_741 VPWR VGND VPWR VGND sky130_ef_sc_hd__decap_12
XTAP_TAPCELL_ROW_160_2_4714 VGND VPWR sky130_fd_sc_hd__tapvpwrvgnd_1
XTAP_TAPCELL_ROW_159_2_4708 VGND VPWR sky130_fd_sc_hd__tapvpwrvgnd_1
XFILLER_237_785 VPWR VGND VPWR VGND sky130_ef_sc_hd__decap_12
XFILLER_236_251 VGND VGND VPWR VPWR sky130_fd_sc_hd__fill_1
XFILLER_149_1213 VGND VGND VPWR VPWR sky130_fd_sc_hd__decap_4
XFILLER_224_413 VGND VGND VPWR VPWR sky130_fd_sc_hd__decap_6
XFILLER_188_1273 VPWR VGND VPWR VGND sky130_ef_sc_hd__decap_12
XFILLER_252_755 VGND VGND VPWR VPWR sky130_fd_sc_hd__fill_1
XFILLER_97_1189 VPWR VGND VPWR VGND sky130_ef_sc_hd__decap_12
XFILLER_221_57 VPWR VGND VPWR VGND sky130_ef_sc_hd__decap_12
XFILLER_224_457 VPWR VGND VPWR VGND sky130_ef_sc_hd__decap_12
XFILLER_240_917 VGND VGND VPWR VPWR sky130_fd_sc_hd__decap_6
XFILLER_225_1101 VPWR VGND VPWR VGND sky130_ef_sc_hd__decap_12
XFILLER_75_1443 VPWR VGND VPWR VGND sky130_ef_sc_hd__decap_12
XFILLER_127_1511 VGND VGND VPWR VPWR sky130_fd_sc_hd__decap_4
XFILLER_196_309 VPWR VGND VPWR VGND sky130_ef_sc_hd__decap_12
XFILLER_205_671 VGND VGND VPWR VPWR sky130_fd_sc_hd__fill_1
XFILLER_229_1281 VGND VGND VPWR VPWR sky130_fd_sc_hd__decap_6
XFILLER_162_1413 VGND VGND VPWR VPWR sky130_fd_sc_hd__fill_1
XFILLER_36_1427 VPWR VGND VPWR VGND sky130_ef_sc_hd__decap_12
XFILLER_189_361 VPWR VGND VPWR VGND sky130_ef_sc_hd__decap_12
XFILLER_225_1145 VPWR VGND VPWR VGND sky130_ef_sc_hd__decap_12
XFILLER_71_1329 VGND VGND VPWR VPWR sky130_fd_sc_hd__fill_1
XFILLER_221_1009 VPWR VGND VPWR VGND sky130_ef_sc_hd__decap_12
XFILLER_225_1189 VPWR VGND VPWR VGND sky130_ef_sc_hd__decap_12
XFILLER_165_729 VPWR VGND VPWR VGND sky130_ef_sc_hd__decap_12
XPHY_EDGE_ROW_88_1_Left_343 VGND VGND VPWR VPWR sky130_fd_sc_hd__decap_3
XTAP_TAPCELL_ROW_234_3193 VGND VPWR sky130_fd_sc_hd__tapvpwrvgnd_1
XFILLER_121_1165 VPWR VGND VPWR VGND sky130_ef_sc_hd__decap_12
XPHY_EDGE_ROW_140_1_Left_395 VGND VGND VPWR VPWR sky130_fd_sc_hd__decap_3
XFILLER_195_1233 VPWR VGND VPWR VGND sky130_ef_sc_hd__decap_12
XFILLER_12_1471 VPWR VGND VPWR VGND sky130_ef_sc_hd__decap_12
XFILLER_246_65 VPWR VGND VPWR VGND sky130_ef_sc_hd__decap_12
XFILLER_191_1119 VGND VGND VPWR VPWR sky130_fd_sc_hd__fill_1
XFILLER_156_1239 VGND VGND VPWR VPWR sky130_fd_sc_hd__decap_6
XTAP_TAPCELL_ROW_247_3543 VGND VPWR sky130_fd_sc_hd__tapvpwrvgnd_1
XFILLER_236_1241 VPWR VGND VPWR VGND sky130_ef_sc_hd__decap_12
XTAP_TAPCELL_ROW_247_3554 VGND VPWR sky130_fd_sc_hd__tapvpwrvgnd_1
XTAP_TAPCELL_ROW_247_3565 VGND VPWR sky130_fd_sc_hd__tapvpwrvgnd_1
XFILLER_5_90 VPWR VGND VPWR VGND sky130_ef_sc_hd__decap_12
XFILLER_8_1005 VPWR VGND VPWR VGND sky130_ef_sc_hd__decap_12
XFILLER_232_1105 VPWR VGND VPWR VGND sky130_ef_sc_hd__decap_12
XFILLER_236_1285 VPWR VGND VPWR VGND sky130_ef_sc_hd__decap_12
XFILLER_247_505 VPWR VGND VPWR VGND sky130_ef_sc_hd__decap_12
XFILLER_82_1469 VGND VGND VPWR VPWR sky130_fd_sc_hd__fill_1
XFILLER_8_1049 VPWR VGND VPWR VGND sky130_ef_sc_hd__decap_12
XFILLER_232_1149 VPWR VGND VPWR VGND sky130_ef_sc_hd__decap_12
XFILLER_115_69 VGND VGND VPWR VPWR sky130_fd_sc_hd__fill_2
XTAP_TAPCELL_ROW_3_934 VGND VPWR sky130_fd_sc_hd__tapvpwrvgnd_1
XTAP_TAPCELL_ROW_3_945 VGND VPWR sky130_fd_sc_hd__tapvpwrvgnd_1
XTAP_TAPCELL_ROW_3_956 VGND VPWR sky130_fd_sc_hd__tapvpwrvgnd_1
XTAP_TAPCELL_ROW_9_1099 VGND VPWR sky130_fd_sc_hd__tapvpwrvgnd_1
XFILLER_132_1283 VPWR VGND VPWR VGND sky130_ef_sc_hd__decap_12
XFILLER_216_925 VPWR VGND VPWR VGND sky130_ef_sc_hd__decap_12
XFILLER_41_1177 VPWR VGND VPWR VGND sky130_ef_sc_hd__decap_12
XFILLER_167_1313 VPWR VGND VPWR VGND sky130_ef_sc_hd__decap_12
XFILLER_227_273 VGND VGND VPWR VPWR sky130_fd_sc_hd__decap_6
XFILLER_242_221 VPWR VGND VPWR VGND sky130_ef_sc_hd__decap_12
XFILLER_131_57 VPWR VGND VPWR VGND sky130_ef_sc_hd__decap_12
XFILLER_199_125 VPWR VGND VPWR VGND sky130_ef_sc_hd__decap_12
XFILLER_167_1357 VPWR VGND VPWR VGND sky130_ef_sc_hd__decap_12
XFILLER_243_777 VGND VGND VPWR VPWR sky130_fd_sc_hd__decap_6
XFILLER_243_1201 VPWR VGND VPWR VGND sky130_ef_sc_hd__decap_12
XFILLER_242_265 VPWR VGND VPWR VGND sky130_ef_sc_hd__decap_12
XFILLER_91_39 VPWR VGND VPWR VGND sky130_ef_sc_hd__decap_12
XFILLER_199_169 VPWR VGND VPWR VGND sky130_ef_sc_hd__decap_12
XFILLER_247_1381 VPWR VGND VPWR VGND sky130_ef_sc_hd__decap_12
XFILLER_168_501 VPWR VGND VPWR VGND sky130_ef_sc_hd__decap_12
XFILLER_243_1245 VPWR VGND VPWR VGND sky130_ef_sc_hd__decap_12
XFILLER_208_1365 VGND VGND VPWR VPWR sky130_fd_sc_hd__decap_6
XFILLER_211_641 VPWR VGND VPWR VGND sky130_ef_sc_hd__decap_12
XFILLER_168_545 VPWR VGND VPWR VGND sky130_ef_sc_hd__decap_12
XTAP_TAPCELL_ROW_14_2_3841 VGND VPWR sky130_fd_sc_hd__tapvpwrvgnd_1
XFILLER_204_1229 VPWR VGND VPWR VGND sky130_ef_sc_hd__decap_12
XFILLER_243_1289 VPWR VGND VPWR VGND sky130_ef_sc_hd__decap_12
XFILLER_211_685 VPWR VGND VPWR VGND sky130_ef_sc_hd__decap_12
Xwire626 net40 VGND VGND VPWR VPWR net626 sky130_fd_sc_hd__buf_1
XFILLER_168_589 VPWR VGND VPWR VGND sky130_ef_sc_hd__decap_12
XFILLER_13_1213 VGND VGND VPWR VPWR sky130_fd_sc_hd__decap_4
Xwire637 net31 VGND VGND VPWR VPWR net637 sky130_fd_sc_hd__buf_1
XTAP_TAPCELL_ROW_143_1_1278 VGND VPWR sky130_fd_sc_hd__tapvpwrvgnd_1
Xwire648 net22 VGND VGND VPWR VPWR net648 sky130_fd_sc_hd__buf_1
XFILLER_210_195 VGND VGND VPWR VPWR sky130_fd_sc_hd__fill_1
XFILLER_52_1295 VGND VGND VPWR VPWR sky130_fd_sc_hd__decap_6
Xwire659 net13 VGND VGND VPWR VPWR net659 sky130_fd_sc_hd__buf_1
XFILLER_183_559 VGND VGND VPWR VPWR sky130_fd_sc_hd__fill_1
XFILLER_100_1227 VPWR VGND VPWR VGND sky130_ef_sc_hd__decap_12
XFILLER_170_209 VPWR VGND VPWR VGND sky130_ef_sc_hd__decap_12
XFILLER_178_1453 VPWR VGND VPWR VGND sky130_ef_sc_hd__decap_12
XFILLER_200_3 VPWR VGND VPWR VGND sky130_ef_sc_hd__decap_12
XFILLER_156_65 VGND VGND VPWR VPWR sky130_fd_sc_hd__decap_6
XFILLER_174_1317 VPWR VGND VPWR VGND sky130_ef_sc_hd__decap_12
XFILLER_178_1497 VPWR VGND VPWR VGND sky130_ef_sc_hd__decap_12
XFILLER_3_945 VGND VGND VPWR VPWR sky130_fd_sc_hd__decap_6
XFILLER_254_1341 VPWR VGND VPWR VGND sky130_ef_sc_hd__decap_12
XFILLER_3_989 VPWR VGND VPWR VGND sky130_ef_sc_hd__decap_12
XFILLER_250_1205 VPWR VGND VPWR VGND sky130_ef_sc_hd__decap_12
XFILLER_2_477 VGND VGND VPWR VPWR sky130_fd_sc_hd__fill_2
XFILLER_215_1325 VPWR VGND VPWR VGND sky130_ef_sc_hd__decap_12
XFILLER_254_1385 VPWR VGND VPWR VGND sky130_ef_sc_hd__decap_12
XFILLER_49_63 VGND VGND VPWR VPWR sky130_fd_sc_hd__decap_8
XFILLER_2_499 VGND VGND VPWR VPWR sky130_fd_sc_hd__fill_1
XFILLER_172_53 VPWR VGND VPWR VGND sky130_ef_sc_hd__decap_12
XFILLER_172_1085 VGND VGND VPWR VPWR sky130_fd_sc_hd__decap_6
XFILLER_215_1369 VPWR VGND VPWR VGND sky130_ef_sc_hd__decap_12
XTAP_TAPCELL_ROW_145_2_4627 VGND VPWR sky130_fd_sc_hd__tapvpwrvgnd_1
XFILLER_219_741 VPWR VGND VPWR VGND sky130_ef_sc_hd__decap_12
XFILLER_172_97 VPWR VGND VPWR VGND sky130_ef_sc_hd__decap_12
XFILLER_111_1323 VGND VGND VPWR VPWR sky130_fd_sc_hd__decap_6
XFILLER_150_1383 VPWR VGND VPWR VGND sky130_ef_sc_hd__decap_12
XFILLER_218_251 VGND VGND VPWR VPWR sky130_fd_sc_hd__fill_1
XFILLER_219_785 VPWR VGND VPWR VGND sky130_ef_sc_hd__decap_12
XFILLER_206_413 VGND VGND VPWR VPWR sky130_fd_sc_hd__decap_6
XFILLER_20_1239 VGND VGND VPWR VPWR sky130_fd_sc_hd__decap_6
XPHY_EDGE_ROW_147_1_Right_803 VGND VGND VPWR VPWR sky130_fd_sc_hd__decap_3
XFILLER_185_1413 VPWR VGND VPWR VGND sky130_ef_sc_hd__decap_12
XFILLER_111_1367 VPWR VGND VPWR VGND sky130_ef_sc_hd__decap_12
XFILLER_234_755 VGND VGND VPWR VPWR sky130_fd_sc_hd__fill_1
XTAP_TAPCELL_ROW_125_2_4503 VGND VPWR sky130_fd_sc_hd__tapvpwrvgnd_1
XFILLER_206_457 VPWR VGND VPWR VGND sky130_ef_sc_hd__decap_12
XFILLER_185_1457 VPWR VGND VPWR VGND sky130_ef_sc_hd__decap_12
XFILLER_222_917 VGND VGND VPWR VPWR sky130_fd_sc_hd__decap_6
XFILLER_221_405 VPWR VGND VPWR VGND sky130_ef_sc_hd__decap_12
XFILLER_178_309 VPWR VGND VPWR VGND sky130_ef_sc_hd__decap_12
XFILLER_226_1421 VGND VGND VPWR VPWR sky130_fd_sc_hd__decap_6
XFILLER_187_821 VPWR VGND VPWR VGND sky130_ef_sc_hd__decap_12
XTAP_TAPCELL_ROW_93_2_4314 VGND VPWR sky130_fd_sc_hd__tapvpwrvgnd_1
XFILLER_221_449 VPWR VGND VPWR VGND sky130_ef_sc_hd__decap_12
X_427_ net594 dout0_q\[22\] net533 VGND VGND VPWR VPWR _216_ sky130_fd_sc_hd__a21oi_1
XFILLER_226_1465 VPWR VGND VPWR VGND sky130_ef_sc_hd__decap_12
XFILLER_230_961 VPWR VGND VPWR VGND sky130_ef_sc_hd__decap_12
XFILLER_187_865 VPWR VGND VPWR VGND sky130_ef_sc_hd__decap_12
XFILLER_144_1165 VPWR VGND VPWR VGND sky130_ef_sc_hd__decap_12
XFILLER_222_1329 VPWR VGND VPWR VGND sky130_ef_sc_hd__decap_12
X_358_ net168 _144_ net135 net134 VGND VGND VPWR VPWR _147_ sky130_fd_sc_hd__o211a_1
XFILLER_70_1351 VGND VGND VPWR VPWR sky130_fd_sc_hd__decap_6
X_289_ net604 net139 VGND VGND VPWR VPWR _081_ sky130_fd_sc_hd__xor2_1
XFILLER_70_1395 VPWR VGND VPWR VGND sky130_ef_sc_hd__decap_12
XFILLER_122_1463 VGND VGND VPWR VPWR sky130_fd_sc_hd__decap_6
XFILLER_31_1379 VGND VGND VPWR VPWR sky130_fd_sc_hd__decap_6
XFILLER_255_1105 VPWR VGND VPWR VGND sky130_ef_sc_hd__decap_12
XFILLER_6_783 VGND VGND VPWR VPWR sky130_fd_sc_hd__decap_8
XFILLER_182_581 VGND VGND VPWR VPWR sky130_fd_sc_hd__decap_6
XFILLER_255_1149 VPWR VGND VPWR VGND sky130_ef_sc_hd__decap_12
XFILLER_46_3 VPWR VGND VPWR VGND sky130_ef_sc_hd__decap_12
XFILLER_29_1231 VPWR VGND VPWR VGND sky130_ef_sc_hd__decap_12
XFILLER_233_1425 VPWR VGND VPWR VGND sky130_ef_sc_hd__decap_12
XFILLER_190_1141 VGND VGND VPWR VPWR sky130_fd_sc_hd__decap_6
XFILLER_29_1275 VPWR VGND VPWR VGND sky130_ef_sc_hd__decap_12
XFILLER_229_505 VPWR VGND VPWR VGND sky130_ef_sc_hd__decap_12
XTAP_TAPCELL_ROW_40_2_3997 VGND VPWR sky130_fd_sc_hd__tapvpwrvgnd_1
XFILLER_64_1177 VPWR VGND VPWR VGND sky130_ef_sc_hd__decap_12
XFILLER_9_1369 VGND VGND VPWR VPWR sky130_fd_sc_hd__decap_3
XFILLER_116_1245 VGND VGND VPWR VPWR sky130_fd_sc_hd__fill_1
XFILLER_233_1469 VPWR VGND VPWR VGND sky130_ef_sc_hd__decap_12
XFILLER_190_1185 VPWR VGND VPWR VGND sky130_ef_sc_hd__decap_12
XFILLER_81_1491 VGND VGND VPWR VPWR sky130_fd_sc_hd__decap_6
Xinput3 wr_addr[1] VGND VGND VPWR VPWR net3 sky130_fd_sc_hd__clkbuf_1
XPHY_EDGE_ROW_3_Left_259 VGND VGND VPWR VPWR sky130_fd_sc_hd__decap_3
XTAP_TAPCELL_ROW_20_2_3873 VGND VPWR sky130_fd_sc_hd__tapvpwrvgnd_1
XFILLER_209_273 VGND VGND VPWR VPWR sky130_fd_sc_hd__decap_6
XTAP_TAPCELL_ROW_19_2_3867 VGND VPWR sky130_fd_sc_hd__tapvpwrvgnd_1
XFILLER_224_221 VPWR VGND VPWR VGND sky130_ef_sc_hd__decap_12
XFILLER_225_777 VGND VGND VPWR VPWR sky130_fd_sc_hd__decap_6
XTAP_TAPCELL_ROW_255_3801 VGND VPWR sky130_fd_sc_hd__tapvpwrvgnd_1
XFILLER_224_265 VPWR VGND VPWR VGND sky130_ef_sc_hd__decap_12
XFILLER_240_725 VPWR VGND VPWR VGND sky130_ef_sc_hd__decap_12
XFILLER_101_27 VPWR VGND VPWR VGND sky130_ef_sc_hd__decap_12
XFILLER_197_629 VPWR VGND VPWR VGND sky130_ef_sc_hd__decap_12
XFILLER_240_769 VPWR VGND VPWR VGND sky130_ef_sc_hd__decap_12
XFILLER_75_1273 VGND VGND VPWR VPWR sky130_fd_sc_hd__fill_1
XFILLER_205_1505 VGND VGND VPWR VPWR sky130_fd_sc_hd__decap_6
XTAP_TAPCELL_ROW_236_3244 VGND VPWR sky130_fd_sc_hd__tapvpwrvgnd_1
XFILLER_196_139 VGND VGND VPWR VPWR sky130_fd_sc_hd__fill_1
XTAP_TAPCELL_ROW_236_3255 VGND VPWR sky130_fd_sc_hd__tapvpwrvgnd_1
XFILLER_240_1429 VPWR VGND VPWR VGND sky130_ef_sc_hd__decap_12
XTAP_TAPCELL_ROW_236_3266 VGND VPWR sky130_fd_sc_hd__tapvpwrvgnd_1
XFILLER_127_1385 VGND VGND VPWR VPWR sky130_fd_sc_hd__fill_1
XFILLER_192_301 VGND VGND VPWR VPWR sky130_fd_sc_hd__decap_6
XTAP_TAPCELL_ROW_138_2_4581 VGND VPWR sky130_fd_sc_hd__tapvpwrvgnd_1
XFILLER_192_345 VPWR VGND VPWR VGND sky130_ef_sc_hd__decap_12
XTAP_TAPCELL_ROW_249_3605 VGND VPWR sky130_fd_sc_hd__tapvpwrvgnd_1
XTAP_TAPCELL_ROW_249_3616 VGND VPWR sky130_fd_sc_hd__tapvpwrvgnd_1
XFILLER_192_389 VPWR VGND VPWR VGND sky130_ef_sc_hd__decap_12
XTAP_TAPCELL_ROW_151_2_4659 VGND VPWR sky130_fd_sc_hd__tapvpwrvgnd_1
XFILLER_195_1063 VGND VGND VPWR VPWR sky130_fd_sc_hd__fill_1
XFILLER_47_1331 VPWR VGND VPWR VGND sky130_ef_sc_hd__decap_12
XFILLER_134_1301 VGND VGND VPWR VPWR sky130_fd_sc_hd__fill_1
XFILLER_0_937 VPWR VGND VPWR VGND sky130_ef_sc_hd__decap_12
XFILLER_248_825 VPWR VGND VPWR VGND sky130_ef_sc_hd__decap_12
XFILLER_236_1093 VPWR VGND VPWR VGND sky130_ef_sc_hd__decap_12
XFILLER_43_1217 VGND VGND VPWR VPWR sky130_fd_sc_hd__fill_1
XFILLER_212_1509 VGND VGND VPWR VPWR sky130_fd_sc_hd__decap_6
XFILLER_247_335 VGND VGND VPWR VPWR sky130_fd_sc_hd__fill_1
XFILLER_248_869 VPWR VGND VPWR VGND sky130_ef_sc_hd__decap_12
XFILLER_19_55 VGND VGND VPWR VPWR sky130_fd_sc_hd__fill_1
XTAP_TAPCELL_ROW_225_2970 VGND VPWR sky130_fd_sc_hd__tapvpwrvgnd_1
XTAP_TAPCELL_ROW_111_2_4422 VGND VPWR sky130_fd_sc_hd__tapvpwrvgnd_1
XFILLER_167_1121 VPWR VGND VPWR VGND sky130_ef_sc_hd__decap_12
XFILLER_243_541 VPWR VGND VPWR VGND sky130_ef_sc_hd__decap_12
XFILLER_216_755 VGND VGND VPWR VPWR sky130_fd_sc_hd__fill_1
XTAP_TAPCELL_ROW_221_2845 VGND VPWR sky130_fd_sc_hd__tapvpwrvgnd_1
XTAP_TAPCELL_ROW_221_2856 VGND VPWR sky130_fd_sc_hd__tapvpwrvgnd_1
XFILLER_204_917 VGND VGND VPWR VPWR sky130_fd_sc_hd__decap_6
XFILLER_203_405 VPWR VGND VPWR VGND sky130_ef_sc_hd__decap_12
XFILLER_243_585 VPWR VGND VPWR VGND sky130_ef_sc_hd__decap_12
XFILLER_35_65 VGND VGND VPWR VPWR sky130_fd_sc_hd__decap_3
XFILLER_19_1411 VPWR VGND VPWR VGND sky130_ef_sc_hd__decap_12
XFILLER_150_3 VPWR VGND VPWR VGND sky130_ef_sc_hd__decap_12
XFILLER_58_1471 VPWR VGND VPWR VGND sky130_ef_sc_hd__decap_12
XFILLER_169_821 VPWR VGND VPWR VGND sky130_ef_sc_hd__decap_12
XFILLER_203_449 VPWR VGND VPWR VGND sky130_ef_sc_hd__decap_12
XFILLER_248_3 VPWR VGND VPWR VGND sky130_ef_sc_hd__decap_12
XFILLER_145_1441 VGND VGND VPWR VPWR sky130_fd_sc_hd__fill_1
XFILLER_19_1455 VPWR VGND VPWR VGND sky130_ef_sc_hd__decap_12
XFILLER_212_961 VPWR VGND VPWR VGND sky130_ef_sc_hd__decap_12
XFILLER_208_1173 VPWR VGND VPWR VGND sky130_ef_sc_hd__decap_12
XFILLER_54_1357 VGND VGND VPWR VPWR sky130_fd_sc_hd__fill_1
XFILLER_169_865 VPWR VGND VPWR VGND sky130_ef_sc_hd__decap_12
XFILLER_180_1365 VGND VGND VPWR VPWR sky130_fd_sc_hd__decap_6
XFILLER_204_1037 VPWR VGND VPWR VGND sky130_ef_sc_hd__decap_12
XFILLER_19_1499 VPWR VGND VPWR VGND sky130_ef_sc_hd__decap_12
Xwire401 net402 VGND VGND VPWR VPWR net401 sky130_fd_sc_hd__clkbuf_1
XFILLER_184_813 VPWR VGND VPWR VGND sky130_ef_sc_hd__decap_12
Xwire412 net413 VGND VGND VPWR VPWR net412 sky130_fd_sc_hd__clkbuf_1
XFILLER_195_161 VGND VGND VPWR VPWR sky130_fd_sc_hd__decap_6
XFILLER_106_1469 VGND VGND VPWR VPWR sky130_fd_sc_hd__fill_1
XTAP_TAPCELL_ROW_219_2785 VGND VPWR sky130_fd_sc_hd__tapvpwrvgnd_1
XTAP_TAPCELL_ROW_58_2_4103 VGND VPWR sky130_fd_sc_hd__tapvpwrvgnd_1
Xwire423 net424 VGND VGND VPWR VPWR net423 sky130_fd_sc_hd__clkbuf_1
Xwire434 net435 VGND VGND VPWR VPWR net434 sky130_fd_sc_hd__clkbuf_1
XTAP_TAPCELL_ROW_219_2796 VGND VPWR sky130_fd_sc_hd__tapvpwrvgnd_1
Xwire445 net446 VGND VGND VPWR VPWR net445 sky130_fd_sc_hd__clkbuf_1
Xwire456 net457 VGND VGND VPWR VPWR net456 sky130_fd_sc_hd__clkbuf_1
Xwire467 net468 VGND VGND VPWR VPWR net467 sky130_fd_sc_hd__clkbuf_1
Xwire478 net479 VGND VGND VPWR VPWR net478 sky130_fd_sc_hd__clkbuf_1
Xwire489 net490 VGND VGND VPWR VPWR net489 sky130_fd_sc_hd__clkbuf_1
XTAP_TAPCELL_ROW_77_1_1212 VGND VPWR sky130_fd_sc_hd__tapvpwrvgnd_1
XFILLER_139_1201 VPWR VGND VPWR VGND sky130_ef_sc_hd__decap_12
XFILLER_171_529 VPWR VGND VPWR VGND sky130_ef_sc_hd__decap_12
XFILLER_178_1261 VPWR VGND VPWR VGND sky130_ef_sc_hd__decap_12
XFILLER_87_1177 VPWR VGND VPWR VGND sky130_ef_sc_hd__decap_12
XFILLER_3_742 VGND VGND VPWR VPWR sky130_fd_sc_hd__fill_2
XFILLER_139_1267 VGND VGND VPWR VPWR sky130_fd_sc_hd__decap_6
XFILLER_174_1147 VGND VGND VPWR VPWR sky130_fd_sc_hd__fill_1
XFILLER_26_1415 VPWR VGND VPWR VGND sky130_ef_sc_hd__decap_12
XFILLER_215_1133 VPWR VGND VPWR VGND sky130_ef_sc_hd__decap_12
XFILLER_250_1035 VGND VGND VPWR VPWR sky130_fd_sc_hd__fill_1
XFILLER_6_1509 VGND VGND VPWR VPWR sky130_fd_sc_hd__decap_6
XFILLER_65_1497 VGND VGND VPWR VPWR sky130_fd_sc_hd__fill_1
XFILLER_215_1177 VPWR VGND VPWR VGND sky130_ef_sc_hd__decap_12
XFILLER_238_357 VGND VGND VPWR VPWR sky130_fd_sc_hd__decap_6
XFILLER_253_305 VPWR VGND VPWR VGND sky130_ef_sc_hd__decap_12
XFILLER_150_1191 VPWR VGND VPWR VGND sky130_ef_sc_hd__decap_12
XPHY_EDGE_ROW_105_2_Left_607 VGND VGND VPWR VPWR sky130_fd_sc_hd__decap_3
XFILLER_202_15 VPWR VGND VPWR VGND sky130_ef_sc_hd__decap_12
XFILLER_253_349 VPWR VGND VPWR VGND sky130_ef_sc_hd__decap_12
XFILLER_59_1213 VGND VGND VPWR VPWR sky130_fd_sc_hd__decap_4
XFILLER_206_221 VPWR VGND VPWR VGND sky130_ef_sc_hd__decap_12
XFILLER_98_1295 VGND VGND VPWR VPWR sky130_fd_sc_hd__decap_6
XPHY_EDGE_ROW_148_1_Right_804 VGND VGND VPWR VPWR sky130_fd_sc_hd__decap_3
XFILLER_207_777 VGND VGND VPWR VPWR sky130_fd_sc_hd__decap_6
XFILLER_206_265 VPWR VGND VPWR VGND sky130_ef_sc_hd__decap_12
XFILLER_222_725 VPWR VGND VPWR VGND sky130_ef_sc_hd__decap_12
XFILLER_146_1227 VPWR VGND VPWR VGND sky130_ef_sc_hd__decap_12
XFILLER_37_1511 VGND VGND VPWR VPWR sky130_fd_sc_hd__decap_4
XFILLER_179_629 VPWR VGND VPWR VGND sky130_ef_sc_hd__decap_12
XFILLER_185_1287 VGND VGND VPWR VPWR sky130_fd_sc_hd__fill_1
XFILLER_72_1413 VGND VGND VPWR VPWR sky130_fd_sc_hd__fill_1
XFILLER_222_769 VPWR VGND VPWR VGND sky130_ef_sc_hd__decap_12
XFILLER_178_139 VGND VGND VPWR VPWR sky130_fd_sc_hd__fill_1
XFILLER_226_1273 VPWR VGND VPWR VGND sky130_ef_sc_hd__decap_12
XFILLER_221_279 VGND VGND VPWR VPWR sky130_fd_sc_hd__fill_1
XFILLER_187_673 VPWR VGND VPWR VGND sky130_ef_sc_hd__decap_12
XFILLER_174_301 VGND VGND VPWR VPWR sky130_fd_sc_hd__decap_6
XTAP_TAPCELL_ROW_231_3130 VGND VPWR sky130_fd_sc_hd__tapvpwrvgnd_1
XFILLER_174_345 VPWR VGND VPWR VGND sky130_ef_sc_hd__decap_12
XFILLER_190_805 VGND VGND VPWR VPWR sky130_fd_sc_hd__decap_6
XFILLER_122_1271 VPWR VGND VPWR VGND sky130_ef_sc_hd__decap_12
XFILLER_31_1165 VPWR VGND VPWR VGND sky130_ef_sc_hd__decap_12
XFILLER_174_389 VPWR VGND VPWR VGND sky130_ef_sc_hd__decap_12
XFILLER_190_849 VPWR VGND VPWR VGND sky130_ef_sc_hd__decap_12
XFILLER_157_1323 VGND VGND VPWR VPWR sky130_fd_sc_hd__decap_6
XFILLER_192_1203 VGND VGND VPWR VPWR sky130_fd_sc_hd__fill_1
XFILLER_66_1239 VGND VGND VPWR VPWR sky130_fd_sc_hd__decap_6
XFILLER_157_1367 VPWR VGND VPWR VGND sky130_ef_sc_hd__decap_12
XTAP_TAPCELL_ROW_116_2_4448 VGND VPWR sky130_fd_sc_hd__tapvpwrvgnd_1
XFILLER_9_1133 VPWR VGND VPWR VGND sky130_ef_sc_hd__decap_12
XTAP_TAPCELL_ROW_229_3070 VGND VPWR sky130_fd_sc_hd__tapvpwrvgnd_1
XFILLER_233_1233 VPWR VGND VPWR VGND sky130_ef_sc_hd__decap_12
XTAP_TAPCELL_ROW_229_3081 VGND VPWR sky130_fd_sc_hd__tapvpwrvgnd_1
XFILLER_243_55 VGND VGND VPWR VPWR sky130_fd_sc_hd__fill_1
XFILLER_9_1177 VPWR VGND VPWR VGND sky130_ef_sc_hd__decap_12
XFILLER_229_335 VGND VGND VPWR VPWR sky130_fd_sc_hd__fill_1
XTAP_TAPCELL_ROW_84_2_4259 VGND VPWR sky130_fd_sc_hd__tapvpwrvgnd_1
XTAP_TAPCELL_ROW_6_1014 VGND VPWR sky130_fd_sc_hd__tapvpwrvgnd_1
XPHY_EDGE_ROW_37_2_Left_539 VGND VGND VPWR VPWR sky130_fd_sc_hd__decap_3
XTAP_TAPCELL_ROW_6_1025 VGND VPWR sky130_fd_sc_hd__tapvpwrvgnd_1
XFILLER_245_839 VGND VGND VPWR VPWR sky130_fd_sc_hd__fill_1
XTAP_TAPCELL_ROW_6_1036 VGND VPWR sky130_fd_sc_hd__tapvpwrvgnd_1
XFILLER_42_1283 VPWR VGND VPWR VGND sky130_ef_sc_hd__decap_12
XFILLER_186_1029 VGND VGND VPWR VPWR sky130_fd_sc_hd__decap_6
XFILLER_112_15 VPWR VGND VPWR VGND sky130_ef_sc_hd__decap_12
XFILLER_168_1441 VPWR VGND VPWR VGND sky130_ef_sc_hd__decap_12
XFILLER_225_541 VPWR VGND VPWR VGND sky130_ef_sc_hd__decap_12
XTAP_TAPCELL_ROW_238_3306 VGND VPWR sky130_fd_sc_hd__tapvpwrvgnd_1
XFILLER_198_905 VPWR VGND VPWR VGND sky130_ef_sc_hd__decap_12
XTAP_TAPCELL_ROW_238_3317 VGND VPWR sky130_fd_sc_hd__tapvpwrvgnd_1
XFILLER_168_1485 VPWR VGND VPWR VGND sky130_ef_sc_hd__decap_12
XFILLER_225_585 VPWR VGND VPWR VGND sky130_ef_sc_hd__decap_12
XFILLER_77_1379 VGND VGND VPWR VPWR sky130_fd_sc_hd__decap_6
XFILLER_164_1327 VPWR VGND VPWR VGND sky130_ef_sc_hd__decap_12
XFILLER_240_533 VPWR VGND VPWR VGND sky130_ef_sc_hd__decap_12
XFILLER_198_949 VPWR VGND VPWR VGND sky130_ef_sc_hd__decap_12
XFILLER_201_909 VPWR VGND VPWR VGND sky130_ef_sc_hd__decap_12
XFILLER_205_1313 VPWR VGND VPWR VGND sky130_ef_sc_hd__decap_12
XFILLER_244_1373 VPWR VGND VPWR VGND sky130_ef_sc_hd__decap_12
XPHY_EDGE_ROW_99_2_Left_601 VGND VGND VPWR VPWR sky130_fd_sc_hd__decap_3
XFILLER_200_419 VGND VGND VPWR VPWR sky130_fd_sc_hd__fill_1
XFILLER_209_1493 VPWR VGND VPWR VGND sky130_ef_sc_hd__decap_12
XFILLER_166_813 VPWR VGND VPWR VGND sky130_ef_sc_hd__decap_12
XFILLER_184_109 VPWR VGND VPWR VGND sky130_ef_sc_hd__decap_12
XFILLER_205_1357 VPWR VGND VPWR VGND sky130_ef_sc_hd__decap_12
XFILLER_177_161 VGND VGND VPWR VPWR sky130_fd_sc_hd__decap_6
XFILLER_240_1259 VGND VGND VPWR VPWR sky130_fd_sc_hd__fill_1
XPHY_EDGE_ROW_151_2_Left_653 VGND VGND VPWR VPWR sky130_fd_sc_hd__decap_3
XPHY_EDGE_ROW_110_1_Right_766 VGND VGND VPWR VPWR sky130_fd_sc_hd__decap_3
XFILLER_193_665 VGND VGND VPWR VPWR sky130_fd_sc_hd__decap_6
XFILLER_101_1311 VPWR VGND VPWR VGND sky130_ef_sc_hd__decap_12
XFILLER_192_153 VPWR VGND VPWR VGND sky130_ef_sc_hd__decap_12
XFILLER_105_1491 VGND VGND VPWR VPWR sky130_fd_sc_hd__decap_6
XFILLER_140_1371 VPWR VGND VPWR VGND sky130_ef_sc_hd__decap_12
XFILLER_165_389 VGND VGND VPWR VPWR sky130_fd_sc_hd__decap_3
XFILLER_10_1227 VPWR VGND VPWR VGND sky130_ef_sc_hd__decap_12
XFILLER_197_1169 VGND VGND VPWR VPWR sky130_fd_sc_hd__decap_6
XTAP_TAPCELL_ROW_214_2660 VGND VPWR sky130_fd_sc_hd__tapvpwrvgnd_1
XFILLER_175_1401 VPWR VGND VPWR VGND sky130_ef_sc_hd__decap_12
XTAP_TAPCELL_ROW_214_2671 VGND VPWR sky130_fd_sc_hd__tapvpwrvgnd_1
XFILLER_101_1355 VPWR VGND VPWR VGND sky130_ef_sc_hd__decap_12
XFILLER_192_197 VPWR VGND VPWR VGND sky130_ef_sc_hd__decap_12
XFILLER_97_27 VPWR VGND VPWR VGND sky130_ef_sc_hd__decap_12
XFILLER_101_1399 VPWR VGND VPWR VGND sky130_ef_sc_hd__decap_12
XTAP_TAPCELL_ROW_210_2546 VGND VPWR sky130_fd_sc_hd__tapvpwrvgnd_1
XFILLER_84_1339 VPWR VGND VPWR VGND sky130_ef_sc_hd__decap_12
XFILLER_136_1407 VGND VGND VPWR VPWR sky130_fd_sc_hd__decap_6
XTAP_TAPCELL_ROW_210_2557 VGND VPWR sky130_fd_sc_hd__tapvpwrvgnd_1
XTAP_TAPCELL_ROW_210_2568 VGND VPWR sky130_fd_sc_hd__tapvpwrvgnd_1
XTAP_TAPCELL_ROW_138_1_1273 VGND VPWR sky130_fd_sc_hd__tapvpwrvgnd_1
XPHY_EDGE_ROW_103_1_Left_358 VGND VGND VPWR VPWR sky130_fd_sc_hd__decap_3
XFILLER_216_1453 VPWR VGND VPWR VGND sky130_ef_sc_hd__decap_12
XFILLER_153_55 VGND VGND VPWR VPWR sky130_fd_sc_hd__fill_1
XFILLER_212_1317 VPWR VGND VPWR VGND sky130_ef_sc_hd__decap_12
XFILLER_198_3 VPWR VGND VPWR VGND sky130_ef_sc_hd__decap_12
XFILLER_216_1497 VPWR VGND VPWR VGND sky130_ef_sc_hd__decap_12
XFILLER_251_1399 VGND VGND VPWR VPWR sky130_fd_sc_hd__fill_1
XTAP_TAPCELL_ROW_223_2907 VGND VPWR sky130_fd_sc_hd__tapvpwrvgnd_1
XFILLER_235_305 VPWR VGND VPWR VGND sky130_ef_sc_hd__decap_12
XTAP_TAPCELL_ROW_223_2918 VGND VPWR sky130_fd_sc_hd__tapvpwrvgnd_1
XFILLER_248_699 VGND VGND VPWR VPWR sky130_fd_sc_hd__fill_1
XFILLER_21_1323 VGND VGND VPWR VPWR sky130_fd_sc_hd__decap_6
XFILLER_60_1383 VPWR VGND VPWR VGND sky130_ef_sc_hd__decap_12
XFILLER_112_1451 VPWR VGND VPWR VGND sky130_ef_sc_hd__decap_12
XTAP_TAPCELL_ROW_208_2497 VGND VPWR sky130_fd_sc_hd__tapvpwrvgnd_1
XFILLER_235_349 VPWR VGND VPWR VGND sky130_ef_sc_hd__decap_12
XFILLER_251_809 VPWR VGND VPWR VGND sky130_ef_sc_hd__decap_12
XFILLER_21_1367 VPWR VGND VPWR VGND sky130_ef_sc_hd__decap_12
XFILLER_244_861 VGND VGND VPWR VPWR sky130_fd_sc_hd__decap_6
XFILLER_210_1085 VGND VGND VPWR VPWR sky130_fd_sc_hd__decap_6
XFILLER_95_1435 VGND VGND VPWR VPWR sky130_fd_sc_hd__decap_6
XFILLER_112_1495 VPWR VGND VPWR VGND sky130_ef_sc_hd__decap_12
Xmax_cap76 _255_ VGND VGND VPWR VPWR net76 sky130_fd_sc_hd__clkbuf_1
Xmax_cap87 _249_ VGND VGND VPWR VPWR net87 sky130_fd_sc_hd__clkbuf_1
XFILLER_204_725 VPWR VGND VPWR VGND sky130_ef_sc_hd__decap_12
Xmax_cap98 _244_ VGND VGND VPWR VPWR net98 sky130_fd_sc_hd__clkbuf_1
XFILLER_95_1479 VPWR VGND VPWR VGND sky130_ef_sc_hd__decap_12
XFILLER_182_1427 VGND VGND VPWR VPWR sky130_fd_sc_hd__fill_1
XFILLER_243_393 VPWR VGND VPWR VGND sky130_ef_sc_hd__decap_12
XFILLER_204_769 VPWR VGND VPWR VGND sky130_ef_sc_hd__decap_12
XFILLER_62_41 VGND VGND VPWR VPWR sky130_fd_sc_hd__decap_8
XFILLER_223_1413 VPWR VGND VPWR VGND sky130_ef_sc_hd__decap_12
XFILLER_203_279 VGND VGND VPWR VPWR sky130_fd_sc_hd__fill_1
XPHY_EDGE_ROW_83_2_Left_585 VGND VGND VPWR VPWR sky130_fd_sc_hd__decap_3
XFILLER_178_41 VPWR VGND VPWR VGND sky130_ef_sc_hd__decap_12
XFILLER_54_1165 VPWR VGND VPWR VGND sky130_ef_sc_hd__decap_12
XFILLER_169_673 VPWR VGND VPWR VGND sky130_ef_sc_hd__decap_12
XFILLER_180_1173 VPWR VGND VPWR VGND sky130_ef_sc_hd__decap_12
XFILLER_223_1457 VPWR VGND VPWR VGND sky130_ef_sc_hd__decap_12
Xwire220 net221 VGND VGND VPWR VPWR net220 sky130_fd_sc_hd__clkbuf_1
XFILLER_178_85 VPWR VGND VPWR VGND sky130_ef_sc_hd__decap_12
Xwire231 net232 VGND VGND VPWR VPWR net231 sky130_fd_sc_hd__clkbuf_1
XFILLER_89_1217 VGND VGND VPWR VPWR sky130_fd_sc_hd__fill_1
XFILLER_184_643 VGND VGND VPWR VPWR sky130_fd_sc_hd__fill_1
Xwire242 net243 VGND VGND VPWR VPWR net242 sky130_fd_sc_hd__clkbuf_1
XFILLER_172_805 VGND VGND VPWR VPWR sky130_fd_sc_hd__decap_6
Xwire253 net254 VGND VGND VPWR VPWR net253 sky130_fd_sc_hd__clkbuf_1
XFILLER_32_1463 VGND VGND VPWR VPWR sky130_fd_sc_hd__decap_6
Xwire264 net265 VGND VGND VPWR VPWR net264 sky130_fd_sc_hd__clkbuf_1
XFILLER_7_69 VPWR VGND VPWR VGND sky130_ef_sc_hd__decap_12
Xwire275 net276 VGND VGND VPWR VPWR net275 sky130_fd_sc_hd__clkbuf_1
Xwire286 net287 VGND VGND VPWR VPWR net286 sky130_fd_sc_hd__clkbuf_1
XFILLER_172_849 VPWR VGND VPWR VGND sky130_ef_sc_hd__decap_12
Xwire297 net298 VGND VGND VPWR VPWR net297 sky130_fd_sc_hd__clkbuf_1
XFILLER_171_337 VPWR VGND VPWR VGND sky130_ef_sc_hd__decap_12
XFILLER_178_1091 VGND VGND VPWR VPWR sky130_fd_sc_hd__fill_1
XTAP_TAPCELL_ROW_102_2_4367 VGND VPWR sky130_fd_sc_hd__tapvpwrvgnd_1
XFILLER_154_1507 VGND VGND VPWR VPWR sky130_fd_sc_hd__decap_8
XFILLER_3_561 VGND VGND VPWR VPWR sky130_fd_sc_hd__fill_1
XFILLER_180_893 VPWR VGND VPWR VGND sky130_ef_sc_hd__decap_12
XTAP_TAPCELL_ROW_189_1980 VGND VPWR sky130_fd_sc_hd__tapvpwrvgnd_1
XTAP_TAPCELL_ROW_189_1991 VGND VPWR sky130_fd_sc_hd__tapvpwrvgnd_1
XFILLER_26_1245 VGND VGND VPWR VPWR sky130_fd_sc_hd__fill_1
XFILLER_6_1317 VPWR VGND VPWR VGND sky130_ef_sc_hd__decap_12
XFILLER_238_121 VPWR VGND VPWR VGND sky130_ef_sc_hd__decap_12
XTAP_TAPCELL_ROW_185_1877 VGND VPWR sky130_fd_sc_hd__tapvpwrvgnd_1
XFILLER_238_165 VPWR VGND VPWR VGND sky130_ef_sc_hd__decap_12
XTAP_TAPCELL_ROW_185_1888 VGND VPWR sky130_fd_sc_hd__tapvpwrvgnd_1
XFILLER_227_839 VGND VGND VPWR VPWR sky130_fd_sc_hd__fill_1
XFILLER_254_625 VPWR VGND VPWR VGND sky130_ef_sc_hd__decap_12
XFILLER_253_113 VPWR VGND VPWR VGND sky130_ef_sc_hd__decap_12
XPHY_EDGE_ROW_97_1_Left_352 VGND VGND VPWR VPWR sky130_fd_sc_hd__decap_3
XFILLER_213_69 VPWR VGND VPWR VGND sky130_ef_sc_hd__decap_12
XTAP_TAPCELL_ROW_50_2_4054 VGND VPWR sky130_fd_sc_hd__tapvpwrvgnd_1
XFILLER_254_669 VPWR VGND VPWR VGND sky130_ef_sc_hd__decap_12
XFILLER_207_541 VPWR VGND VPWR VGND sky130_ef_sc_hd__decap_12
XTAP_TAPCELL_ROW_49_2_4048 VGND VPWR sky130_fd_sc_hd__tapvpwrvgnd_1
XFILLER_4_1085 VGND VGND VPWR VPWR sky130_fd_sc_hd__decap_6
XFILLER_207_585 VPWR VGND VPWR VGND sky130_ef_sc_hd__decap_12
XPHY_EDGE_ROW_149_1_Right_805 VGND VGND VPWR VPWR sky130_fd_sc_hd__decap_3
XFILLER_222_533 VPWR VGND VPWR VGND sky130_ef_sc_hd__decap_12
XFILLER_241_1513 VGND VGND VPWR VPWR sky130_fd_sc_hd__fill_2
XFILLER_166_109 VPWR VGND VPWR VGND sky130_ef_sc_hd__decap_12
XFILLER_37_1385 VGND VGND VPWR VPWR sky130_fd_sc_hd__fill_1
XFILLER_188_993 VPWR VGND VPWR VGND sky130_ef_sc_hd__decap_12
XTAP_TAPCELL_ROW_27_2_3918 VGND VPWR sky130_fd_sc_hd__tapvpwrvgnd_1
XFILLER_175_665 VGND VGND VPWR VPWR sky130_fd_sc_hd__decap_6
XFILLER_174_153 VPWR VGND VPWR VGND sky130_ef_sc_hd__decap_12
XFILLER_190_613 VPWR VGND VPWR VGND sky130_ef_sc_hd__decap_12
XFILLER_194_1309 VGND VGND VPWR VPWR sky130_fd_sc_hd__decap_6
XFILLER_238_77 VGND VGND VPWR VPWR sky130_fd_sc_hd__decap_6
Xmax_cap520 net521 VGND VGND VPWR VPWR net520 sky130_fd_sc_hd__clkbuf_1
XFILLER_174_197 VPWR VGND VPWR VGND sky130_ef_sc_hd__decap_12
Xmax_cap531 net59 VGND VGND VPWR VPWR net531 sky130_fd_sc_hd__clkbuf_1
XFILLER_190_657 VPWR VGND VPWR VGND sky130_ef_sc_hd__decap_12
Xmax_cap564 net65 VGND VGND VPWR VPWR net564 sky130_fd_sc_hd__clkbuf_1
XFILLER_107_15 VPWR VGND VPWR VGND sky130_ef_sc_hd__decap_12
XTAP_TAPCELL_ROW_227_3007 VGND VPWR sky130_fd_sc_hd__tapvpwrvgnd_1
XTAP_TAPCELL_ROW_227_3018 VGND VPWR sky130_fd_sc_hd__tapvpwrvgnd_1
XFILLER_254_65 VPWR VGND VPWR VGND sky130_ef_sc_hd__decap_12
XFILLER_44_1301 VGND VGND VPWR VPWR sky130_fd_sc_hd__fill_1
XFILLER_233_1063 VGND VGND VPWR VPWR sky130_fd_sc_hd__fill_1
XTAP_TAPCELL_ROW_146_2_4632 VGND VPWR sky130_fd_sc_hd__tapvpwrvgnd_1
XFILLER_170_1353 VPWR VGND VPWR VGND sky130_ef_sc_hd__decap_12
XFILLER_217_305 VPWR VGND VPWR VGND sky130_ef_sc_hd__decap_12
XFILLER_170_1397 VPWR VGND VPWR VGND sky130_ef_sc_hd__decap_12
XFILLER_123_69 VGND VGND VPWR VPWR sky130_fd_sc_hd__fill_2
XFILLER_217_349 VPWR VGND VPWR VGND sky130_ef_sc_hd__decap_12
XFILLER_233_809 VPWR VGND VPWR VGND sky130_ef_sc_hd__decap_12
XFILLER_226_861 VGND VGND VPWR VPWR sky130_fd_sc_hd__decap_6
XFILLER_198_713 VPWR VGND VPWR VGND sky130_ef_sc_hd__decap_12
XTAP_TAPCELL_ROW_203_2361 VGND VPWR sky130_fd_sc_hd__tapvpwrvgnd_1
XFILLER_77_1165 VPWR VGND VPWR VGND sky130_ef_sc_hd__decap_12
XTAP_TAPCELL_ROW_203_2372 VGND VPWR sky130_fd_sc_hd__tapvpwrvgnd_1
XFILLER_225_393 VPWR VGND VPWR VGND sky130_ef_sc_hd__decap_12
XFILLER_241_853 VPWR VGND VPWR VGND sky130_ef_sc_hd__decap_12
XPHY_EDGE_ROW_0_Right_0 VGND VGND VPWR VPWR sky130_fd_sc_hd__decap_3
XFILLER_129_1255 VPWR VGND VPWR VGND sky130_ef_sc_hd__decap_12
XFILLER_197_223 VGND VGND VPWR VPWR sky130_fd_sc_hd__fill_1
XFILLER_198_757 VPWR VGND VPWR VGND sky130_ef_sc_hd__decap_12
XTAP_TAPCELL_ROW_195_2140 VGND VPWR sky130_fd_sc_hd__tapvpwrvgnd_1
XFILLER_240_363 VGND VGND VPWR VPWR sky130_fd_sc_hd__fill_1
XFILLER_55_1441 VGND VGND VPWR VPWR sky130_fd_sc_hd__fill_1
XTAP_TAPCELL_ROW_195_2151 VGND VPWR sky130_fd_sc_hd__tapvpwrvgnd_1
XFILLER_241_897 VPWR VGND VPWR VGND sky130_ef_sc_hd__decap_12
XFILLER_129_1299 VPWR VGND VPWR VGND sky130_ef_sc_hd__decap_12
XTAP_TAPCELL_ROW_195_2162 VGND VPWR sky130_fd_sc_hd__tapvpwrvgnd_1
XFILLER_205_1121 VPWR VGND VPWR VGND sky130_ef_sc_hd__decap_12
XFILLER_185_429 VPWR VGND VPWR VGND sky130_ef_sc_hd__decap_12
XFILLER_181_1493 VPWR VGND VPWR VGND sky130_ef_sc_hd__decap_12
XTAP_TAPCELL_ROW_191_2037 VGND VPWR sky130_fd_sc_hd__tapvpwrvgnd_1
XTAP_TAPCELL_ROW_216_2711 VGND VPWR sky130_fd_sc_hd__tapvpwrvgnd_1
XTAP_TAPCELL_ROW_191_2048 VGND VPWR sky130_fd_sc_hd__tapvpwrvgnd_1
XTAP_TAPCELL_ROW_216_2722 VGND VPWR sky130_fd_sc_hd__tapvpwrvgnd_1
XFILLER_166_643 VGND VGND VPWR VPWR sky130_fd_sc_hd__fill_1
XFILLER_201_1007 VGND VGND VPWR VPWR sky130_fd_sc_hd__fill_1
XFILLER_16_1469 VGND VGND VPWR VPWR sky130_fd_sc_hd__fill_1
XFILLER_165_153 VPWR VGND VPWR VGND sky130_ef_sc_hd__decap_12
XTAP_TAPCELL_ROW_212_2608 VGND VPWR sky130_fd_sc_hd__tapvpwrvgnd_1
XFILLER_193_473 VPWR VGND VPWR VGND sky130_ef_sc_hd__decap_12
XTAP_TAPCELL_ROW_212_2619 VGND VPWR sky130_fd_sc_hd__tapvpwrvgnd_1
XPHY_EDGE_ROW_111_1_Right_767 VGND VGND VPWR VPWR sky130_fd_sc_hd__decap_3
XFILLER_113_3 VPWR VGND VPWR VGND sky130_ef_sc_hd__decap_12
XFILLER_49_1201 VPWR VGND VPWR VGND sky130_ef_sc_hd__decap_12
XFILLER_165_197 VPWR VGND VPWR VGND sky130_ef_sc_hd__decap_12
XFILLER_4_336 VGND VGND VPWR VPWR sky130_fd_sc_hd__fill_1
XFILLER_88_1283 VPWR VGND VPWR VGND sky130_ef_sc_hd__decap_12
XFILLER_175_1231 VGND VGND VPWR VPWR sky130_fd_sc_hd__fill_1
XFILLER_49_1267 VGND VGND VPWR VPWR sky130_fd_sc_hd__decap_6
XFILLER_136_1215 VPWR VGND VPWR VGND sky130_ef_sc_hd__decap_12
XFILLER_180_189 VGND VGND VPWR VPWR sky130_fd_sc_hd__decap_6
XFILLER_164_65 VGND VGND VPWR VPWR sky130_fd_sc_hd__decap_6
XFILLER_136_1259 VPWR VGND VPWR VGND sky130_ef_sc_hd__decap_12
XFILLER_216_1261 VPWR VGND VPWR VGND sky130_ef_sc_hd__decap_12
XFILLER_249_953 VPWR VGND VPWR VGND sky130_ef_sc_hd__decap_12
XFILLER_212_1147 VGND VGND VPWR VPWR sky130_fd_sc_hd__fill_1
XFILLER_236_625 VPWR VGND VPWR VGND sky130_ef_sc_hd__decap_12
XFILLER_209_839 VGND VGND VPWR VPWR sky130_fd_sc_hd__fill_1
XFILLER_235_113 VPWR VGND VPWR VGND sky130_ef_sc_hd__decap_12
XFILLER_180_53 VPWR VGND VPWR VGND sky130_ef_sc_hd__decap_12
XFILLER_236_669 VPWR VGND VPWR VGND sky130_ef_sc_hd__decap_12
XFILLER_60_1191 VPWR VGND VPWR VGND sky130_ef_sc_hd__decap_12
XFILLER_1_1225 VGND VGND VPWR VPWR sky130_fd_sc_hd__decap_6
XFILLER_169_1057 VGND VGND VPWR VPWR sky130_fd_sc_hd__decap_6
XFILLER_180_97 VPWR VGND VPWR VGND sky130_ef_sc_hd__decap_12
XTAP_TAPCELL_ROW_180_1741 VGND VPWR sky130_fd_sc_hd__tapvpwrvgnd_1
XFILLER_251_617 VPWR VGND VPWR VGND sky130_ef_sc_hd__decap_12
XTAP_TAPCELL_ROW_180_1752 VGND VPWR sky130_fd_sc_hd__tapvpwrvgnd_1
XFILLER_95_1243 VPWR VGND VPWR VGND sky130_ef_sc_hd__decap_12
XFILLER_147_1311 VPWR VGND VPWR VGND sky130_ef_sc_hd__decap_12
XFILLER_1_1269 VPWR VGND VPWR VGND sky130_ef_sc_hd__decap_12
XFILLER_73_51 VGND VGND VPWR VPWR sky130_fd_sc_hd__decap_4
XFILLER_186_1371 VGND VGND VPWR VPWR sky130_fd_sc_hd__fill_1
XFILLER_204_533 VPWR VGND VPWR VGND sky130_ef_sc_hd__decap_12
XFILLER_56_1227 VPWR VGND VPWR VGND sky130_ef_sc_hd__decap_12
XFILLER_95_1287 VPWR VGND VPWR VGND sky130_ef_sc_hd__decap_12
XFILLER_147_1355 VPWR VGND VPWR VGND sky130_ef_sc_hd__decap_12
XFILLER_189_51 VGND VGND VPWR VPWR sky130_fd_sc_hd__decap_4
XFILLER_188_245 VGND VGND VPWR VPWR sky130_fd_sc_hd__decap_6
XFILLER_108_1339 VPWR VGND VPWR VGND sky130_ef_sc_hd__decap_12
XFILLER_143_1219 VPWR VGND VPWR VGND sky130_ef_sc_hd__decap_12
XFILLER_147_1399 VPWR VGND VPWR VGND sky130_ef_sc_hd__decap_12
XFILLER_231_385 VGND VGND VPWR VPWR sky130_fd_sc_hd__decap_6
XFILLER_188_289 VPWR VGND VPWR VGND sky130_ef_sc_hd__decap_12
XTAP_TAPCELL_ROW_178_1681 VGND VPWR sky130_fd_sc_hd__tapvpwrvgnd_1
XTAP_TAPCELL_ROW_178_1692 VGND VPWR sky130_fd_sc_hd__tapvpwrvgnd_1
XFILLER_8_642 VGND VGND VPWR VPWR sky130_fd_sc_hd__fill_2
XFILLER_223_1287 VGND VGND VPWR VPWR sky130_fd_sc_hd__fill_1
XFILLER_172_613 VPWR VGND VPWR VGND sky130_ef_sc_hd__decap_12
XTAP_TAPCELL_ROW_174_1578 VGND VPWR sky130_fd_sc_hd__tapvpwrvgnd_1
XFILLER_32_1271 VPWR VGND VPWR VGND sky130_ef_sc_hd__decap_12
XTAP_TAPCELL_ROW_174_1589 VGND VPWR sky130_fd_sc_hd__tapvpwrvgnd_1
XFILLER_176_1017 VPWR VGND VPWR VGND sky130_ef_sc_hd__decap_12
XTAP_TAPCELL_ROW_152_2_4664 VGND VPWR sky130_fd_sc_hd__tapvpwrvgnd_1
XFILLER_172_657 VPWR VGND VPWR VGND sky130_ef_sc_hd__decap_12
XFILLER_67_1323 VGND VGND VPWR VPWR sky130_fd_sc_hd__decap_6
XFILLER_158_1451 VPWR VGND VPWR VGND sky130_ef_sc_hd__decap_12
XFILLER_171_167 VGND VGND VPWR VPWR sky130_fd_sc_hd__fill_1
XFILLER_67_1367 VPWR VGND VPWR VGND sky130_ef_sc_hd__decap_12
XFILLER_119_1435 VGND VGND VPWR VPWR sky130_fd_sc_hd__decap_6
XFILLER_154_1315 VPWR VGND VPWR VGND sky130_ef_sc_hd__decap_12
XFILLER_158_1495 VPWR VGND VPWR VGND sky130_ef_sc_hd__decap_12
XTAP_TAPCELL_ROW_187_1928 VGND VPWR sky130_fd_sc_hd__tapvpwrvgnd_1
XTAP_TAPCELL_ROW_187_1939 VGND VPWR sky130_fd_sc_hd__tapvpwrvgnd_1
XFILLER_119_1479 VPWR VGND VPWR VGND sky130_ef_sc_hd__decap_12
XFILLER_154_1359 VPWR VGND VPWR VGND sky130_ef_sc_hd__decap_12
XFILLER_230_1203 VGND VGND VPWR VPWR sky130_fd_sc_hd__fill_1
XFILLER_239_441 VGND VGND VPWR VPWR sky130_fd_sc_hd__decap_6
XFILLER_6_1147 VGND VGND VPWR VPWR sky130_fd_sc_hd__fill_1
XFILLER_239_485 VPWR VGND VPWR VGND sky130_ef_sc_hd__decap_12
XFILLER_187_1113 VGND VGND VPWR VPWR sky130_fd_sc_hd__decap_6
XFILLER_254_433 VPWR VGND VPWR VGND sky130_ef_sc_hd__decap_12
XFILLER_215_809 VPWR VGND VPWR VGND sky130_ef_sc_hd__decap_12
XFILLER_208_861 VGND VGND VPWR VPWR sky130_fd_sc_hd__decap_6
XFILLER_254_477 VPWR VGND VPWR VGND sky130_ef_sc_hd__decap_12
XFILLER_187_1157 VPWR VGND VPWR VGND sky130_ef_sc_hd__decap_12
XFILLER_241_105 VGND VGND VPWR VPWR sky130_fd_sc_hd__decap_6
XFILLER_78_1463 VGND VGND VPWR VPWR sky130_fd_sc_hd__decap_6
XFILLER_207_393 VPWR VGND VPWR VGND sky130_ef_sc_hd__decap_12
XFILLER_241_149 VPWR VGND VPWR VGND sky130_ef_sc_hd__decap_12
XFILLER_74_1327 VPWR VGND VPWR VGND sky130_ef_sc_hd__decap_12
XFILLER_223_853 VPWR VGND VPWR VGND sky130_ef_sc_hd__decap_12
XFILLER_179_223 VGND VGND VPWR VPWR sky130_fd_sc_hd__fill_1
XFILLER_222_363 VGND VGND VPWR VPWR sky130_fd_sc_hd__fill_1
XFILLER_126_1439 VPWR VGND VPWR VGND sky130_ef_sc_hd__decap_12
XFILLER_223_897 VPWR VGND VPWR VGND sky130_ef_sc_hd__decap_12
XFILLER_224_1029 VGND VGND VPWR VPWR sky130_fd_sc_hd__decap_6
XFILLER_195_727 VGND VGND VPWR VPWR sky130_fd_sc_hd__fill_1
XFILLER_210_525 VGND VGND VPWR VPWR sky130_fd_sc_hd__decap_6
XFILLER_206_1441 VPWR VGND VPWR VGND sky130_ef_sc_hd__decap_12
XFILLER_167_429 VPWR VGND VPWR VGND sky130_ef_sc_hd__decap_12
XFILLER_241_1343 VGND VGND VPWR VPWR sky130_fd_sc_hd__fill_1
XFILLER_210_569 VPWR VGND VPWR VGND sky130_ef_sc_hd__decap_12
XFILLER_206_1485 VPWR VGND VPWR VGND sky130_ef_sc_hd__decap_12
XTAP_TAPCELL_ROW_252_3678 VGND VPWR sky130_fd_sc_hd__tapvpwrvgnd_1
XTAP_TAPCELL_ROW_252_3689 VGND VPWR sky130_fd_sc_hd__tapvpwrvgnd_1
XFILLER_175_473 VPWR VGND VPWR VGND sky130_ef_sc_hd__decap_12
XFILLER_198_1253 VGND VGND VPWR VPWR sky130_fd_sc_hd__decap_6
XFILLER_11_1311 VPWR VGND VPWR VGND sky130_ef_sc_hd__decap_12
XFILLER_191_933 VPWR VGND VPWR VGND sky130_ef_sc_hd__decap_12
XFILLER_50_1371 VPWR VGND VPWR VGND sky130_ef_sc_hd__decap_12
XFILLER_15_1491 VGND VGND VPWR VPWR sky130_fd_sc_hd__decap_6
XFILLER_190_421 VPWR VGND VPWR VGND sky130_ef_sc_hd__decap_12
XFILLER_194_1117 VPWR VGND VPWR VGND sky130_ef_sc_hd__decap_12
XFILLER_198_1297 VPWR VGND VPWR VGND sky130_ef_sc_hd__decap_12
XFILLER_11_1355 VPWR VGND VPWR VGND sky130_ef_sc_hd__decap_12
XFILLER_191_977 VPWR VGND VPWR VGND sky130_ef_sc_hd__decap_12
XFILLER_85_1423 VPWR VGND VPWR VGND sky130_ef_sc_hd__decap_12
XFILLER_102_1483 VPWR VGND VPWR VGND sky130_ef_sc_hd__decap_12
XFILLER_200_1073 VPWR VGND VPWR VGND sky130_ef_sc_hd__decap_12
XFILLER_78_29 VPWR VGND VPWR VGND sky130_ef_sc_hd__decap_12
XFILLER_46_1407 VGND VGND VPWR VPWR sky130_fd_sc_hd__decap_6
XFILLER_11_1399 VPWR VGND VPWR VGND sky130_ef_sc_hd__decap_12
XFILLER_85_1467 VPWR VGND VPWR VGND sky130_ef_sc_hd__decap_12
XFILLER_249_205 VPWR VGND VPWR VGND sky130_ef_sc_hd__decap_12
XFILLER_235_1169 VGND VGND VPWR VPWR sky130_fd_sc_hd__decap_6
XFILLER_213_1401 VPWR VGND VPWR VGND sky130_ef_sc_hd__decap_12
XFILLER_249_249 VPWR VGND VPWR VGND sky130_ef_sc_hd__decap_12
XFILLER_252_1483 VGND VGND VPWR VPWR sky130_fd_sc_hd__fill_1
XFILLER_170_1161 VPWR VGND VPWR VGND sky130_ef_sc_hd__decap_12
XFILLER_246_923 VGND VGND VPWR VPWR sky130_fd_sc_hd__fill_1
XFILLER_218_625 VPWR VGND VPWR VGND sky130_ef_sc_hd__decap_12
XTAP_TAPCELL_ROW_205_2412 VGND VPWR sky130_fd_sc_hd__tapvpwrvgnd_1
XFILLER_217_113 VPWR VGND VPWR VGND sky130_ef_sc_hd__decap_12
XTAP_TAPCELL_ROW_205_2423 VGND VPWR sky130_fd_sc_hd__tapvpwrvgnd_1
XFILLER_22_1451 VPWR VGND VPWR VGND sky130_ef_sc_hd__decap_12
XFILLER_218_669 VPWR VGND VPWR VGND sky130_ef_sc_hd__decap_12
XFILLER_131_1189 VPWR VGND VPWR VGND sky130_ef_sc_hd__decap_12
XFILLER_27_55 VGND VGND VPWR VPWR sky130_fd_sc_hd__fill_1
XFILLER_233_617 VPWR VGND VPWR VGND sky130_ef_sc_hd__decap_12
XTAP_TAPCELL_ROW_201_2309 VGND VPWR sky130_fd_sc_hd__tapvpwrvgnd_1
XTAP_TAPCELL_ROW_197_2202 VGND VPWR sky130_fd_sc_hd__tapvpwrvgnd_1
XFILLER_22_1495 VPWR VGND VPWR VGND sky130_ef_sc_hd__decap_12
XTAP_TAPCELL_ROW_197_2213 VGND VPWR sky130_fd_sc_hd__tapvpwrvgnd_1
X_460_ net606 net8 net42 VGND VGND VPWR VPWR addr0\[6\] sky130_fd_sc_hd__mux2_1
XFILLER_183_1511 VGND VGND VPWR VPWR sky130_fd_sc_hd__fill_1
XTAP_TAPCELL_ROW_1_884 VGND VPWR sky130_fd_sc_hd__tapvpwrvgnd_1
XTAP_TAPCELL_ROW_1_895 VGND VPWR sky130_fd_sc_hd__tapvpwrvgnd_1
XFILLER_92_1427 VPWR VGND VPWR VGND sky130_ef_sc_hd__decap_12
X_391_ net208 net207 VGND VGND VPWR VPWR _180_ sky130_fd_sc_hd__nor2_1
XFILLER_201_503 VGND VGND VPWR VPWR sky130_fd_sc_hd__fill_1
XFILLER_242_1129 VPWR VGND VPWR VGND sky130_ef_sc_hd__decap_12
XFILLER_198_587 VGND VGND VPWR VPWR sky130_fd_sc_hd__fill_1
XFILLER_213_385 VGND VGND VPWR VPWR sky130_fd_sc_hd__decap_6
XFILLER_43_65 VGND VGND VPWR VPWR sky130_fd_sc_hd__decap_6
XFILLER_9_417 VGND VGND VPWR VPWR sky130_fd_sc_hd__decap_3
XFILLER_186_749 VGND VGND VPWR VPWR sky130_fd_sc_hd__decap_6
XFILLER_230_3 VPWR VGND VPWR VGND sky130_ef_sc_hd__decap_12
XFILLER_185_237 VPWR VGND VPWR VGND sky130_ef_sc_hd__decap_12
XFILLER_220_1427 VGND VGND VPWR VPWR sky130_fd_sc_hd__fill_1
XTAP_TAPCELL_ROW_137_2_4577 VGND VPWR sky130_fd_sc_hd__tapvpwrvgnd_1
XFILLER_194_793 VPWR VGND VPWR VGND sky130_ef_sc_hd__decap_12
XPHY_EDGE_ROW_253_Left_508 VGND VGND VPWR VPWR sky130_fd_sc_hd__decap_3
XFILLER_5_623 VGND VGND VPWR VPWR sky130_fd_sc_hd__fill_1
XFILLER_193_281 VPWR VGND VPWR VGND sky130_ef_sc_hd__decap_12
XFILLER_4_100 VPWR VGND VPWR VGND sky130_ef_sc_hd__decap_12
XFILLER_177_1337 VGND VGND VPWR VPWR sky130_fd_sc_hd__decap_6
XPHY_EDGE_ROW_112_1_Right_768 VGND VGND VPWR VPWR sky130_fd_sc_hd__decap_3
XFILLER_5_667 VGND VGND VPWR VPWR sky130_fd_sc_hd__fill_2
XPHY_EDGE_ROW_114_2_Left_616 VGND VGND VPWR VPWR sky130_fd_sc_hd__decap_3
XFILLER_64_1507 VGND VGND VPWR VPWR sky130_fd_sc_hd__decap_8
XFILLER_253_1225 VGND VGND VPWR VPWR sky130_fd_sc_hd__decap_6
XFILLER_253_1269 VPWR VGND VPWR VGND sky130_ef_sc_hd__decap_12
XFILLER_7_1401 VPWR VGND VPWR VGND sky130_ef_sc_hd__decap_12
XTAP_TAPCELL_ROW_85_2_4264 VGND VPWR sky130_fd_sc_hd__tapvpwrvgnd_1
XFILLER_249_783 VGND VGND VPWR VPWR sky130_fd_sc_hd__fill_1
XTAP_TAPCELL_ROW_182_1803 VGND VPWR sky130_fd_sc_hd__tapvpwrvgnd_1
XFILLER_216_1091 VGND VGND VPWR VPWR sky130_fd_sc_hd__fill_1
XFILLER_237_945 VGND VGND VPWR VPWR sky130_fd_sc_hd__decap_6
XTAP_TAPCELL_ROW_167_1382 VGND VPWR sky130_fd_sc_hd__tapvpwrvgnd_1
XFILLER_236_433 VPWR VGND VPWR VGND sky130_ef_sc_hd__decap_12
XTAP_TAPCELL_ROW_167_1393 VGND VPWR sky130_fd_sc_hd__tapvpwrvgnd_1
XFILLER_237_989 VPWR VGND VPWR VGND sky130_ef_sc_hd__decap_12
XFILLER_247_1007 VGND VGND VPWR VPWR sky130_fd_sc_hd__fill_1
XFILLER_236_477 VPWR VGND VPWR VGND sky130_ef_sc_hd__decap_12
XFILLER_252_937 VPWR VGND VPWR VGND sky130_ef_sc_hd__decap_12
XFILLER_188_1477 VGND VGND VPWR VPWR sky130_fd_sc_hd__decap_6
XFILLER_223_105 VGND VGND VPWR VPWR sky130_fd_sc_hd__decap_6
XFILLER_1_1033 VPWR VGND VPWR VGND sky130_ef_sc_hd__decap_12
X_658_ clknet_3_4__leaf_clk acc_core.adder.cla_blocks\[6\].block.sum\[0\] _066_ VGND
+ VGND VPWR VPWR net59 sky130_fd_sc_hd__dfrtp_1
XFILLER_251_447 VGND VGND VPWR VPWR sky130_fd_sc_hd__fill_1
XFILLER_210_15 VPWR VGND VPWR VGND sky130_ef_sc_hd__decap_12
XFILLER_223_149 VPWR VGND VPWR VGND sky130_ef_sc_hd__decap_12
XFILLER_1_1077 VPWR VGND VPWR VGND sky130_ef_sc_hd__decap_12
XFILLER_205_853 VPWR VGND VPWR VGND sky130_ef_sc_hd__decap_12
X_589_ net670 VGND VGND VPWR VPWR _071_ sky130_fd_sc_hd__inv_2
XFILLER_204_363 VGND VGND VPWR VPWR sky130_fd_sc_hd__fill_1
XFILLER_205_897 VPWR VGND VPWR VGND sky130_ef_sc_hd__decap_12
XFILLER_177_727 VGND VGND VPWR VPWR sky130_fd_sc_hd__fill_1
XTAP_TAPCELL_ROW_176_1629 VGND VPWR sky130_fd_sc_hd__tapvpwrvgnd_1
XFILLER_220_867 VGND VGND VPWR VPWR sky130_fd_sc_hd__fill_1
XFILLER_231_193 VPWR VGND VPWR VGND sky130_ef_sc_hd__decap_12
XTAP_TAPCELL_ROW_161_1_1296 VGND VPWR sky130_fd_sc_hd__tapvpwrvgnd_1
XPHY_EDGE_ROW_74_1_Right_730 VGND VGND VPWR VPWR sky130_fd_sc_hd__decap_3
XFILLER_76_3 VPWR VGND VPWR VGND sky130_ef_sc_hd__decap_12
XFILLER_173_933 VPWR VGND VPWR VGND sky130_ef_sc_hd__decap_12
XFILLER_219_57 VPWR VGND VPWR VGND sky130_ef_sc_hd__decap_12
XFILLER_172_421 VPWR VGND VPWR VGND sky130_ef_sc_hd__decap_12
XPHY_EDGE_ROW_46_2_Left_548 VGND VGND VPWR VPWR sky130_fd_sc_hd__decap_3
XFILLER_195_1437 VPWR VGND VPWR VGND sky130_ef_sc_hd__decap_12
XFILLER_173_977 VPWR VGND VPWR VGND sky130_ef_sc_hd__decap_12
XFILLER_201_1393 VGND VGND VPWR VPWR sky130_fd_sc_hd__decap_6
XFILLER_119_1243 VPWR VGND VPWR VGND sky130_ef_sc_hd__decap_12
XFILLER_232_1309 VGND VGND VPWR VPWR sky130_fd_sc_hd__decap_6
XFILLER_247_709 VPWR VGND VPWR VGND sky130_ef_sc_hd__decap_12
XFILLER_119_1287 VPWR VGND VPWR VGND sky130_ef_sc_hd__decap_12
XFILLER_154_1189 VGND VGND VPWR VPWR sky130_fd_sc_hd__fill_1
XFILLER_228_923 VGND VGND VPWR VPWR sky130_fd_sc_hd__fill_1
XTAP_TAPCELL_ROW_245_3493 VGND VPWR sky130_fd_sc_hd__tapvpwrvgnd_1
XFILLER_171_1481 VPWR VGND VPWR VGND sky130_ef_sc_hd__decap_12
XFILLER_104_27 VGND VGND VPWR VPWR sky130_fd_sc_hd__fill_1
XFILLER_239_293 VPWR VGND VPWR VGND sky130_ef_sc_hd__decap_12
XFILLER_255_753 VGND VGND VPWR VPWR sky130_fd_sc_hd__decap_3
XFILLER_251_55 VGND VGND VPWR VPWR sky130_fd_sc_hd__fill_1
XPHY_EDGE_ROW_160_2_Left_662 VGND VGND VPWR VPWR sky130_fd_sc_hd__decap_3
XTAP_TAPCELL_ROW_241_3379 VGND VPWR sky130_fd_sc_hd__tapvpwrvgnd_1
XFILLER_215_617 VPWR VGND VPWR VGND sky130_ef_sc_hd__decap_12
XFILLER_255_797 VPWR VGND VPWR VGND sky130_ef_sc_hd__decap_12
XFILLER_199_329 VGND VGND VPWR VPWR sky130_fd_sc_hd__decap_6
XFILLER_78_1271 VPWR VGND VPWR VGND sky130_ef_sc_hd__decap_12
XFILLER_120_15 VPWR VGND VPWR VGND sky130_ef_sc_hd__decap_12
XFILLER_242_469 VGND VGND VPWR VPWR sky130_fd_sc_hd__decap_6
XFILLER_39_1255 VPWR VGND VPWR VGND sky130_ef_sc_hd__decap_12
XFILLER_126_1203 VPWR VGND VPWR VGND sky130_ef_sc_hd__decap_12
XFILLER_243_1449 VGND VGND VPWR VPWR sky130_fd_sc_hd__decap_6
XFILLER_165_1285 VGND VGND VPWR VPWR sky130_fd_sc_hd__decap_3
XFILLER_39_1299 VPWR VGND VPWR VGND sky130_ef_sc_hd__decap_12
XFILLER_126_1247 VPWR VGND VPWR VGND sky130_ef_sc_hd__decap_12
XFILLER_168_749 VGND VGND VPWR VPWR sky130_fd_sc_hd__decap_6
XFILLER_210_333 VPWR VGND VPWR VGND sky130_ef_sc_hd__decap_12
XPHY_EDGE_ROW_10_2_Right_101 VGND VGND VPWR VPWR sky130_fd_sc_hd__decap_3
XPHY_EDGE_ROW_112_1_Left_367 VGND VGND VPWR VPWR sky130_fd_sc_hd__decap_3
XFILLER_167_237 VPWR VGND VPWR VGND sky130_ef_sc_hd__decap_12
XFILLER_211_889 VGND VGND VPWR VPWR sky130_fd_sc_hd__decap_6
XFILLER_210_377 VPWR VGND VPWR VGND sky130_ef_sc_hd__decap_12
XFILLER_13_57 VPWR VGND VPWR VGND sky130_ef_sc_hd__decap_12
XFILLER_176_793 VPWR VGND VPWR VGND sky130_ef_sc_hd__decap_12
XFILLER_129_57 VPWR VGND VPWR VGND sky130_ef_sc_hd__decap_12
XFILLER_175_281 VPWR VGND VPWR VGND sky130_ef_sc_hd__decap_12
XFILLER_198_1061 VPWR VGND VPWR VGND sky130_ef_sc_hd__decap_12
XFILLER_191_741 VPWR VGND VPWR VGND sky130_ef_sc_hd__decap_12
XFILLER_89_39 VPWR VGND VPWR VGND sky130_ef_sc_hd__decap_12
XFILLER_190_251 VGND VGND VPWR VPWR sky130_fd_sc_hd__fill_1
XFILLER_191_785 VPWR VGND VPWR VGND sky130_ef_sc_hd__decap_12
XFILLER_85_1231 VPWR VGND VPWR VGND sky130_ef_sc_hd__decap_12
XTAP_TAPCELL_ROW_103_2_4372 VGND VPWR sky130_fd_sc_hd__tapvpwrvgnd_1
XFILLER_46_1215 VPWR VGND VPWR VGND sky130_ef_sc_hd__decap_12
Xmax_cap180 _094_ VGND VGND VPWR VPWR net180 sky130_fd_sc_hd__clkbuf_1
XFILLER_1_125 VPWR VGND VPWR VGND sky130_ef_sc_hd__decap_12
Xmax_cap191 net192 VGND VGND VPWR VPWR net191 sky130_fd_sc_hd__clkbuf_1
XFILLER_85_1275 VPWR VGND VPWR VGND sky130_ef_sc_hd__decap_12
XFILLER_137_1343 VPWR VGND VPWR VGND sky130_ef_sc_hd__decap_12
XFILLER_250_1409 VPWR VGND VPWR VGND sky130_ef_sc_hd__decap_12
XFILLER_46_1259 VPWR VGND VPWR VGND sky130_ef_sc_hd__decap_12
XFILLER_1_169 VGND VGND VPWR VPWR sky130_fd_sc_hd__decap_6
XTAP_TAPCELL_ROW_71_2_4183 VGND VPWR sky130_fd_sc_hd__tapvpwrvgnd_1
XFILLER_137_1387 VPWR VGND VPWR VGND sky130_ef_sc_hd__decap_12
XFILLER_213_1231 VGND VGND VPWR VPWR sky130_fd_sc_hd__fill_1
XPHY_EDGE_ROW_92_2_Left_594 VGND VGND VPWR VPWR sky130_fd_sc_hd__decap_3
XFILLER_219_945 VGND VGND VPWR VPWR sky130_fd_sc_hd__decap_6
XFILLER_180_3 VPWR VGND VPWR VGND sky130_ef_sc_hd__decap_12
XFILLER_218_433 VPWR VGND VPWR VGND sky130_ef_sc_hd__decap_12
XFILLER_161_55 VGND VGND VPWR VPWR sky130_fd_sc_hd__fill_1
XFILLER_219_989 VPWR VGND VPWR VGND sky130_ef_sc_hd__decap_12
XFILLER_218_477 VPWR VGND VPWR VGND sky130_ef_sc_hd__decap_12
XFILLER_234_937 VPWR VGND VPWR VGND sky130_ef_sc_hd__decap_12
XFILLER_166_1005 VPWR VGND VPWR VGND sky130_ef_sc_hd__decap_12
XFILLER_205_105 VGND VGND VPWR VPWR sky130_fd_sc_hd__decap_6
X_512_ net183 VGND VGND VPWR VPWR _263_ sky130_fd_sc_hd__inv_2
XFILLER_2_1353 VPWR VGND VPWR VGND sky130_ef_sc_hd__decap_12
XFILLER_233_447 VGND VGND VPWR VPWR sky130_fd_sc_hd__fill_1
XFILLER_57_1311 VPWR VGND VPWR VGND sky130_ef_sc_hd__decap_12
XFILLER_96_1371 VPWR VGND VPWR VGND sky130_ef_sc_hd__decap_12
XFILLER_166_1049 VPWR VGND VPWR VGND sky130_ef_sc_hd__decap_12
XFILLER_205_149 VPWR VGND VPWR VGND sky130_ef_sc_hd__decap_12
XFILLER_54_53 VPWR VGND VPWR VGND sky130_ef_sc_hd__decap_12
XFILLER_2_1397 VPWR VGND VPWR VGND sky130_ef_sc_hd__decap_12
XFILLER_199_841 VPWR VGND VPWR VGND sky130_ef_sc_hd__decap_12
XFILLER_221_609 VGND VGND VPWR VPWR sky130_fd_sc_hd__decap_6
X_443_ _220_ _222_ _231_ VGND VGND VPWR VPWR _232_ sky130_fd_sc_hd__a21o_1
XFILLER_242_981 VPWR VGND VPWR VGND sky130_ef_sc_hd__decap_12
XFILLER_57_1355 VPWR VGND VPWR VGND sky130_ef_sc_hd__decap_12
XFILLER_109_1423 VPWR VGND VPWR VGND sky130_ef_sc_hd__decap_12
XFILLER_144_1303 VPWR VGND VPWR VGND sky130_ef_sc_hd__decap_12
XFILLER_246_1073 VPWR VGND VPWR VGND sky130_ef_sc_hd__decap_12
XFILLER_148_1483 VPWR VGND VPWR VGND sky130_ef_sc_hd__decap_12
XPHY_EDGE_ROW_44_1_Left_299 VGND VGND VPWR VPWR sky130_fd_sc_hd__decap_3
XFILLER_53_1219 VPWR VGND VPWR VGND sky130_ef_sc_hd__decap_12
XFILLER_18_1339 VPWR VGND VPWR VGND sky130_ef_sc_hd__decap_12
XFILLER_186_513 VPWR VGND VPWR VGND sky130_ef_sc_hd__decap_12
X_374_ net132 net158 VGND VGND VPWR VPWR _163_ sky130_fd_sc_hd__or2_1
XFILLER_207_1057 VGND VGND VPWR VPWR sky130_fd_sc_hd__decap_6
XFILLER_57_1399 VPWR VGND VPWR VGND sky130_ef_sc_hd__decap_12
XFILLER_109_1467 VPWR VGND VPWR VGND sky130_ef_sc_hd__decap_12
XFILLER_213_193 VPWR VGND VPWR VGND sky130_ef_sc_hd__decap_12
XFILLER_202_867 VGND VGND VPWR VPWR sky130_fd_sc_hd__fill_1
XFILLER_9_225 VPWR VGND VPWR VGND sky130_ef_sc_hd__decap_12
XFILLER_186_557 VPWR VGND VPWR VGND sky130_ef_sc_hd__decap_12
XFILLER_70_41 VPWR VGND VPWR VGND sky130_ef_sc_hd__decap_12
XFILLER_224_1371 VGND VGND VPWR VPWR sky130_fd_sc_hd__fill_1
XTAP_TAPCELL_ROW_28_2_3923 VGND VPWR sky130_fd_sc_hd__tapvpwrvgnd_1
XFILLER_186_41 VPWR VGND VPWR VGND sky130_ef_sc_hd__decap_12
XTAP_TAPCELL_ROW_171_1504 VGND VPWR sky130_fd_sc_hd__tapvpwrvgnd_1
XTAP_TAPCELL_ROW_171_1515 VGND VPWR sky130_fd_sc_hd__tapvpwrvgnd_1
XFILLER_177_1101 VPWR VGND VPWR VGND sky130_ef_sc_hd__decap_12
XFILLER_186_85 VPWR VGND VPWR VGND sky130_ef_sc_hd__decap_12
XFILLER_177_1145 VPWR VGND VPWR VGND sky130_ef_sc_hd__decap_12
XFILLER_170_925 VPWR VGND VPWR VGND sky130_ef_sc_hd__decap_12
XFILLER_68_1451 VPWR VGND VPWR VGND sky130_ef_sc_hd__decap_12
XFILLER_173_1009 VPWR VGND VPWR VGND sky130_ef_sc_hd__decap_12
XFILLER_181_273 VGND VGND VPWR VPWR sky130_fd_sc_hd__decap_6
XPHY_EDGE_ROW_113_1_Right_769 VGND VGND VPWR VPWR sky130_fd_sc_hd__decap_3
XFILLER_177_1189 VPWR VGND VPWR VGND sky130_ef_sc_hd__decap_12
XFILLER_64_1315 VPWR VGND VPWR VGND sky130_ef_sc_hd__decap_12
XFILLER_253_1033 VPWR VGND VPWR VGND sky130_ef_sc_hd__decap_12
XFILLER_29_1435 VGND VGND VPWR VPWR sky130_fd_sc_hd__decap_6
XFILLER_68_1495 VPWR VGND VPWR VGND sky130_ef_sc_hd__decap_12
XFILLER_155_1443 VPWR VGND VPWR VGND sky130_ef_sc_hd__decap_12
XFILLER_64_1359 VPWR VGND VPWR VGND sky130_ef_sc_hd__decap_12
XFILLER_214_1017 VPWR VGND VPWR VGND sky130_ef_sc_hd__decap_12
XFILLER_253_1077 VPWR VGND VPWR VGND sky130_ef_sc_hd__decap_12
XFILLER_29_1479 VPWR VGND VPWR VGND sky130_ef_sc_hd__decap_12
XFILLER_116_1427 VPWR VGND VPWR VGND sky130_ef_sc_hd__decap_12
XTAP_TAPCELL_ROW_169_1444 VGND VPWR sky130_fd_sc_hd__tapvpwrvgnd_1
XFILLER_205_15 VPWR VGND VPWR VGND sky130_ef_sc_hd__decap_12
XFILLER_218_1197 VGND VGND VPWR VPWR sky130_fd_sc_hd__decap_6
XFILLER_229_709 VPWR VGND VPWR VGND sky130_ef_sc_hd__decap_12
XTAP_TAPCELL_ROW_169_1455 VGND VPWR sky130_fd_sc_hd__tapvpwrvgnd_1
XFILLER_151_1329 VGND VGND VPWR VPWR sky130_fd_sc_hd__fill_1
XFILLER_7_1231 VGND VGND VPWR VPWR sky130_fd_sc_hd__fill_1
XTAP_TAPCELL_ROW_165_1308 VGND VPWR sky130_fd_sc_hd__tapvpwrvgnd_1
XTAP_TAPCELL_ROW_165_1319 VGND VPWR sky130_fd_sc_hd__tapvpwrvgnd_1
XFILLER_237_753 VPWR VGND VPWR VGND sky130_ef_sc_hd__decap_12
XTAP_TAPCELL_ROW_160_2_4715 VGND VPWR sky130_fd_sc_hd__tapvpwrvgnd_1
XTAP_TAPCELL_ROW_159_2_4709 VGND VPWR sky130_fd_sc_hd__tapvpwrvgnd_1
XFILLER_252_701 VPWR VGND VPWR VGND sky130_ef_sc_hd__decap_12
XFILLER_188_1241 VPWR VGND VPWR VGND sky130_ef_sc_hd__decap_12
XFILLER_237_797 VPWR VGND VPWR VGND sky130_ef_sc_hd__decap_12
XFILLER_184_1105 VPWR VGND VPWR VGND sky130_ef_sc_hd__decap_12
XFILLER_188_1285 VPWR VGND VPWR VGND sky130_ef_sc_hd__decap_12
XFILLER_75_1411 VPWR VGND VPWR VGND sky130_ef_sc_hd__decap_12
XFILLER_184_1149 VPWR VGND VPWR VGND sky130_ef_sc_hd__decap_12
XFILLER_221_69 VPWR VGND VPWR VGND sky130_ef_sc_hd__decap_12
XFILLER_224_469 VGND VGND VPWR VPWR sky130_fd_sc_hd__decap_6
XFILLER_225_1113 VGND VGND VPWR VPWR sky130_fd_sc_hd__decap_6
XFILLER_75_1455 VPWR VGND VPWR VGND sky130_ef_sc_hd__decap_12
XFILLER_36_1439 VPWR VGND VPWR VGND sky130_ef_sc_hd__decap_12
XFILLER_189_373 VPWR VGND VPWR VGND sky130_ef_sc_hd__decap_12
XFILLER_75_1499 VPWR VGND VPWR VGND sky130_ef_sc_hd__decap_12
XFILLER_225_1157 VPWR VGND VPWR VGND sky130_ef_sc_hd__decap_12
XFILLER_162_1469 VGND VGND VPWR VPWR sky130_fd_sc_hd__fill_1
XFILLER_203_1455 VGND VGND VPWR VPWR sky130_fd_sc_hd__fill_1
XFILLER_9_781 VGND VGND VPWR VPWR sky130_fd_sc_hd__decap_3
XPHY_EDGE_ROW_75_1_Right_731 VGND VGND VPWR VPWR sky130_fd_sc_hd__decap_3
XTAP_TAPCELL_ROW_95_1_1230 VGND VPWR sky130_fd_sc_hd__tapvpwrvgnd_1
XTAP_TAPCELL_ROW_234_3194 VGND VPWR sky130_fd_sc_hd__tapvpwrvgnd_1
XFILLER_195_1201 VPWR VGND VPWR VGND sky130_ef_sc_hd__decap_12
XFILLER_173_741 VPWR VGND VPWR VGND sky130_ef_sc_hd__decap_12
XFILLER_199_1381 VPWR VGND VPWR VGND sky130_ef_sc_hd__decap_12
XFILLER_121_1177 VPWR VGND VPWR VGND sky130_ef_sc_hd__decap_12
XFILLER_195_1245 VPWR VGND VPWR VGND sky130_ef_sc_hd__decap_12
XFILLER_172_251 VGND VGND VPWR VPWR sky130_fd_sc_hd__fill_1
XFILLER_173_785 VPWR VGND VPWR VGND sky130_ef_sc_hd__decap_12
XFILLER_12_1483 VPWR VGND VPWR VGND sky130_ef_sc_hd__decap_12
XFILLER_246_77 VGND VGND VPWR VPWR sky130_fd_sc_hd__decap_6
XFILLER_195_1289 VPWR VGND VPWR VGND sky130_ef_sc_hd__decap_12
XFILLER_82_1415 VPWR VGND VPWR VGND sky130_ef_sc_hd__decap_12
XTAP_TAPCELL_ROW_247_3544 VGND VPWR sky130_fd_sc_hd__tapvpwrvgnd_1
XFILLER_236_1253 VGND VGND VPWR VPWR sky130_fd_sc_hd__decap_6
XTAP_TAPCELL_ROW_247_3555 VGND VPWR sky130_fd_sc_hd__tapvpwrvgnd_1
XTAP_TAPCELL_ROW_247_3566 VGND VPWR sky130_fd_sc_hd__tapvpwrvgnd_1
XFILLER_8_1017 VPWR VGND VPWR VGND sky130_ef_sc_hd__decap_12
XFILLER_115_15 VPWR VGND VPWR VGND sky130_ef_sc_hd__decap_12
XFILLER_232_1117 VPWR VGND VPWR VGND sky130_ef_sc_hd__decap_12
XFILLER_236_1297 VPWR VGND VPWR VGND sky130_ef_sc_hd__decap_12
XFILLER_247_517 VPWR VGND VPWR VGND sky130_ef_sc_hd__decap_12
XTAP_TAPCELL_ROW_3_935 VGND VPWR sky130_fd_sc_hd__tapvpwrvgnd_1
XTAP_TAPCELL_ROW_3_946 VGND VPWR sky130_fd_sc_hd__tapvpwrvgnd_1
XFILLER_255_561 VPWR VGND VPWR VGND sky130_ef_sc_hd__decap_12
XFILLER_132_1295 VGND VGND VPWR VPWR sky130_fd_sc_hd__decap_6
XFILLER_41_1189 VPWR VGND VPWR VGND sky130_ef_sc_hd__decap_12
XFILLER_216_937 VPWR VGND VPWR VGND sky130_ef_sc_hd__decap_12
XFILLER_167_1325 VPWR VGND VPWR VGND sky130_ef_sc_hd__decap_12
XFILLER_215_447 VGND VGND VPWR VPWR sky130_fd_sc_hd__fill_1
XFILLER_242_233 VPWR VGND VPWR VGND sky130_ef_sc_hd__decap_12
XFILLER_93_1511 VGND VGND VPWR VPWR sky130_fd_sc_hd__decap_4
XFILLER_131_69 VGND VGND VPWR VPWR sky130_fd_sc_hd__fill_2
XFILLER_199_137 VPWR VGND VPWR VGND sky130_ef_sc_hd__decap_12
XFILLER_167_1369 VPWR VGND VPWR VGND sky130_ef_sc_hd__decap_12
XFILLER_203_609 VGND VGND VPWR VPWR sky130_fd_sc_hd__decap_6
XFILLER_243_1213 VPWR VGND VPWR VGND sky130_ef_sc_hd__decap_12
XFILLER_242_277 VPWR VGND VPWR VGND sky130_ef_sc_hd__decap_12
XFILLER_224_981 VPWR VGND VPWR VGND sky130_ef_sc_hd__decap_12
XFILLER_247_1393 VGND VGND VPWR VPWR sky130_fd_sc_hd__decap_6
XFILLER_196_811 VGND VGND VPWR VPWR sky130_fd_sc_hd__fill_1
XFILLER_168_513 VPWR VGND VPWR VGND sky130_ef_sc_hd__decap_12
XFILLER_243_1257 VPWR VGND VPWR VGND sky130_ef_sc_hd__decap_12
XFILLER_165_1093 VPWR VGND VPWR VGND sky130_ef_sc_hd__decap_12
XFILLER_211_653 VPWR VGND VPWR VGND sky130_ef_sc_hd__decap_12
XFILLER_168_557 VPWR VGND VPWR VGND sky130_ef_sc_hd__decap_12
XFILLER_210_141 VPWR VGND VPWR VGND sky130_ef_sc_hd__decap_12
XFILLER_221_1511 VGND VGND VPWR VPWR sky130_fd_sc_hd__fill_1
Xwire605 rd_addr\[7\] VGND VGND VPWR VPWR net605 sky130_fd_sc_hd__clkbuf_1
XFILLER_183_505 VPWR VGND VPWR VGND sky130_ef_sc_hd__decap_12
XPHY_EDGE_ROW_11_2_Right_102 VGND VGND VPWR VPWR sky130_fd_sc_hd__decap_3
XFILLER_211_697 VPWR VGND VPWR VGND sky130_ef_sc_hd__decap_12
Xwire627 net628 VGND VGND VPWR VPWR net627 sky130_fd_sc_hd__buf_1
XFILLER_7_729 VPWR VGND VPWR VGND sky130_ef_sc_hd__decap_12
Xwire638 net30 VGND VGND VPWR VPWR net638 sky130_fd_sc_hd__buf_1
Xwire649 net21 VGND VGND VPWR VPWR net649 sky130_fd_sc_hd__buf_1
XFILLER_178_1421 VGND VGND VPWR VPWR sky130_fd_sc_hd__decap_6
XFILLER_100_1239 VGND VGND VPWR VPWR sky130_fd_sc_hd__decap_6
XFILLER_178_1465 VPWR VGND VPWR VGND sky130_ef_sc_hd__decap_12
XFILLER_174_1329 VPWR VGND VPWR VGND sky130_ef_sc_hd__decap_12
XFILLER_254_1353 VPWR VGND VPWR VGND sky130_ef_sc_hd__decap_12
XFILLER_250_1217 VPWR VGND VPWR VGND sky130_ef_sc_hd__decap_12
XFILLER_2_489 VGND VGND VPWR VPWR sky130_fd_sc_hd__fill_1
XFILLER_215_1337 VGND VGND VPWR VPWR sky130_fd_sc_hd__decap_6
XFILLER_254_1397 VPWR VGND VPWR VGND sky130_ef_sc_hd__decap_12
XFILLER_172_65 VPWR VGND VPWR VGND sky130_ef_sc_hd__decap_12
XFILLER_150_1351 VGND VGND VPWR VPWR sky130_fd_sc_hd__decap_6
XFILLER_219_753 VPWR VGND VPWR VGND sky130_ef_sc_hd__decap_12
XFILLER_234_701 VPWR VGND VPWR VGND sky130_ef_sc_hd__decap_12
XFILLER_150_1395 VPWR VGND VPWR VGND sky130_ef_sc_hd__decap_12
XFILLER_219_797 VPWR VGND VPWR VGND sky130_ef_sc_hd__decap_12
XFILLER_185_1425 VPWR VGND VPWR VGND sky130_ef_sc_hd__decap_12
XFILLER_111_1379 VGND VGND VPWR VPWR sky130_fd_sc_hd__decap_6
XFILLER_2_1161 VPWR VGND VPWR VGND sky130_ef_sc_hd__decap_12
XTAP_TAPCELL_ROW_125_2_4504 VGND VPWR sky130_fd_sc_hd__tapvpwrvgnd_1
XFILLER_209_1119 VGND VGND VPWR VPWR sky130_fd_sc_hd__fill_1
XFILLER_206_469 VGND VGND VPWR VPWR sky130_fd_sc_hd__decap_6
XFILLER_185_1469 VPWR VGND VPWR VGND sky130_ef_sc_hd__decap_12
XFILLER_221_417 VPWR VGND VPWR VGND sky130_ef_sc_hd__decap_12
XFILLER_199_671 VGND VGND VPWR VPWR sky130_fd_sc_hd__fill_1
X_426_ _213_ _214_ VGND VGND VPWR VPWR _215_ sky130_fd_sc_hd__or2_1
XFILLER_109_1231 VPWR VGND VPWR VGND sky130_ef_sc_hd__decap_12
XTAP_TAPCELL_ROW_93_2_4315 VGND VPWR sky130_fd_sc_hd__tapvpwrvgnd_1
XFILLER_187_833 VGND VGND VPWR VPWR sky130_fd_sc_hd__decap_6
XFILLER_81_51 VGND VGND VPWR VPWR sky130_fd_sc_hd__decap_4
XFILLER_186_321 VPWR VGND VPWR VGND sky130_ef_sc_hd__decap_12
XFILLER_226_1477 VGND VGND VPWR VPWR sky130_fd_sc_hd__decap_6
XFILLER_109_1275 VPWR VGND VPWR VGND sky130_ef_sc_hd__decap_12
XFILLER_197_51 VGND VGND VPWR VPWR sky130_fd_sc_hd__decap_4
XFILLER_230_973 VGND VGND VPWR VPWR sky130_fd_sc_hd__decap_6
X_357_ _138_ net330 net334 VGND VGND VPWR VPWR _146_ sky130_fd_sc_hd__a21oi_1
XFILLER_187_877 VPWR VGND VPWR VGND sky130_ef_sc_hd__decap_12
XFILLER_144_1177 VPWR VGND VPWR VGND sky130_ef_sc_hd__decap_12
XFILLER_186_365 VPWR VGND VPWR VGND sky130_ef_sc_hd__decap_12
X_288_ net606 net607 net181 VGND VGND VPWR VPWR _085_ sky130_fd_sc_hd__and3_1
XFILLER_161_1491 VGND VGND VPWR VPWR sky130_fd_sc_hd__decap_6
XFILLER_60_6 VPWR VGND VPWR VGND sky130_ef_sc_hd__decap_12
XFILLER_255_1117 VGND VGND VPWR VPWR sky130_fd_sc_hd__decap_3
XFILLER_5_250 VGND VGND VPWR VPWR sky130_fd_sc_hd__fill_1
XFILLER_192_1429 VPWR VGND VPWR VGND sky130_ef_sc_hd__decap_12
XTAP_TAPCELL_ROW_156_1_1291 VGND VPWR sky130_fd_sc_hd__tapvpwrvgnd_1
XFILLER_170_755 VGND VGND VPWR VPWR sky130_fd_sc_hd__fill_1
XFILLER_29_1243 VPWR VGND VPWR VGND sky130_ef_sc_hd__decap_12
XFILLER_39_3 VPWR VGND VPWR VGND sky130_ef_sc_hd__decap_12
XFILLER_233_1437 VPWR VGND VPWR VGND sky130_ef_sc_hd__decap_12
XFILLER_155_1273 VGND VGND VPWR VPWR sky130_fd_sc_hd__fill_1
XFILLER_29_1287 VPWR VGND VPWR VGND sky130_ef_sc_hd__decap_12
XFILLER_229_517 VPWR VGND VPWR VGND sky130_ef_sc_hd__decap_12
XFILLER_64_1189 VGND VGND VPWR VPWR sky130_fd_sc_hd__fill_1
XTAP_TAPCELL_ROW_242_3430 VGND VPWR sky130_fd_sc_hd__tapvpwrvgnd_1
XFILLER_190_1197 VGND VGND VPWR VPWR sky130_fd_sc_hd__decap_6
XFILLER_99_1219 VPWR VGND VPWR VGND sky130_ef_sc_hd__decap_12
Xinput4 wr_addr[2] VGND VGND VPWR VPWR net4 sky130_fd_sc_hd__clkbuf_1
XFILLER_237_561 VPWR VGND VPWR VGND sky130_ef_sc_hd__decap_12
XTAP_TAPCELL_ROW_20_2_3874 VGND VPWR sky130_fd_sc_hd__tapvpwrvgnd_1
XTAP_TAPCELL_ROW_19_2_3868 VGND VPWR sky130_fd_sc_hd__tapvpwrvgnd_1
XFILLER_252_531 VGND VGND VPWR VPWR sky130_fd_sc_hd__fill_1
XFILLER_224_233 VPWR VGND VPWR VGND sky130_ef_sc_hd__decap_12
XFILLER_188_1093 VPWR VGND VPWR VGND sky130_ef_sc_hd__decap_12
XTAP_TAPCELL_ROW_255_3802 VGND VPWR sky130_fd_sc_hd__tapvpwrvgnd_1
XFILLER_206_981 VPWR VGND VPWR VGND sky130_ef_sc_hd__decap_12
XFILLER_224_277 VPWR VGND VPWR VGND sky130_ef_sc_hd__decap_12
XFILLER_240_737 VPWR VGND VPWR VGND sky130_ef_sc_hd__decap_12
XFILLER_36_1203 VPWR VGND VPWR VGND sky130_ef_sc_hd__decap_12
XFILLER_101_39 VPWR VGND VPWR VGND sky130_ef_sc_hd__decap_12
XFILLER_178_811 VGND VGND VPWR VPWR sky130_fd_sc_hd__fill_1
XFILLER_127_1331 VPWR VGND VPWR VGND sky130_ef_sc_hd__decap_12
XFILLER_221_951 VGND VGND VPWR VPWR sky130_fd_sc_hd__fill_1
XTAP_TAPCELL_ROW_236_3245 VGND VPWR sky130_fd_sc_hd__tapvpwrvgnd_1
XFILLER_189_181 VPWR VGND VPWR VGND sky130_ef_sc_hd__decap_12
XTAP_TAPCELL_ROW_236_3256 VGND VPWR sky130_fd_sc_hd__tapvpwrvgnd_1
XFILLER_36_1247 VPWR VGND VPWR VGND sky130_ef_sc_hd__decap_12
XTAP_TAPCELL_ROW_236_3267 VGND VPWR sky130_fd_sc_hd__tapvpwrvgnd_1
XFILLER_123_1217 VGND VGND VPWR VPWR sky130_fd_sc_hd__fill_1
XFILLER_165_505 VPWR VGND VPWR VGND sky130_ef_sc_hd__decap_12
XTAP_TAPCELL_ROW_138_2_4582 VGND VPWR sky130_fd_sc_hd__tapvpwrvgnd_1
XPHY_EDGE_ROW_76_1_Right_732 VGND VGND VPWR VPWR sky130_fd_sc_hd__decap_3
XFILLER_192_357 VGND VGND VPWR VPWR sky130_fd_sc_hd__decap_6
XTAP_TAPCELL_ROW_249_3606 VGND VPWR sky130_fd_sc_hd__tapvpwrvgnd_1
XFILLER_238_1315 VGND VGND VPWR VPWR sky130_fd_sc_hd__fill_1
XTAP_TAPCELL_ROW_249_3617 VGND VPWR sky130_fd_sc_hd__tapvpwrvgnd_1
XFILLER_0_905 VGND VGND VPWR VPWR sky130_fd_sc_hd__fill_1
XFILLER_47_1343 VPWR VGND VPWR VGND sky130_ef_sc_hd__decap_12
XFILLER_236_1061 VPWR VGND VPWR VGND sky130_ef_sc_hd__decap_12
XFILLER_82_1245 VGND VGND VPWR VPWR sky130_fd_sc_hd__fill_1
XFILLER_138_1471 VPWR VGND VPWR VGND sky130_ef_sc_hd__decap_12
XFILLER_86_29 VPWR VGND VPWR VGND sky130_ef_sc_hd__decap_12
XFILLER_0_949 VGND VGND VPWR VPWR sky130_fd_sc_hd__decap_3
XFILLER_47_1387 VPWR VGND VPWR VGND sky130_ef_sc_hd__decap_12
XFILLER_248_837 VPWR VGND VPWR VGND sky130_ef_sc_hd__decap_12
XFILLER_134_1357 VGND VGND VPWR VPWR sky130_fd_sc_hd__fill_1
XFILLER_216_701 VPWR VGND VPWR VGND sky130_ef_sc_hd__decap_12
XTAP_TAPCELL_ROW_225_2960 VGND VPWR sky130_fd_sc_hd__tapvpwrvgnd_1
XTAP_TAPCELL_ROW_225_2971 VGND VPWR sky130_fd_sc_hd__tapvpwrvgnd_1
XTAP_TAPCELL_ROW_111_2_4423 VGND VPWR sky130_fd_sc_hd__tapvpwrvgnd_1
XFILLER_249_1455 VGND VGND VPWR VPWR sky130_fd_sc_hd__fill_1
XTAP_TAPCELL_ROW_221_2846 VGND VPWR sky130_fd_sc_hd__tapvpwrvgnd_1
XFILLER_167_1133 VPWR VGND VPWR VGND sky130_ef_sc_hd__decap_12
XFILLER_243_553 VGND VGND VPWR VPWR sky130_fd_sc_hd__decap_6
XFILLER_3_1481 VPWR VGND VPWR VGND sky130_ef_sc_hd__decap_12
XTAP_TAPCELL_ROW_221_2857 VGND VPWR sky130_fd_sc_hd__tapvpwrvgnd_1
XFILLER_203_417 VPWR VGND VPWR VGND sky130_ef_sc_hd__decap_12
XPHY_EDGE_ROW_123_2_Left_625 VGND VGND VPWR VPWR sky130_fd_sc_hd__decap_3
XFILLER_167_1177 VPWR VGND VPWR VGND sky130_ef_sc_hd__decap_12
XFILLER_243_597 VPWR VGND VPWR VGND sky130_ef_sc_hd__decap_12
XFILLER_54_1303 VPWR VGND VPWR VGND sky130_ef_sc_hd__decap_12
XFILLER_19_1423 VPWR VGND VPWR VGND sky130_ef_sc_hd__decap_12
XFILLER_243_1021 VPWR VGND VPWR VGND sky130_ef_sc_hd__decap_12
XFILLER_58_1483 VPWR VGND VPWR VGND sky130_ef_sc_hd__decap_12
XFILLER_208_1141 VGND VGND VPWR VPWR sky130_fd_sc_hd__decap_6
XFILLER_169_833 VGND VGND VPWR VPWR sky130_fd_sc_hd__decap_6
XFILLER_168_321 VPWR VGND VPWR VGND sky130_ef_sc_hd__decap_12
XFILLER_93_1385 VGND VGND VPWR VPWR sky130_fd_sc_hd__fill_1
XFILLER_143_3 VPWR VGND VPWR VGND sky130_ef_sc_hd__decap_12
XFILLER_204_1005 VPWR VGND VPWR VGND sky130_ef_sc_hd__decap_12
XFILLER_19_1467 VPWR VGND VPWR VGND sky130_ef_sc_hd__decap_12
XFILLER_106_1415 VPWR VGND VPWR VGND sky130_ef_sc_hd__decap_12
XFILLER_212_973 VGND VGND VPWR VPWR sky130_fd_sc_hd__decap_6
XFILLER_243_1065 VPWR VGND VPWR VGND sky130_ef_sc_hd__decap_12
XFILLER_208_1185 VPWR VGND VPWR VGND sky130_ef_sc_hd__decap_12
XFILLER_169_877 VPWR VGND VPWR VGND sky130_ef_sc_hd__decap_12
XFILLER_211_461 VPWR VGND VPWR VGND sky130_ef_sc_hd__decap_12
XFILLER_168_365 VPWR VGND VPWR VGND sky130_ef_sc_hd__decap_12
Xwire402 net403 VGND VGND VPWR VPWR net402 sky130_fd_sc_hd__clkbuf_1
XFILLER_145_1497 VGND VGND VPWR VPWR sky130_fd_sc_hd__fill_1
XFILLER_184_825 VPWR VGND VPWR VGND sky130_ef_sc_hd__decap_12
XFILLER_204_1049 VPWR VGND VPWR VGND sky130_ef_sc_hd__decap_12
Xwire413 net414 VGND VGND VPWR VPWR net413 sky130_fd_sc_hd__clkbuf_1
XTAP_TAPCELL_ROW_58_2_4104 VGND VPWR sky130_fd_sc_hd__tapvpwrvgnd_1
Xwire424 net425 VGND VGND VPWR VPWR net424 sky130_fd_sc_hd__clkbuf_1
XTAP_TAPCELL_ROW_219_2786 VGND VPWR sky130_fd_sc_hd__tapvpwrvgnd_1
Xwire435 net436 VGND VGND VPWR VPWR net435 sky130_fd_sc_hd__clkbuf_1
XTAP_TAPCELL_ROW_219_2797 VGND VPWR sky130_fd_sc_hd__tapvpwrvgnd_1
XFILLER_183_335 VGND VGND VPWR VPWR sky130_fd_sc_hd__fill_1
XPHY_EDGE_ROW_12_2_Right_103 VGND VGND VPWR VPWR sky130_fd_sc_hd__decap_3
Xwire446 net447 VGND VGND VPWR VPWR net446 sky130_fd_sc_hd__clkbuf_1
XFILLER_184_869 VPWR VGND VPWR VGND sky130_ef_sc_hd__decap_12
Xwire457 net458 VGND VGND VPWR VPWR net457 sky130_fd_sc_hd__clkbuf_1
Xwire468 net469 VGND VGND VPWR VPWR net468 sky130_fd_sc_hd__clkbuf_1
Xwire479 net480 VGND VGND VPWR VPWR net479 sky130_fd_sc_hd__clkbuf_1
XFILLER_139_1213 VGND VGND VPWR VPWR sky130_fd_sc_hd__decap_4
XFILLER_178_1273 VPWR VGND VPWR VGND sky130_ef_sc_hd__decap_12
XFILLER_3_721 VGND VGND VPWR VPWR sky130_fd_sc_hd__decap_4
XFILLER_3_732 VGND VGND VPWR VPWR sky130_fd_sc_hd__fill_1
XFILLER_87_1189 VPWR VGND VPWR VGND sky130_ef_sc_hd__decap_12
XFILLER_65_1443 VPWR VGND VPWR VGND sky130_ef_sc_hd__decap_12
XFILLER_2_253 VGND VGND VPWR VPWR sky130_fd_sc_hd__fill_1
XFILLER_117_1511 VGND VGND VPWR VPWR sky130_fd_sc_hd__decap_4
XFILLER_215_1101 VPWR VGND VPWR VGND sky130_ef_sc_hd__decap_12
XFILLER_254_1161 VPWR VGND VPWR VGND sky130_ef_sc_hd__decap_12
XFILLER_2_264 VPWR VGND VPWR VGND sky130_ef_sc_hd__decap_12
XFILLER_219_1281 VGND VGND VPWR VPWR sky130_fd_sc_hd__decap_6
XFILLER_152_1413 VGND VGND VPWR VPWR sky130_fd_sc_hd__fill_1
XFILLER_26_1427 VPWR VGND VPWR VGND sky130_ef_sc_hd__decap_12
XFILLER_215_1145 VPWR VGND VPWR VGND sky130_ef_sc_hd__decap_12
XFILLER_61_1329 VGND VGND VPWR VPWR sky130_fd_sc_hd__fill_1
XFILLER_211_1009 VPWR VGND VPWR VGND sky130_ef_sc_hd__decap_12
XFILLER_215_1189 VPWR VGND VPWR VGND sky130_ef_sc_hd__decap_12
Xfanout590 net591 VGND VGND VPWR VPWR net590 sky130_fd_sc_hd__clkbuf_2
XFILLER_219_561 VPWR VGND VPWR VGND sky130_ef_sc_hd__decap_12
XFILLER_253_317 VPWR VGND VPWR VGND sky130_ef_sc_hd__decap_12
XFILLER_234_531 VGND VGND VPWR VPWR sky130_fd_sc_hd__fill_1
XFILLER_111_1165 VPWR VGND VPWR VGND sky130_ef_sc_hd__decap_12
XFILLER_202_27 VGND VGND VPWR VPWR sky130_fd_sc_hd__fill_1
XFILLER_206_233 VPWR VGND VPWR VGND sky130_ef_sc_hd__decap_12
XPHY_EDGE_ROW_55_2_Left_557 VGND VGND VPWR VPWR sky130_fd_sc_hd__decap_3
XFILLER_185_1233 VPWR VGND VPWR VGND sky130_ef_sc_hd__decap_12
XFILLER_206_277 VPWR VGND VPWR VGND sky130_ef_sc_hd__decap_12
XFILLER_222_737 VPWR VGND VPWR VGND sky130_ef_sc_hd__decap_12
XFILLER_146_1239 VGND VGND VPWR VPWR sky130_fd_sc_hd__decap_6
XFILLER_181_1119 VGND VGND VPWR VPWR sky130_fd_sc_hd__fill_1
XFILLER_221_225 VPWR VGND VPWR VGND sky130_ef_sc_hd__decap_12
XFILLER_226_1241 VPWR VGND VPWR VGND sky130_ef_sc_hd__decap_12
XFILLER_203_951 VGND VGND VPWR VPWR sky130_fd_sc_hd__fill_1
XFILLER_187_641 VPWR VGND VPWR VGND sky130_ef_sc_hd__decap_12
XFILLER_222_1105 VPWR VGND VPWR VGND sky130_ef_sc_hd__decap_12
X_409_ net202 net131 net204 VGND VGND VPWR VPWR _198_ sky130_fd_sc_hd__a21oi_1
XFILLER_226_1285 VPWR VGND VPWR VGND sky130_ef_sc_hd__decap_12
XFILLER_72_1469 VGND VGND VPWR VPWR sky130_fd_sc_hd__fill_1
XFILLER_230_781 VPWR VGND VPWR VGND sky130_ef_sc_hd__decap_12
XFILLER_187_685 VPWR VGND VPWR VGND sky130_ef_sc_hd__decap_12
XFILLER_222_1149 VPWR VGND VPWR VGND sky130_ef_sc_hd__decap_12
XTAP_TAPCELL_ROW_231_3120 VGND VPWR sky130_fd_sc_hd__tapvpwrvgnd_1
XFILLER_186_195 VGND VGND VPWR VPWR sky130_fd_sc_hd__fill_1
XTAP_TAPCELL_ROW_231_3131 VGND VPWR sky130_fd_sc_hd__tapvpwrvgnd_1
XFILLER_174_357 VGND VGND VPWR VPWR sky130_fd_sc_hd__decap_6
XFILLER_122_1283 VPWR VGND VPWR VGND sky130_ef_sc_hd__decap_12
XFILLER_31_1177 VPWR VGND VPWR VGND sky130_ef_sc_hd__decap_12
XFILLER_196_1373 VPWR VGND VPWR VGND sky130_ef_sc_hd__decap_12
XFILLER_227_57 VPWR VGND VPWR VGND sky130_ef_sc_hd__decap_12
XFILLER_157_1379 VGND VGND VPWR VPWR sky130_fd_sc_hd__decap_6
XFILLER_192_1259 VGND VGND VPWR VPWR sky130_fd_sc_hd__fill_1
XFILLER_233_1201 VPWR VGND VPWR VGND sky130_ef_sc_hd__decap_12
XFILLER_237_1381 VPWR VGND VPWR VGND sky130_ef_sc_hd__decap_12
XTAP_TAPCELL_ROW_116_2_4449 VGND VPWR sky130_fd_sc_hd__tapvpwrvgnd_1
XTAP_TAPCELL_ROW_229_3060 VGND VPWR sky130_fd_sc_hd__tapvpwrvgnd_1
XTAP_TAPCELL_ROW_229_3071 VGND VPWR sky130_fd_sc_hd__tapvpwrvgnd_1
XFILLER_233_1245 VPWR VGND VPWR VGND sky130_ef_sc_hd__decap_12
XPHY_EDGE_ROW_69_1_Left_324 VGND VGND VPWR VPWR sky130_fd_sc_hd__decap_3
XFILLER_9_1145 VGND VGND VPWR VPWR sky130_fd_sc_hd__decap_3
XFILLER_5_1009 VPWR VGND VPWR VGND sky130_ef_sc_hd__decap_12
XFILLER_233_1289 VPWR VGND VPWR VGND sky130_ef_sc_hd__decap_12
XFILLER_9_1189 VPWR VGND VPWR VGND sky130_ef_sc_hd__decap_12
XPHY_EDGE_ROW_121_1_Left_376 VGND VGND VPWR VPWR sky130_fd_sc_hd__decap_3
XTAP_TAPCELL_ROW_6_1015 VGND VPWR sky130_fd_sc_hd__tapvpwrvgnd_1
XTAP_TAPCELL_ROW_6_1026 VGND VPWR sky130_fd_sc_hd__tapvpwrvgnd_1
XFILLER_238_881 VPWR VGND VPWR VGND sky130_ef_sc_hd__decap_12
XTAP_TAPCELL_ROW_6_1037 VGND VPWR sky130_fd_sc_hd__tapvpwrvgnd_1
XFILLER_42_1295 VGND VGND VPWR VPWR sky130_fd_sc_hd__decap_6
XFILLER_237_391 VGND VGND VPWR VPWR sky130_fd_sc_hd__fill_1
XFILLER_112_27 VGND VGND VPWR VPWR sky130_fd_sc_hd__fill_1
XFILLER_168_1453 VPWR VGND VPWR VGND sky130_ef_sc_hd__decap_12
XFILLER_225_553 VGND VGND VPWR VPWR sky130_fd_sc_hd__decap_6
XTAP_TAPCELL_ROW_238_3307 VGND VPWR sky130_fd_sc_hd__tapvpwrvgnd_1
XTAP_TAPCELL_ROW_64_2_4136 VGND VPWR sky130_fd_sc_hd__tapvpwrvgnd_1
XFILLER_240_501 VPWR VGND VPWR VGND sky130_ef_sc_hd__decap_12
XTAP_TAPCELL_ROW_238_3318 VGND VPWR sky130_fd_sc_hd__tapvpwrvgnd_1
XFILLER_198_917 VGND VGND VPWR VPWR sky130_fd_sc_hd__decap_6
XFILLER_253_895 VGND VGND VPWR VPWR sky130_fd_sc_hd__fill_1
XFILLER_197_405 VPWR VGND VPWR VGND sky130_ef_sc_hd__decap_12
XFILLER_225_597 VPWR VGND VPWR VGND sky130_ef_sc_hd__decap_12
XFILLER_168_1497 VPWR VGND VPWR VGND sky130_ef_sc_hd__decap_12
XFILLER_164_1339 VPWR VGND VPWR VGND sky130_ef_sc_hd__decap_12
XFILLER_240_545 VPWR VGND VPWR VGND sky130_ef_sc_hd__decap_12
XFILLER_244_1341 VPWR VGND VPWR VGND sky130_ef_sc_hd__decap_12
XFILLER_197_449 VPWR VGND VPWR VGND sky130_ef_sc_hd__decap_12
XFILLER_240_1205 VPWR VGND VPWR VGND sky130_ef_sc_hd__decap_12
XFILLER_205_1325 VPWR VGND VPWR VGND sky130_ef_sc_hd__decap_12
XFILLER_240_589 VPWR VGND VPWR VGND sky130_ef_sc_hd__decap_12
XFILLER_244_1385 VPWR VGND VPWR VGND sky130_ef_sc_hd__decap_12
XFILLER_166_825 VPWR VGND VPWR VGND sky130_ef_sc_hd__decap_12
XFILLER_205_1369 VPWR VGND VPWR VGND sky130_ef_sc_hd__decap_12
XFILLER_192_121 VPWR VGND VPWR VGND sky130_ef_sc_hd__decap_12
XTAP_TAPCELL_ROW_193_2090 VGND VPWR sky130_fd_sc_hd__tapvpwrvgnd_1
XFILLER_166_869 VPWR VGND VPWR VGND sky130_ef_sc_hd__decap_12
XFILLER_101_1323 VGND VGND VPWR VPWR sky130_fd_sc_hd__decap_6
XFILLER_192_165 VPWR VGND VPWR VGND sky130_ef_sc_hd__decap_12
XFILLER_21_57 VPWR VGND VPWR VGND sky130_ef_sc_hd__decap_12
XFILLER_140_1383 VPWR VGND VPWR VGND sky130_ef_sc_hd__decap_12
XFILLER_181_839 VGND VGND VPWR VPWR sky130_fd_sc_hd__fill_1
XTAP_TAPCELL_ROW_214_2650 VGND VPWR sky130_fd_sc_hd__tapvpwrvgnd_1
XTAP_TAPCELL_ROW_214_2661 VGND VPWR sky130_fd_sc_hd__tapvpwrvgnd_1
XFILLER_10_1239 VGND VGND VPWR VPWR sky130_fd_sc_hd__decap_6
XPHY_EDGE_ROW_77_1_Right_733 VGND VGND VPWR VPWR sky130_fd_sc_hd__decap_3
XTAP_TAPCELL_ROW_214_2672 VGND VPWR sky130_fd_sc_hd__tapvpwrvgnd_1
XTAP_TAPCELL_ROW_63_1_1198 VGND VPWR sky130_fd_sc_hd__tapvpwrvgnd_1
XFILLER_101_1367 VPWR VGND VPWR VGND sky130_ef_sc_hd__decap_12
XFILLER_175_1413 VPWR VGND VPWR VGND sky130_ef_sc_hd__decap_12
XFILLER_137_57 VPWR VGND VPWR VGND sky130_ef_sc_hd__decap_12
XFILLER_175_1457 VPWR VGND VPWR VGND sky130_ef_sc_hd__decap_12
XTAP_TAPCELL_ROW_210_2547 VGND VPWR sky130_fd_sc_hd__tapvpwrvgnd_1
XFILLER_97_39 VPWR VGND VPWR VGND sky130_ef_sc_hd__decap_12
XPHY_EDGE_ROW_208_Right_53 VGND VGND VPWR VPWR sky130_fd_sc_hd__decap_3
XTAP_TAPCELL_ROW_210_2558 VGND VPWR sky130_fd_sc_hd__tapvpwrvgnd_1
XFILLER_251_1301 VPWR VGND VPWR VGND sky130_ef_sc_hd__decap_12
XFILLER_216_1421 VGND VGND VPWR VPWR sky130_fd_sc_hd__decap_6
XFILLER_255_1481 VGND VGND VPWR VPWR sky130_fd_sc_hd__decap_3
XFILLER_248_601 VPWR VGND VPWR VGND sky130_ef_sc_hd__decap_12
XFILLER_251_1345 VPWR VGND VPWR VGND sky130_ef_sc_hd__decap_12
XFILLER_216_1465 VPWR VGND VPWR VGND sky130_ef_sc_hd__decap_12
XFILLER_247_111 VGND VGND VPWR VPWR sky130_fd_sc_hd__fill_1
XFILLER_248_645 VPWR VGND VPWR VGND sky130_ef_sc_hd__decap_12
XFILLER_134_1165 VPWR VGND VPWR VGND sky130_ef_sc_hd__decap_12
XFILLER_212_1329 VPWR VGND VPWR VGND sky130_ef_sc_hd__decap_12
XTAP_TAPCELL_ROW_161_2_4720 VGND VPWR sky130_fd_sc_hd__tapvpwrvgnd_1
XTAP_TAPCELL_ROW_223_2908 VGND VPWR sky130_fd_sc_hd__tapvpwrvgnd_1
XFILLER_60_1351 VGND VGND VPWR VPWR sky130_fd_sc_hd__decap_6
XTAP_TAPCELL_ROW_223_2919 VGND VPWR sky130_fd_sc_hd__tapvpwrvgnd_1
XFILLER_235_317 VPWR VGND VPWR VGND sky130_ef_sc_hd__decap_12
XTAP_TAPCELL_ROW_208_2498 VGND VPWR sky130_fd_sc_hd__tapvpwrvgnd_1
XFILLER_60_1395 VPWR VGND VPWR VGND sky130_ef_sc_hd__decap_12
XFILLER_112_1463 VGND VGND VPWR VPWR sky130_fd_sc_hd__decap_6
XFILLER_216_531 VGND VGND VPWR VPWR sky130_fd_sc_hd__fill_1
XFILLER_21_1379 VGND VGND VPWR VPWR sky130_fd_sc_hd__decap_6
XFILLER_250_309 VPWR VGND VPWR VGND sky130_ef_sc_hd__decap_12
XFILLER_243_361 VPWR VGND VPWR VGND sky130_ef_sc_hd__decap_12
Xmax_cap77 net78 VGND VGND VPWR VPWR net77 sky130_fd_sc_hd__clkbuf_1
XPHY_EDGE_ROW_217_Right_62 VGND VGND VPWR VPWR sky130_fd_sc_hd__decap_3
XFILLER_204_737 VPWR VGND VPWR VGND sky130_ef_sc_hd__decap_12
Xmax_cap99 _242_ VGND VGND VPWR VPWR net99 sky130_fd_sc_hd__clkbuf_1
XFILLER_203_225 VPWR VGND VPWR VGND sky130_ef_sc_hd__decap_12
XFILLER_19_1231 VPWR VGND VPWR VGND sky130_ef_sc_hd__decap_12
XFILLER_169_641 VPWR VGND VPWR VGND sky130_ef_sc_hd__decap_12
XFILLER_180_1141 VGND VGND VPWR VPWR sky130_fd_sc_hd__decap_6
XFILLER_223_1425 VPWR VGND VPWR VGND sky130_ef_sc_hd__decap_12
XFILLER_19_1275 VPWR VGND VPWR VGND sky130_ef_sc_hd__decap_12
XFILLER_212_781 VPWR VGND VPWR VGND sky130_ef_sc_hd__decap_12
XFILLER_169_685 VPWR VGND VPWR VGND sky130_ef_sc_hd__decap_12
XFILLER_178_53 VPWR VGND VPWR VGND sky130_ef_sc_hd__decap_12
XFILLER_54_1177 VPWR VGND VPWR VGND sky130_ef_sc_hd__decap_12
XFILLER_8_813 VPWR VGND VPWR VGND sky130_ef_sc_hd__decap_12
XFILLER_106_1245 VGND VGND VPWR VPWR sky130_fd_sc_hd__fill_1
XFILLER_180_1185 VPWR VGND VPWR VGND sky130_ef_sc_hd__decap_12
XFILLER_223_1469 VPWR VGND VPWR VGND sky130_ef_sc_hd__decap_12
Xwire221 net222 VGND VGND VPWR VPWR net221 sky130_fd_sc_hd__clkbuf_1
Xwire232 net233 VGND VGND VPWR VPWR net232 sky130_fd_sc_hd__clkbuf_1
XFILLER_168_195 VGND VGND VPWR VPWR sky130_fd_sc_hd__fill_1
XFILLER_178_97 VPWR VGND VPWR VGND sky130_ef_sc_hd__decap_12
Xwire243 net245 VGND VGND VPWR VPWR net243 sky130_fd_sc_hd__clkbuf_1
XFILLER_71_1491 VGND VGND VPWR VPWR sky130_fd_sc_hd__decap_6
Xwire254 net255 VGND VGND VPWR VPWR net254 sky130_fd_sc_hd__clkbuf_1
Xwire265 net266 VGND VGND VPWR VPWR net265 sky130_fd_sc_hd__clkbuf_1
XFILLER_171_305 VPWR VGND VPWR VGND sky130_ef_sc_hd__decap_12
XPHY_EDGE_ROW_13_2_Right_104 VGND VGND VPWR VPWR sky130_fd_sc_hd__decap_3
Xwire276 net277 VGND VGND VPWR VPWR net276 sky130_fd_sc_hd__clkbuf_1
XFILLER_184_699 VGND VGND VPWR VPWR sky130_fd_sc_hd__fill_1
Xwire287 net288 VGND VGND VPWR VPWR net287 sky130_fd_sc_hd__clkbuf_1
Xwire298 net299 VGND VGND VPWR VPWR net298 sky130_fd_sc_hd__clkbuf_1
XFILLER_194_41 VPWR VGND VPWR VGND sky130_ef_sc_hd__decap_12
XFILLER_193_1513 VGND VGND VPWR VPWR sky130_fd_sc_hd__fill_2
XFILLER_171_349 VPWR VGND VPWR VGND sky130_ef_sc_hd__decap_12
XPHY_EDGE_ROW_226_Right_71 VGND VGND VPWR VPWR sky130_fd_sc_hd__decap_3
XFILLER_180_861 VGND VGND VPWR VPWR sky130_fd_sc_hd__decap_6
XFILLER_194_85 VPWR VGND VPWR VGND sky130_ef_sc_hd__decap_12
XTAP_TAPCELL_ROW_102_2_4368 VGND VPWR sky130_fd_sc_hd__tapvpwrvgnd_1
XFILLER_3_573 VGND VGND VPWR VPWR sky130_fd_sc_hd__fill_1
XFILLER_65_1273 VGND VGND VPWR VPWR sky130_fd_sc_hd__fill_1
XTAP_TAPCELL_ROW_189_1981 VGND VPWR sky130_fd_sc_hd__tapvpwrvgnd_1
XFILLER_191_1281 VGND VGND VPWR VPWR sky130_fd_sc_hd__decap_6
XTAP_TAPCELL_ROW_189_1992 VGND VPWR sky130_fd_sc_hd__tapvpwrvgnd_1
XFILLER_6_1329 VPWR VGND VPWR VGND sky130_ef_sc_hd__decap_12
XFILLER_238_133 VGND VGND VPWR VPWR sky130_fd_sc_hd__decap_6
XFILLER_117_1385 VGND VGND VPWR VPWR sky130_fd_sc_hd__fill_1
XFILLER_230_1429 VPWR VGND VPWR VGND sky130_ef_sc_hd__decap_12
XTAP_TAPCELL_ROW_185_1867 VGND VPWR sky130_fd_sc_hd__tapvpwrvgnd_1
XFILLER_213_15 VPWR VGND VPWR VGND sky130_ef_sc_hd__decap_12
XTAP_TAPCELL_ROW_185_1878 VGND VPWR sky130_fd_sc_hd__tapvpwrvgnd_1
XTAP_TAPCELL_ROW_185_1889 VGND VPWR sky130_fd_sc_hd__tapvpwrvgnd_1
XFILLER_238_177 VPWR VGND VPWR VGND sky130_ef_sc_hd__decap_12
XFILLER_254_637 VGND VGND VPWR VPWR sky130_fd_sc_hd__decap_6
XFILLER_253_125 VPWR VGND VPWR VGND sky130_ef_sc_hd__decap_12
XPHY_EDGE_ROW_235_Right_80 VGND VGND VPWR VPWR sky130_fd_sc_hd__decap_3
XTAP_TAPCELL_ROW_50_2_4055 VGND VPWR sky130_fd_sc_hd__tapvpwrvgnd_1
XFILLER_219_391 VGND VGND VPWR VPWR sky130_fd_sc_hd__fill_1
XTAP_TAPCELL_ROW_49_2_4049 VGND VPWR sky130_fd_sc_hd__tapvpwrvgnd_1
XFILLER_207_553 VGND VGND VPWR VPWR sky130_fd_sc_hd__decap_6
XFILLER_253_169 VPWR VGND VPWR VGND sky130_ef_sc_hd__decap_12
XFILLER_222_501 VPWR VGND VPWR VGND sky130_ef_sc_hd__decap_12
XFILLER_235_895 VGND VGND VPWR VPWR sky130_fd_sc_hd__fill_1
XFILLER_179_405 VPWR VGND VPWR VGND sky130_ef_sc_hd__decap_12
XFILLER_185_1063 VGND VGND VPWR VPWR sky130_fd_sc_hd__fill_1
XFILLER_207_597 VPWR VGND VPWR VGND sky130_ef_sc_hd__decap_12
XFILLER_222_545 VPWR VGND VPWR VGND sky130_ef_sc_hd__decap_12
XFILLER_179_449 VPWR VGND VPWR VGND sky130_ef_sc_hd__decap_12
XFILLER_37_1331 VPWR VGND VPWR VGND sky130_ef_sc_hd__decap_12
XFILLER_195_909 VPWR VGND VPWR VGND sky130_ef_sc_hd__decap_12
XFILLER_124_1301 VGND VGND VPWR VPWR sky130_fd_sc_hd__fill_1
XFILLER_188_961 VPWR VGND VPWR VGND sky130_ef_sc_hd__decap_12
XFILLER_222_589 VPWR VGND VPWR VGND sky130_ef_sc_hd__decap_12
XFILLER_194_419 VGND VGND VPWR VPWR sky130_fd_sc_hd__fill_1
XFILLER_226_1093 VPWR VGND VPWR VGND sky130_ef_sc_hd__decap_12
XFILLER_33_1217 VGND VGND VPWR VPWR sky130_fd_sc_hd__fill_1
XFILLER_202_1509 VGND VGND VPWR VPWR sky130_fd_sc_hd__decap_6
XFILLER_174_121 VPWR VGND VPWR VGND sky130_ef_sc_hd__decap_12
XTAP_TAPCELL_ROW_27_2_3919 VGND VPWR sky130_fd_sc_hd__tapvpwrvgnd_1
Xinput40 wr_data[8] VGND VGND VPWR VPWR net40 sky130_fd_sc_hd__clkbuf_1
XFILLER_174_165 VPWR VGND VPWR VGND sky130_ef_sc_hd__decap_12
XFILLER_190_625 VPWR VGND VPWR VGND sky130_ef_sc_hd__decap_12
Xmax_cap510 net511 VGND VGND VPWR VPWR net510 sky130_fd_sc_hd__clkbuf_1
Xmax_cap521 net522 VGND VGND VPWR VPWR net521 sky130_fd_sc_hd__buf_1
Xmax_cap532 net58 VGND VGND VPWR VPWR net532 sky130_fd_sc_hd__clkbuf_1
Xmax_cap543 net544 VGND VGND VPWR VPWR net543 sky130_fd_sc_hd__clkbuf_1
XFILLER_190_669 VPWR VGND VPWR VGND sky130_ef_sc_hd__decap_12
Xmax_cap554 net71 VGND VGND VPWR VPWR net554 sky130_fd_sc_hd__clkbuf_1
XFILLER_107_27 VPWR VGND VPWR VGND sky130_ef_sc_hd__decap_12
XFILLER_157_1165 VPWR VGND VPWR VGND sky130_ef_sc_hd__decap_12
XTAP_TAPCELL_ROW_227_3008 VGND VPWR sky130_fd_sc_hd__tapvpwrvgnd_1
XTAP_TAPCELL_ROW_227_3019 VGND VPWR sky130_fd_sc_hd__tapvpwrvgnd_1
XFILLER_48_1471 VPWR VGND VPWR VGND sky130_ef_sc_hd__decap_12
XFILLER_254_77 VGND VGND VPWR VPWR sky130_fd_sc_hd__decap_6
XFILLER_135_1441 VGND VGND VPWR VPWR sky130_fd_sc_hd__fill_1
XFILLER_229_111 VGND VGND VPWR VPWR sky130_fd_sc_hd__fill_1
XFILLER_44_1357 VGND VGND VPWR VPWR sky130_fd_sc_hd__fill_1
XTAP_TAPCELL_ROW_146_2_4633 VGND VPWR sky130_fd_sc_hd__tapvpwrvgnd_1
XFILLER_170_1365 VGND VGND VPWR VPWR sky130_fd_sc_hd__decap_6
XFILLER_123_15 VPWR VGND VPWR VGND sky130_ef_sc_hd__decap_12
XFILLER_245_615 VGND VGND VPWR VPWR sky130_fd_sc_hd__fill_1
XFILLER_217_317 VPWR VGND VPWR VGND sky130_ef_sc_hd__decap_12
XFILLER_232_309 VPWR VGND VPWR VGND sky130_ef_sc_hd__decap_12
XFILLER_129_1201 VPWR VGND VPWR VGND sky130_ef_sc_hd__decap_12
XFILLER_203_81 VPWR VGND VPWR VGND sky130_ef_sc_hd__decap_12
XFILLER_225_361 VPWR VGND VPWR VGND sky130_ef_sc_hd__decap_12
XFILLER_241_821 VPWR VGND VPWR VGND sky130_ef_sc_hd__decap_12
XFILLER_168_1261 VPWR VGND VPWR VGND sky130_ef_sc_hd__decap_12
XTAP_TAPCELL_ROW_203_2362 VGND VPWR sky130_fd_sc_hd__tapvpwrvgnd_1
XTAP_TAPCELL_ROW_203_2373 VGND VPWR sky130_fd_sc_hd__tapvpwrvgnd_1
XFILLER_198_725 VPWR VGND VPWR VGND sky130_ef_sc_hd__decap_12
XFILLER_77_1177 VPWR VGND VPWR VGND sky130_ef_sc_hd__decap_12
XFILLER_241_865 VPWR VGND VPWR VGND sky130_ef_sc_hd__decap_12
XTAP_TAPCELL_ROW_94_2_4320 VGND VPWR sky130_fd_sc_hd__tapvpwrvgnd_1
XFILLER_129_1267 VGND VGND VPWR VPWR sky130_fd_sc_hd__decap_6
XTAP_TAPCELL_ROW_195_2141 VGND VPWR sky130_fd_sc_hd__tapvpwrvgnd_1
XFILLER_198_769 VPWR VGND VPWR VGND sky130_ef_sc_hd__decap_12
XTAP_TAPCELL_ROW_195_2152 VGND VPWR sky130_fd_sc_hd__tapvpwrvgnd_1
XTAP_TAPCELL_ROW_195_2163 VGND VPWR sky130_fd_sc_hd__tapvpwrvgnd_1
XFILLER_201_729 VPWR VGND VPWR VGND sky130_ef_sc_hd__decap_12
XFILLER_16_1415 VPWR VGND VPWR VGND sky130_ef_sc_hd__decap_12
XFILLER_197_279 VGND VGND VPWR VPWR sky130_fd_sc_hd__fill_1
XFILLER_205_1133 VPWR VGND VPWR VGND sky130_ef_sc_hd__decap_12
XFILLER_8_109 VPWR VGND VPWR VGND sky130_ef_sc_hd__decap_12
XFILLER_240_1035 VGND VGND VPWR VPWR sky130_fd_sc_hd__fill_1
XFILLER_55_1497 VGND VGND VPWR VPWR sky130_fd_sc_hd__fill_1
XTAP_TAPCELL_ROW_191_2038 VGND VPWR sky130_fd_sc_hd__tapvpwrvgnd_1
XTAP_TAPCELL_ROW_216_2712 VGND VPWR sky130_fd_sc_hd__tapvpwrvgnd_1
XTAP_TAPCELL_ROW_191_2049 VGND VPWR sky130_fd_sc_hd__tapvpwrvgnd_1
XTAP_TAPCELL_ROW_216_2723 VGND VPWR sky130_fd_sc_hd__tapvpwrvgnd_1
XFILLER_205_1177 VPWR VGND VPWR VGND sky130_ef_sc_hd__decap_12
XFILLER_193_441 VGND VGND VPWR VPWR sky130_fd_sc_hd__decap_6
XPHY_EDGE_ROW_140_2_Right_231 VGND VGND VPWR VPWR sky130_fd_sc_hd__decap_3
XFILLER_165_165 VGND VGND VPWR VPWR sky130_fd_sc_hd__decap_3
XTAP_TAPCELL_ROW_212_2609 VGND VPWR sky130_fd_sc_hd__tapvpwrvgnd_1
XFILLER_166_699 VGND VGND VPWR VPWR sky130_fd_sc_hd__fill_1
XFILLER_193_485 VPWR VGND VPWR VGND sky130_ef_sc_hd__decap_12
XFILLER_140_1191 VPWR VGND VPWR VGND sky130_ef_sc_hd__decap_12
XFILLER_49_1213 VGND VGND VPWR VPWR sky130_fd_sc_hd__decap_4
XFILLER_106_3 VPWR VGND VPWR VGND sky130_ef_sc_hd__decap_12
XPHY_EDGE_ROW_78_1_Right_734 VGND VGND VPWR VPWR sky130_fd_sc_hd__decap_3
XFILLER_88_1295 VGND VGND VPWR VPWR sky130_fd_sc_hd__decap_6
XFILLER_136_1227 VPWR VGND VPWR VGND sky130_ef_sc_hd__decap_12
XFILLER_27_1511 VGND VGND VPWR VPWR sky130_fd_sc_hd__decap_4
XTAP_TAPCELL_ROW_11_1_1146 VGND VPWR sky130_fd_sc_hd__tapvpwrvgnd_1
XFILLER_175_1287 VGND VGND VPWR VPWR sky130_fd_sc_hd__fill_1
XFILLER_249_921 VPWR VGND VPWR VGND sky130_ef_sc_hd__decap_12
XFILLER_62_1413 VGND VGND VPWR VPWR sky130_fd_sc_hd__fill_1
XFILLER_216_1273 VPWR VGND VPWR VGND sky130_ef_sc_hd__decap_12
XFILLER_249_965 VPWR VGND VPWR VGND sky130_ef_sc_hd__decap_12
XFILLER_251_1175 VGND VGND VPWR VPWR sky130_fd_sc_hd__fill_1
XFILLER_248_475 VGND VGND VPWR VPWR sky130_fd_sc_hd__fill_1
XFILLER_236_637 VGND VGND VPWR VPWR sky130_fd_sc_hd__decap_6
XFILLER_235_125 VPWR VGND VPWR VGND sky130_ef_sc_hd__decap_12
XFILLER_180_65 VPWR VGND VPWR VGND sky130_ef_sc_hd__decap_12
XFILLER_112_1271 VPWR VGND VPWR VGND sky130_ef_sc_hd__decap_12
XTAP_TAPCELL_ROW_180_1742 VGND VPWR sky130_fd_sc_hd__tapvpwrvgnd_1
XFILLER_21_1165 VPWR VGND VPWR VGND sky130_ef_sc_hd__decap_12
XFILLER_235_169 VPWR VGND VPWR VGND sky130_ef_sc_hd__decap_12
XTAP_TAPCELL_ROW_180_1753 VGND VPWR sky130_fd_sc_hd__tapvpwrvgnd_1
XFILLER_251_629 VPWR VGND VPWR VGND sky130_ef_sc_hd__decap_12
XFILLER_204_501 VPWR VGND VPWR VGND sky130_ef_sc_hd__decap_12
XFILLER_217_895 VGND VGND VPWR VPWR sky130_fd_sc_hd__fill_1
XFILLER_244_681 VPWR VGND VPWR VGND sky130_ef_sc_hd__decap_12
XFILLER_95_1255 VPWR VGND VPWR VGND sky130_ef_sc_hd__decap_12
XFILLER_182_1203 VGND VGND VPWR VPWR sky130_fd_sc_hd__fill_1
XFILLER_147_1323 VGND VGND VPWR VPWR sky130_fd_sc_hd__decap_6
XFILLER_250_139 VGND VGND VPWR VPWR sky130_fd_sc_hd__fill_1
XFILLER_204_545 VPWR VGND VPWR VGND sky130_ef_sc_hd__decap_12
XFILLER_56_1239 VGND VGND VPWR VPWR sky130_fd_sc_hd__decap_6
XFILLER_95_1299 VPWR VGND VPWR VGND sky130_ef_sc_hd__decap_12
XFILLER_147_1367 VPWR VGND VPWR VGND sky130_ef_sc_hd__decap_12
XFILLER_177_909 VPWR VGND VPWR VGND sky130_ef_sc_hd__decap_12
XFILLER_204_589 VPWR VGND VPWR VGND sky130_ef_sc_hd__decap_12
XFILLER_176_419 VGND VGND VPWR VPWR sky130_fd_sc_hd__fill_1
XFILLER_223_1233 VPWR VGND VPWR VGND sky130_ef_sc_hd__decap_12
XFILLER_8_610 VPWR VGND VPWR VGND sky130_ef_sc_hd__decap_12
XTAP_TAPCELL_ROW_178_1682 VGND VPWR sky130_fd_sc_hd__tapvpwrvgnd_1
XTAP_TAPCELL_ROW_178_1693 VGND VPWR sky130_fd_sc_hd__tapvpwrvgnd_1
XFILLER_185_953 VPWR VGND VPWR VGND sky130_ef_sc_hd__decap_12
XTAP_TAPCELL_ROW_174_1579 VGND VPWR sky130_fd_sc_hd__tapvpwrvgnd_1
XFILLER_172_625 VPWR VGND VPWR VGND sky130_ef_sc_hd__decap_12
XFILLER_32_1283 VPWR VGND VPWR VGND sky130_ef_sc_hd__decap_12
XFILLER_171_113 VPWR VGND VPWR VGND sky130_ef_sc_hd__decap_12
XFILLER_208_15 VPWR VGND VPWR VGND sky130_ef_sc_hd__decap_12
XTAP_TAPCELL_ROW_152_2_4665 VGND VPWR sky130_fd_sc_hd__tapvpwrvgnd_1
XFILLER_176_1029 VGND VGND VPWR VPWR sky130_fd_sc_hd__decap_6
XPHY_EDGE_ROW_14_2_Right_105 VGND VGND VPWR VPWR sky130_fd_sc_hd__decap_3
XFILLER_172_669 VPWR VGND VPWR VGND sky130_ef_sc_hd__decap_12
XFILLER_158_1463 VGND VGND VPWR VPWR sky130_fd_sc_hd__decap_6
XFILLER_193_1343 VGND VGND VPWR VPWR sky130_fd_sc_hd__fill_1
XFILLER_67_1379 VGND VGND VPWR VPWR sky130_fd_sc_hd__decap_6
XFILLER_154_1327 VPWR VGND VPWR VGND sky130_ef_sc_hd__decap_12
XTAP_TAPCELL_ROW_187_1929 VGND VPWR sky130_fd_sc_hd__tapvpwrvgnd_1
XFILLER_234_1373 VPWR VGND VPWR VGND sky130_ef_sc_hd__decap_12
XFILLER_21_3 VPWR VGND VPWR VGND sky130_ef_sc_hd__decap_12
XFILLER_227_615 VGND VGND VPWR VPWR sky130_fd_sc_hd__fill_1
XFILLER_254_401 VPWR VGND VPWR VGND sky130_ef_sc_hd__decap_12
XTAP_TAPCELL_ROW_99_2_4346 VGND VPWR sky130_fd_sc_hd__tapvpwrvgnd_1
XFILLER_230_1259 VGND VGND VPWR VPWR sky130_fd_sc_hd__fill_1
XFILLER_239_497 VGND VGND VPWR VPWR sky130_fd_sc_hd__decap_6
XFILLER_254_445 VPWR VGND VPWR VGND sky130_ef_sc_hd__decap_12
XPHY_EDGE_ROW_40_1_Right_696 VGND VGND VPWR VPWR sky130_fd_sc_hd__decap_3
XFILLER_130_1371 VPWR VGND VPWR VGND sky130_ef_sc_hd__decap_12
XFILLER_214_309 VPWR VGND VPWR VGND sky130_ef_sc_hd__decap_12
XFILLER_254_489 VPWR VGND VPWR VGND sky130_ef_sc_hd__decap_12
XFILLER_187_1169 VGND VGND VPWR VPWR sky130_fd_sc_hd__decap_6
XFILLER_165_1401 VPWR VGND VPWR VGND sky130_ef_sc_hd__decap_12
XFILLER_207_361 VPWR VGND VPWR VGND sky130_ef_sc_hd__decap_12
XFILLER_223_821 VPWR VGND VPWR VGND sky130_ef_sc_hd__decap_12
XFILLER_74_1339 VPWR VGND VPWR VGND sky130_ef_sc_hd__decap_12
XFILLER_126_1407 VGND VGND VPWR VPWR sky130_fd_sc_hd__decap_6
XFILLER_223_865 VPWR VGND VPWR VGND sky130_ef_sc_hd__decap_12
XFILLER_179_279 VGND VGND VPWR VPWR sky130_fd_sc_hd__fill_1
XFILLER_206_1453 VPWR VGND VPWR VGND sky130_ef_sc_hd__decap_12
XFILLER_249_55 VGND VGND VPWR VPWR sky130_fd_sc_hd__fill_1
XFILLER_202_1317 VPWR VGND VPWR VGND sky130_ef_sc_hd__decap_12
XTAP_TAPCELL_ROW_252_3679 VGND VPWR sky130_fd_sc_hd__tapvpwrvgnd_1
XFILLER_175_441 VGND VGND VPWR VPWR sky130_fd_sc_hd__decap_6
XFILLER_206_1497 VPWR VGND VPWR VGND sky130_ef_sc_hd__decap_12
XFILLER_241_1399 VGND VGND VPWR VPWR sky130_fd_sc_hd__fill_1
XFILLER_175_485 VPWR VGND VPWR VGND sky130_ef_sc_hd__decap_12
XFILLER_11_1323 VGND VGND VPWR VPWR sky130_fd_sc_hd__decap_6
XFILLER_118_15 VPWR VGND VPWR VGND sky130_ef_sc_hd__decap_12
XFILLER_191_945 VGND VGND VPWR VPWR sky130_fd_sc_hd__decap_6
XFILLER_50_1383 VPWR VGND VPWR VGND sky130_ef_sc_hd__decap_12
XFILLER_102_1451 VPWR VGND VPWR VGND sky130_ef_sc_hd__decap_12
XFILLER_190_433 VPWR VGND VPWR VGND sky130_ef_sc_hd__decap_12
XFILLER_194_1129 VPWR VGND VPWR VGND sky130_ef_sc_hd__decap_12
XFILLER_11_1367 VPWR VGND VPWR VGND sky130_ef_sc_hd__decap_12
XFILLER_191_989 VPWR VGND VPWR VGND sky130_ef_sc_hd__decap_12
XFILLER_200_1085 VGND VGND VPWR VPWR sky130_fd_sc_hd__decap_6
XFILLER_85_1435 VGND VGND VPWR VPWR sky130_fd_sc_hd__decap_6
XFILLER_102_1495 VPWR VGND VPWR VGND sky130_ef_sc_hd__decap_12
XFILLER_190_477 VPWR VGND VPWR VGND sky130_ef_sc_hd__decap_12
XFILLER_1_307 VPWR VGND VPWR VGND sky130_ef_sc_hd__decap_12
XFILLER_85_1479 VPWR VGND VPWR VGND sky130_ef_sc_hd__decap_12
XFILLER_172_1427 VGND VGND VPWR VPWR sky130_fd_sc_hd__fill_1
XFILLER_249_217 VGND VGND VPWR VPWR sky130_fd_sc_hd__decap_6
XPHY_EDGE_ROW_132_2_Left_634 VGND VGND VPWR VPWR sky130_fd_sc_hd__decap_3
XFILLER_213_1413 VPWR VGND VPWR VGND sky130_ef_sc_hd__decap_12
XFILLER_44_1165 VPWR VGND VPWR VGND sky130_ef_sc_hd__decap_12
XTAP_TAPCELL_ROW_58_1_1193 VGND VPWR sky130_fd_sc_hd__tapvpwrvgnd_1
XFILLER_213_1457 VPWR VGND VPWR VGND sky130_ef_sc_hd__decap_12
XFILLER_94_29 VPWR VGND VPWR VGND sky130_ef_sc_hd__decap_12
XFILLER_170_1173 VPWR VGND VPWR VGND sky130_ef_sc_hd__decap_12
XTAP_TAPCELL_ROW_205_2413 VGND VPWR sky130_fd_sc_hd__tapvpwrvgnd_1
XFILLER_218_637 VGND VGND VPWR VPWR sky130_fd_sc_hd__decap_6
XTAP_TAPCELL_ROW_205_2424 VGND VPWR sky130_fd_sc_hd__tapvpwrvgnd_1
XFILLER_79_1217 VGND VGND VPWR VPWR sky130_fd_sc_hd__fill_1
XFILLER_217_125 VPWR VGND VPWR VGND sky130_ef_sc_hd__decap_12
XFILLER_248_1509 VGND VGND VPWR VPWR sky130_fd_sc_hd__decap_6
XFILLER_246_979 VGND VGND VPWR VPWR sky130_fd_sc_hd__fill_1
XFILLER_22_1463 VGND VGND VPWR VPWR sky130_fd_sc_hd__decap_6
XFILLER_217_169 VPWR VGND VPWR VGND sky130_ef_sc_hd__decap_12
XFILLER_233_629 VPWR VGND VPWR VGND sky130_ef_sc_hd__decap_12
XTAP_TAPCELL_ROW_197_2203 VGND VPWR sky130_fd_sc_hd__tapvpwrvgnd_1
XTAP_TAPCELL_ROW_197_2214 VGND VPWR sky130_fd_sc_hd__tapvpwrvgnd_1
XFILLER_226_681 VPWR VGND VPWR VGND sky130_ef_sc_hd__decap_12
XTAP_TAPCELL_ROW_1_885 VGND VPWR sky130_fd_sc_hd__tapvpwrvgnd_1
XFILLER_232_139 VGND VGND VPWR VPWR sky130_fd_sc_hd__fill_1
XTAP_TAPCELL_ROW_1_896 VGND VPWR sky130_fd_sc_hd__tapvpwrvgnd_1
X_390_ net590 net583 net70 VGND VGND VPWR VPWR _179_ sky130_fd_sc_hd__a21oi_1
XFILLER_168_1091 VGND VGND VPWR VPWR sky130_fd_sc_hd__fill_1
XFILLER_198_533 VPWR VGND VPWR VGND sky130_ef_sc_hd__decap_12
XFILLER_92_1439 VPWR VGND VPWR VGND sky130_ef_sc_hd__decap_12
XFILLER_144_1507 VGND VGND VPWR VPWR sky130_fd_sc_hd__decap_8
XFILLER_241_673 VPWR VGND VPWR VGND sky130_ef_sc_hd__decap_12
XFILLER_185_205 VPWR VGND VPWR VGND sky130_ef_sc_hd__decap_12
XFILLER_199_1007 VGND VGND VPWR VPWR sky130_fd_sc_hd__fill_1
XFILLER_159_55 VGND VGND VPWR VPWR sky130_fd_sc_hd__fill_1
XFILLER_201_559 VGND VGND VPWR VPWR sky130_fd_sc_hd__fill_1
XFILLER_16_1245 VGND VGND VPWR VPWR sky130_fd_sc_hd__fill_1
XFILLER_167_953 VPWR VGND VPWR VGND sky130_ef_sc_hd__decap_12
XFILLER_185_249 VPWR VGND VPWR VGND sky130_ef_sc_hd__decap_12
XFILLER_223_3 VPWR VGND VPWR VGND sky130_ef_sc_hd__decap_12
XPHY_EDGE_ROW_146_1_Left_401 VGND VGND VPWR VPWR sky130_fd_sc_hd__decap_3
XFILLER_182_923 VGND VGND VPWR VPWR sky130_fd_sc_hd__fill_1
XTAP_TAPCELL_ROW_137_2_4578 VGND VPWR sky130_fd_sc_hd__tapvpwrvgnd_1
XPHY_EDGE_ROW_141_2_Right_232 VGND VGND VPWR VPWR sky130_fd_sc_hd__decap_3
XFILLER_4_112 VPWR VGND VPWR VGND sky130_ef_sc_hd__decap_12
XFILLER_193_293 VPWR VGND VPWR VGND sky130_ef_sc_hd__decap_12
XPHY_EDGE_ROW_64_2_Left_566 VGND VGND VPWR VPWR sky130_fd_sc_hd__decap_3
XFILLER_4_27 VGND VGND VPWR VPWR sky130_fd_sc_hd__fill_1
XPHY_EDGE_ROW_79_1_Right_735 VGND VGND VPWR VPWR sky130_fd_sc_hd__decap_3
XTAP_TAPCELL_ROW_117_2_4454 VGND VPWR sky130_fd_sc_hd__tapvpwrvgnd_1
XFILLER_68_41 VPWR VGND VPWR VGND sky130_ef_sc_hd__decap_12
XFILLER_7_1413 VPWR VGND VPWR VGND sky130_ef_sc_hd__decap_12
XFILLER_231_1513 VGND VGND VPWR VPWR sky130_fd_sc_hd__fill_2
XFILLER_1_885 VGND VGND VPWR VPWR sky130_fd_sc_hd__decap_8
XFILLER_255_209 VPWR VGND VPWR VGND sky130_ef_sc_hd__decap_12
XTAP_TAPCELL_ROW_85_2_4265 VGND VPWR sky130_fd_sc_hd__tapvpwrvgnd_1
XFILLER_27_1385 VGND VGND VPWR VPWR sky130_fd_sc_hd__fill_1
XTAP_TAPCELL_ROW_182_1804 VGND VPWR sky130_fd_sc_hd__tapvpwrvgnd_1
XFILLER_236_401 VPWR VGND VPWR VGND sky130_ef_sc_hd__decap_12
XFILLER_7_1457 VPWR VGND VPWR VGND sky130_ef_sc_hd__decap_12
XFILLER_209_615 VGND VGND VPWR VPWR sky130_fd_sc_hd__fill_1
XTAP_TAPCELL_ROW_167_1383 VGND VPWR sky130_fd_sc_hd__tapvpwrvgnd_1
XTAP_TAPCELL_ROW_167_1394 VGND VPWR sky130_fd_sc_hd__tapvpwrvgnd_1
XFILLER_236_445 VPWR VGND VPWR VGND sky130_ef_sc_hd__decap_12
XFILLER_252_905 VPWR VGND VPWR VGND sky130_ef_sc_hd__decap_12
XFILLER_1_1001 VGND VGND VPWR VPWR sky130_fd_sc_hd__decap_6
XFILLER_184_1309 VGND VGND VPWR VPWR sky130_fd_sc_hd__decap_6
XFILLER_236_489 VPWR VGND VPWR VGND sky130_ef_sc_hd__decap_12
XFILLER_252_949 VPWR VGND VPWR VGND sky130_ef_sc_hd__decap_12
X_657_ clknet_3_4__leaf_clk acc_core.adder.cla_blocks\[5\].block.sum\[3\] _065_ VGND
+ VGND VPWR VPWR net58 sky130_fd_sc_hd__dfrtp_1
XFILLER_1_1045 VPWR VGND VPWR VGND sky130_ef_sc_hd__decap_12
XFILLER_205_821 VPWR VGND VPWR VGND sky130_ef_sc_hd__decap_12
XFILLER_1_1089 VPWR VGND VPWR VGND sky130_ef_sc_hd__decap_12
XFILLER_205_865 VPWR VGND VPWR VGND sky130_ef_sc_hd__decap_12
XFILLER_210_27 VGND VGND VPWR VPWR sky130_fd_sc_hd__fill_1
X_588_ net670 VGND VGND VPWR VPWR _070_ sky130_fd_sc_hd__inv_2
XFILLER_220_813 VPWR VGND VPWR VGND sky130_ef_sc_hd__decap_12
XFILLER_231_161 VGND VGND VPWR VPWR sky130_fd_sc_hd__decap_6
XFILLER_34_1301 VGND VGND VPWR VPWR sky130_fd_sc_hd__fill_1
XPHY_EDGE_ROW_78_1_Left_333 VGND VGND VPWR VPWR sky130_fd_sc_hd__decap_3
XFILLER_223_1063 VGND VGND VPWR VPWR sky130_fd_sc_hd__fill_1
XFILLER_185_783 VGND VGND VPWR VPWR sky130_fd_sc_hd__fill_1
XFILLER_200_581 VGND VGND VPWR VPWR sky130_fd_sc_hd__decap_6
XPHY_EDGE_ROW_130_1_Left_385 VGND VGND VPWR VPWR sky130_fd_sc_hd__decap_3
XFILLER_69_3 VPWR VGND VPWR VGND sky130_ef_sc_hd__decap_12
XFILLER_173_945 VGND VGND VPWR VPWR sky130_fd_sc_hd__decap_6
XFILLER_219_69 VPWR VGND VPWR VGND sky130_ef_sc_hd__decap_12
XFILLER_172_433 VPWR VGND VPWR VGND sky130_ef_sc_hd__decap_12
XFILLER_195_1449 VGND VGND VPWR VPWR sky130_fd_sc_hd__decap_6
XFILLER_173_989 VPWR VGND VPWR VGND sky130_ef_sc_hd__decap_12
XFILLER_172_477 VPWR VGND VPWR VGND sky130_ef_sc_hd__decap_12
XPHY_EDGE_ROW_15_2_Right_106 VGND VGND VPWR VPWR sky130_fd_sc_hd__decap_3
XFILLER_158_1271 VPWR VGND VPWR VGND sky130_ef_sc_hd__decap_12
XFILLER_67_1165 VPWR VGND VPWR VGND sky130_ef_sc_hd__decap_12
XFILLER_235_57 VPWR VGND VPWR VGND sky130_ef_sc_hd__decap_12
XFILLER_119_1255 VPWR VGND VPWR VGND sky130_ef_sc_hd__decap_12
XFILLER_45_1441 VGND VGND VPWR VPWR sky130_fd_sc_hd__fill_1
XFILLER_119_1299 VPWR VGND VPWR VGND sky130_ef_sc_hd__decap_12
XFILLER_246_209 VPWR VGND VPWR VGND sky130_ef_sc_hd__decap_12
XTAP_TAPCELL_ROW_245_3494 VGND VPWR sky130_fd_sc_hd__tapvpwrvgnd_1
XFILLER_239_261 VPWR VGND VPWR VGND sky130_ef_sc_hd__decap_12
XFILLER_171_1493 VPWR VGND VPWR VGND sky130_ef_sc_hd__decap_12
XFILLER_228_979 VGND VGND VPWR VPWR sky130_fd_sc_hd__fill_1
XFILLER_254_253 VPWR VGND VPWR VGND sky130_ef_sc_hd__decap_12
XFILLER_215_629 VPWR VGND VPWR VGND sky130_ef_sc_hd__decap_12
XPHY_EDGE_ROW_41_1_Right_697 VGND VGND VPWR VPWR sky130_fd_sc_hd__decap_3
XFILLER_208_681 VPWR VGND VPWR VGND sky130_ef_sc_hd__decap_12
XFILLER_214_139 VGND VGND VPWR VPWR sky130_fd_sc_hd__fill_1
XFILLER_78_1283 VPWR VGND VPWR VGND sky130_ef_sc_hd__decap_12
XFILLER_120_27 VGND VGND VPWR VPWR sky130_fd_sc_hd__fill_1
XFILLER_39_1267 VGND VGND VPWR VPWR sky130_fd_sc_hd__decap_6
XFILLER_126_1215 VPWR VGND VPWR VGND sky130_ef_sc_hd__decap_12
XFILLER_223_673 VPWR VGND VPWR VGND sky130_ef_sc_hd__decap_12
XFILLER_195_503 VGND VGND VPWR VPWR sky130_fd_sc_hd__fill_1
XFILLER_210_301 VGND VGND VPWR VPWR sky130_fd_sc_hd__decap_6
XFILLER_167_205 VPWR VGND VPWR VGND sky130_ef_sc_hd__decap_12
XFILLER_126_1259 VPWR VGND VPWR VGND sky130_ef_sc_hd__decap_12
XFILLER_210_345 VPWR VGND VPWR VGND sky130_ef_sc_hd__decap_12
XFILLER_167_249 VPWR VGND VPWR VGND sky130_ef_sc_hd__decap_12
XFILLER_206_1261 VPWR VGND VPWR VGND sky130_ef_sc_hd__decap_12
XFILLER_183_709 VPWR VGND VPWR VGND sky130_ef_sc_hd__decap_12
XFILLER_210_389 VPWR VGND VPWR VGND sky130_ef_sc_hd__decap_12
XFILLER_13_69 VGND VGND VPWR VPWR sky130_fd_sc_hd__fill_2
XFILLER_202_1147 VGND VGND VPWR VPWR sky130_fd_sc_hd__fill_1
XFILLER_129_69 VGND VGND VPWR VPWR sky130_fd_sc_hd__fill_2
XFILLER_175_293 VPWR VGND VPWR VGND sky130_ef_sc_hd__decap_12
XFILLER_198_1073 VPWR VGND VPWR VGND sky130_ef_sc_hd__decap_12
XFILLER_191_753 VPWR VGND VPWR VGND sky130_ef_sc_hd__decap_12
XFILLER_50_1191 VPWR VGND VPWR VGND sky130_ef_sc_hd__decap_12
XTAP_TAPCELL_ROW_103_2_4373 VGND VPWR sky130_fd_sc_hd__tapvpwrvgnd_1
XFILLER_191_797 VPWR VGND VPWR VGND sky130_ef_sc_hd__decap_12
XFILLER_85_1243 VPWR VGND VPWR VGND sky130_ef_sc_hd__decap_12
XFILLER_137_1311 VPWR VGND VPWR VGND sky130_ef_sc_hd__decap_12
XFILLER_176_1371 VGND VGND VPWR VPWR sky130_fd_sc_hd__fill_1
Xmax_cap181 net182 VGND VGND VPWR VPWR net181 sky130_fd_sc_hd__clkbuf_1
XFILLER_46_1227 VPWR VGND VPWR VGND sky130_ef_sc_hd__decap_12
XFILLER_1_137 VPWR VGND VPWR VGND sky130_ef_sc_hd__decap_12
Xmax_cap192 _217_ VGND VGND VPWR VPWR net192 sky130_fd_sc_hd__clkbuf_1
XFILLER_145_57 VPWR VGND VPWR VGND sky130_ef_sc_hd__decap_12
XFILLER_85_1287 VPWR VGND VPWR VGND sky130_ef_sc_hd__decap_12
XFILLER_137_1355 VPWR VGND VPWR VGND sky130_ef_sc_hd__decap_12
XFILLER_133_1219 VPWR VGND VPWR VGND sky130_ef_sc_hd__decap_12
XFILLER_137_1399 VPWR VGND VPWR VGND sky130_ef_sc_hd__decap_12
XFILLER_218_401 VPWR VGND VPWR VGND sky130_ef_sc_hd__decap_12
XFILLER_213_1287 VGND VGND VPWR VPWR sky130_fd_sc_hd__fill_1
XFILLER_218_445 VPWR VGND VPWR VGND sky130_ef_sc_hd__decap_12
XFILLER_234_905 VPWR VGND VPWR VGND sky130_ef_sc_hd__decap_12
XTAP_TAPCELL_ROW_51_2_4060 VGND VPWR sky130_fd_sc_hd__tapvpwrvgnd_1
XFILLER_248_1317 VPWR VGND VPWR VGND sky130_ef_sc_hd__decap_12
XFILLER_173_3 VPWR VGND VPWR VGND sky130_ef_sc_hd__decap_12
XFILLER_22_1271 VPWR VGND VPWR VGND sky130_ef_sc_hd__decap_12
X_511_ net596 dout0_q\[30\] net525 VGND VGND VPWR VPWR _262_ sky130_fd_sc_hd__and3_1
XFILLER_218_489 VPWR VGND VPWR VGND sky130_ef_sc_hd__decap_12
XFILLER_234_949 VPWR VGND VPWR VGND sky130_ef_sc_hd__decap_12
XFILLER_166_1017 VPWR VGND VPWR VGND sky130_ef_sc_hd__decap_12
XFILLER_2_1365 VGND VGND VPWR VPWR sky130_fd_sc_hd__decap_6
XFILLER_57_1323 VGND VGND VPWR VPWR sky130_fd_sc_hd__decap_6
XFILLER_92_1203 VPWR VGND VPWR VGND sky130_ef_sc_hd__decap_12
X_442_ _224_ _226_ _230_ net196 VGND VGND VPWR VPWR _231_ sky130_fd_sc_hd__a211o_1
XFILLER_96_1383 VPWR VGND VPWR VGND sky130_ef_sc_hd__decap_12
XFILLER_148_1451 VPWR VGND VPWR VGND sky130_ef_sc_hd__decap_12
XFILLER_54_65 VGND VGND VPWR VPWR sky130_fd_sc_hd__decap_6
XFILLER_199_853 VPWR VGND VPWR VGND sky130_ef_sc_hd__decap_12
XFILLER_220_109 VPWR VGND VPWR VGND sky130_ef_sc_hd__decap_12
XFILLER_92_1247 VPWR VGND VPWR VGND sky130_ef_sc_hd__decap_12
XFILLER_202_813 VPWR VGND VPWR VGND sky130_ef_sc_hd__decap_12
XFILLER_242_993 VPWR VGND VPWR VGND sky130_ef_sc_hd__decap_12
XFILLER_57_1367 VPWR VGND VPWR VGND sky130_ef_sc_hd__decap_12
XFILLER_109_1435 VGND VGND VPWR VPWR sky130_fd_sc_hd__decap_6
XFILLER_144_1315 VPWR VGND VPWR VGND sky130_ef_sc_hd__decap_12
XFILLER_213_161 VGND VGND VPWR VPWR sky130_fd_sc_hd__decap_6
XFILLER_246_1085 VGND VGND VPWR VPWR sky130_fd_sc_hd__decap_6
XFILLER_148_1495 VPWR VGND VPWR VGND sky130_ef_sc_hd__decap_12
XFILLER_198_363 VGND VGND VPWR VPWR sky130_fd_sc_hd__fill_1
X_373_ net244 _161_ VGND VGND VPWR VPWR _162_ sky130_fd_sc_hd__nand2_1
XFILLER_199_897 VPWR VGND VPWR VGND sky130_ef_sc_hd__decap_12
XFILLER_186_525 VGND VGND VPWR VPWR sky130_fd_sc_hd__decap_6
XFILLER_144_1359 VPWR VGND VPWR VGND sky130_ef_sc_hd__decap_12
XFILLER_109_1479 VPWR VGND VPWR VGND sky130_ef_sc_hd__decap_12
XFILLER_9_237 VPWR VGND VPWR VGND sky130_ef_sc_hd__decap_12
XFILLER_220_1203 VGND VGND VPWR VPWR sky130_fd_sc_hd__fill_1
XFILLER_186_569 VPWR VGND VPWR VGND sky130_ef_sc_hd__decap_12
XFILLER_70_53 VPWR VGND VPWR VGND sky130_ef_sc_hd__decap_12
XTAP_TAPCELL_ROW_28_2_3924 VGND VPWR sky130_fd_sc_hd__tapvpwrvgnd_1
XFILLER_167_783 VGND VGND VPWR VPWR sky130_fd_sc_hd__fill_1
XTAP_TAPCELL_ROW_171_1505 VGND VPWR sky130_fd_sc_hd__tapvpwrvgnd_1
XFILLER_186_53 VPWR VGND VPWR VGND sky130_ef_sc_hd__decap_12
XPHY_EDGE_ROW_167_Right_12 VGND VGND VPWR VPWR sky130_fd_sc_hd__decap_3
XFILLER_177_1113 VGND VGND VPWR VPWR sky130_fd_sc_hd__decap_6
XFILLER_186_97 VPWR VGND VPWR VGND sky130_ef_sc_hd__decap_12
XPHY_EDGE_ROW_142_2_Right_233 VGND VGND VPWR VPWR sky130_fd_sc_hd__decap_3
XFILLER_177_1157 VPWR VGND VPWR VGND sky130_ef_sc_hd__decap_12
XFILLER_170_937 VPWR VGND VPWR VGND sky130_ef_sc_hd__decap_12
XFILLER_253_1001 VGND VGND VPWR VPWR sky130_fd_sc_hd__decap_6
XFILLER_79_51 VGND VGND VPWR VPWR sky130_fd_sc_hd__decap_4
XFILLER_68_1463 VGND VGND VPWR VPWR sky130_fd_sc_hd__decap_6
XFILLER_155_1411 VPWR VGND VPWR VGND sky130_ef_sc_hd__decap_12
XFILLER_64_1327 VPWR VGND VPWR VGND sky130_ef_sc_hd__decap_12
XFILLER_253_1045 VPWR VGND VPWR VGND sky130_ef_sc_hd__decap_12
XFILLER_155_1455 VPWR VGND VPWR VGND sky130_ef_sc_hd__decap_12
XTAP_TAPCELL_ROW_169_1445 VGND VPWR sky130_fd_sc_hd__tapvpwrvgnd_1
XFILLER_116_1439 VPWR VGND VPWR VGND sky130_ef_sc_hd__decap_12
XTAP_TAPCELL_ROW_169_1456 VGND VPWR sky130_fd_sc_hd__tapvpwrvgnd_1
XFILLER_214_1029 VGND VGND VPWR VPWR sky130_fd_sc_hd__decap_6
XFILLER_253_1089 VPWR VGND VPWR VGND sky130_ef_sc_hd__decap_12
XFILLER_205_27 VPWR VGND VPWR VGND sky130_ef_sc_hd__decap_12
XFILLER_155_1499 VPWR VGND VPWR VGND sky130_ef_sc_hd__decap_12
XFILLER_228_209 VPWR VGND VPWR VGND sky130_ef_sc_hd__decap_12
XTAP_TAPCELL_ROW_165_1309 VGND VPWR sky130_fd_sc_hd__tapvpwrvgnd_1
XFILLER_237_721 VGND VGND VPWR VPWR sky130_fd_sc_hd__decap_6
XFILLER_0_181 VPWR VGND VPWR VGND sky130_ef_sc_hd__decap_12
XFILLER_231_1343 VGND VGND VPWR VPWR sky130_fd_sc_hd__fill_1
XPHY_EDGE_ROW_176_Right_21 VGND VGND VPWR VPWR sky130_fd_sc_hd__decap_3
XFILLER_7_1287 VGND VGND VPWR VPWR sky130_fd_sc_hd__fill_1
XTAP_TAPCELL_ROW_160_2_4716 VGND VPWR sky130_fd_sc_hd__tapvpwrvgnd_1
XFILLER_237_765 VPWR VGND VPWR VGND sky130_ef_sc_hd__decap_12
XFILLER_236_253 VPWR VGND VPWR VGND sky130_ef_sc_hd__decap_12
XFILLER_252_713 VPWR VGND VPWR VGND sky130_ef_sc_hd__decap_12
XFILLER_188_1253 VGND VGND VPWR VPWR sky130_fd_sc_hd__decap_6
XFILLER_221_15 VPWR VGND VPWR VGND sky130_ef_sc_hd__decap_12
XFILLER_40_1371 VPWR VGND VPWR VGND sky130_ef_sc_hd__decap_12
XFILLER_184_1117 VPWR VGND VPWR VGND sky130_ef_sc_hd__decap_12
XFILLER_251_223 VGND VGND VPWR VPWR sky130_fd_sc_hd__fill_1
XFILLER_188_1297 VPWR VGND VPWR VGND sky130_ef_sc_hd__decap_12
XFILLER_252_757 VPWR VGND VPWR VGND sky130_ef_sc_hd__decap_12
XFILLER_75_1423 VPWR VGND VPWR VGND sky130_ef_sc_hd__decap_12
XFILLER_36_1407 VGND VGND VPWR VPWR sky130_fd_sc_hd__decap_6
XFILLER_205_673 VPWR VGND VPWR VGND sky130_ef_sc_hd__decap_12
XFILLER_75_1467 VPWR VGND VPWR VGND sky130_ef_sc_hd__decap_12
XFILLER_162_1415 VPWR VGND VPWR VGND sky130_ef_sc_hd__decap_12
XFILLER_177_503 VGND VGND VPWR VPWR sky130_fd_sc_hd__fill_1
XFILLER_189_385 VGND VGND VPWR VPWR sky130_fd_sc_hd__decap_6
XFILLER_220_643 VGND VGND VPWR VPWR sky130_fd_sc_hd__fill_1
XFILLER_225_1169 VGND VGND VPWR VPWR sky130_fd_sc_hd__decap_6
XFILLER_203_1401 VPWR VGND VPWR VGND sky130_ef_sc_hd__decap_12
XPHY_EDGE_ROW_185_Right_30 VGND VGND VPWR VPWR sky130_fd_sc_hd__decap_3
XFILLER_242_1483 VGND VGND VPWR VPWR sky130_fd_sc_hd__fill_1
XTAP_TAPCELL_ROW_234_3195 VGND VPWR sky130_fd_sc_hd__tapvpwrvgnd_1
XFILLER_195_1213 VPWR VGND VPWR VGND sky130_ef_sc_hd__decap_12
XFILLER_173_753 VPWR VGND VPWR VGND sky130_ef_sc_hd__decap_12
XFILLER_12_1451 VPWR VGND VPWR VGND sky130_ef_sc_hd__decap_12
XFILLER_199_1393 VGND VGND VPWR VPWR sky130_fd_sc_hd__decap_6
XFILLER_121_1189 VPWR VGND VPWR VGND sky130_ef_sc_hd__decap_12
XFILLER_195_1257 VPWR VGND VPWR VGND sky130_ef_sc_hd__decap_12
XFILLER_173_797 VPWR VGND VPWR VGND sky130_ef_sc_hd__decap_12
XFILLER_12_1495 VPWR VGND VPWR VGND sky130_ef_sc_hd__decap_12
XFILLER_173_1511 VGND VGND VPWR VPWR sky130_fd_sc_hd__fill_1
XTAP_TAPCELL_ROW_247_3545 VGND VPWR sky130_fd_sc_hd__tapvpwrvgnd_1
XTAP_TAPCELL_ROW_247_3556 VGND VPWR sky130_fd_sc_hd__tapvpwrvgnd_1
XPHY_EDGE_ROW_16_2_Right_107 VGND VGND VPWR VPWR sky130_fd_sc_hd__decap_3
XFILLER_5_81 VGND VGND VPWR VPWR sky130_fd_sc_hd__decap_6
XFILLER_82_1427 VPWR VGND VPWR VGND sky130_ef_sc_hd__decap_12
XTAP_TAPCELL_ROW_247_3567 VGND VPWR sky130_fd_sc_hd__tapvpwrvgnd_1
XFILLER_8_1029 VGND VGND VPWR VPWR sky130_fd_sc_hd__decap_6
XFILLER_115_27 VPWR VGND VPWR VGND sky130_ef_sc_hd__decap_12
XFILLER_232_1129 VPWR VGND VPWR VGND sky130_ef_sc_hd__decap_12
XFILLER_247_529 VPWR VGND VPWR VGND sky130_ef_sc_hd__decap_12
XTAP_TAPCELL_ROW_3_936 VGND VPWR sky130_fd_sc_hd__tapvpwrvgnd_1
XTAP_TAPCELL_ROW_3_947 VGND VPWR sky130_fd_sc_hd__tapvpwrvgnd_1
XFILLER_210_1427 VGND VGND VPWR VPWR sky130_fd_sc_hd__fill_1
XFILLER_216_905 VPWR VGND VPWR VGND sky130_ef_sc_hd__decap_12
XFILLER_255_573 VPWR VGND VPWR VGND sky130_ef_sc_hd__decap_12
XFILLER_131_15 VPWR VGND VPWR VGND sky130_ef_sc_hd__decap_12
XFILLER_216_949 VPWR VGND VPWR VGND sky130_ef_sc_hd__decap_12
XFILLER_199_105 VGND VGND VPWR VPWR sky130_fd_sc_hd__decap_6
XFILLER_167_1337 VGND VGND VPWR VPWR sky130_fd_sc_hd__decap_6
XTAP_TAPCELL_ROW_34_2_3956 VGND VPWR sky130_fd_sc_hd__tapvpwrvgnd_1
XPHY_EDGE_ROW_42_1_Right_698 VGND VGND VPWR VPWR sky130_fd_sc_hd__decap_3
XFILLER_242_245 VGND VGND VPWR VPWR sky130_fd_sc_hd__decap_6
XFILLER_199_149 VPWR VGND VPWR VGND sky130_ef_sc_hd__decap_12
XFILLER_202_109 VPWR VGND VPWR VGND sky130_ef_sc_hd__decap_12
XFILLER_242_289 VPWR VGND VPWR VGND sky130_ef_sc_hd__decap_12
XFILLER_54_1507 VGND VGND VPWR VPWR sky130_fd_sc_hd__decap_8
XFILLER_243_1225 VGND VGND VPWR VPWR sky130_fd_sc_hd__decap_6
XFILLER_165_1061 VGND VGND VPWR VPWR sky130_fd_sc_hd__decap_3
XFILLER_211_81 VPWR VGND VPWR VGND sky130_ef_sc_hd__decap_12
XFILLER_224_993 VPWR VGND VPWR VGND sky130_ef_sc_hd__decap_12
XFILLER_168_525 VGND VGND VPWR VPWR sky130_fd_sc_hd__decap_6
XFILLER_243_1269 VPWR VGND VPWR VGND sky130_ef_sc_hd__decap_12
XFILLER_196_867 VGND VGND VPWR VPWR sky130_fd_sc_hd__fill_1
XFILLER_211_665 VGND VGND VPWR VPWR sky130_fd_sc_hd__decap_6
XFILLER_168_569 VPWR VGND VPWR VGND sky130_ef_sc_hd__decap_12
XFILLER_210_153 VPWR VGND VPWR VGND sky130_ef_sc_hd__decap_12
Xwire628 net4 VGND VGND VPWR VPWR net628 sky130_fd_sc_hd__clkbuf_1
XFILLER_183_517 VPWR VGND VPWR VGND sky130_ef_sc_hd__decap_12
Xwire639 net640 VGND VGND VPWR VPWR net639 sky130_fd_sc_hd__buf_1
XFILLER_206_1091 VGND VGND VPWR VPWR sky130_fd_sc_hd__fill_1
XFILLER_210_197 VPWR VGND VPWR VGND sky130_ef_sc_hd__decap_12
XTAP_TAPCELL_ROW_153_2_4670 VGND VPWR sky130_fd_sc_hd__tapvpwrvgnd_1
XFILLER_237_1007 VGND VGND VPWR VPWR sky130_fd_sc_hd__fill_1
XFILLER_40_67 VGND VGND VPWR VPWR sky130_fd_sc_hd__fill_1
XFILLER_191_561 VPWR VGND VPWR VGND sky130_ef_sc_hd__decap_12
XFILLER_178_1477 VGND VGND VPWR VPWR sky130_fd_sc_hd__decap_6
XFILLER_2_457 VGND VGND VPWR VPWR sky130_fd_sc_hd__fill_1
XFILLER_254_1365 VGND VGND VPWR VPWR sky130_fd_sc_hd__decap_6
XFILLER_250_1229 VPWR VGND VPWR VGND sky130_ef_sc_hd__decap_12
XFILLER_172_77 VGND VGND VPWR VPWR sky130_fd_sc_hd__decap_6
XFILLER_219_721 VGND VGND VPWR VPWR sky130_fd_sc_hd__decap_6
XFILLER_4_1427 VGND VGND VPWR VPWR sky130_fd_sc_hd__fill_1
XFILLER_219_765 VPWR VGND VPWR VGND sky130_ef_sc_hd__decap_12
XFILLER_65_31 VPWR VGND VPWR VGND sky130_ef_sc_hd__decap_12
XFILLER_218_253 VPWR VGND VPWR VGND sky130_ef_sc_hd__decap_12
XFILLER_234_713 VPWR VGND VPWR VGND sky130_ef_sc_hd__decap_12
XFILLER_233_223 VGND VGND VPWR VPWR sky130_fd_sc_hd__fill_1
XFILLER_248_1147 VGND VGND VPWR VPWR sky130_fd_sc_hd__fill_1
XFILLER_234_757 VPWR VGND VPWR VGND sky130_ef_sc_hd__decap_12
XFILLER_185_1437 VPWR VGND VPWR VGND sky130_ef_sc_hd__decap_12
XTAP_TAPCELL_ROW_125_2_4505 VGND VPWR sky130_fd_sc_hd__tapvpwrvgnd_1
XFILLER_2_1173 VPWR VGND VPWR VGND sky130_ef_sc_hd__decap_12
XTAP_TAPCELL_ROW_114_1_1249 VGND VPWR sky130_fd_sc_hd__tapvpwrvgnd_1
XFILLER_96_1191 VPWR VGND VPWR VGND sky130_ef_sc_hd__decap_12
XFILLER_221_429 VPWR VGND VPWR VGND sky130_ef_sc_hd__decap_12
X_425_ net595 dout0_q\[23\] net532 VGND VGND VPWR VPWR _214_ sky130_fd_sc_hd__a21oi_1
XFILLER_109_1243 VPWR VGND VPWR VGND sky130_ef_sc_hd__decap_12
XFILLER_202_643 VGND VGND VPWR VPWR sky130_fd_sc_hd__fill_1
XFILLER_222_1309 VGND VGND VPWR VPWR sky130_fd_sc_hd__decap_6
XFILLER_186_333 VPWR VGND VPWR VGND sky130_ef_sc_hd__decap_12
X_356_ net334 net333 net165 _134_ VGND VGND VPWR VPWR _145_ sky130_fd_sc_hd__or4b_1
XFILLER_109_1287 VPWR VGND VPWR VGND sky130_ef_sc_hd__decap_12
XFILLER_187_889 VGND VGND VPWR VPWR sky130_fd_sc_hd__decap_6
XFILLER_144_1189 VGND VGND VPWR VPWR sky130_fd_sc_hd__fill_1
XFILLER_186_377 VPWR VGND VPWR VGND sky130_ef_sc_hd__decap_12
X_287_ net610 net611 net520 VGND VGND VPWR VPWR _084_ sky130_fd_sc_hd__and3_1
XFILLER_6_752 VGND VGND VPWR VPWR sky130_fd_sc_hd__fill_1
XFILLER_170_701 VPWR VGND VPWR VGND sky130_ef_sc_hd__decap_12
XPHY_EDGE_ROW_143_2_Right_234 VGND VGND VPWR VPWR sky130_fd_sc_hd__decap_3
XFILLER_216_15 VPWR VGND VPWR VGND sky130_ef_sc_hd__decap_12
XFILLER_68_1271 VPWR VGND VPWR VGND sky130_ef_sc_hd__decap_12
XFILLER_29_1255 VPWR VGND VPWR VGND sky130_ef_sc_hd__decap_12
XFILLER_116_1203 VPWR VGND VPWR VGND sky130_ef_sc_hd__decap_12
XFILLER_233_1449 VGND VGND VPWR VPWR sky130_fd_sc_hd__decap_6
XFILLER_29_1299 VPWR VGND VPWR VGND sky130_ef_sc_hd__decap_12
XFILLER_116_1247 VPWR VGND VPWR VGND sky130_ef_sc_hd__decap_12
XFILLER_229_529 VPWR VGND VPWR VGND sky130_ef_sc_hd__decap_12
XTAP_TAPCELL_ROW_242_3420 VGND VPWR sky130_fd_sc_hd__tapvpwrvgnd_1
XTAP_TAPCELL_ROW_242_3431 VGND VPWR sky130_fd_sc_hd__tapvpwrvgnd_1
XPHY_EDGE_ROW_27_2_Left_529 VGND VGND VPWR VPWR sky130_fd_sc_hd__decap_3
Xinput5 wr_addr[3] VGND VGND VPWR VPWR net5 sky130_fd_sc_hd__clkbuf_1
XFILLER_237_573 VPWR VGND VPWR VGND sky130_ef_sc_hd__decap_12
XTAP_TAPCELL_ROW_20_2_3875 VGND VPWR sky130_fd_sc_hd__tapvpwrvgnd_1
XTAP_TAPCELL_ROW_8_1090 VGND VPWR sky130_fd_sc_hd__tapvpwrvgnd_1
XTAP_TAPCELL_ROW_19_2_3869 VGND VPWR sky130_fd_sc_hd__tapvpwrvgnd_1
XFILLER_188_1061 VPWR VGND VPWR VGND sky130_ef_sc_hd__decap_12
XFILLER_224_245 VGND VGND VPWR VPWR sky130_fd_sc_hd__decap_6
XTAP_TAPCELL_ROW_255_3803 VGND VPWR sky130_fd_sc_hd__tapvpwrvgnd_1
XFILLER_75_1231 VPWR VGND VPWR VGND sky130_ef_sc_hd__decap_12
XFILLER_197_609 VGND VGND VPWR VPWR sky130_fd_sc_hd__decap_6
XFILLER_252_587 VGND VGND VPWR VPWR sky130_fd_sc_hd__fill_1
XFILLER_206_993 VPWR VGND VPWR VGND sky130_ef_sc_hd__decap_12
XFILLER_224_289 VPWR VGND VPWR VGND sky130_ef_sc_hd__decap_12
XFILLER_240_749 VGND VGND VPWR VPWR sky130_fd_sc_hd__decap_6
XFILLER_36_1215 VPWR VGND VPWR VGND sky130_ef_sc_hd__decap_12
XFILLER_75_1275 VPWR VGND VPWR VGND sky130_ef_sc_hd__decap_12
XFILLER_127_1343 VPWR VGND VPWR VGND sky130_ef_sc_hd__decap_12
XTAP_TAPCELL_ROW_236_3246 VGND VPWR sky130_fd_sc_hd__tapvpwrvgnd_1
XFILLER_240_1409 VPWR VGND VPWR VGND sky130_ef_sc_hd__decap_12
XTAP_TAPCELL_ROW_236_3257 VGND VPWR sky130_fd_sc_hd__tapvpwrvgnd_1
XFILLER_162_1245 VGND VGND VPWR VPWR sky130_fd_sc_hd__fill_1
XFILLER_189_193 VPWR VGND VPWR VGND sky130_ef_sc_hd__decap_12
XTAP_TAPCELL_ROW_236_3268 VGND VPWR sky130_fd_sc_hd__tapvpwrvgnd_1
XFILLER_36_1259 VPWR VGND VPWR VGND sky130_ef_sc_hd__decap_12
XPHY_EDGE_ROW_141_2_Left_643 VGND VGND VPWR VPWR sky130_fd_sc_hd__decap_3
XFILLER_178_867 VGND VGND VPWR VPWR sky130_fd_sc_hd__fill_1
XFILLER_127_1387 VPWR VGND VPWR VGND sky130_ef_sc_hd__decap_12
XFILLER_165_517 VPWR VGND VPWR VGND sky130_ef_sc_hd__decap_12
XFILLER_203_1231 VGND VGND VPWR VPWR sky130_fd_sc_hd__fill_1
XTAP_TAPCELL_ROW_138_2_4583 VGND VPWR sky130_fd_sc_hd__tapvpwrvgnd_1
XTAP_TAPCELL_ROW_249_3607 VGND VPWR sky130_fd_sc_hd__tapvpwrvgnd_1
XFILLER_195_1021 VPWR VGND VPWR VGND sky130_ef_sc_hd__decap_12
XTAP_TAPCELL_ROW_249_3618 VGND VPWR sky130_fd_sc_hd__tapvpwrvgnd_1
XFILLER_173_561 VPWR VGND VPWR VGND sky130_ef_sc_hd__decap_12
XFILLER_10_26 VGND VGND VPWR VPWR sky130_fd_sc_hd__fill_2
XFILLER_195_1065 VPWR VGND VPWR VGND sky130_ef_sc_hd__decap_12
XFILLER_47_1311 VPWR VGND VPWR VGND sky130_ef_sc_hd__decap_12
XFILLER_126_15 VPWR VGND VPWR VGND sky130_ef_sc_hd__decap_12
XFILLER_86_1371 VPWR VGND VPWR VGND sky130_ef_sc_hd__decap_12
XFILLER_251_1505 VGND VGND VPWR VPWR sky130_fd_sc_hd__decap_6
XFILLER_47_1355 VPWR VGND VPWR VGND sky130_ef_sc_hd__decap_12
XFILLER_134_1303 VPWR VGND VPWR VGND sky130_ef_sc_hd__decap_12
XFILLER_248_805 VGND VGND VPWR VPWR sky130_fd_sc_hd__decap_6
XFILLER_236_1073 VPWR VGND VPWR VGND sky130_ef_sc_hd__decap_12
XFILLER_138_1483 VPWR VGND VPWR VGND sky130_ef_sc_hd__decap_12
XPHY_EDGE_ROW_17_2_Right_108 VGND VGND VPWR VPWR sky130_fd_sc_hd__decap_3
XFILLER_43_1219 VPWR VGND VPWR VGND sky130_ef_sc_hd__decap_12
XTAP_TAPCELL_ROW_86_2_4270 VGND VPWR sky130_fd_sc_hd__tapvpwrvgnd_1
XFILLER_47_1399 VPWR VGND VPWR VGND sky130_ef_sc_hd__decap_12
XFILLER_248_849 VPWR VGND VPWR VGND sky130_ef_sc_hd__decap_12
XFILLER_247_337 VPWR VGND VPWR VGND sky130_ef_sc_hd__decap_12
XFILLER_214_1371 VGND VGND VPWR VPWR sky130_fd_sc_hd__fill_1
XFILLER_19_57 VPWR VGND VPWR VGND sky130_ef_sc_hd__decap_12
XFILLER_249_1401 VPWR VGND VPWR VGND sky130_ef_sc_hd__decap_12
XTAP_TAPCELL_ROW_225_2950 VGND VPWR sky130_fd_sc_hd__tapvpwrvgnd_1
XTAP_TAPCELL_ROW_225_2961 VGND VPWR sky130_fd_sc_hd__tapvpwrvgnd_1
XFILLER_216_713 VPWR VGND VPWR VGND sky130_ef_sc_hd__decap_12
XTAP_TAPCELL_ROW_225_2972 VGND VPWR sky130_fd_sc_hd__tapvpwrvgnd_1
XPHY_EDGE_ROW_155_1_Left_410 VGND VGND VPWR VPWR sky130_fd_sc_hd__decap_3
XFILLER_167_1101 VPWR VGND VPWR VGND sky130_ef_sc_hd__decap_12
XFILLER_215_223 VGND VGND VPWR VPWR sky130_fd_sc_hd__fill_1
XFILLER_216_757 VPWR VGND VPWR VGND sky130_ef_sc_hd__decap_12
XTAP_TAPCELL_ROW_221_2847 VGND VPWR sky130_fd_sc_hd__tapvpwrvgnd_1
XTAP_TAPCELL_ROW_221_2858 VGND VPWR sky130_fd_sc_hd__tapvpwrvgnd_1
XFILLER_167_1145 VPWR VGND VPWR VGND sky130_ef_sc_hd__decap_12
XFILLER_3_1493 VPWR VGND VPWR VGND sky130_ef_sc_hd__decap_12
XFILLER_58_1451 VPWR VGND VPWR VGND sky130_ef_sc_hd__decap_12
XFILLER_93_1331 VPWR VGND VPWR VGND sky130_ef_sc_hd__decap_12
XFILLER_231_727 VGND VGND VPWR VPWR sky130_fd_sc_hd__fill_1
XPHY_EDGE_ROW_43_1_Right_699 VGND VGND VPWR VPWR sky130_fd_sc_hd__decap_3
XFILLER_203_429 VPWR VGND VPWR VGND sky130_ef_sc_hd__decap_12
XFILLER_167_1189 VPWR VGND VPWR VGND sky130_ef_sc_hd__decap_12
XFILLER_54_1315 VPWR VGND VPWR VGND sky130_ef_sc_hd__decap_12
XFILLER_19_1435 VGND VGND VPWR VPWR sky130_fd_sc_hd__decap_6
XPHY_EDGE_ROW_73_2_Left_575 VGND VGND VPWR VPWR sky130_fd_sc_hd__decap_3
XFILLER_243_1033 VPWR VGND VPWR VGND sky130_ef_sc_hd__decap_12
XFILLER_58_1495 VPWR VGND VPWR VGND sky130_ef_sc_hd__decap_12
XFILLER_145_1443 VPWR VGND VPWR VGND sky130_ef_sc_hd__decap_12
XFILLER_168_333 VPWR VGND VPWR VGND sky130_ef_sc_hd__decap_12
XFILLER_204_1017 VPWR VGND VPWR VGND sky130_ef_sc_hd__decap_12
XFILLER_54_1359 VPWR VGND VPWR VGND sky130_ef_sc_hd__decap_12
XFILLER_19_1479 VPWR VGND VPWR VGND sky130_ef_sc_hd__decap_12
XFILLER_106_1427 VPWR VGND VPWR VGND sky130_ef_sc_hd__decap_12
XFILLER_243_1077 VPWR VGND VPWR VGND sky130_ef_sc_hd__decap_12
XFILLER_208_1197 VGND VGND VPWR VPWR sky130_fd_sc_hd__decap_6
Xwire403 net404 VGND VGND VPWR VPWR net403 sky130_fd_sc_hd__clkbuf_1
XFILLER_136_3 VPWR VGND VPWR VGND sky130_ef_sc_hd__decap_12
XFILLER_141_1329 VGND VGND VPWR VPWR sky130_fd_sc_hd__fill_1
XFILLER_169_889 VGND VGND VPWR VPWR sky130_fd_sc_hd__decap_6
XFILLER_211_473 VPWR VGND VPWR VGND sky130_ef_sc_hd__decap_12
XFILLER_7_505 VGND VGND VPWR VPWR sky130_fd_sc_hd__fill_2
XFILLER_168_377 VPWR VGND VPWR VGND sky130_ef_sc_hd__decap_12
Xwire414 net415 VGND VGND VPWR VPWR net414 sky130_fd_sc_hd__clkbuf_1
XFILLER_184_837 VPWR VGND VPWR VGND sky130_ef_sc_hd__decap_12
XTAP_TAPCELL_ROW_58_2_4105 VGND VPWR sky130_fd_sc_hd__tapvpwrvgnd_1
XFILLER_51_55 VGND VGND VPWR VPWR sky130_fd_sc_hd__fill_1
Xwire425 net426 VGND VGND VPWR VPWR net425 sky130_fd_sc_hd__clkbuf_1
XTAP_TAPCELL_ROW_219_2787 VGND VPWR sky130_fd_sc_hd__tapvpwrvgnd_1
Xwire436 net437 VGND VGND VPWR VPWR net436 sky130_fd_sc_hd__clkbuf_1
XTAP_TAPCELL_ROW_219_2798 VGND VPWR sky130_fd_sc_hd__tapvpwrvgnd_1
Xwire447 net448 VGND VGND VPWR VPWR net447 sky130_fd_sc_hd__clkbuf_1
Xwire458 net459 VGND VGND VPWR VPWR net458 sky130_fd_sc_hd__clkbuf_1
XFILLER_167_55 VGND VGND VPWR VPWR sky130_fd_sc_hd__fill_1
Xwire469 net470 VGND VGND VPWR VPWR net469 sky130_fd_sc_hd__clkbuf_1
XFILLER_178_1241 VPWR VGND VPWR VGND sky130_ef_sc_hd__decap_12
XFILLER_192_881 VPWR VGND VPWR VGND sky130_ef_sc_hd__decap_12
XFILLER_174_1105 VPWR VGND VPWR VGND sky130_ef_sc_hd__decap_12
XFILLER_178_1285 VPWR VGND VPWR VGND sky130_ef_sc_hd__decap_12
XFILLER_191_391 VGND VGND VPWR VPWR sky130_fd_sc_hd__fill_1
XFILLER_65_1411 VPWR VGND VPWR VGND sky130_ef_sc_hd__decap_12
XFILLER_2_221 VPWR VGND VPWR VGND sky130_ef_sc_hd__decap_12
XFILLER_174_1149 VPWR VGND VPWR VGND sky130_ef_sc_hd__decap_12
XFILLER_65_1455 VPWR VGND VPWR VGND sky130_ef_sc_hd__decap_12
XFILLER_215_1113 VGND VGND VPWR VPWR sky130_fd_sc_hd__decap_6
XFILLER_254_1173 VPWR VGND VPWR VGND sky130_ef_sc_hd__decap_12
XFILLER_2_276 VGND VGND VPWR VPWR sky130_fd_sc_hd__decap_3
XFILLER_250_1037 VPWR VGND VPWR VGND sky130_ef_sc_hd__decap_12
XFILLER_26_1439 VPWR VGND VPWR VGND sky130_ef_sc_hd__decap_12
XFILLER_2_298 VGND VGND VPWR VPWR sky130_fd_sc_hd__decap_8
XFILLER_215_1157 VPWR VGND VPWR VGND sky130_ef_sc_hd__decap_12
XFILLER_65_1499 VPWR VGND VPWR VGND sky130_ef_sc_hd__decap_12
XFILLER_76_41 VPWR VGND VPWR VGND sky130_ef_sc_hd__decap_12
XFILLER_152_1469 VGND VGND VPWR VPWR sky130_fd_sc_hd__fill_1
XFILLER_8_1371 VGND VGND VPWR VPWR sky130_fd_sc_hd__fill_1
XPHY_EDGE_ROW_87_1_Left_342 VGND VGND VPWR VPWR sky130_fd_sc_hd__decap_3
Xfanout591 valid_d2 VGND VGND VPWR VPWR net591 sky130_fd_sc_hd__clkbuf_2
XFILLER_253_329 VGND VGND VPWR VPWR sky130_fd_sc_hd__decap_6
XFILLER_219_573 VPWR VGND VPWR VGND sky130_ef_sc_hd__decap_12
XFILLER_185_1201 VPWR VGND VPWR VGND sky130_ef_sc_hd__decap_12
XFILLER_189_1381 VPWR VGND VPWR VGND sky130_ef_sc_hd__decap_12
XFILLER_111_1177 VPWR VGND VPWR VGND sky130_ef_sc_hd__decap_12
XFILLER_206_245 VGND VGND VPWR VPWR sky130_fd_sc_hd__decap_6
XFILLER_185_1245 VPWR VGND VPWR VGND sky130_ef_sc_hd__decap_12
XFILLER_179_609 VGND VGND VPWR VPWR sky130_fd_sc_hd__decap_6
XFILLER_234_587 VGND VGND VPWR VPWR sky130_fd_sc_hd__fill_1
XFILLER_185_1289 VPWR VGND VPWR VGND sky130_ef_sc_hd__decap_12
XFILLER_206_289 VPWR VGND VPWR VGND sky130_ef_sc_hd__decap_12
XFILLER_222_749 VGND VGND VPWR VPWR sky130_fd_sc_hd__decap_6
XFILLER_221_237 VPWR VGND VPWR VGND sky130_ef_sc_hd__decap_12
XFILLER_72_1415 VPWR VGND VPWR VGND sky130_ef_sc_hd__decap_12
XFILLER_226_1253 VGND VGND VPWR VPWR sky130_fd_sc_hd__decap_6
X_408_ _186_ _187_ VGND VGND VPWR VPWR _197_ sky130_fd_sc_hd__and2b_1
XFILLER_187_653 VPWR VGND VPWR VGND sky130_ef_sc_hd__decap_12
XFILLER_222_1117 VPWR VGND VPWR VGND sky130_ef_sc_hd__decap_12
XFILLER_186_141 VPWR VGND VPWR VGND sky130_ef_sc_hd__decap_12
XFILLER_226_1297 VPWR VGND VPWR VGND sky130_ef_sc_hd__decap_12
XFILLER_230_793 VPWR VGND VPWR VGND sky130_ef_sc_hd__decap_12
X_339_ _116_ _126_ _127_ net498 VGND VGND VPWR VPWR _128_ sky130_fd_sc_hd__a211o_1
XFILLER_187_697 VPWR VGND VPWR VGND sky130_ef_sc_hd__decap_12
XTAP_TAPCELL_ROW_231_3110 VGND VPWR sky130_fd_sc_hd__tapvpwrvgnd_1
XTAP_TAPCELL_ROW_231_3121 VGND VPWR sky130_fd_sc_hd__tapvpwrvgnd_1
XTAP_TAPCELL_ROW_231_3132 VGND VPWR sky130_fd_sc_hd__tapvpwrvgnd_1
XFILLER_196_1341 VPWR VGND VPWR VGND sky130_ef_sc_hd__decap_12
XFILLER_122_1295 VGND VGND VPWR VPWR sky130_fd_sc_hd__decap_6
XFILLER_31_1189 VPWR VGND VPWR VGND sky130_ef_sc_hd__decap_12
XFILLER_192_1205 VPWR VGND VPWR VGND sky130_ef_sc_hd__decap_12
XFILLER_51_3 VPWR VGND VPWR VGND sky130_ef_sc_hd__decap_12
XFILLER_170_531 VGND VGND VPWR VPWR sky130_fd_sc_hd__fill_1
XFILLER_196_1385 VPWR VGND VPWR VGND sky130_ef_sc_hd__decap_12
XFILLER_227_69 VPWR VGND VPWR VGND sky130_ef_sc_hd__decap_12
XFILLER_83_1511 VGND VGND VPWR VPWR sky130_fd_sc_hd__decap_4
XPHY_EDGE_ROW_144_2_Right_235 VGND VGND VPWR VPWR sky130_fd_sc_hd__decap_3
XFILLER_233_1213 VPWR VGND VPWR VGND sky130_ef_sc_hd__decap_12
XTAP_TAPCELL_ROW_229_3061 VGND VPWR sky130_fd_sc_hd__tapvpwrvgnd_1
XFILLER_237_1393 VGND VGND VPWR VPWR sky130_fd_sc_hd__decap_6
XTAP_TAPCELL_ROW_229_3072 VGND VPWR sky130_fd_sc_hd__tapvpwrvgnd_1
XFILLER_233_1257 VPWR VGND VPWR VGND sky130_ef_sc_hd__decap_12
XFILLER_243_57 VPWR VGND VPWR VGND sky130_ef_sc_hd__decap_12
XFILLER_229_337 VPWR VGND VPWR VGND sky130_ef_sc_hd__decap_12
XFILLER_211_1511 VGND VGND VPWR VPWR sky130_fd_sc_hd__fill_1
XTAP_TAPCELL_ROW_6_1016 VGND VPWR sky130_fd_sc_hd__tapvpwrvgnd_1
XFILLER_244_307 VGND VGND VPWR VPWR sky130_fd_sc_hd__fill_1
XTAP_TAPCELL_ROW_6_1027 VGND VPWR sky130_fd_sc_hd__tapvpwrvgnd_1
XFILLER_238_893 VPWR VGND VPWR VGND sky130_ef_sc_hd__decap_12
XFILLER_168_1421 VGND VGND VPWR VPWR sky130_fd_sc_hd__decap_6
XFILLER_253_841 VPWR VGND VPWR VGND sky130_ef_sc_hd__decap_12
XTAP_TAPCELL_ROW_238_3308 VGND VPWR sky130_fd_sc_hd__tapvpwrvgnd_1
XTAP_TAPCELL_ROW_64_2_4137 VGND VPWR sky130_fd_sc_hd__tapvpwrvgnd_1
XFILLER_168_1465 VPWR VGND VPWR VGND sky130_ef_sc_hd__decap_12
XTAP_TAPCELL_ROW_238_3319 VGND VPWR sky130_fd_sc_hd__tapvpwrvgnd_1
XFILLER_240_513 VPWR VGND VPWR VGND sky130_ef_sc_hd__decap_12
XFILLER_213_727 VGND VGND VPWR VPWR sky130_fd_sc_hd__fill_1
XFILLER_197_417 VPWR VGND VPWR VGND sky130_ef_sc_hd__decap_12
XFILLER_240_557 VPWR VGND VPWR VGND sky130_ef_sc_hd__decap_12
XFILLER_244_1353 VPWR VGND VPWR VGND sky130_ef_sc_hd__decap_12
XFILLER_240_1217 VPWR VGND VPWR VGND sky130_ef_sc_hd__decap_12
XFILLER_205_1337 VGND VGND VPWR VPWR sky130_fd_sc_hd__decap_6
XFILLER_244_1397 VPWR VGND VPWR VGND sky130_ef_sc_hd__decap_12
XFILLER_166_837 VPWR VGND VPWR VGND sky130_ef_sc_hd__decap_12
XTAP_TAPCELL_ROW_193_2091 VGND VPWR sky130_fd_sc_hd__tapvpwrvgnd_1
XFILLER_192_133 VGND VGND VPWR VPWR sky130_fd_sc_hd__decap_6
XFILLER_140_1351 VGND VGND VPWR VPWR sky130_fd_sc_hd__decap_6
XTAP_TAPCELL_ROW_214_2651 VGND VPWR sky130_fd_sc_hd__tapvpwrvgnd_1
XFILLER_174_881 VPWR VGND VPWR VGND sky130_ef_sc_hd__decap_12
XFILLER_192_177 VPWR VGND VPWR VGND sky130_ef_sc_hd__decap_12
XTAP_TAPCELL_ROW_214_2662 VGND VPWR sky130_fd_sc_hd__tapvpwrvgnd_1
XFILLER_21_69 VGND VGND VPWR VPWR sky130_fd_sc_hd__fill_2
XFILLER_140_1395 VPWR VGND VPWR VGND sky130_ef_sc_hd__decap_12
XTAP_TAPCELL_ROW_214_2673 VGND VPWR sky130_fd_sc_hd__tapvpwrvgnd_1
XFILLER_175_1425 VPWR VGND VPWR VGND sky130_ef_sc_hd__decap_12
XFILLER_101_1379 VGND VGND VPWR VPWR sky130_fd_sc_hd__decap_6
XFILLER_173_391 VGND VGND VPWR VPWR sky130_fd_sc_hd__fill_1
XFILLER_137_69 VGND VGND VPWR VPWR sky130_fd_sc_hd__fill_2
XTAP_TAPCELL_ROW_210_2548 VGND VPWR sky130_fd_sc_hd__tapvpwrvgnd_1
XFILLER_175_1469 VPWR VGND VPWR VGND sky130_ef_sc_hd__decap_12
XTAP_TAPCELL_ROW_210_2559 VGND VPWR sky130_fd_sc_hd__tapvpwrvgnd_1
XFILLER_251_1313 VPWR VGND VPWR VGND sky130_ef_sc_hd__decap_12
XFILLER_248_613 VPWR VGND VPWR VGND sky130_ef_sc_hd__decap_12
XFILLER_251_1357 VPWR VGND VPWR VGND sky130_ef_sc_hd__decap_12
XFILLER_216_1477 VGND VGND VPWR VPWR sky130_fd_sc_hd__decap_6
XPHY_EDGE_ROW_18_2_Right_109 VGND VGND VPWR VPWR sky130_fd_sc_hd__decap_3
XFILLER_153_57 VPWR VGND VPWR VGND sky130_ef_sc_hd__decap_12
XFILLER_248_657 VPWR VGND VPWR VGND sky130_ef_sc_hd__decap_12
XFILLER_5_1511 VGND VGND VPWR VPWR sky130_fd_sc_hd__fill_1
XFILLER_134_1177 VPWR VGND VPWR VGND sky130_ef_sc_hd__decap_12
XTAP_TAPCELL_ROW_161_2_4721 VGND VPWR sky130_fd_sc_hd__tapvpwrvgnd_1
XTAP_TAPCELL_ROW_223_2909 VGND VPWR sky130_fd_sc_hd__tapvpwrvgnd_1
XFILLER_247_167 VGND VGND VPWR VPWR sky130_fd_sc_hd__fill_1
XFILLER_235_329 VGND VGND VPWR VPWR sky130_fd_sc_hd__decap_6
XFILLER_151_1491 VGND VGND VPWR VPWR sky130_fd_sc_hd__decap_6
XTAP_TAPCELL_ROW_208_2488 VGND VPWR sky130_fd_sc_hd__tapvpwrvgnd_1
XTAP_TAPCELL_ROW_208_2499 VGND VPWR sky130_fd_sc_hd__tapvpwrvgnd_1
XFILLER_249_1231 VGND VGND VPWR VPWR sky130_fd_sc_hd__fill_1
XFILLER_243_373 VPWR VGND VPWR VGND sky130_ef_sc_hd__decap_12
XFILLER_216_587 VGND VGND VPWR VPWR sky130_fd_sc_hd__fill_1
XFILLER_253_3 VPWR VGND VPWR VGND sky130_ef_sc_hd__decap_12
Xmax_cap89 net90 VGND VGND VPWR VPWR net89 sky130_fd_sc_hd__clkbuf_1
XFILLER_182_1429 VPWR VGND VPWR VGND sky130_ef_sc_hd__decap_12
XFILLER_204_749 VGND VGND VPWR VPWR sky130_fd_sc_hd__decap_6
XFILLER_203_237 VPWR VGND VPWR VGND sky130_ef_sc_hd__decap_12
XFILLER_19_1243 VPWR VGND VPWR VGND sky130_ef_sc_hd__decap_12
XFILLER_197_951 VGND VGND VPWR VPWR sky130_fd_sc_hd__fill_1
XFILLER_169_653 VPWR VGND VPWR VGND sky130_ef_sc_hd__decap_12
XFILLER_145_1273 VGND VGND VPWR VPWR sky130_fd_sc_hd__fill_1
XFILLER_168_141 VPWR VGND VPWR VGND sky130_ef_sc_hd__decap_12
XFILLER_223_1437 VPWR VGND VPWR VGND sky130_ef_sc_hd__decap_12
XFILLER_184_601 VPWR VGND VPWR VGND sky130_ef_sc_hd__decap_12
XFILLER_19_1287 VPWR VGND VPWR VGND sky130_ef_sc_hd__decap_12
XFILLER_212_793 VPWR VGND VPWR VGND sky130_ef_sc_hd__decap_12
XFILLER_169_697 VPWR VGND VPWR VGND sky130_ef_sc_hd__decap_12
XFILLER_178_65 VPWR VGND VPWR VGND sky130_ef_sc_hd__decap_12
XFILLER_211_281 VPWR VGND VPWR VGND sky130_ef_sc_hd__decap_12
XFILLER_54_1189 VGND VGND VPWR VPWR sky130_fd_sc_hd__fill_1
XFILLER_8_825 VPWR VGND VPWR VGND sky130_ef_sc_hd__decap_12
Xwire222 net223 VGND VGND VPWR VPWR net222 sky130_fd_sc_hd__clkbuf_1
XFILLER_180_1197 VGND VGND VPWR VPWR sky130_fd_sc_hd__decap_6
XFILLER_183_111 VGND VGND VPWR VPWR sky130_fd_sc_hd__fill_1
XFILLER_184_645 VPWR VGND VPWR VGND sky130_ef_sc_hd__decap_12
Xwire233 net234 VGND VGND VPWR VPWR net233 sky130_fd_sc_hd__clkbuf_1
XFILLER_89_1219 VPWR VGND VPWR VGND sky130_ef_sc_hd__decap_12
XFILLER_8_869 VPWR VGND VPWR VGND sky130_ef_sc_hd__decap_12
XFILLER_7_335 VGND VGND VPWR VPWR sky130_fd_sc_hd__fill_1
Xwire255 net256 VGND VGND VPWR VPWR net255 sky130_fd_sc_hd__clkbuf_1
XTAP_TAPCELL_ROW_109_1_1244 VGND VPWR sky130_fd_sc_hd__tapvpwrvgnd_1
Xwire266 net267 VGND VGND VPWR VPWR net266 sky130_fd_sc_hd__clkbuf_1
Xwire277 net278 VGND VGND VPWR VPWR net277 sky130_fd_sc_hd__clkbuf_1
XFILLER_171_317 VPWR VGND VPWR VGND sky130_ef_sc_hd__decap_12
Xwire288 net289 VGND VGND VPWR VPWR net288 sky130_fd_sc_hd__clkbuf_1
XFILLER_165_881 VPWR VGND VPWR VGND sky130_ef_sc_hd__decap_12
Xwire299 net300 VGND VGND VPWR VPWR net299 sky130_fd_sc_hd__clkbuf_1
XFILLER_194_53 VPWR VGND VPWR VGND sky130_ef_sc_hd__decap_12
XFILLER_178_1093 VPWR VGND VPWR VGND sky130_ef_sc_hd__decap_12
XTAP_TAPCELL_ROW_102_2_4369 VGND VPWR sky130_fd_sc_hd__tapvpwrvgnd_1
XFILLER_194_97 VPWR VGND VPWR VGND sky130_ef_sc_hd__decap_12
XFILLER_26_1203 VPWR VGND VPWR VGND sky130_ef_sc_hd__decap_12
XFILLER_87_51 VGND VGND VPWR VPWR sky130_fd_sc_hd__decap_4
XFILLER_117_1331 VPWR VGND VPWR VGND sky130_ef_sc_hd__decap_12
XTAP_TAPCELL_ROW_189_1982 VGND VPWR sky130_fd_sc_hd__tapvpwrvgnd_1
XTAP_TAPCELL_ROW_189_1993 VGND VPWR sky130_fd_sc_hd__tapvpwrvgnd_1
XFILLER_26_1247 VPWR VGND VPWR VGND sky130_ef_sc_hd__decap_12
XFILLER_113_1217 VGND VGND VPWR VPWR sky130_fd_sc_hd__fill_1
XTAP_TAPCELL_ROW_185_1868 VGND VPWR sky130_fd_sc_hd__tapvpwrvgnd_1
XTAP_TAPCELL_ROW_185_1879 VGND VPWR sky130_fd_sc_hd__tapvpwrvgnd_1
XFILLER_213_27 VPWR VGND VPWR VGND sky130_ef_sc_hd__decap_12
XFILLER_226_307 VGND VGND VPWR VPWR sky130_fd_sc_hd__fill_1
XFILLER_238_189 VGND VGND VPWR VPWR sky130_fd_sc_hd__decap_6
XFILLER_253_137 VPWR VGND VPWR VGND sky130_ef_sc_hd__decap_12
XFILLER_235_841 VPWR VGND VPWR VGND sky130_ef_sc_hd__decap_12
XTAP_TAPCELL_ROW_50_2_4056 VGND VPWR sky130_fd_sc_hd__tapvpwrvgnd_1
XFILLER_228_1315 VGND VGND VPWR VPWR sky130_fd_sc_hd__fill_1
XFILLER_250_811 VGND VGND VPWR VPWR sky130_fd_sc_hd__fill_1
XFILLER_222_513 VPWR VGND VPWR VGND sky130_ef_sc_hd__decap_12
XFILLER_179_417 VPWR VGND VPWR VGND sky130_ef_sc_hd__decap_12
XFILLER_222_557 VPWR VGND VPWR VGND sky130_ef_sc_hd__decap_12
XFILLER_37_1343 VPWR VGND VPWR VGND sky130_ef_sc_hd__decap_12
XFILLER_99_3 VPWR VGND VPWR VGND sky130_ef_sc_hd__decap_12
XFILLER_226_1061 VPWR VGND VPWR VGND sky130_ef_sc_hd__decap_12
XFILLER_128_1471 VPWR VGND VPWR VGND sky130_ef_sc_hd__decap_12
XFILLER_72_1245 VGND VGND VPWR VPWR sky130_fd_sc_hd__fill_1
XFILLER_188_973 VGND VGND VPWR VPWR sky130_fd_sc_hd__decap_6
XFILLER_37_1387 VPWR VGND VPWR VGND sky130_ef_sc_hd__decap_12
XFILLER_187_461 VPWR VGND VPWR VGND sky130_ef_sc_hd__decap_12
XFILLER_124_1357 VGND VGND VPWR VPWR sky130_fd_sc_hd__fill_1
XFILLER_174_133 VGND VGND VPWR VPWR sky130_fd_sc_hd__decap_6
Xinput30 wr_data[28] VGND VGND VPWR VPWR net30 sky130_fd_sc_hd__clkbuf_1
Xinput41 wr_data[9] VGND VGND VPWR VPWR net41 sky130_fd_sc_hd__clkbuf_1
Xmax_cap500 net501 VGND VGND VPWR VPWR net500 sky130_fd_sc_hd__clkbuf_1
XFILLER_174_177 VPWR VGND VPWR VGND sky130_ef_sc_hd__decap_12
Xmax_cap511 net512 VGND VGND VPWR VPWR net511 sky130_fd_sc_hd__clkbuf_1
XFILLER_190_637 VGND VGND VPWR VPWR sky130_fd_sc_hd__decap_6
XFILLER_7_880 VPWR VGND VPWR VGND sky130_ef_sc_hd__decap_12
Xmax_cap533 net57 VGND VGND VPWR VPWR net533 sky130_fd_sc_hd__clkbuf_1
XFILLER_239_1455 VGND VGND VPWR VPWR sky130_fd_sc_hd__fill_1
XFILLER_192_1035 VGND VGND VPWR VPWR sky130_fd_sc_hd__fill_1
XFILLER_107_39 VPWR VGND VPWR VGND sky130_ef_sc_hd__decap_12
XTAP_TAPCELL_ROW_227_3009 VGND VPWR sky130_fd_sc_hd__tapvpwrvgnd_1
XFILLER_157_1177 VPWR VGND VPWR VGND sky130_ef_sc_hd__decap_12
XFILLER_171_895 VGND VGND VPWR VPWR sky130_fd_sc_hd__fill_1
XFILLER_44_1303 VPWR VGND VPWR VGND sky130_ef_sc_hd__decap_12
XFILLER_233_1021 VPWR VGND VPWR VGND sky130_ef_sc_hd__decap_12
XFILLER_48_1483 VPWR VGND VPWR VGND sky130_ef_sc_hd__decap_12
XPHY_EDGE_ROW_145_2_Right_236 VGND VGND VPWR VPWR sky130_fd_sc_hd__decap_3
XFILLER_83_1385 VGND VGND VPWR VPWR sky130_fd_sc_hd__fill_1
XFILLER_233_1065 VPWR VGND VPWR VGND sky130_ef_sc_hd__decap_12
XFILLER_135_1497 VGND VGND VPWR VPWR sky130_fd_sc_hd__fill_1
XFILLER_123_27 VPWR VGND VPWR VGND sky130_ef_sc_hd__decap_12
XFILLER_229_167 VGND VGND VPWR VPWR sky130_fd_sc_hd__fill_1
XFILLER_217_329 VGND VGND VPWR VPWR sky130_fd_sc_hd__decap_6
XTAP_TAPCELL_ROW_126_2_4510 VGND VPWR sky130_fd_sc_hd__tapvpwrvgnd_1
XFILLER_253_671 VGND VGND VPWR VPWR sky130_fd_sc_hd__fill_1
XFILLER_129_1213 VGND VGND VPWR VPWR sky130_fd_sc_hd__decap_4
XFILLER_0_1441 VPWR VGND VPWR VGND sky130_ef_sc_hd__decap_12
XFILLER_168_1273 VPWR VGND VPWR VGND sky130_ef_sc_hd__decap_12
XFILLER_203_93 VPWR VGND VPWR VGND sky130_ef_sc_hd__decap_12
XTAP_TAPCELL_ROW_203_2363 VGND VPWR sky130_fd_sc_hd__tapvpwrvgnd_1
XFILLER_225_373 VPWR VGND VPWR VGND sky130_ef_sc_hd__decap_12
XFILLER_241_833 VGND VGND VPWR VPWR sky130_fd_sc_hd__decap_6
XTAP_TAPCELL_ROW_203_2374 VGND VPWR sky130_fd_sc_hd__tapvpwrvgnd_1
XFILLER_240_321 VPWR VGND VPWR VGND sky130_ef_sc_hd__decap_12
XPHY_EDGE_ROW_9_Left_265 VGND VGND VPWR VPWR sky130_fd_sc_hd__decap_3
XFILLER_198_737 VPWR VGND VPWR VGND sky130_ef_sc_hd__decap_12
XFILLER_77_1189 VPWR VGND VPWR VGND sky130_ef_sc_hd__decap_12
XFILLER_197_225 VPWR VGND VPWR VGND sky130_ef_sc_hd__decap_12
XFILLER_0_1485 VPWR VGND VPWR VGND sky130_ef_sc_hd__decap_12
XFILLER_90_1301 VGND VGND VPWR VPWR sky130_fd_sc_hd__fill_1
XTAP_TAPCELL_ROW_94_2_4321 VGND VPWR sky130_fd_sc_hd__tapvpwrvgnd_1
XFILLER_241_877 VPWR VGND VPWR VGND sky130_ef_sc_hd__decap_12
XTAP_TAPCELL_ROW_195_2142 VGND VPWR sky130_fd_sc_hd__tapvpwrvgnd_1
XFILLER_55_1443 VPWR VGND VPWR VGND sky130_ef_sc_hd__decap_12
XFILLER_179_951 VGND VGND VPWR VPWR sky130_fd_sc_hd__fill_1
XFILLER_205_1101 VPWR VGND VPWR VGND sky130_ef_sc_hd__decap_12
XFILLER_244_1161 VPWR VGND VPWR VGND sky130_ef_sc_hd__decap_12
XFILLER_240_365 VPWR VGND VPWR VGND sky130_ef_sc_hd__decap_12
XFILLER_107_1511 VGND VGND VPWR VPWR sky130_fd_sc_hd__decap_4
XTAP_TAPCELL_ROW_195_2153 VGND VPWR sky130_fd_sc_hd__tapvpwrvgnd_1
XFILLER_209_1281 VGND VGND VPWR VPWR sky130_fd_sc_hd__decap_6
XFILLER_142_1413 VGND VGND VPWR VPWR sky130_fd_sc_hd__fill_1
XFILLER_16_1427 VPWR VGND VPWR VGND sky130_ef_sc_hd__decap_12
XFILLER_166_601 VPWR VGND VPWR VGND sky130_ef_sc_hd__decap_12
XFILLER_205_1145 VPWR VGND VPWR VGND sky130_ef_sc_hd__decap_12
XFILLER_51_1329 VGND VGND VPWR VPWR sky130_fd_sc_hd__fill_1
XTAP_TAPCELL_ROW_191_2039 VGND VPWR sky130_fd_sc_hd__tapvpwrvgnd_1
XTAP_TAPCELL_ROW_216_2713 VGND VPWR sky130_fd_sc_hd__tapvpwrvgnd_1
XFILLER_201_1009 VPWR VGND VPWR VGND sky130_ef_sc_hd__decap_12
XTAP_TAPCELL_ROW_216_2724 VGND VPWR sky130_fd_sc_hd__tapvpwrvgnd_1
XFILLER_166_645 VPWR VGND VPWR VGND sky130_ef_sc_hd__decap_12
XFILLER_205_1189 VPWR VGND VPWR VGND sky130_ef_sc_hd__decap_12
XFILLER_5_806 VGND VGND VPWR VPWR sky130_fd_sc_hd__decap_6
XFILLER_181_615 VGND VGND VPWR VPWR sky130_fd_sc_hd__fill_1
XPHY_EDGE_ROW_104_2_Left_606 VGND VGND VPWR VPWR sky130_fd_sc_hd__decap_3
XFILLER_193_497 VGND VGND VPWR VPWR sky130_fd_sc_hd__decap_6
XFILLER_101_1165 VPWR VGND VPWR VGND sky130_ef_sc_hd__decap_12
XFILLER_175_1233 VPWR VGND VPWR VGND sky130_ef_sc_hd__decap_12
XFILLER_136_1239 VGND VGND VPWR VPWR sky130_fd_sc_hd__decap_6
XFILLER_171_1119 VGND VGND VPWR VPWR sky130_fd_sc_hd__fill_1
XFILLER_251_1121 VPWR VGND VPWR VGND sky130_ef_sc_hd__decap_12
XFILLER_0_533 VGND VGND VPWR VPWR sky130_fd_sc_hd__fill_2
XFILLER_216_1241 VPWR VGND VPWR VGND sky130_ef_sc_hd__decap_12
XFILLER_249_933 VPWR VGND VPWR VGND sky130_ef_sc_hd__decap_12
XFILLER_248_421 VPWR VGND VPWR VGND sky130_ef_sc_hd__decap_12
XFILLER_212_1105 VPWR VGND VPWR VGND sky130_ef_sc_hd__decap_12
XFILLER_216_1285 VPWR VGND VPWR VGND sky130_ef_sc_hd__decap_12
XFILLER_249_977 VPWR VGND VPWR VGND sky130_ef_sc_hd__decap_12
XFILLER_62_1469 VGND VGND VPWR VPWR sky130_fd_sc_hd__fill_1
XFILLER_208_307 VGND VGND VPWR VPWR sky130_fd_sc_hd__fill_1
XFILLER_212_1149 VPWR VGND VPWR VGND sky130_ef_sc_hd__decap_12
XTAP_TAPCELL_ROW_21_2_3880 VGND VPWR sky130_fd_sc_hd__tapvpwrvgnd_1
XFILLER_235_137 VPWR VGND VPWR VGND sky130_ef_sc_hd__decap_12
XFILLER_180_77 VGND VGND VPWR VPWR sky130_fd_sc_hd__decap_6
XFILLER_217_841 VPWR VGND VPWR VGND sky130_ef_sc_hd__decap_12
XFILLER_95_1201 VPWR VGND VPWR VGND sky130_ef_sc_hd__decap_12
XTAP_TAPCELL_ROW_180_1732 VGND VPWR sky130_fd_sc_hd__tapvpwrvgnd_1
XTAP_TAPCELL_ROW_180_1743 VGND VPWR sky130_fd_sc_hd__tapvpwrvgnd_1
XFILLER_112_1283 VPWR VGND VPWR VGND sky130_ef_sc_hd__decap_12
XTAP_TAPCELL_ROW_180_1754 VGND VPWR sky130_fd_sc_hd__tapvpwrvgnd_1
XFILLER_21_1177 VPWR VGND VPWR VGND sky130_ef_sc_hd__decap_12
XFILLER_232_811 VGND VGND VPWR VPWR sky130_fd_sc_hd__fill_1
XFILLER_204_513 VPWR VGND VPWR VGND sky130_ef_sc_hd__decap_12
XFILLER_186_1373 VPWR VGND VPWR VGND sky130_ef_sc_hd__decap_12
XFILLER_244_693 VGND VGND VPWR VPWR sky130_fd_sc_hd__decap_6
XFILLER_95_1267 VGND VGND VPWR VPWR sky130_fd_sc_hd__decap_6
XFILLER_243_181 VPWR VGND VPWR VGND sky130_ef_sc_hd__decap_12
XFILLER_204_557 VPWR VGND VPWR VGND sky130_ef_sc_hd__decap_12
XFILLER_147_1379 VGND VGND VPWR VPWR sky130_fd_sc_hd__decap_6
XFILLER_182_1259 VGND VGND VPWR VPWR sky130_fd_sc_hd__fill_1
XFILLER_223_1201 VPWR VGND VPWR VGND sky130_ef_sc_hd__decap_12
XFILLER_227_1381 VPWR VGND VPWR VGND sky130_ef_sc_hd__decap_12
XFILLER_169_461 VPWR VGND VPWR VGND sky130_ef_sc_hd__decap_12
XFILLER_185_921 VPWR VGND VPWR VGND sky130_ef_sc_hd__decap_12
XFILLER_223_1245 VPWR VGND VPWR VGND sky130_ef_sc_hd__decap_12
XTAP_TAPCELL_ROW_178_1683 VGND VPWR sky130_fd_sc_hd__tapvpwrvgnd_1
XFILLER_8_622 VPWR VGND VPWR VGND sky130_ef_sc_hd__decap_12
XTAP_TAPCELL_ROW_178_1694 VGND VPWR sky130_fd_sc_hd__tapvpwrvgnd_1
XFILLER_7_110 VGND VGND VPWR VPWR sky130_fd_sc_hd__fill_2
XFILLER_185_965 VPWR VGND VPWR VGND sky130_ef_sc_hd__decap_12
XPHY_EDGE_ROW_36_2_Left_538 VGND VGND VPWR VPWR sky130_fd_sc_hd__decap_3
XFILLER_223_1289 VPWR VGND VPWR VGND sky130_ef_sc_hd__decap_12
XFILLER_184_475 VGND VGND VPWR VPWR sky130_fd_sc_hd__fill_1
XFILLER_172_637 VGND VGND VPWR VPWR sky130_fd_sc_hd__decap_6
XFILLER_8_699 VGND VGND VPWR VPWR sky130_fd_sc_hd__fill_1
XFILLER_32_1295 VGND VGND VPWR VPWR sky130_fd_sc_hd__decap_6
XTAP_TAPCELL_ROW_152_2_4666 VGND VPWR sky130_fd_sc_hd__tapvpwrvgnd_1
XFILLER_171_125 VPWR VGND VPWR VGND sky130_ef_sc_hd__decap_12
XFILLER_208_27 VGND VGND VPWR VPWR sky130_fd_sc_hd__fill_1
XFILLER_171_169 VPWR VGND VPWR VGND sky130_ef_sc_hd__decap_12
XFILLER_180_681 VPWR VGND VPWR VGND sky130_ef_sc_hd__decap_12
XFILLER_154_1339 VPWR VGND VPWR VGND sky130_ef_sc_hd__decap_12
XFILLER_193_1399 VGND VGND VPWR VPWR sky130_fd_sc_hd__fill_1
XFILLER_234_1341 VPWR VGND VPWR VGND sky130_ef_sc_hd__decap_12
XPHY_EDGE_ROW_98_2_Left_600 VGND VGND VPWR VPWR sky130_fd_sc_hd__decap_3
XFILLER_224_15 VPWR VGND VPWR VGND sky130_ef_sc_hd__decap_12
XFILLER_6_1105 VPWR VGND VPWR VGND sky130_ef_sc_hd__decap_12
XFILLER_230_1205 VPWR VGND VPWR VGND sky130_ef_sc_hd__decap_12
XFILLER_234_1385 VPWR VGND VPWR VGND sky130_ef_sc_hd__decap_12
XPHY_EDGE_ROW_150_2_Left_652 VGND VGND VPWR VPWR sky130_fd_sc_hd__decap_3
XFILLER_255_925 VPWR VGND VPWR VGND sky130_ef_sc_hd__decap_12
XFILLER_6_1149 VPWR VGND VPWR VGND sky130_ef_sc_hd__decap_12
XFILLER_254_413 VGND VGND VPWR VPWR sky130_fd_sc_hd__decap_6
XFILLER_14_3 VPWR VGND VPWR VGND sky130_ef_sc_hd__decap_12
XTAP_TAPCELL_ROW_99_2_4347 VGND VPWR sky130_fd_sc_hd__tapvpwrvgnd_1
XFILLER_254_457 VPWR VGND VPWR VGND sky130_ef_sc_hd__decap_12
XFILLER_130_1383 VPWR VGND VPWR VGND sky130_ef_sc_hd__decap_12
XFILLER_235_671 VGND VGND VPWR VPWR sky130_fd_sc_hd__fill_1
XFILLER_165_1413 VPWR VGND VPWR VGND sky130_ef_sc_hd__decap_12
XFILLER_207_373 VPWR VGND VPWR VGND sky130_ef_sc_hd__decap_12
XFILLER_223_833 VGND VGND VPWR VPWR sky130_fd_sc_hd__decap_6
XFILLER_222_321 VPWR VGND VPWR VGND sky130_ef_sc_hd__decap_12
XFILLER_179_225 VPWR VGND VPWR VGND sky130_ef_sc_hd__decap_12
XFILLER_165_1457 VPWR VGND VPWR VGND sky130_ef_sc_hd__decap_12
XFILLER_223_877 VPWR VGND VPWR VGND sky130_ef_sc_hd__decap_12
XPHY_EDGE_ROW_102_1_Left_357 VGND VGND VPWR VPWR sky130_fd_sc_hd__decap_3
XFILLER_222_365 VPWR VGND VPWR VGND sky130_ef_sc_hd__decap_12
XFILLER_241_1301 VPWR VGND VPWR VGND sky130_ef_sc_hd__decap_12
XFILLER_206_1421 VGND VGND VPWR VPWR sky130_fd_sc_hd__decap_6
XFILLER_245_1481 VPWR VGND VPWR VGND sky130_ef_sc_hd__decap_12
XFILLER_195_729 VPWR VGND VPWR VGND sky130_ef_sc_hd__decap_12
XFILLER_188_781 VPWR VGND VPWR VGND sky130_ef_sc_hd__decap_12
XFILLER_241_1345 VPWR VGND VPWR VGND sky130_ef_sc_hd__decap_12
XFILLER_206_1465 VPWR VGND VPWR VGND sky130_ef_sc_hd__decap_12
XTAP_TAPCELL_ROW_59_2_4110 VGND VPWR sky130_fd_sc_hd__tapvpwrvgnd_1
XFILLER_202_1329 VPWR VGND VPWR VGND sky130_ef_sc_hd__decap_12
XFILLER_124_1165 VPWR VGND VPWR VGND sky130_ef_sc_hd__decap_12
XFILLER_50_1351 VGND VGND VPWR VPWR sky130_fd_sc_hd__decap_6
XFILLER_190_401 VPWR VGND VPWR VGND sky130_ef_sc_hd__decap_12
XFILLER_159_1217 VGND VGND VPWR VPWR sky130_fd_sc_hd__fill_1
XFILLER_175_497 VGND VGND VPWR VPWR sky130_fd_sc_hd__decap_6
XFILLER_118_27 VGND VGND VPWR VPWR sky130_fd_sc_hd__fill_1
XFILLER_50_1395 VPWR VGND VPWR VGND sky130_ef_sc_hd__decap_12
XFILLER_102_1463 VGND VGND VPWR VPWR sky130_fd_sc_hd__decap_6
XFILLER_190_445 VPWR VGND VPWR VGND sky130_ef_sc_hd__decap_12
XFILLER_11_1379 VGND VGND VPWR VPWR sky130_fd_sc_hd__decap_6
XFILLER_2_809 VGND VGND VPWR VPWR sky130_fd_sc_hd__decap_3
XFILLER_190_489 VPWR VGND VPWR VGND sky130_ef_sc_hd__decap_12
XFILLER_1_319 VGND VGND VPWR VPWR sky130_fd_sc_hd__fill_2
XFILLER_252_1441 VPWR VGND VPWR VGND sky130_ef_sc_hd__decap_12
XFILLER_134_15 VPWR VGND VPWR VGND sky130_ef_sc_hd__decap_12
XPHY_EDGE_ROW_82_2_Left_584 VGND VGND VPWR VPWR sky130_fd_sc_hd__decap_3
XFILLER_213_1425 VPWR VGND VPWR VGND sky130_ef_sc_hd__decap_12
XPHY_EDGE_ROW_146_2_Right_237 VGND VGND VPWR VPWR sky130_fd_sc_hd__decap_3
XFILLER_170_1141 VGND VGND VPWR VPWR sky130_fd_sc_hd__decap_6
XFILLER_252_1485 VPWR VGND VPWR VGND sky130_ef_sc_hd__decap_12
XFILLER_246_925 VPWR VGND VPWR VGND sky130_ef_sc_hd__decap_12
XFILLER_44_1177 VPWR VGND VPWR VGND sky130_ef_sc_hd__decap_12
XTAP_TAPCELL_ROW_71_1_1206 VGND VPWR sky130_fd_sc_hd__tapvpwrvgnd_1
XFILLER_170_1185 VPWR VGND VPWR VGND sky130_ef_sc_hd__decap_12
XFILLER_213_1469 VPWR VGND VPWR VGND sky130_ef_sc_hd__decap_12
XTAP_TAPCELL_ROW_205_2414 VGND VPWR sky130_fd_sc_hd__tapvpwrvgnd_1
XTAP_TAPCELL_ROW_205_2425 VGND VPWR sky130_fd_sc_hd__tapvpwrvgnd_1
XFILLER_61_1491 VGND VGND VPWR VPWR sky130_fd_sc_hd__decap_6
XFILLER_217_137 VPWR VGND VPWR VGND sky130_ef_sc_hd__decap_12
XFILLER_27_57 VGND VGND VPWR VPWR sky130_fd_sc_hd__fill_2
XTAP_TAPCELL_ROW_197_2204 VGND VPWR sky130_fd_sc_hd__tapvpwrvgnd_1
XFILLER_214_811 VGND VGND VPWR VPWR sky130_fd_sc_hd__fill_1
XTAP_TAPCELL_ROW_197_2215 VGND VPWR sky130_fd_sc_hd__tapvpwrvgnd_1
XTAP_TAPCELL_ROW_1_886 VGND VPWR sky130_fd_sc_hd__tapvpwrvgnd_1
XFILLER_183_1513 VGND VGND VPWR VPWR sky130_fd_sc_hd__fill_2
XFILLER_198_501 VPWR VGND VPWR VGND sky130_ef_sc_hd__decap_12
XFILLER_226_693 VGND VGND VPWR VPWR sky130_fd_sc_hd__decap_6
XFILLER_92_1407 VGND VGND VPWR VPWR sky130_fd_sc_hd__decap_6
XPHY_EDGE_ROW_34_1_Left_289 VGND VGND VPWR VPWR sky130_fd_sc_hd__decap_3
XTAP_TAPCELL_ROW_1_897 VGND VPWR sky130_fd_sc_hd__tapvpwrvgnd_1
XFILLER_225_181 VPWR VGND VPWR VGND sky130_ef_sc_hd__decap_12
XFILLER_241_641 VPWR VGND VPWR VGND sky130_ef_sc_hd__decap_12
XFILLER_198_545 VPWR VGND VPWR VGND sky130_ef_sc_hd__decap_12
XFILLER_201_505 VPWR VGND VPWR VGND sky130_ef_sc_hd__decap_12
XFILLER_241_685 VPWR VGND VPWR VGND sky130_ef_sc_hd__decap_12
XPHY_EDGE_ROW_254_Right_99 VGND VGND VPWR VPWR sky130_fd_sc_hd__decap_3
XFILLER_198_589 VPWR VGND VPWR VGND sky130_ef_sc_hd__decap_12
XFILLER_167_921 VPWR VGND VPWR VGND sky130_ef_sc_hd__decap_12
XFILLER_185_217 VGND VGND VPWR VPWR sky130_fd_sc_hd__decap_6
XFILLER_240_195 VGND VGND VPWR VPWR sky130_fd_sc_hd__fill_1
XFILLER_55_1273 VGND VGND VPWR VPWR sky130_fd_sc_hd__fill_1
XFILLER_181_1281 VGND VGND VPWR VPWR sky130_fd_sc_hd__decap_6
XFILLER_167_965 VPWR VGND VPWR VGND sky130_ef_sc_hd__decap_12
XFILLER_220_1429 VPWR VGND VPWR VGND sky130_ef_sc_hd__decap_12
XFILLER_107_1385 VGND VGND VPWR VPWR sky130_fd_sc_hd__fill_1
XFILLER_5_603 VGND VGND VPWR VPWR sky130_fd_sc_hd__fill_1
XFILLER_166_475 VGND VGND VPWR VPWR sky130_fd_sc_hd__fill_1
XFILLER_193_261 VPWR VGND VPWR VGND sky130_ef_sc_hd__decap_12
XPHY_EDGE_ROW_96_1_Left_351 VGND VGND VPWR VPWR sky130_fd_sc_hd__decap_3
XFILLER_216_3 VPWR VGND VPWR VGND sky130_ef_sc_hd__decap_12
XTAP_TAPCELL_ROW_137_2_4579 VGND VPWR sky130_fd_sc_hd__tapvpwrvgnd_1
XFILLER_4_124 VPWR VGND VPWR VGND sky130_ef_sc_hd__decap_12
XFILLER_175_55 VGND VGND VPWR VPWR sky130_fd_sc_hd__fill_1
XFILLER_182_979 VGND VGND VPWR VPWR sky130_fd_sc_hd__fill_1
XFILLER_175_1063 VGND VGND VPWR VPWR sky130_fd_sc_hd__fill_1
XTAP_TAPCELL_ROW_117_2_4455 VGND VPWR sky130_fd_sc_hd__tapvpwrvgnd_1
XFILLER_68_53 VPWR VGND VPWR VGND sky130_ef_sc_hd__decap_12
XFILLER_27_1331 VPWR VGND VPWR VGND sky130_ef_sc_hd__decap_12
XFILLER_249_741 VPWR VGND VPWR VGND sky130_ef_sc_hd__decap_12
XFILLER_114_1301 VGND VGND VPWR VPWR sky130_fd_sc_hd__fill_1
XFILLER_7_1425 VPWR VGND VPWR VGND sky130_ef_sc_hd__decap_12
XTAP_TAPCELL_ROW_85_2_4266 VGND VPWR sky130_fd_sc_hd__tapvpwrvgnd_1
XFILLER_248_251 VGND VGND VPWR VPWR sky130_fd_sc_hd__fill_1
XFILLER_23_1217 VGND VGND VPWR VPWR sky130_fd_sc_hd__fill_1
XTAP_TAPCELL_ROW_182_1805 VGND VPWR sky130_fd_sc_hd__tapvpwrvgnd_1
XFILLER_216_1093 VPWR VGND VPWR VGND sky130_ef_sc_hd__decap_12
XFILLER_249_785 VPWR VGND VPWR VGND sky130_ef_sc_hd__decap_12
XFILLER_236_413 VGND VGND VPWR VPWR sky130_fd_sc_hd__decap_6
XFILLER_7_1469 VPWR VGND VPWR VGND sky130_ef_sc_hd__decap_12
XTAP_TAPCELL_ROW_167_1384 VGND VPWR sky130_fd_sc_hd__tapvpwrvgnd_1
XTAP_TAPCELL_ROW_167_1395 VGND VPWR sky130_fd_sc_hd__tapvpwrvgnd_1
XFILLER_84_41 VPWR VGND VPWR VGND sky130_ef_sc_hd__decap_12
XFILLER_97_1329 VGND VGND VPWR VPWR sky130_fd_sc_hd__fill_1
XFILLER_236_457 VPWR VGND VPWR VGND sky130_ef_sc_hd__decap_12
XFILLER_252_917 VGND VGND VPWR VPWR sky130_fd_sc_hd__decap_6
XFILLER_247_1009 VPWR VGND VPWR VGND sky130_ef_sc_hd__decap_12
XFILLER_251_405 VPWR VGND VPWR VGND sky130_ef_sc_hd__decap_12
XTAP_TAPCELL_ROW_65_2_4142 VGND VPWR sky130_fd_sc_hd__tapvpwrvgnd_1
X_656_ clknet_3_4__leaf_clk acc_core.adder.cla_blocks\[5\].block.sum\[2\] _064_ VGND
+ VGND VPWR VPWR net57 sky130_fd_sc_hd__dfrtp_1
XFILLER_217_671 VGND VGND VPWR VPWR sky130_fd_sc_hd__fill_1
XFILLER_1_1057 VGND VGND VPWR VPWR sky130_fd_sc_hd__decap_6
XFILLER_205_833 VGND VGND VPWR VPWR sky130_fd_sc_hd__decap_6
XFILLER_251_449 VPWR VGND VPWR VGND sky130_ef_sc_hd__decap_12
XFILLER_204_321 VPWR VGND VPWR VGND sky130_ef_sc_hd__decap_12
X_587_ net670 VGND VGND VPWR VPWR _069_ sky130_fd_sc_hd__inv_2
XFILLER_205_877 VPWR VGND VPWR VGND sky130_ef_sc_hd__decap_12
XFILLER_147_1165 VPWR VGND VPWR VGND sky130_ef_sc_hd__decap_12
XFILLER_204_365 VPWR VGND VPWR VGND sky130_ef_sc_hd__decap_12
XFILLER_220_825 VPWR VGND VPWR VGND sky130_ef_sc_hd__decap_12
XFILLER_177_729 VPWR VGND VPWR VGND sky130_ef_sc_hd__decap_12
XFILLER_38_1471 VPWR VGND VPWR VGND sky130_ef_sc_hd__decap_12
XFILLER_125_1441 VGND VGND VPWR VPWR sky130_fd_sc_hd__fill_1
XFILLER_220_869 VPWR VGND VPWR VGND sky130_ef_sc_hd__decap_12
XFILLER_34_1357 VGND VGND VPWR VPWR sky130_fd_sc_hd__fill_1
XFILLER_9_953 VPWR VGND VPWR VGND sky130_ef_sc_hd__decap_12
XFILLER_219_15 VPWR VGND VPWR VGND sky130_ef_sc_hd__decap_12
XFILLER_172_401 VPWR VGND VPWR VGND sky130_ef_sc_hd__decap_12
XFILLER_8_474 VGND VGND VPWR VPWR sky130_fd_sc_hd__fill_2
XFILLER_172_445 VPWR VGND VPWR VGND sky130_ef_sc_hd__decap_12
XFILLER_119_1201 VPWR VGND VPWR VGND sky130_ef_sc_hd__decap_12
XPHY_EDGE_ROW_134_1_Right_790 VGND VGND VPWR VPWR sky130_fd_sc_hd__decap_3
XFILLER_172_489 VPWR VGND VPWR VGND sky130_ef_sc_hd__decap_12
XFILLER_4_680 VGND VGND VPWR VPWR sky130_fd_sc_hd__fill_2
XFILLER_158_1283 VPWR VGND VPWR VGND sky130_ef_sc_hd__decap_12
XFILLER_67_1177 VPWR VGND VPWR VGND sky130_ef_sc_hd__decap_12
XFILLER_235_69 VPWR VGND VPWR VGND sky130_ef_sc_hd__decap_12
XFILLER_119_1267 VGND VGND VPWR VPWR sky130_fd_sc_hd__decap_6
XTAP_TAPCELL_ROW_245_3495 VGND VPWR sky130_fd_sc_hd__tapvpwrvgnd_1
XFILLER_228_925 VPWR VGND VPWR VGND sky130_ef_sc_hd__decap_12
XFILLER_45_1497 VGND VGND VPWR VPWR sky130_fd_sc_hd__fill_1
XFILLER_230_1035 VGND VGND VPWR VPWR sky130_fd_sc_hd__fill_1
XFILLER_239_273 VGND VGND VPWR VPWR sky130_fd_sc_hd__decap_6
XFILLER_104_29 VPWR VGND VPWR VGND sky130_ef_sc_hd__decap_12
XFILLER_254_221 VPWR VGND VPWR VGND sky130_ef_sc_hd__decap_12
XFILLER_251_57 VPWR VGND VPWR VGND sky130_ef_sc_hd__decap_12
XPHY_EDGE_ROW_70_2_Right_161 VGND VGND VPWR VPWR sky130_fd_sc_hd__decap_3
XFILLER_254_265 VPWR VGND VPWR VGND sky130_ef_sc_hd__decap_12
XFILLER_130_1191 VPWR VGND VPWR VGND sky130_ef_sc_hd__decap_12
XTAP_TAPCELL_ROW_132_1_1267 VGND VPWR sky130_fd_sc_hd__tapvpwrvgnd_1
XFILLER_208_693 VGND VGND VPWR VPWR sky130_fd_sc_hd__decap_6
XFILLER_207_181 VPWR VGND VPWR VGND sky130_ef_sc_hd__decap_12
XFILLER_223_641 VPWR VGND VPWR VGND sky130_ef_sc_hd__decap_12
XFILLER_78_1295 VGND VGND VPWR VPWR sky130_fd_sc_hd__decap_6
XFILLER_223_685 VPWR VGND VPWR VGND sky130_ef_sc_hd__decap_12
XFILLER_126_1227 VPWR VGND VPWR VGND sky130_ef_sc_hd__decap_12
XFILLER_17_1511 VGND VGND VPWR VPWR sky130_fd_sc_hd__decap_4
XFILLER_167_217 VGND VGND VPWR VPWR sky130_fd_sc_hd__decap_6
XFILLER_52_1413 VGND VGND VPWR VPWR sky130_fd_sc_hd__fill_1
XFILLER_222_195 VGND VGND VPWR VPWR sky130_fd_sc_hd__fill_1
XFILLER_13_15 VPWR VGND VPWR VGND sky130_ef_sc_hd__decap_12
XFILLER_195_559 VGND VGND VPWR VPWR sky130_fd_sc_hd__fill_1
XFILLER_200_83 VGND VGND VPWR VPWR sky130_fd_sc_hd__fill_1
XFILLER_206_1273 VPWR VGND VPWR VGND sky130_ef_sc_hd__decap_12
XFILLER_210_357 VGND VGND VPWR VPWR sky130_fd_sc_hd__decap_6
XFILLER_129_15 VPWR VGND VPWR VGND sky130_ef_sc_hd__decap_12
XFILLER_241_1175 VGND VGND VPWR VPWR sky130_fd_sc_hd__fill_1
XFILLER_182_209 VPWR VGND VPWR VGND sky130_ef_sc_hd__decap_12
XFILLER_175_261 VPWR VGND VPWR VGND sky130_ef_sc_hd__decap_12
XFILLER_191_721 VGND VGND VPWR VPWR sky130_fd_sc_hd__decap_6
XTAP_TAPCELL_ROW_91_2_4298 VGND VPWR sky130_fd_sc_hd__tapvpwrvgnd_1
XFILLER_198_1085 VGND VGND VPWR VPWR sky130_fd_sc_hd__decap_6
XFILLER_191_765 VPWR VGND VPWR VGND sky130_ef_sc_hd__decap_12
XFILLER_102_1271 VPWR VGND VPWR VGND sky130_ef_sc_hd__decap_12
XFILLER_190_253 VPWR VGND VPWR VGND sky130_ef_sc_hd__decap_12
XFILLER_11_1165 VPWR VGND VPWR VGND sky130_ef_sc_hd__decap_12
XFILLER_209_81 VPWR VGND VPWR VGND sky130_ef_sc_hd__decap_12
XTAP_TAPCELL_ROW_103_2_4374 VGND VPWR sky130_fd_sc_hd__tapvpwrvgnd_1
XFILLER_2_639 VGND VGND VPWR VPWR sky130_fd_sc_hd__fill_2
XFILLER_85_1255 VPWR VGND VPWR VGND sky130_ef_sc_hd__decap_12
XFILLER_137_1323 VGND VGND VPWR VPWR sky130_fd_sc_hd__decap_6
XFILLER_172_1203 VGND VGND VPWR VPWR sky130_fd_sc_hd__fill_1
Xmax_cap182 _084_ VGND VGND VPWR VPWR net182 sky130_fd_sc_hd__buf_1
XFILLER_46_1239 VGND VGND VPWR VPWR sky130_fd_sc_hd__decap_6
Xmax_cap193 net194 VGND VGND VPWR VPWR net193 sky130_fd_sc_hd__clkbuf_1
XFILLER_1_149 VPWR VGND VPWR VGND sky130_ef_sc_hd__decap_12
XFILLER_145_69 VGND VGND VPWR VPWR sky130_fd_sc_hd__fill_2
XFILLER_85_1299 VPWR VGND VPWR VGND sky130_ef_sc_hd__decap_12
XFILLER_137_1367 VPWR VGND VPWR VGND sky130_ef_sc_hd__decap_12
XFILLER_213_1233 VPWR VGND VPWR VGND sky130_ef_sc_hd__decap_12
XFILLER_38_56 VPWR VGND VPWR VGND sky130_ef_sc_hd__decap_12
XPHY_EDGE_ROW_147_2_Right_238 VGND VGND VPWR VPWR sky130_fd_sc_hd__decap_3
XFILLER_218_413 VGND VGND VPWR VPWR sky130_fd_sc_hd__decap_6
XFILLER_246_755 VGND VGND VPWR VPWR sky130_fd_sc_hd__fill_1
XFILLER_161_57 VPWR VGND VPWR VGND sky130_ef_sc_hd__decap_12
XFILLER_218_457 VPWR VGND VPWR VGND sky130_ef_sc_hd__decap_12
XTAP_TAPCELL_ROW_51_2_4061 VGND VPWR sky130_fd_sc_hd__tapvpwrvgnd_1
XFILLER_234_917 VGND VGND VPWR VPWR sky130_fd_sc_hd__decap_6
XFILLER_248_1329 VPWR VGND VPWR VGND sky130_ef_sc_hd__decap_12
XFILLER_233_405 VPWR VGND VPWR VGND sky130_ef_sc_hd__decap_12
X_510_ net596 dout0_q\[30\] net525 VGND VGND VPWR VPWR _261_ sky130_fd_sc_hd__a21o_1
XFILLER_22_1283 VPWR VGND VPWR VGND sky130_ef_sc_hd__decap_12
XFILLER_96_1351 VGND VGND VPWR VPWR sky130_fd_sc_hd__decap_6
XFILLER_166_1029 VGND VGND VPWR VPWR sky130_fd_sc_hd__decap_6
XFILLER_233_449 VPWR VGND VPWR VGND sky130_ef_sc_hd__decap_12
XFILLER_166_3 VPWR VGND VPWR VGND sky130_ef_sc_hd__decap_12
XFILLER_199_821 VPWR VGND VPWR VGND sky130_ef_sc_hd__decap_12
X_441_ net195 _217_ VGND VGND VPWR VPWR _230_ sky130_fd_sc_hd__and2b_1
XFILLER_92_1215 VPWR VGND VPWR VGND sky130_ef_sc_hd__decap_12
XFILLER_242_961 VPWR VGND VPWR VGND sky130_ef_sc_hd__decap_12
XFILLER_96_1395 VPWR VGND VPWR VGND sky130_ef_sc_hd__decap_12
XFILLER_148_1463 VGND VGND VPWR VPWR sky130_fd_sc_hd__decap_6
XFILLER_183_1343 VGND VGND VPWR VPWR sky130_fd_sc_hd__fill_1
XFILLER_199_865 VPWR VGND VPWR VGND sky130_ef_sc_hd__decap_12
XFILLER_202_825 VPWR VGND VPWR VGND sky130_ef_sc_hd__decap_12
XFILLER_57_1379 VGND VGND VPWR VPWR sky130_fd_sc_hd__decap_6
X_372_ net592 net576 net549 VGND VGND VPWR VPWR _161_ sky130_fd_sc_hd__a21o_1
XFILLER_92_1259 VPWR VGND VPWR VGND sky130_ef_sc_hd__decap_12
XFILLER_144_1327 VPWR VGND VPWR VGND sky130_ef_sc_hd__decap_12
XFILLER_201_335 VGND VGND VPWR VPWR sky130_fd_sc_hd__fill_1
XFILLER_202_869 VPWR VGND VPWR VGND sky130_ef_sc_hd__decap_12
XTAP_TAPCELL_ROW_175_1620 VGND VPWR sky130_fd_sc_hd__tapvpwrvgnd_1
XFILLER_224_1373 VPWR VGND VPWR VGND sky130_ef_sc_hd__decap_12
XFILLER_9_249 VGND VGND VPWR VPWR sky130_fd_sc_hd__decap_3
XTAP_TAPCELL_ROW_28_2_3925 VGND VPWR sky130_fd_sc_hd__tapvpwrvgnd_1
XFILLER_70_65 VGND VGND VPWR VPWR sky130_fd_sc_hd__decap_6
XTAP_TAPCELL_ROW_171_1506 VGND VPWR sky130_fd_sc_hd__tapvpwrvgnd_1
XFILLER_194_581 VGND VGND VPWR VPWR sky130_fd_sc_hd__decap_6
XFILLER_220_1259 VGND VGND VPWR VPWR sky130_fd_sc_hd__fill_1
XFILLER_186_65 VPWR VGND VPWR VGND sky130_ef_sc_hd__decap_12
XFILLER_170_905 VPWR VGND VPWR VGND sky130_ef_sc_hd__decap_12
XFILLER_120_1371 VPWR VGND VPWR VGND sky130_ef_sc_hd__decap_12
XFILLER_177_1169 VGND VGND VPWR VPWR sky130_fd_sc_hd__decap_6
XFILLER_170_949 VPWR VGND VPWR VGND sky130_ef_sc_hd__decap_12
XFILLER_155_1423 VPWR VGND VPWR VGND sky130_ef_sc_hd__decap_12
XFILLER_9_1509 VGND VGND VPWR VPWR sky130_fd_sc_hd__decap_3
XFILLER_194_1483 VGND VGND VPWR VPWR sky130_fd_sc_hd__fill_1
XFILLER_64_1339 VPWR VGND VPWR VGND sky130_ef_sc_hd__decap_12
XFILLER_116_1407 VGND VGND VPWR VPWR sky130_fd_sc_hd__decap_6
XFILLER_253_1057 VGND VGND VPWR VPWR sky130_fd_sc_hd__decap_6
XFILLER_155_1467 VPWR VGND VPWR VGND sky130_ef_sc_hd__decap_12
XTAP_TAPCELL_ROW_169_1435 VGND VPWR sky130_fd_sc_hd__tapvpwrvgnd_1
XTAP_TAPCELL_ROW_169_1446 VGND VPWR sky130_fd_sc_hd__tapvpwrvgnd_1
XTAP_TAPCELL_ROW_169_1457 VGND VPWR sky130_fd_sc_hd__tapvpwrvgnd_1
XFILLER_205_39 VPWR VGND VPWR VGND sky130_ef_sc_hd__decap_12
XFILLER_7_1233 VPWR VGND VPWR VGND sky130_ef_sc_hd__decap_12
XFILLER_95_51 VGND VGND VPWR VPWR sky130_fd_sc_hd__decap_4
XFILLER_0_193 VGND VGND VPWR VPWR sky130_fd_sc_hd__decap_3
XFILLER_236_221 VPWR VGND VPWR VGND sky130_ef_sc_hd__decap_12
XFILLER_3_1119 VGND VGND VPWR VPWR sky130_fd_sc_hd__fill_1
XTAP_TAPCELL_ROW_160_2_4717 VGND VPWR sky130_fd_sc_hd__tapvpwrvgnd_1
XFILLER_231_1399 VGND VGND VPWR VPWR sky130_fd_sc_hd__fill_1
XFILLER_237_777 VGND VGND VPWR VPWR sky130_fd_sc_hd__decap_6
XTAP_TAPCELL_ROW_240_3370 VGND VPWR sky130_fd_sc_hd__tapvpwrvgnd_1
XFILLER_236_265 VPWR VGND VPWR VGND sky130_ef_sc_hd__decap_12
XFILLER_252_725 VPWR VGND VPWR VGND sky130_ef_sc_hd__decap_12
XFILLER_221_27 VPWR VGND VPWR VGND sky130_ef_sc_hd__decap_12
XFILLER_40_1383 VPWR VGND VPWR VGND sky130_ef_sc_hd__decap_12
XFILLER_184_1129 VPWR VGND VPWR VGND sky130_ef_sc_hd__decap_12
XFILLER_252_769 VPWR VGND VPWR VGND sky130_ef_sc_hd__decap_12
X_639_ clknet_3_3__leaf_clk acc_core.adder.cla_blocks\[1\].block.sum\[1\] _047_ VGND
+ VGND VPWR VPWR net70 sky130_fd_sc_hd__dfrtp_1
XFILLER_205_641 VPWR VGND VPWR VGND sky130_ef_sc_hd__decap_12
XFILLER_75_1435 VGND VGND VPWR VPWR sky130_fd_sc_hd__decap_6
XFILLER_251_279 VGND VGND VPWR VPWR sky130_fd_sc_hd__fill_1
XFILLER_205_685 VPWR VGND VPWR VGND sky130_ef_sc_hd__decap_12
XFILLER_75_1479 VPWR VGND VPWR VGND sky130_ef_sc_hd__decap_12
XFILLER_162_1427 VPWR VGND VPWR VGND sky130_ef_sc_hd__decap_12
XTAP_TAPCELL_ROW_253_3720 VGND VPWR sky130_fd_sc_hd__tapvpwrvgnd_1
XPHY_EDGE_ROW_109_2_Right_200 VGND VGND VPWR VPWR sky130_fd_sc_hd__decap_3
XFILLER_204_195 VGND VGND VPWR VPWR sky130_fd_sc_hd__fill_1
XFILLER_81_3 VPWR VGND VPWR VGND sky130_ef_sc_hd__decap_12
XFILLER_177_559 VGND VGND VPWR VPWR sky130_fd_sc_hd__fill_1
XFILLER_203_1413 VPWR VGND VPWR VGND sky130_ef_sc_hd__decap_12
XFILLER_220_699 VGND VGND VPWR VPWR sky130_fd_sc_hd__fill_1
XFILLER_34_1165 VPWR VGND VPWR VGND sky130_ef_sc_hd__decap_12
XFILLER_203_1457 VPWR VGND VPWR VGND sky130_ef_sc_hd__decap_12
XFILLER_173_721 VGND VGND VPWR VPWR sky130_fd_sc_hd__decap_6
XTAP_TAPCELL_ROW_234_3196 VGND VPWR sky130_fd_sc_hd__tapvpwrvgnd_1
XFILLER_69_1217 VGND VGND VPWR VPWR sky130_fd_sc_hd__fill_1
XFILLER_238_1509 VGND VGND VPWR VPWR sky130_fd_sc_hd__decap_6
XFILLER_195_1225 VGND VGND VPWR VPWR sky130_fd_sc_hd__decap_6
XFILLER_173_765 VPWR VGND VPWR VGND sky130_ef_sc_hd__decap_12
XFILLER_12_1463 VGND VGND VPWR VPWR sky130_fd_sc_hd__decap_6
XFILLER_172_253 VPWR VGND VPWR VGND sky130_ef_sc_hd__decap_12
XFILLER_195_1269 VPWR VGND VPWR VGND sky130_ef_sc_hd__decap_12
XTAP_TAPCELL_ROW_247_3546 VGND VPWR sky130_fd_sc_hd__tapvpwrvgnd_1
XPHY_EDGE_ROW_135_1_Right_791 VGND VGND VPWR VPWR sky130_fd_sc_hd__decap_3
XTAP_TAPCELL_ROW_247_3557 VGND VPWR sky130_fd_sc_hd__tapvpwrvgnd_1
XFILLER_82_1439 VPWR VGND VPWR VGND sky130_ef_sc_hd__decap_12
XFILLER_134_1507 VGND VGND VPWR VPWR sky130_fd_sc_hd__decap_8
XFILLER_115_39 VPWR VGND VPWR VGND sky130_ef_sc_hd__decap_12
XFILLER_189_1007 VGND VGND VPWR VPWR sky130_fd_sc_hd__fill_1
XTAP_TAPCELL_ROW_3_937 VGND VPWR sky130_fd_sc_hd__tapvpwrvgnd_1
XTAP_TAPCELL_ROW_3_948 VGND VPWR sky130_fd_sc_hd__tapvpwrvgnd_1
XFILLER_228_755 VGND VGND VPWR VPWR sky130_fd_sc_hd__fill_1
XFILLER_216_917 VGND VGND VPWR VPWR sky130_fd_sc_hd__decap_6
XFILLER_215_405 VPWR VGND VPWR VGND sky130_ef_sc_hd__decap_12
XFILLER_255_585 VGND VGND VPWR VPWR sky130_fd_sc_hd__decap_3
XFILLER_131_27 VPWR VGND VPWR VGND sky130_ef_sc_hd__decap_12
XPHY_EDGE_ROW_71_2_Right_162 VGND VGND VPWR VPWR sky130_fd_sc_hd__decap_3
XPHY_EDGE_ROW_113_2_Left_615 VGND VGND VPWR VPWR sky130_fd_sc_hd__decap_3
XTAP_TAPCELL_ROW_34_2_3957 VGND VPWR sky130_fd_sc_hd__tapvpwrvgnd_1
XFILLER_215_449 VPWR VGND VPWR VGND sky130_ef_sc_hd__decap_12
XFILLER_231_909 VPWR VGND VPWR VGND sky130_ef_sc_hd__decap_12
XFILLER_224_961 VPWR VGND VPWR VGND sky130_ef_sc_hd__decap_12
XTAP_TAPCELL_ROW_66_1_1201 VGND VPWR sky130_fd_sc_hd__tapvpwrvgnd_1
XFILLER_230_419 VGND VGND VPWR VPWR sky130_fd_sc_hd__fill_1
XFILLER_196_813 VPWR VGND VPWR VGND sky130_ef_sc_hd__decap_12
XFILLER_165_1073 VGND VGND VPWR VPWR sky130_fd_sc_hd__decap_3
XFILLER_211_93 VPWR VGND VPWR VGND sky130_ef_sc_hd__decap_12
XFILLER_210_121 VPWR VGND VPWR VGND sky130_ef_sc_hd__decap_12
XFILLER_221_1513 VGND VGND VPWR VPWR sky130_fd_sc_hd__fill_2
XFILLER_210_165 VPWR VGND VPWR VGND sky130_ef_sc_hd__decap_12
Xwire629 net39 VGND VGND VPWR VPWR net629 sky130_fd_sc_hd__buf_1
XFILLER_17_1385 VGND VGND VPWR VPWR sky130_fd_sc_hd__fill_1
XFILLER_183_529 VPWR VGND VPWR VGND sky130_ef_sc_hd__decap_12
XFILLER_176_581 VGND VGND VPWR VPWR sky130_fd_sc_hd__decap_6
XTAP_TAPCELL_ROW_153_2_4671 VGND VPWR sky130_fd_sc_hd__tapvpwrvgnd_1
XFILLER_191_573 VPWR VGND VPWR VGND sky130_ef_sc_hd__decap_12
XFILLER_174_1309 VGND VGND VPWR VPWR sky130_fd_sc_hd__decap_6
XFILLER_2_436 VGND VGND VPWR VPWR sky130_fd_sc_hd__fill_1
XFILLER_49_55 VGND VGND VPWR VPWR sky130_fd_sc_hd__fill_1
XFILLER_24_1301 VGND VGND VPWR VPWR sky130_fd_sc_hd__fill_1
XFILLER_213_1063 VGND VGND VPWR VPWR sky130_fd_sc_hd__fill_1
XFILLER_218_221 VPWR VGND VPWR VGND sky130_ef_sc_hd__decap_12
XFILLER_98_1413 VGND VGND VPWR VPWR sky130_fd_sc_hd__fill_1
XPHY_EDGE_ROW_148_2_Right_239 VGND VGND VPWR VPWR sky130_fd_sc_hd__decap_3
XFILLER_219_777 VGND VGND VPWR VPWR sky130_fd_sc_hd__decap_6
XFILLER_65_43 VPWR VGND VPWR VGND sky130_ef_sc_hd__decap_12
XPHY_EDGE_ROW_45_2_Left_547 VGND VGND VPWR VPWR sky130_fd_sc_hd__decap_3
XFILLER_218_265 VPWR VGND VPWR VGND sky130_ef_sc_hd__decap_12
XFILLER_234_725 VPWR VGND VPWR VGND sky130_ef_sc_hd__decap_12
XFILLER_2_1141 VGND VGND VPWR VPWR sky130_fd_sc_hd__decap_6
XFILLER_234_769 VPWR VGND VPWR VGND sky130_ef_sc_hd__decap_12
XTAP_TAPCELL_ROW_125_2_4506 VGND VPWR sky130_fd_sc_hd__tapvpwrvgnd_1
XFILLER_185_1449 VGND VGND VPWR VPWR sky130_fd_sc_hd__decap_6
XFILLER_2_1185 VPWR VGND VPWR VGND sky130_ef_sc_hd__decap_12
XFILLER_233_279 VGND VGND VPWR VPWR sky130_fd_sc_hd__fill_1
X_424_ net595 dout0_q\[23\] net532 VGND VGND VPWR VPWR _213_ sky130_fd_sc_hd__and3_1
XFILLER_148_1271 VPWR VGND VPWR VGND sky130_ef_sc_hd__decap_12
XFILLER_199_673 VPWR VGND VPWR VGND sky130_ef_sc_hd__decap_12
XFILLER_57_1165 VPWR VGND VPWR VGND sky130_ef_sc_hd__decap_12
XFILLER_186_301 VGND VGND VPWR VPWR sky130_fd_sc_hd__decap_6
XFILLER_109_1255 VPWR VGND VPWR VGND sky130_ef_sc_hd__decap_12
X_355_ _139_ net165 VGND VGND VPWR VPWR _144_ sky130_fd_sc_hd__or2_1
XFILLER_35_1441 VGND VGND VPWR VPWR sky130_fd_sc_hd__fill_1
XFILLER_186_345 VPWR VGND VPWR VGND sky130_ef_sc_hd__decap_12
XFILLER_109_1299 VPWR VGND VPWR VGND sky130_ef_sc_hd__decap_12
XFILLER_202_699 VGND VGND VPWR VPWR sky130_fd_sc_hd__fill_1
X_286_ web0 net613 net614 net617 VGND VGND VPWR VPWR _083_ sky130_fd_sc_hd__and4_1
XFILLER_186_389 VPWR VGND VPWR VGND sky130_ef_sc_hd__decap_12
XFILLER_170_713 VPWR VGND VPWR VGND sky130_ef_sc_hd__decap_12
XFILLER_192_1409 VPWR VGND VPWR VGND sky130_ef_sc_hd__decap_12
XFILLER_6_797 VPWR VGND VPWR VGND sky130_ef_sc_hd__decap_12
XFILLER_29_1201 VPWR VGND VPWR VGND sky130_ef_sc_hd__decap_12
XFILLER_170_757 VPWR VGND VPWR VGND sky130_ef_sc_hd__decap_12
XFILLER_216_27 VGND VGND VPWR VPWR sky130_fd_sc_hd__fill_1
XFILLER_68_1283 VPWR VGND VPWR VGND sky130_ef_sc_hd__decap_12
XFILLER_155_1231 VPWR VGND VPWR VGND sky130_ef_sc_hd__decap_12
XPHY_EDGE_ROW_59_1_Left_314 VGND VGND VPWR VPWR sky130_fd_sc_hd__decap_3
XFILLER_9_1317 VPWR VGND VPWR VGND sky130_ef_sc_hd__decap_12
XFILLER_29_1267 VGND VGND VPWR VPWR sky130_fd_sc_hd__decap_6
XFILLER_116_1215 VPWR VGND VPWR VGND sky130_ef_sc_hd__decap_12
XFILLER_2_981 VPWR VGND VPWR VGND sky130_ef_sc_hd__decap_12
XFILLER_155_1275 VPWR VGND VPWR VGND sky130_ef_sc_hd__decap_12
XPHY_EDGE_ROW_111_1_Left_366 VGND VGND VPWR VPWR sky130_fd_sc_hd__decap_3
XTAP_TAPCELL_ROW_242_3410 VGND VPWR sky130_fd_sc_hd__tapvpwrvgnd_1
XTAP_TAPCELL_ROW_242_3421 VGND VPWR sky130_fd_sc_hd__tapvpwrvgnd_1
XFILLER_116_1259 VPWR VGND VPWR VGND sky130_ef_sc_hd__decap_12
XTAP_TAPCELL_ROW_242_3432 VGND VPWR sky130_fd_sc_hd__tapvpwrvgnd_1
XFILLER_232_15 VPWR VGND VPWR VGND sky130_ef_sc_hd__decap_12
XFILLER_7_1063 VGND VGND VPWR VPWR sky130_fd_sc_hd__fill_1
XFILLER_237_541 VPWR VGND VPWR VGND sky130_ef_sc_hd__decap_12
Xinput6 wr_addr[4] VGND VGND VPWR VPWR net6 sky130_fd_sc_hd__clkbuf_1
XTAP_TAPCELL_ROW_8_1080 VGND VPWR sky130_fd_sc_hd__tapvpwrvgnd_1
XFILLER_237_585 VPWR VGND VPWR VGND sky130_ef_sc_hd__decap_12
XTAP_TAPCELL_ROW_20_2_3876 VGND VPWR sky130_fd_sc_hd__tapvpwrvgnd_1
XTAP_TAPCELL_ROW_8_1091 VGND VPWR sky130_fd_sc_hd__tapvpwrvgnd_1
XFILLER_252_533 VPWR VGND VPWR VGND sky130_ef_sc_hd__decap_12
XFILLER_188_1073 VPWR VGND VPWR VGND sky130_ef_sc_hd__decap_12
XFILLER_40_1191 VPWR VGND VPWR VGND sky130_ef_sc_hd__decap_12
XFILLER_213_909 VPWR VGND VPWR VGND sky130_ef_sc_hd__decap_12
XFILLER_206_961 VPWR VGND VPWR VGND sky130_ef_sc_hd__decap_12
XTAP_TAPCELL_ROW_255_3804 VGND VPWR sky130_fd_sc_hd__tapvpwrvgnd_1
XFILLER_212_419 VGND VGND VPWR VPWR sky130_fd_sc_hd__fill_1
XFILLER_75_1243 VPWR VGND VPWR VGND sky130_ef_sc_hd__decap_12
XFILLER_127_1311 VPWR VGND VPWR VGND sky130_ef_sc_hd__decap_12
XFILLER_178_813 VPWR VGND VPWR VGND sky130_ef_sc_hd__decap_12
XFILLER_196_109 VPWR VGND VPWR VGND sky130_ef_sc_hd__decap_12
XFILLER_166_1371 VGND VGND VPWR VPWR sky130_fd_sc_hd__fill_1
XFILLER_189_161 VGND VGND VPWR VPWR sky130_fd_sc_hd__decap_6
XFILLER_36_1227 VPWR VGND VPWR VGND sky130_ef_sc_hd__decap_12
XTAP_TAPCELL_ROW_236_3247 VGND VPWR sky130_fd_sc_hd__tapvpwrvgnd_1
XFILLER_75_1287 VPWR VGND VPWR VGND sky130_ef_sc_hd__decap_12
XFILLER_127_1355 VPWR VGND VPWR VGND sky130_ef_sc_hd__decap_12
XFILLER_221_953 VPWR VGND VPWR VGND sky130_ef_sc_hd__decap_12
XTAP_TAPCELL_ROW_236_3258 VGND VPWR sky130_fd_sc_hd__tapvpwrvgnd_1
XTAP_TAPCELL_ROW_236_3269 VGND VPWR sky130_fd_sc_hd__tapvpwrvgnd_1
XFILLER_123_1219 VPWR VGND VPWR VGND sky130_ef_sc_hd__decap_12
XFILLER_127_1399 VPWR VGND VPWR VGND sky130_ef_sc_hd__decap_12
XPHY_EDGE_ROW_91_2_Left_593 VGND VGND VPWR VPWR sky130_fd_sc_hd__decap_3
XTAP_TAPCELL_ROW_127_1_1262 VGND VPWR sky130_fd_sc_hd__tapvpwrvgnd_1
XFILLER_165_529 VGND VGND VPWR VPWR sky130_fd_sc_hd__decap_3
XTAP_TAPCELL_ROW_138_2_4584 VGND VPWR sky130_fd_sc_hd__tapvpwrvgnd_1
XFILLER_203_1287 VGND VGND VPWR VPWR sky130_fd_sc_hd__fill_1
XTAP_TAPCELL_ROW_249_3608 VGND VPWR sky130_fd_sc_hd__tapvpwrvgnd_1
XTAP_TAPCELL_ROW_249_3619 VGND VPWR sky130_fd_sc_hd__tapvpwrvgnd_1
XFILLER_238_1317 VPWR VGND VPWR VGND sky130_ef_sc_hd__decap_12
XFILLER_195_1033 VPWR VGND VPWR VGND sky130_ef_sc_hd__decap_12
XFILLER_173_573 VPWR VGND VPWR VGND sky130_ef_sc_hd__decap_12
XFILLER_12_1271 VPWR VGND VPWR VGND sky130_ef_sc_hd__decap_12
XFILLER_195_1077 VPWR VGND VPWR VGND sky130_ef_sc_hd__decap_12
XFILLER_126_27 VGND VGND VPWR VPWR sky130_fd_sc_hd__fill_1
XFILLER_47_1323 VGND VGND VPWR VPWR sky130_fd_sc_hd__decap_6
XFILLER_82_1203 VPWR VGND VPWR VGND sky130_ef_sc_hd__decap_12
XTAP_TAPCELL_ROW_118_2_4460 VGND VPWR sky130_fd_sc_hd__tapvpwrvgnd_1
XFILLER_86_1383 VPWR VGND VPWR VGND sky130_ef_sc_hd__decap_12
XFILLER_138_1451 VPWR VGND VPWR VGND sky130_ef_sc_hd__decap_12
XPHY_EDGE_ROW_43_1_Left_298 VGND VGND VPWR VPWR sky130_fd_sc_hd__decap_3
XFILLER_47_1367 VPWR VGND VPWR VGND sky130_ef_sc_hd__decap_12
XFILLER_82_1247 VPWR VGND VPWR VGND sky130_ef_sc_hd__decap_12
XFILLER_134_1315 VPWR VGND VPWR VGND sky130_ef_sc_hd__decap_12
XPHY_EDGE_ROW_136_1_Right_792 VGND VGND VPWR VPWR sky130_fd_sc_hd__decap_3
XFILLER_236_1085 VGND VGND VPWR VPWR sky130_fd_sc_hd__decap_6
XFILLER_138_1495 VPWR VGND VPWR VGND sky130_ef_sc_hd__decap_12
XTAP_TAPCELL_ROW_131_2_4538 VGND VPWR sky130_fd_sc_hd__tapvpwrvgnd_1
XFILLER_247_305 VPWR VGND VPWR VGND sky130_ef_sc_hd__decap_12
XTAP_TAPCELL_ROW_86_2_4271 VGND VPWR sky130_fd_sc_hd__tapvpwrvgnd_1
XFILLER_134_1359 VPWR VGND VPWR VGND sky130_ef_sc_hd__decap_12
XFILLER_247_349 VPWR VGND VPWR VGND sky130_ef_sc_hd__decap_12
XFILLER_142_15 VPWR VGND VPWR VGND sky130_ef_sc_hd__decap_12
XFILLER_210_1203 VGND VGND VPWR VPWR sky130_fd_sc_hd__fill_1
XFILLER_19_69 VGND VGND VPWR VPWR sky130_fd_sc_hd__fill_2
XTAP_TAPCELL_ROW_225_2951 VGND VPWR sky130_fd_sc_hd__tapvpwrvgnd_1
XFILLER_249_1413 VPWR VGND VPWR VGND sky130_ef_sc_hd__decap_12
XTAP_TAPCELL_ROW_225_2962 VGND VPWR sky130_fd_sc_hd__tapvpwrvgnd_1
XTAP_TAPCELL_ROW_225_2973 VGND VPWR sky130_fd_sc_hd__tapvpwrvgnd_1
XFILLER_216_725 VPWR VGND VPWR VGND sky130_ef_sc_hd__decap_12
XFILLER_167_1113 VGND VGND VPWR VPWR sky130_fd_sc_hd__decap_6
XFILLER_255_393 VPWR VGND VPWR VGND sky130_ef_sc_hd__decap_12
XFILLER_249_1457 VPWR VGND VPWR VGND sky130_ef_sc_hd__decap_12
XTAP_TAPCELL_ROW_221_2848 VGND VPWR sky130_fd_sc_hd__tapvpwrvgnd_1
XFILLER_216_769 VPWR VGND VPWR VGND sky130_ef_sc_hd__decap_12
XTAP_TAPCELL_ROW_221_2859 VGND VPWR sky130_fd_sc_hd__tapvpwrvgnd_1
XPHY_EDGE_ROW_72_2_Right_163 VGND VGND VPWR VPWR sky130_fd_sc_hd__decap_3
XFILLER_167_1157 VPWR VGND VPWR VGND sky130_ef_sc_hd__decap_12
XFILLER_35_57 VGND VGND VPWR VPWR sky130_fd_sc_hd__decap_8
XFILLER_215_279 VGND VGND VPWR VPWR sky130_fd_sc_hd__fill_1
XFILLER_243_1001 VGND VGND VPWR VPWR sky130_fd_sc_hd__decap_6
XFILLER_58_1463 VGND VGND VPWR VPWR sky130_fd_sc_hd__decap_6
XFILLER_93_1343 VPWR VGND VPWR VGND sky130_ef_sc_hd__decap_12
XFILLER_145_1411 VPWR VGND VPWR VGND sky130_ef_sc_hd__decap_12
XFILLER_168_301 VGND VGND VPWR VPWR sky130_fd_sc_hd__decap_6
XFILLER_54_1327 VPWR VGND VPWR VGND sky130_ef_sc_hd__decap_12
XFILLER_243_1045 VPWR VGND VPWR VGND sky130_ef_sc_hd__decap_12
XFILLER_93_1387 VPWR VGND VPWR VGND sky130_ef_sc_hd__decap_12
XFILLER_145_1455 VPWR VGND VPWR VGND sky130_ef_sc_hd__decap_12
XFILLER_196_643 VGND VGND VPWR VPWR sky130_fd_sc_hd__fill_1
XFILLER_211_441 VGND VGND VPWR VPWR sky130_fd_sc_hd__decap_6
XFILLER_168_345 VPWR VGND VPWR VGND sky130_ef_sc_hd__decap_12
Xclkbuf_3_3__f_clk clknet_0_clk VGND VGND VPWR VPWR clknet_3_3__leaf_clk sky130_fd_sc_hd__clkbuf_16
XFILLER_184_805 VGND VGND VPWR VPWR sky130_fd_sc_hd__decap_6
XFILLER_204_1029 VGND VGND VPWR VPWR sky130_fd_sc_hd__decap_6
XFILLER_243_1089 VPWR VGND VPWR VGND sky130_ef_sc_hd__decap_12
XFILLER_106_1439 VPWR VGND VPWR VGND sky130_ef_sc_hd__decap_12
Xwire404 net405 VGND VGND VPWR VPWR net404 sky130_fd_sc_hd__clkbuf_1
XFILLER_145_1499 VPWR VGND VPWR VGND sky130_ef_sc_hd__decap_12
XFILLER_211_485 VPWR VGND VPWR VGND sky130_ef_sc_hd__decap_12
Xwire415 net416 VGND VGND VPWR VPWR net415 sky130_fd_sc_hd__clkbuf_1
Xwire426 net427 VGND VGND VPWR VPWR net426 sky130_fd_sc_hd__clkbuf_1
XFILLER_168_389 VPWR VGND VPWR VGND sky130_ef_sc_hd__decap_12
XTAP_TAPCELL_ROW_219_2788 VGND VPWR sky130_fd_sc_hd__tapvpwrvgnd_1
XFILLER_184_849 VPWR VGND VPWR VGND sky130_ef_sc_hd__decap_12
XTAP_TAPCELL_ROW_219_2799 VGND VPWR sky130_fd_sc_hd__tapvpwrvgnd_1
XFILLER_221_1343 VGND VGND VPWR VPWR sky130_fd_sc_hd__fill_1
Xwire437 net438 VGND VGND VPWR VPWR net437 sky130_fd_sc_hd__clkbuf_1
Xwire448 net449 VGND VGND VPWR VPWR net448 sky130_fd_sc_hd__clkbuf_1
XFILLER_129_3 VPWR VGND VPWR VGND sky130_ef_sc_hd__decap_12
XFILLER_183_337 VPWR VGND VPWR VGND sky130_ef_sc_hd__decap_12
Xwire459 net460 VGND VGND VPWR VPWR net459 sky130_fd_sc_hd__clkbuf_1
XFILLER_178_1253 VGND VGND VPWR VPWR sky130_fd_sc_hd__decap_6
XFILLER_30_1371 VPWR VGND VPWR VGND sky130_ef_sc_hd__decap_12
XFILLER_192_893 VPWR VGND VPWR VGND sky130_ef_sc_hd__decap_12
XFILLER_174_1117 VPWR VGND VPWR VGND sky130_ef_sc_hd__decap_12
XFILLER_178_1297 VPWR VGND VPWR VGND sky130_ef_sc_hd__decap_12
XFILLER_65_1423 VPWR VGND VPWR VGND sky130_ef_sc_hd__decap_12
XFILLER_2_233 VPWR VGND VPWR VGND sky130_ef_sc_hd__decap_12
XFILLER_254_1141 VGND VGND VPWR VPWR sky130_fd_sc_hd__decap_6
XFILLER_3_767 VGND VGND VPWR VPWR sky130_fd_sc_hd__fill_2
XFILLER_183_55 VGND VGND VPWR VPWR sky130_fd_sc_hd__fill_1
XFILLER_26_1407 VGND VGND VPWR VPWR sky130_fd_sc_hd__decap_6
XFILLER_250_1005 VPWR VGND VPWR VGND sky130_ef_sc_hd__decap_12
XFILLER_65_1467 VPWR VGND VPWR VGND sky130_ef_sc_hd__decap_12
XFILLER_152_1415 VPWR VGND VPWR VGND sky130_ef_sc_hd__decap_12
XFILLER_254_1185 VPWR VGND VPWR VGND sky130_ef_sc_hd__decap_12
XFILLER_239_839 VGND VGND VPWR VPWR sky130_fd_sc_hd__fill_1
XFILLER_250_1049 VPWR VGND VPWR VGND sky130_ef_sc_hd__decap_12
XFILLER_215_1169 VGND VGND VPWR VPWR sky130_fd_sc_hd__decap_6
XFILLER_4_1203 VGND VGND VPWR VPWR sky130_fd_sc_hd__fill_1
XFILLER_76_53 VPWR VGND VPWR VGND sky130_ef_sc_hd__decap_12
Xfanout592 net603 VGND VGND VPWR VPWR net592 sky130_fd_sc_hd__clkbuf_2
XFILLER_219_541 VPWR VGND VPWR VGND sky130_ef_sc_hd__decap_12
XFILLER_232_1483 VGND VGND VPWR VPWR sky130_fd_sc_hd__fill_1
XFILLER_219_585 VPWR VGND VPWR VGND sky130_ef_sc_hd__decap_12
XFILLER_234_533 VPWR VGND VPWR VGND sky130_ef_sc_hd__decap_12
XFILLER_185_1213 VPWR VGND VPWR VGND sky130_ef_sc_hd__decap_12
XFILLER_202_29 VPWR VGND VPWR VGND sky130_ef_sc_hd__decap_12
XFILLER_189_1393 VGND VGND VPWR VPWR sky130_fd_sc_hd__decap_6
XFILLER_111_1189 VPWR VGND VPWR VGND sky130_ef_sc_hd__decap_12
XFILLER_92_41 VPWR VGND VPWR VGND sky130_ef_sc_hd__decap_12
XFILLER_185_1257 VPWR VGND VPWR VGND sky130_ef_sc_hd__decap_12
XFILLER_221_205 VPWR VGND VPWR VGND sky130_ef_sc_hd__decap_12
XFILLER_163_1511 VGND VGND VPWR VPWR sky130_fd_sc_hd__decap_4
XFILLER_178_109 VPWR VGND VPWR VGND sky130_ef_sc_hd__decap_12
XFILLER_72_1427 VPWR VGND VPWR VGND sky130_ef_sc_hd__decap_12
XFILLER_203_953 VPWR VGND VPWR VGND sky130_ef_sc_hd__decap_12
XFILLER_221_249 VPWR VGND VPWR VGND sky130_ef_sc_hd__decap_12
X_407_ _189_ _195_ _188_ VGND VGND VPWR VPWR _196_ sky130_fd_sc_hd__a21boi_1
XFILLER_187_665 VGND VGND VPWR VPWR sky130_fd_sc_hd__decap_6
XFILLER_222_1129 VPWR VGND VPWR VGND sky130_ef_sc_hd__decap_12
XFILLER_186_153 VPWR VGND VPWR VGND sky130_ef_sc_hd__decap_12
X_338_ net497 _123_ VGND VGND VPWR VPWR _127_ sky130_fd_sc_hd__and2b_1
XTAP_TAPCELL_ROW_231_3111 VGND VPWR sky130_fd_sc_hd__tapvpwrvgnd_1
XTAP_TAPCELL_ROW_231_3122 VGND VPWR sky130_fd_sc_hd__tapvpwrvgnd_1
XFILLER_186_197 VPWR VGND VPWR VGND sky130_ef_sc_hd__decap_12
XTAP_TAPCELL_ROW_231_3133 VGND VPWR sky130_fd_sc_hd__tapvpwrvgnd_1
XFILLER_200_1427 VGND VGND VPWR VPWR sky130_fd_sc_hd__fill_1
XFILLER_227_15 VPWR VGND VPWR VGND sky130_ef_sc_hd__decap_12
XFILLER_196_1353 VPWR VGND VPWR VGND sky130_ef_sc_hd__decap_12
XFILLER_192_1217 VPWR VGND VPWR VGND sky130_ef_sc_hd__decap_12
XFILLER_196_1397 VPWR VGND VPWR VGND sky130_ef_sc_hd__decap_12
XFILLER_44_3 VPWR VGND VPWR VGND sky130_ef_sc_hd__decap_12
XFILLER_44_1507 VGND VGND VPWR VPWR sky130_fd_sc_hd__decap_8
XFILLER_170_587 VGND VGND VPWR VPWR sky130_fd_sc_hd__fill_1
XTAP_TAPCELL_ROW_229_3062 VGND VPWR sky130_fd_sc_hd__tapvpwrvgnd_1
XFILLER_233_1225 VGND VGND VPWR VPWR sky130_fd_sc_hd__decap_6
XTAP_TAPCELL_ROW_229_3073 VGND VPWR sky130_fd_sc_hd__tapvpwrvgnd_1
XFILLER_229_305 VPWR VGND VPWR VGND sky130_ef_sc_hd__decap_12
XFILLER_233_1269 VPWR VGND VPWR VGND sky130_ef_sc_hd__decap_12
XFILLER_243_69 VPWR VGND VPWR VGND sky130_ef_sc_hd__decap_12
XFILLER_229_349 VPWR VGND VPWR VGND sky130_ef_sc_hd__decap_12
XFILLER_245_809 VPWR VGND VPWR VGND sky130_ef_sc_hd__decap_12
XTAP_TAPCELL_ROW_6_1017 VGND VPWR sky130_fd_sc_hd__tapvpwrvgnd_1
XFILLER_238_861 VGND VGND VPWR VPWR sky130_fd_sc_hd__decap_6
XTAP_TAPCELL_ROW_6_1028 VGND VPWR sky130_fd_sc_hd__tapvpwrvgnd_1
XFILLER_2_83 VGND VGND VPWR VPWR sky130_fd_sc_hd__fill_1
XFILLER_237_393 VPWR VGND VPWR VGND sky130_ef_sc_hd__decap_12
XFILLER_112_29 VPWR VGND VPWR VGND sky130_ef_sc_hd__decap_12
XFILLER_253_853 VPWR VGND VPWR VGND sky130_ef_sc_hd__decap_12
XTAP_TAPCELL_ROW_238_3309 VGND VPWR sky130_fd_sc_hd__tapvpwrvgnd_1
XTAP_TAPCELL_ROW_64_2_4138 VGND VPWR sky130_fd_sc_hd__tapvpwrvgnd_1
XFILLER_227_1007 VGND VGND VPWR VPWR sky130_fd_sc_hd__fill_1
XFILLER_168_1477 VGND VGND VPWR VPWR sky130_fd_sc_hd__decap_6
XFILLER_253_897 VPWR VGND VPWR VGND sky130_ef_sc_hd__decap_12
XFILLER_252_363 VGND VGND VPWR VPWR sky130_fd_sc_hd__fill_1
XFILLER_240_525 VGND VGND VPWR VPWR sky130_fd_sc_hd__decap_6
XFILLER_197_429 VPWR VGND VPWR VGND sky130_ef_sc_hd__decap_12
XFILLER_244_1365 VGND VGND VPWR VPWR sky130_fd_sc_hd__decap_6
XFILLER_240_569 VPWR VGND VPWR VGND sky130_ef_sc_hd__decap_12
XFILLER_178_643 VGND VGND VPWR VPWR sky130_fd_sc_hd__fill_1
XFILLER_166_805 VGND VGND VPWR VPWR sky130_fd_sc_hd__decap_6
XFILLER_240_1229 VPWR VGND VPWR VGND sky130_ef_sc_hd__decap_12
XFILLER_221_783 VGND VGND VPWR VPWR sky130_fd_sc_hd__fill_1
XTAP_TAPCELL_ROW_29_2_3930 VGND VPWR sky130_fd_sc_hd__tapvpwrvgnd_1
XFILLER_166_849 VPWR VGND VPWR VGND sky130_ef_sc_hd__decap_12
XFILLER_165_337 VPWR VGND VPWR VGND sky130_ef_sc_hd__decap_12
XTAP_TAPCELL_ROW_193_2092 VGND VPWR sky130_fd_sc_hd__tapvpwrvgnd_1
XFILLER_21_15 VPWR VGND VPWR VGND sky130_ef_sc_hd__decap_12
XFILLER_137_15 VPWR VGND VPWR VGND sky130_ef_sc_hd__decap_12
XFILLER_180_307 VGND VGND VPWR VPWR sky130_fd_sc_hd__fill_1
XTAP_TAPCELL_ROW_214_2652 VGND VPWR sky130_fd_sc_hd__tapvpwrvgnd_1
XTAP_TAPCELL_ROW_214_2663 VGND VPWR sky130_fd_sc_hd__tapvpwrvgnd_1
XFILLER_174_893 VPWR VGND VPWR VGND sky130_ef_sc_hd__decap_12
XFILLER_192_189 VGND VGND VPWR VPWR sky130_fd_sc_hd__decap_6
XTAP_TAPCELL_ROW_214_2674 VGND VPWR sky130_fd_sc_hd__tapvpwrvgnd_1
XFILLER_238_1147 VGND VGND VPWR VPWR sky130_fd_sc_hd__fill_1
XFILLER_175_1437 VPWR VGND VPWR VGND sky130_ef_sc_hd__decap_12
XTAP_TAPCELL_ROW_210_2549 VGND VPWR sky130_fd_sc_hd__tapvpwrvgnd_1
XFILLER_86_1191 VPWR VGND VPWR VGND sky130_ef_sc_hd__decap_12
XFILLER_217_81 VPWR VGND VPWR VGND sky130_ef_sc_hd__decap_12
XFILLER_251_1325 VPWR VGND VPWR VGND sky130_ef_sc_hd__decap_12
XFILLER_248_625 VPWR VGND VPWR VGND sky130_ef_sc_hd__decap_12
XPHY_EDGE_ROW_137_1_Right_793 VGND VGND VPWR VPWR sky130_fd_sc_hd__decap_3
XFILLER_247_113 VPWR VGND VPWR VGND sky130_ef_sc_hd__decap_12
XFILLER_212_1309 VGND VGND VPWR VPWR sky130_fd_sc_hd__decap_6
XFILLER_251_1369 VPWR VGND VPWR VGND sky130_ef_sc_hd__decap_12
XFILLER_153_69 VGND VGND VPWR VPWR sky130_fd_sc_hd__fill_2
XFILLER_248_669 VPWR VGND VPWR VGND sky130_ef_sc_hd__decap_12
XFILLER_134_1189 VGND VGND VPWR VPWR sky130_fd_sc_hd__fill_1
XTAP_TAPCELL_ROW_161_2_4722 VGND VPWR sky130_fd_sc_hd__tapvpwrvgnd_1
XTAP_TAPCELL_ROW_208_2489 VGND VPWR sky130_fd_sc_hd__tapvpwrvgnd_1
XFILLER_216_533 VPWR VGND VPWR VGND sky130_ef_sc_hd__decap_12
XFILLER_249_1287 VGND VGND VPWR VPWR sky130_fd_sc_hd__fill_1
Xmax_cap79 net80 VGND VGND VPWR VPWR net79 sky130_fd_sc_hd__clkbuf_1
XFILLER_231_503 VGND VGND VPWR VPWR sky130_fd_sc_hd__fill_1
XFILLER_203_205 VPWR VGND VPWR VGND sky130_ef_sc_hd__decap_12
XFILLER_243_385 VGND VGND VPWR VPWR sky130_fd_sc_hd__decap_6
XPHY_EDGE_ROW_73_2_Right_164 VGND VGND VPWR VPWR sky130_fd_sc_hd__decap_3
XFILLER_58_1271 VPWR VGND VPWR VGND sky130_ef_sc_hd__decap_12
XFILLER_246_3 VPWR VGND VPWR VGND sky130_ef_sc_hd__decap_12
XFILLER_203_249 VPWR VGND VPWR VGND sky130_ef_sc_hd__decap_12
XFILLER_19_1255 VPWR VGND VPWR VGND sky130_ef_sc_hd__decap_12
XFILLER_106_1203 VPWR VGND VPWR VGND sky130_ef_sc_hd__decap_12
XFILLER_169_665 VGND VGND VPWR VPWR sky130_fd_sc_hd__decap_6
XTAP_TAPCELL_ROW_34_1_1169 VGND VPWR sky130_fd_sc_hd__tapvpwrvgnd_1
XFILLER_200_923 VGND VGND VPWR VPWR sky130_fd_sc_hd__fill_1
XFILLER_168_153 VPWR VGND VPWR VGND sky130_ef_sc_hd__decap_12
XFILLER_223_1449 VGND VGND VPWR VPWR sky130_fd_sc_hd__decap_6
XFILLER_19_1299 VPWR VGND VPWR VGND sky130_ef_sc_hd__decap_12
XFILLER_106_1247 VPWR VGND VPWR VGND sky130_ef_sc_hd__decap_12
XFILLER_184_613 VPWR VGND VPWR VGND sky130_ef_sc_hd__decap_12
XFILLER_178_77 VGND VGND VPWR VPWR sky130_fd_sc_hd__decap_6
XFILLER_8_837 VGND VGND VPWR VPWR sky130_fd_sc_hd__decap_4
Xwire212 net213 VGND VGND VPWR VPWR net212 sky130_fd_sc_hd__clkbuf_1
XFILLER_211_293 VPWR VGND VPWR VGND sky130_ef_sc_hd__decap_12
Xwire223 net224 VGND VGND VPWR VPWR net223 sky130_fd_sc_hd__clkbuf_1
Xwire234 net235 VGND VGND VPWR VPWR net234 sky130_fd_sc_hd__clkbuf_1
XFILLER_168_197 VPWR VGND VPWR VGND sky130_ef_sc_hd__decap_12
XFILLER_184_657 VPWR VGND VPWR VGND sky130_ef_sc_hd__decap_12
XFILLER_7_347 VGND VGND VPWR VPWR sky130_fd_sc_hd__fill_2
Xwire256 net257 VGND VGND VPWR VPWR net256 sky130_fd_sc_hd__clkbuf_1
Xwire267 net268 VGND VGND VPWR VPWR net267 sky130_fd_sc_hd__clkbuf_1
Xwire278 net279 VGND VGND VPWR VPWR net278 sky130_fd_sc_hd__clkbuf_1
XFILLER_183_167 VGND VGND VPWR VPWR sky130_fd_sc_hd__fill_1
Xwire289 net290 VGND VGND VPWR VPWR net289 sky130_fd_sc_hd__clkbuf_1
XFILLER_165_893 VGND VGND VPWR VPWR sky130_fd_sc_hd__decap_3
XFILLER_171_329 VGND VGND VPWR VPWR sky130_fd_sc_hd__decap_6
XFILLER_178_1061 VPWR VGND VPWR VGND sky130_ef_sc_hd__decap_12
XFILLER_194_65 VPWR VGND VPWR VGND sky130_ef_sc_hd__decap_12
XFILLER_65_1231 VPWR VGND VPWR VGND sky130_ef_sc_hd__decap_12
XFILLER_26_1215 VPWR VGND VPWR VGND sky130_ef_sc_hd__decap_12
XFILLER_65_1275 VPWR VGND VPWR VGND sky130_ef_sc_hd__decap_12
XFILLER_117_1343 VPWR VGND VPWR VGND sky130_ef_sc_hd__decap_12
XTAP_TAPCELL_ROW_189_1983 VGND VPWR sky130_fd_sc_hd__tapvpwrvgnd_1
XFILLER_6_1309 VGND VGND VPWR VPWR sky130_fd_sc_hd__decap_6
XTAP_TAPCELL_ROW_189_1994 VGND VPWR sky130_fd_sc_hd__tapvpwrvgnd_1
XFILLER_230_1409 VPWR VGND VPWR VGND sky130_ef_sc_hd__decap_12
XFILLER_152_1245 VGND VGND VPWR VPWR sky130_fd_sc_hd__fill_1
XFILLER_26_1259 VPWR VGND VPWR VGND sky130_ef_sc_hd__decap_12
XFILLER_117_1387 VPWR VGND VPWR VGND sky130_ef_sc_hd__decap_12
XFILLER_227_809 VPWR VGND VPWR VGND sky130_ef_sc_hd__decap_12
XTAP_TAPCELL_ROW_185_1869 VGND VPWR sky130_fd_sc_hd__tapvpwrvgnd_1
XFILLER_253_105 VGND VGND VPWR VPWR sky130_fd_sc_hd__decap_6
XFILLER_213_39 VPWR VGND VPWR VGND sky130_ef_sc_hd__decap_12
XTAP_TAPCELL_ROW_50_2_4057 VGND VPWR sky130_fd_sc_hd__tapvpwrvgnd_1
XFILLER_219_393 VPWR VGND VPWR VGND sky130_ef_sc_hd__decap_12
XFILLER_253_149 VPWR VGND VPWR VGND sky130_ef_sc_hd__decap_12
XFILLER_235_853 VPWR VGND VPWR VGND sky130_ef_sc_hd__decap_12
XTAP_TAPCELL_ROW_35_2_3962 VGND VPWR sky130_fd_sc_hd__tapvpwrvgnd_1
XFILLER_185_1021 VPWR VGND VPWR VGND sky130_ef_sc_hd__decap_12
XFILLER_234_363 VGND VGND VPWR VPWR sky130_fd_sc_hd__fill_1
XFILLER_235_897 VPWR VGND VPWR VGND sky130_ef_sc_hd__decap_12
XFILLER_185_1065 VPWR VGND VPWR VGND sky130_ef_sc_hd__decap_12
XFILLER_222_525 VGND VGND VPWR VPWR sky130_fd_sc_hd__decap_6
XFILLER_179_429 VPWR VGND VPWR VGND sky130_ef_sc_hd__decap_12
XFILLER_37_1311 VPWR VGND VPWR VGND sky130_ef_sc_hd__decap_12
XFILLER_250_867 VGND VGND VPWR VPWR sky130_fd_sc_hd__fill_1
XFILLER_76_1371 VPWR VGND VPWR VGND sky130_ef_sc_hd__decap_12
XFILLER_222_569 VPWR VGND VPWR VGND sky130_ef_sc_hd__decap_12
XFILLER_241_1505 VGND VGND VPWR VPWR sky130_fd_sc_hd__decap_6
XFILLER_37_1355 VPWR VGND VPWR VGND sky130_ef_sc_hd__decap_12
XFILLER_124_1303 VPWR VGND VPWR VGND sky130_ef_sc_hd__decap_12
XFILLER_226_1073 VPWR VGND VPWR VGND sky130_ef_sc_hd__decap_12
XFILLER_128_1483 VPWR VGND VPWR VGND sky130_ef_sc_hd__decap_12
XFILLER_203_783 VGND VGND VPWR VPWR sky130_fd_sc_hd__fill_1
XFILLER_33_1219 VPWR VGND VPWR VGND sky130_ef_sc_hd__decap_12
XFILLER_163_1385 VGND VGND VPWR VPWR sky130_fd_sc_hd__fill_1
XFILLER_187_473 VPWR VGND VPWR VGND sky130_ef_sc_hd__decap_12
XFILLER_37_1399 VPWR VGND VPWR VGND sky130_ef_sc_hd__decap_12
Xinput20 wr_data[19] VGND VGND VPWR VPWR net20 sky130_fd_sc_hd__clkbuf_1
XFILLER_204_1371 VGND VGND VPWR VPWR sky130_fd_sc_hd__fill_1
Xinput31 wr_data[29] VGND VGND VPWR VPWR net31 sky130_fd_sc_hd__clkbuf_1
XFILLER_239_1401 VPWR VGND VPWR VGND sky130_ef_sc_hd__decap_12
Xinput42 wr_en VGND VGND VPWR VPWR net42 sky130_fd_sc_hd__clkbuf_2
XFILLER_174_189 VGND VGND VPWR VPWR sky130_fd_sc_hd__decap_6
Xmax_cap523 _082_ VGND VGND VPWR VPWR net523 sky130_fd_sc_hd__clkbuf_1
XFILLER_7_892 VGND VGND VPWR VPWR sky130_fd_sc_hd__decap_4
XFILLER_196_1161 VPWR VGND VPWR VGND sky130_ef_sc_hd__decap_12
Xmax_cap534 net56 VGND VGND VPWR VPWR net534 sky130_fd_sc_hd__clkbuf_1
XFILLER_171_841 VPWR VGND VPWR VGND sky130_ef_sc_hd__decap_12
Xmax_cap556 net70 VGND VGND VPWR VPWR net556 sky130_fd_sc_hd__clkbuf_1
Xmax_cap567 net54 VGND VGND VPWR VPWR net567 sky130_fd_sc_hd__clkbuf_1
XPHY_EDGE_ROW_122_2_Left_624 VGND VGND VPWR VPWR sky130_fd_sc_hd__decap_3
Xmax_cap578 net579 VGND VGND VPWR VPWR net578 sky130_fd_sc_hd__clkbuf_1
XFILLER_83_1331 VPWR VGND VPWR VGND sky130_ef_sc_hd__decap_12
XFILLER_48_1451 VPWR VGND VPWR VGND sky130_ef_sc_hd__decap_12
XFILLER_157_1189 VPWR VGND VPWR VGND sky130_ef_sc_hd__decap_12
XFILLER_44_1315 VPWR VGND VPWR VGND sky130_ef_sc_hd__decap_12
XFILLER_233_1033 VPWR VGND VPWR VGND sky130_ef_sc_hd__decap_12
XFILLER_48_1495 VPWR VGND VPWR VGND sky130_ef_sc_hd__decap_12
XFILLER_135_1443 VPWR VGND VPWR VGND sky130_ef_sc_hd__decap_12
XFILLER_229_113 VPWR VGND VPWR VGND sky130_ef_sc_hd__decap_12
XFILLER_44_1359 VPWR VGND VPWR VGND sky130_ef_sc_hd__decap_12
XFILLER_233_1077 VPWR VGND VPWR VGND sky130_ef_sc_hd__decap_12
XFILLER_131_1329 VGND VGND VPWR VPWR sky130_fd_sc_hd__fill_1
XFILLER_245_617 VPWR VGND VPWR VGND sky130_ef_sc_hd__decap_12
XFILLER_123_39 VPWR VGND VPWR VGND sky130_ef_sc_hd__decap_12
XTAP_TAPCELL_ROW_126_2_4511 VGND VPWR sky130_fd_sc_hd__tapvpwrvgnd_1
XFILLER_168_1241 VPWR VGND VPWR VGND sky130_ef_sc_hd__decap_12
XFILLER_16_15 VPWR VGND VPWR VGND sky130_ef_sc_hd__decap_12
XFILLER_246_1427 VGND VGND VPWR VPWR sky130_fd_sc_hd__fill_1
XTAP_TAPCELL_ROW_203_2353 VGND VPWR sky130_fd_sc_hd__tapvpwrvgnd_1
XFILLER_213_503 VGND VGND VPWR VPWR sky130_fd_sc_hd__fill_1
XTAP_TAPCELL_ROW_203_2364 VGND VPWR sky130_fd_sc_hd__tapvpwrvgnd_1
XFILLER_0_1453 VGND VGND VPWR VPWR sky130_fd_sc_hd__decap_3
XFILLER_168_1285 VPWR VGND VPWR VGND sky130_ef_sc_hd__decap_12
XTAP_TAPCELL_ROW_203_2375 VGND VPWR sky130_fd_sc_hd__tapvpwrvgnd_1
XFILLER_225_385 VGND VGND VPWR VPWR sky130_fd_sc_hd__decap_6
XFILLER_55_1411 VPWR VGND VPWR VGND sky130_ef_sc_hd__decap_12
XFILLER_198_749 VGND VGND VPWR VPWR sky130_fd_sc_hd__decap_6
XFILLER_240_333 VPWR VGND VPWR VGND sky130_ef_sc_hd__decap_12
XFILLER_94_1471 VPWR VGND VPWR VGND sky130_ef_sc_hd__decap_12
XFILLER_197_237 VPWR VGND VPWR VGND sky130_ef_sc_hd__decap_12
XFILLER_201_709 VPWR VGND VPWR VGND sky130_ef_sc_hd__decap_12
XFILLER_0_1497 VPWR VGND VPWR VGND sky130_ef_sc_hd__decap_12
XTAP_TAPCELL_ROW_195_2143 VGND VPWR sky130_fd_sc_hd__tapvpwrvgnd_1
XFILLER_241_889 VGND VGND VPWR VPWR sky130_fd_sc_hd__decap_6
XTAP_TAPCELL_ROW_195_2154 VGND VPWR sky130_fd_sc_hd__tapvpwrvgnd_1
XFILLER_240_377 VPWR VGND VPWR VGND sky130_ef_sc_hd__decap_12
XFILLER_55_1455 VPWR VGND VPWR VGND sky130_ef_sc_hd__decap_12
XFILLER_205_1113 VGND VGND VPWR VPWR sky130_fd_sc_hd__decap_6
XFILLER_244_1173 VPWR VGND VPWR VGND sky130_ef_sc_hd__decap_12
XFILLER_90_1357 VGND VGND VPWR VPWR sky130_fd_sc_hd__fill_1
XFILLER_16_1439 VPWR VGND VPWR VGND sky130_ef_sc_hd__decap_12
XFILLER_166_613 VPWR VGND VPWR VGND sky130_ef_sc_hd__decap_12
XTAP_TAPCELL_ROW_191_2029 VGND VPWR sky130_fd_sc_hd__tapvpwrvgnd_1
XFILLER_240_1037 VPWR VGND VPWR VGND sky130_ef_sc_hd__decap_12
XFILLER_55_1499 VPWR VGND VPWR VGND sky130_ef_sc_hd__decap_12
XFILLER_205_1157 VPWR VGND VPWR VGND sky130_ef_sc_hd__decap_12
XTAP_TAPCELL_ROW_216_2714 VGND VPWR sky130_fd_sc_hd__tapvpwrvgnd_1
XTAP_TAPCELL_ROW_216_2725 VGND VPWR sky130_fd_sc_hd__tapvpwrvgnd_1
XFILLER_142_1469 VGND VGND VPWR VPWR sky130_fd_sc_hd__fill_1
XFILLER_166_657 VPWR VGND VPWR VGND sky130_ef_sc_hd__decap_12
XFILLER_4_306 VGND VGND VPWR VPWR sky130_fd_sc_hd__fill_2
XFILLER_175_1201 VPWR VGND VPWR VGND sky130_ef_sc_hd__decap_12
XPHY_EDGE_ROW_54_2_Left_556 VGND VGND VPWR VPWR sky130_fd_sc_hd__decap_3
XFILLER_179_1381 VPWR VGND VPWR VGND sky130_ef_sc_hd__decap_12
XFILLER_101_1177 VPWR VGND VPWR VGND sky130_ef_sc_hd__decap_12
XFILLER_175_1245 VPWR VGND VPWR VGND sky130_ef_sc_hd__decap_12
XFILLER_175_1289 VPWR VGND VPWR VGND sky130_ef_sc_hd__decap_12
XFILLER_62_1415 VPWR VGND VPWR VGND sky130_ef_sc_hd__decap_12
XFILLER_251_1133 VPWR VGND VPWR VGND sky130_ef_sc_hd__decap_12
XFILLER_216_1253 VGND VGND VPWR VPWR sky130_fd_sc_hd__decap_6
XFILLER_249_945 VGND VGND VPWR VPWR sky130_fd_sc_hd__decap_6
XFILLER_248_433 VPWR VGND VPWR VGND sky130_ef_sc_hd__decap_12
XFILLER_212_1117 VPWR VGND VPWR VGND sky130_ef_sc_hd__decap_12
XPHY_EDGE_ROW_214_Left_469 VGND VGND VPWR VPWR sky130_fd_sc_hd__decap_3
XFILLER_196_3 VPWR VGND VPWR VGND sky130_ef_sc_hd__decap_12
XFILLER_209_809 VPWR VGND VPWR VGND sky130_ef_sc_hd__decap_12
XFILLER_251_1177 VPWR VGND VPWR VGND sky130_ef_sc_hd__decap_12
XPHY_EDGE_ROW_138_1_Right_794 VGND VGND VPWR VPWR sky130_fd_sc_hd__decap_3
XFILLER_216_1297 VPWR VGND VPWR VGND sky130_ef_sc_hd__decap_12
XFILLER_249_989 VPWR VGND VPWR VGND sky130_ef_sc_hd__decap_12
XFILLER_57_55 VGND VGND VPWR VPWR sky130_fd_sc_hd__fill_1
XFILLER_248_477 VPWR VGND VPWR VGND sky130_ef_sc_hd__decap_12
XFILLER_57_66 VGND VGND VPWR VPWR sky130_fd_sc_hd__decap_4
XFILLER_235_105 VGND VGND VPWR VPWR sky130_fd_sc_hd__decap_6
XTAP_TAPCELL_ROW_21_2_3881 VGND VPWR sky130_fd_sc_hd__tapvpwrvgnd_1
XTAP_TAPCELL_ROW_150_1_1285 VGND VPWR sky130_fd_sc_hd__tapvpwrvgnd_1
XTAP_TAPCELL_ROW_180_1733 VGND VPWR sky130_fd_sc_hd__tapvpwrvgnd_1
XFILLER_235_149 VPWR VGND VPWR VGND sky130_ef_sc_hd__decap_12
XFILLER_217_853 VPWR VGND VPWR VGND sky130_ef_sc_hd__decap_12
XFILLER_251_609 VGND VGND VPWR VPWR sky130_fd_sc_hd__decap_6
XFILLER_95_1213 VGND VGND VPWR VPWR sky130_fd_sc_hd__decap_4
XTAP_TAPCELL_ROW_180_1744 VGND VPWR sky130_fd_sc_hd__tapvpwrvgnd_1
XTAP_TAPCELL_ROW_180_1755 VGND VPWR sky130_fd_sc_hd__tapvpwrvgnd_1
XFILLER_186_1341 VPWR VGND VPWR VGND sky130_ef_sc_hd__decap_12
XFILLER_112_1295 VGND VGND VPWR VPWR sky130_fd_sc_hd__decap_6
XFILLER_21_1189 VPWR VGND VPWR VGND sky130_ef_sc_hd__decap_12
XFILLER_216_363 VGND VGND VPWR VPWR sky130_fd_sc_hd__fill_1
XFILLER_217_897 VPWR VGND VPWR VGND sky130_ef_sc_hd__decap_12
XFILLER_182_1205 VPWR VGND VPWR VGND sky130_ef_sc_hd__decap_12
XFILLER_189_727 VGND VGND VPWR VPWR sky130_fd_sc_hd__fill_1
XFILLER_204_525 VGND VGND VPWR VPWR sky130_fd_sc_hd__decap_6
XFILLER_186_1385 VPWR VGND VPWR VGND sky130_ef_sc_hd__decap_12
XFILLER_243_193 VPWR VGND VPWR VGND sky130_ef_sc_hd__decap_12
XFILLER_73_1511 VGND VGND VPWR VPWR sky130_fd_sc_hd__decap_4
XFILLER_232_867 VGND VGND VPWR VPWR sky130_fd_sc_hd__fill_1
XFILLER_204_569 VPWR VGND VPWR VGND sky130_ef_sc_hd__decap_12
XPHY_EDGE_ROW_74_2_Right_165 VGND VGND VPWR VPWR sky130_fd_sc_hd__decap_3
XPHY_EDGE_ROW_68_1_Left_323 VGND VGND VPWR VPWR sky130_fd_sc_hd__decap_3
XFILLER_223_1213 VPWR VGND VPWR VGND sky130_ef_sc_hd__decap_12
XPHY_EDGE_ROW_223_Left_478 VGND VGND VPWR VPWR sky130_fd_sc_hd__decap_3
XFILLER_227_1393 VGND VGND VPWR VPWR sky130_fd_sc_hd__decap_6
XFILLER_169_473 VPWR VGND VPWR VGND sky130_ef_sc_hd__decap_12
XFILLER_185_933 VPWR VGND VPWR VGND sky130_ef_sc_hd__decap_12
XTAP_TAPCELL_ROW_178_1684 VGND VPWR sky130_fd_sc_hd__tapvpwrvgnd_1
XFILLER_223_1257 VPWR VGND VPWR VGND sky130_ef_sc_hd__decap_12
XPHY_EDGE_ROW_120_1_Left_375 VGND VGND VPWR VPWR sky130_fd_sc_hd__decap_3
XTAP_TAPCELL_ROW_178_1695 VGND VPWR sky130_fd_sc_hd__tapvpwrvgnd_1
XFILLER_184_421 VPWR VGND VPWR VGND sky130_ef_sc_hd__decap_12
XFILLER_8_634 VGND VGND VPWR VPWR sky130_fd_sc_hd__decap_8
XFILLER_8_645 VPWR VGND VPWR VGND sky130_ef_sc_hd__decap_12
XFILLER_201_1511 VGND VGND VPWR VPWR sky130_fd_sc_hd__fill_1
XFILLER_185_977 VPWR VGND VPWR VGND sky130_ef_sc_hd__decap_12
XTAP_TAPCELL_ROW_152_2_4667 VGND VPWR sky130_fd_sc_hd__tapvpwrvgnd_1
XFILLER_193_1301 VPWR VGND VPWR VGND sky130_ef_sc_hd__decap_12
XFILLER_171_137 VPWR VGND VPWR VGND sky130_ef_sc_hd__decap_12
XFILLER_197_1481 VPWR VGND VPWR VGND sky130_ef_sc_hd__decap_12
XFILLER_193_1345 VPWR VGND VPWR VGND sky130_ef_sc_hd__decap_12
XFILLER_180_693 VGND VGND VPWR VPWR sky130_fd_sc_hd__decap_6
XPHY_EDGE_ROW_232_Left_487 VGND VGND VPWR VPWR sky130_fd_sc_hd__decap_3
XFILLER_234_1353 VPWR VGND VPWR VGND sky130_ef_sc_hd__decap_12
XFILLER_224_27 VGND VGND VPWR VPWR sky130_fd_sc_hd__fill_1
XFILLER_6_1117 VPWR VGND VPWR VGND sky130_ef_sc_hd__decap_12
XFILLER_230_1217 VPWR VGND VPWR VGND sky130_ef_sc_hd__decap_12
XFILLER_234_1397 VPWR VGND VPWR VGND sky130_ef_sc_hd__decap_12
XFILLER_227_617 VPWR VGND VPWR VGND sky130_ef_sc_hd__decap_12
XFILLER_255_937 VPWR VGND VPWR VGND sky130_ef_sc_hd__decap_12
XTAP_TAPCELL_ROW_99_2_4348 VGND VPWR sky130_fd_sc_hd__tapvpwrvgnd_1
XFILLER_130_1351 VGND VGND VPWR VPWR sky130_fd_sc_hd__decap_6
XFILLER_240_15 VPWR VGND VPWR VGND sky130_ef_sc_hd__decap_12
XFILLER_254_469 VGND VGND VPWR VPWR sky130_fd_sc_hd__decap_6
XFILLER_130_1395 VPWR VGND VPWR VGND sky130_ef_sc_hd__decap_12
XFILLER_165_1425 VGND VGND VPWR VPWR sky130_fd_sc_hd__decap_3
XFILLER_207_385 VGND VGND VPWR VPWR sky130_fd_sc_hd__decap_6
XFILLER_222_333 VPWR VGND VPWR VGND sky130_ef_sc_hd__decap_12
XPHY_EDGE_ROW_241_Left_496 VGND VGND VPWR VPWR sky130_fd_sc_hd__decap_3
XFILLER_165_1469 VPWR VGND VPWR VGND sky130_ef_sc_hd__decap_12
XFILLER_179_237 VPWR VGND VPWR VGND sky130_ef_sc_hd__decap_12
XFILLER_223_889 VGND VGND VPWR VPWR sky130_fd_sc_hd__decap_6
XFILLER_222_377 VPWR VGND VPWR VGND sky130_ef_sc_hd__decap_12
XFILLER_241_1313 VPWR VGND VPWR VGND sky130_ef_sc_hd__decap_12
XFILLER_245_1493 VPWR VGND VPWR VGND sky130_ef_sc_hd__decap_12
XFILLER_249_57 VPWR VGND VPWR VGND sky130_ef_sc_hd__decap_12
XFILLER_241_1357 VPWR VGND VPWR VGND sky130_ef_sc_hd__decap_12
XFILLER_188_793 VPWR VGND VPWR VGND sky130_ef_sc_hd__decap_12
XTAP_TAPCELL_ROW_59_2_4111 VGND VPWR sky130_fd_sc_hd__tapvpwrvgnd_1
XFILLER_187_281 VPWR VGND VPWR VGND sky130_ef_sc_hd__decap_12
XFILLER_206_1477 VGND VGND VPWR VPWR sky130_fd_sc_hd__decap_6
XFILLER_124_1177 VPWR VGND VPWR VGND sky130_ef_sc_hd__decap_12
XFILLER_190_413 VGND VGND VPWR VPWR sky130_fd_sc_hd__decap_6
XFILLER_141_1491 VGND VGND VPWR VPWR sky130_fd_sc_hd__decap_6
XFILLER_239_1231 VGND VGND VPWR VPWR sky130_fd_sc_hd__fill_1
Xmax_cap331 _140_ VGND VGND VPWR VPWR net331 sky130_fd_sc_hd__clkbuf_1
XFILLER_190_457 VPWR VGND VPWR VGND sky130_ef_sc_hd__decap_12
XFILLER_171_671 VGND VGND VPWR VPWR sky130_fd_sc_hd__fill_1
XPHY_EDGE_ROW_4_Right_4 VGND VGND VPWR VPWR sky130_fd_sc_hd__decap_3
XFILLER_172_1429 VPWR VGND VPWR VGND sky130_ef_sc_hd__decap_12
XFILLER_252_1453 VPWR VGND VPWR VGND sky130_ef_sc_hd__decap_12
XFILLER_134_27 VGND VGND VPWR VPWR sky130_fd_sc_hd__fill_1
XFILLER_213_1437 VPWR VGND VPWR VGND sky130_ef_sc_hd__decap_12
XFILLER_252_1497 VPWR VGND VPWR VGND sky130_ef_sc_hd__decap_12
XFILLER_135_1273 VGND VGND VPWR VPWR sky130_fd_sc_hd__fill_1
XTAP_TAPCELL_ROW_209_2540 VGND VPWR sky130_fd_sc_hd__tapvpwrvgnd_1
XFILLER_246_937 VPWR VGND VPWR VGND sky130_ef_sc_hd__decap_12
XFILLER_44_1189 VGND VGND VPWR VPWR sky130_fd_sc_hd__fill_1
XFILLER_217_105 VGND VGND VPWR VPWR sky130_fd_sc_hd__decap_6
XFILLER_170_1197 VGND VGND VPWR VPWR sky130_fd_sc_hd__decap_6
XTAP_TAPCELL_ROW_205_2415 VGND VPWR sky130_fd_sc_hd__tapvpwrvgnd_1
XTAP_TAPCELL_ROW_205_2426 VGND VPWR sky130_fd_sc_hd__tapvpwrvgnd_1
XFILLER_79_1219 VPWR VGND VPWR VGND sky130_ef_sc_hd__decap_12
XFILLER_245_447 VGND VGND VPWR VPWR sky130_fd_sc_hd__fill_1
XFILLER_150_15 VPWR VGND VPWR VGND sky130_ef_sc_hd__decap_12
XFILLER_217_149 VPWR VGND VPWR VGND sky130_ef_sc_hd__decap_12
XFILLER_233_609 VGND VGND VPWR VPWR sky130_fd_sc_hd__decap_6
XFILLER_254_981 VPWR VGND VPWR VGND sky130_ef_sc_hd__decap_12
XTAP_TAPCELL_ROW_197_2205 VGND VPWR sky130_fd_sc_hd__tapvpwrvgnd_1
XTAP_TAPCELL_ROW_197_2216 VGND VPWR sky130_fd_sc_hd__tapvpwrvgnd_1
XTAP_TAPCELL_ROW_1_876 VGND VPWR sky130_fd_sc_hd__tapvpwrvgnd_1
XTAP_TAPCELL_ROW_1_887 VGND VPWR sky130_fd_sc_hd__tapvpwrvgnd_1
XFILLER_198_513 VPWR VGND VPWR VGND sky130_ef_sc_hd__decap_12
XTAP_TAPCELL_ROW_1_898 VGND VPWR sky130_fd_sc_hd__tapvpwrvgnd_1
XFILLER_0_1261 VPWR VGND VPWR VGND sky130_ef_sc_hd__decap_12
XFILLER_168_1093 VPWR VGND VPWR VGND sky130_ef_sc_hd__decap_12
XFILLER_214_867 VGND VGND VPWR VPWR sky130_fd_sc_hd__fill_1
XFILLER_225_193 VPWR VGND VPWR VGND sky130_ef_sc_hd__decap_12
XFILLER_241_653 VPWR VGND VPWR VGND sky130_ef_sc_hd__decap_12
XFILLER_240_141 VPWR VGND VPWR VGND sky130_ef_sc_hd__decap_12
XFILLER_198_557 VPWR VGND VPWR VGND sky130_ef_sc_hd__decap_12
XFILLER_201_517 VPWR VGND VPWR VGND sky130_ef_sc_hd__decap_12
XFILLER_241_697 VPWR VGND VPWR VGND sky130_ef_sc_hd__decap_12
XFILLER_16_1203 VPWR VGND VPWR VGND sky130_ef_sc_hd__decap_12
XFILLER_107_1331 VPWR VGND VPWR VGND sky130_ef_sc_hd__decap_12
XFILLER_90_1165 VPWR VGND VPWR VGND sky130_ef_sc_hd__decap_12
XFILLER_159_57 VPWR VGND VPWR VGND sky130_ef_sc_hd__decap_12
XFILLER_167_933 VPWR VGND VPWR VGND sky130_ef_sc_hd__decap_12
XFILLER_199_1009 VPWR VGND VPWR VGND sky130_ef_sc_hd__decap_12
XFILLER_166_421 VPWR VGND VPWR VGND sky130_ef_sc_hd__decap_12
XFILLER_16_1247 VPWR VGND VPWR VGND sky130_ef_sc_hd__decap_12
XFILLER_103_1217 VGND VGND VPWR VPWR sky130_fd_sc_hd__fill_1
XFILLER_167_977 VPWR VGND VPWR VGND sky130_ef_sc_hd__decap_12
XFILLER_182_925 VPWR VGND VPWR VGND sky130_ef_sc_hd__decap_12
XFILLER_193_273 VGND VGND VPWR VPWR sky130_fd_sc_hd__decap_6
XFILLER_111_3 VPWR VGND VPWR VGND sky130_ef_sc_hd__decap_12
XFILLER_209_3 VPWR VGND VPWR VGND sky130_ef_sc_hd__decap_12
XFILLER_4_136 VGND VGND VPWR VPWR sky130_fd_sc_hd__decap_4
XFILLER_218_1315 VGND VGND VPWR VPWR sky130_fd_sc_hd__fill_1
XTAP_TAPCELL_ROW_29_1_1164 VGND VPWR sky130_fd_sc_hd__tapvpwrvgnd_1
XFILLER_4_29 VPWR VGND VPWR VGND sky130_ef_sc_hd__decap_12
XFILLER_4_169 VGND VGND VPWR VPWR sky130_fd_sc_hd__fill_1
XTAP_TAPCELL_ROW_117_2_4456 VGND VPWR sky130_fd_sc_hd__tapvpwrvgnd_1
XTAP_TAPCELL_ROW_186_1920 VGND VPWR sky130_fd_sc_hd__tapvpwrvgnd_1
XFILLER_68_65 VGND VGND VPWR VPWR sky130_fd_sc_hd__decap_6
XFILLER_27_1343 VPWR VGND VPWR VGND sky130_ef_sc_hd__decap_12
XFILLER_118_1471 VPWR VGND VPWR VGND sky130_ef_sc_hd__decap_12
XFILLER_216_1061 VPWR VGND VPWR VGND sky130_ef_sc_hd__decap_12
XFILLER_249_753 VPWR VGND VPWR VGND sky130_ef_sc_hd__decap_12
XFILLER_62_1245 VGND VGND VPWR VPWR sky130_fd_sc_hd__fill_1
XFILLER_191_55 VGND VGND VPWR VPWR sky130_fd_sc_hd__fill_1
XFILLER_7_1437 VPWR VGND VPWR VGND sky130_ef_sc_hd__decap_12
XTAP_TAPCELL_ROW_85_2_4267 VGND VPWR sky130_fd_sc_hd__tapvpwrvgnd_1
XFILLER_27_1387 VPWR VGND VPWR VGND sky130_ef_sc_hd__decap_12
XTAP_TAPCELL_ROW_182_1806 VGND VPWR sky130_fd_sc_hd__tapvpwrvgnd_1
XFILLER_209_617 VPWR VGND VPWR VGND sky130_ef_sc_hd__decap_12
XFILLER_249_797 VPWR VGND VPWR VGND sky130_ef_sc_hd__decap_12
XFILLER_114_1357 VGND VGND VPWR VPWR sky130_fd_sc_hd__fill_1
XPHY_EDGE_ROW_139_1_Right_795 VGND VGND VPWR VPWR sky130_fd_sc_hd__decap_3
XTAP_TAPCELL_ROW_167_1385 VGND VPWR sky130_fd_sc_hd__tapvpwrvgnd_1
XTAP_TAPCELL_ROW_167_1396 VGND VPWR sky130_fd_sc_hd__tapvpwrvgnd_1
XFILLER_84_53 VPWR VGND VPWR VGND sky130_ef_sc_hd__decap_12
XFILLER_236_469 VGND VGND VPWR VPWR sky130_fd_sc_hd__decap_6
XFILLER_251_417 VPWR VGND VPWR VGND sky130_ef_sc_hd__decap_12
XTAP_TAPCELL_ROW_65_2_4143 VGND VPWR sky130_fd_sc_hd__tapvpwrvgnd_1
X_655_ clknet_3_4__leaf_clk acc_core.adder.cla_blocks\[5\].block.sum\[1\] _063_ VGND
+ VGND VPWR VPWR net56 sky130_fd_sc_hd__dfrtp_1
XFILLER_229_1455 VGND VGND VPWR VPWR sky130_fd_sc_hd__fill_1
X_586_ net669 VGND VGND VPWR VPWR _068_ sky130_fd_sc_hd__inv_2
XFILLER_204_333 VPWR VGND VPWR VGND sky130_ef_sc_hd__decap_12
XFILLER_210_29 VPWR VGND VPWR VGND sky130_ef_sc_hd__decap_12
XFILLER_182_1035 VGND VGND VPWR VPWR sky130_fd_sc_hd__fill_1
XFILLER_205_889 VGND VGND VPWR VPWR sky130_fd_sc_hd__decap_6
XFILLER_147_1177 VPWR VGND VPWR VGND sky130_ef_sc_hd__decap_12
XFILLER_204_377 VPWR VGND VPWR VGND sky130_ef_sc_hd__decap_12
XFILLER_220_837 VPWR VGND VPWR VGND sky130_ef_sc_hd__decap_12
XFILLER_34_1303 VPWR VGND VPWR VGND sky130_ef_sc_hd__decap_12
XFILLER_223_1021 VPWR VGND VPWR VGND sky130_ef_sc_hd__decap_12
XFILLER_38_1483 VPWR VGND VPWR VGND sky130_ef_sc_hd__decap_12
XPHY_EDGE_ROW_75_2_Right_166 VGND VGND VPWR VPWR sky130_fd_sc_hd__decap_3
XFILLER_9_921 VGND VGND VPWR VPWR sky130_fd_sc_hd__decap_3
XFILLER_73_1385 VGND VGND VPWR VPWR sky130_fd_sc_hd__fill_1
XFILLER_169_281 VPWR VGND VPWR VGND sky130_ef_sc_hd__decap_12
XFILLER_185_741 VPWR VGND VPWR VGND sky130_ef_sc_hd__decap_12
XFILLER_223_1065 VPWR VGND VPWR VGND sky130_ef_sc_hd__decap_12
XFILLER_9_965 VPWR VGND VPWR VGND sky130_ef_sc_hd__decap_12
XFILLER_125_1497 VGND VGND VPWR VPWR sky130_fd_sc_hd__fill_1
XFILLER_219_27 VPWR VGND VPWR VGND sky130_ef_sc_hd__decap_12
XTAP_TAPCELL_ROW_251_3670 VGND VPWR sky130_fd_sc_hd__tapvpwrvgnd_1
XFILLER_184_251 VGND VGND VPWR VPWR sky130_fd_sc_hd__fill_1
XFILLER_185_785 VPWR VGND VPWR VGND sky130_ef_sc_hd__decap_12
XFILLER_172_413 VGND VGND VPWR VPWR sky130_fd_sc_hd__decap_6
XFILLER_172_457 VPWR VGND VPWR VGND sky130_ef_sc_hd__decap_12
XFILLER_235_15 VPWR VGND VPWR VGND sky130_ef_sc_hd__decap_12
XFILLER_119_1213 VGND VGND VPWR VPWR sky130_fd_sc_hd__decap_4
XFILLER_158_1295 VGND VGND VPWR VPWR sky130_fd_sc_hd__decap_6
XFILLER_193_1175 VGND VGND VPWR VPWR sky130_fd_sc_hd__fill_1
XFILLER_67_1189 VPWR VGND VPWR VGND sky130_ef_sc_hd__decap_12
XFILLER_80_1301 VGND VGND VPWR VPWR sky130_fd_sc_hd__fill_1
XFILLER_45_1443 VPWR VGND VPWR VGND sky130_ef_sc_hd__decap_12
XFILLER_234_1161 VPWR VGND VPWR VGND sky130_ef_sc_hd__decap_12
XFILLER_132_1413 VGND VGND VPWR VPWR sky130_fd_sc_hd__fill_1
XFILLER_255_701 VPWR VGND VPWR VGND sky130_ef_sc_hd__decap_12
XTAP_TAPCELL_ROW_245_3496 VGND VPWR sky130_fd_sc_hd__tapvpwrvgnd_1
XFILLER_41_1329 VGND VGND VPWR VPWR sky130_fd_sc_hd__fill_1
XFILLER_228_937 VPWR VGND VPWR VGND sky130_ef_sc_hd__decap_12
XFILLER_254_233 VPWR VGND VPWR VGND sky130_ef_sc_hd__decap_12
XFILLER_227_447 VGND VGND VPWR VPWR sky130_fd_sc_hd__fill_1
XFILLER_251_69 VPWR VGND VPWR VGND sky130_ef_sc_hd__decap_12
XFILLER_215_609 VGND VGND VPWR VPWR sky130_fd_sc_hd__decap_6
XFILLER_247_1511 VGND VGND VPWR VPWR sky130_fd_sc_hd__fill_1
XFILLER_254_277 VPWR VGND VPWR VGND sky130_ef_sc_hd__decap_12
XFILLER_236_981 VPWR VGND VPWR VGND sky130_ef_sc_hd__decap_12
XFILLER_251_951 VGND VGND VPWR VPWR sky130_fd_sc_hd__fill_1
XFILLER_165_1233 VPWR VGND VPWR VGND sky130_ef_sc_hd__decap_12
XFILLER_207_193 VPWR VGND VPWR VGND sky130_ef_sc_hd__decap_12
XFILLER_120_29 VPWR VGND VPWR VGND sky130_ef_sc_hd__decap_12
XFILLER_223_653 VPWR VGND VPWR VGND sky130_ef_sc_hd__decap_12
XFILLER_222_141 VPWR VGND VPWR VGND sky130_ef_sc_hd__decap_12
XFILLER_195_505 VPWR VGND VPWR VGND sky130_ef_sc_hd__decap_12
XFILLER_91_1441 VGND VGND VPWR VPWR sky130_fd_sc_hd__fill_1
XFILLER_126_1239 VGND VGND VPWR VPWR sky130_fd_sc_hd__decap_6
XFILLER_223_697 VPWR VGND VPWR VGND sky130_ef_sc_hd__decap_12
XFILLER_241_1121 VPWR VGND VPWR VGND sky130_ef_sc_hd__decap_12
XFILLER_206_1241 VPWR VGND VPWR VGND sky130_ef_sc_hd__decap_12
XFILLER_13_27 VPWR VGND VPWR VGND sky130_ef_sc_hd__decap_12
XFILLER_202_1105 VPWR VGND VPWR VGND sky130_ef_sc_hd__decap_12
XFILLER_206_1285 VPWR VGND VPWR VGND sky130_ef_sc_hd__decap_12
XFILLER_52_1469 VGND VGND VPWR VPWR sky130_fd_sc_hd__fill_1
XFILLER_129_27 VPWR VGND VPWR VGND sky130_ef_sc_hd__decap_12
XFILLER_202_1149 VPWR VGND VPWR VGND sky130_ef_sc_hd__decap_12
XFILLER_175_273 VGND VGND VPWR VPWR sky130_fd_sc_hd__decap_6
XFILLER_190_221 VPWR VGND VPWR VGND sky130_ef_sc_hd__decap_12
XFILLER_85_1201 VPWR VGND VPWR VGND sky130_ef_sc_hd__decap_12
XTAP_TAPCELL_ROW_91_2_4299 VGND VPWR sky130_fd_sc_hd__tapvpwrvgnd_1
XFILLER_191_777 VGND VGND VPWR VPWR sky130_fd_sc_hd__decap_6
XFILLER_2_607 VGND VGND VPWR VPWR sky130_fd_sc_hd__fill_2
XFILLER_102_1283 VPWR VGND VPWR VGND sky130_ef_sc_hd__decap_12
XFILLER_190_265 VPWR VGND VPWR VGND sky130_ef_sc_hd__decap_12
XFILLER_11_1177 VPWR VGND VPWR VGND sky130_ef_sc_hd__decap_12
Xmax_cap150 _181_ VGND VGND VPWR VPWR net150 sky130_fd_sc_hd__clkbuf_1
XTAP_TAPCELL_ROW_103_2_4375 VGND VPWR sky130_fd_sc_hd__tapvpwrvgnd_1
XFILLER_209_93 VPWR VGND VPWR VGND sky130_ef_sc_hd__decap_12
XFILLER_145_15 VPWR VGND VPWR VGND sky130_ef_sc_hd__decap_12
XFILLER_176_1373 VPWR VGND VPWR VGND sky130_ef_sc_hd__decap_12
Xmax_cap183 net184 VGND VGND VPWR VPWR net183 sky130_fd_sc_hd__clkbuf_1
XFILLER_85_1267 VGND VGND VPWR VPWR sky130_fd_sc_hd__decap_6
Xmax_cap194 _216_ VGND VGND VPWR VPWR net194 sky130_fd_sc_hd__clkbuf_1
XFILLER_172_1259 VGND VGND VPWR VPWR sky130_fd_sc_hd__fill_1
XFILLER_137_1379 VGND VGND VPWR VPWR sky130_fd_sc_hd__decap_6
XFILLER_213_1201 VPWR VGND VPWR VGND sky130_ef_sc_hd__decap_12
XFILLER_252_1261 VPWR VGND VPWR VGND sky130_ef_sc_hd__decap_12
XFILLER_217_1381 VPWR VGND VPWR VGND sky130_ef_sc_hd__decap_12
XFILLER_225_81 VPWR VGND VPWR VGND sky130_ef_sc_hd__decap_12
XFILLER_246_701 VPWR VGND VPWR VGND sky130_ef_sc_hd__decap_12
XFILLER_213_1245 VPWR VGND VPWR VGND sky130_ef_sc_hd__decap_12
XFILLER_38_68 VGND VGND VPWR VPWR sky130_fd_sc_hd__decap_3
XFILLER_213_1289 VPWR VGND VPWR VGND sky130_ef_sc_hd__decap_12
XTAP_TAPCELL_ROW_51_2_4062 VGND VPWR sky130_fd_sc_hd__tapvpwrvgnd_1
XFILLER_161_69 VGND VGND VPWR VPWR sky130_fd_sc_hd__fill_2
XFILLER_218_469 VGND VGND VPWR VPWR sky130_fd_sc_hd__decap_6
XFILLER_233_417 VPWR VGND VPWR VGND sky130_ef_sc_hd__decap_12
XFILLER_22_1295 VGND VGND VPWR VPWR sky130_fd_sc_hd__decap_6
X_440_ net100 _211_ _228_ net112 VGND VGND VPWR VPWR _229_ sky130_fd_sc_hd__a211oi_1
XFILLER_199_833 VGND VGND VPWR VPWR sky130_fd_sc_hd__decap_6
XFILLER_198_321 VPWR VGND VPWR VGND sky130_ef_sc_hd__decap_12
XFILLER_92_1227 VPWR VGND VPWR VGND sky130_ef_sc_hd__decap_12
XFILLER_242_973 VGND VGND VPWR VPWR sky130_fd_sc_hd__decap_6
XFILLER_159_3 VPWR VGND VPWR VGND sky130_ef_sc_hd__decap_12
XFILLER_241_461 VPWR VGND VPWR VGND sky130_ef_sc_hd__decap_12
X_371_ net133 _158_ _159_ VGND VGND VPWR VPWR _160_ sky130_fd_sc_hd__o21a_1
XFILLER_199_877 VPWR VGND VPWR VGND sky130_ef_sc_hd__decap_12
XFILLER_198_365 VPWR VGND VPWR VGND sky130_ef_sc_hd__decap_12
XFILLER_202_837 VPWR VGND VPWR VGND sky130_ef_sc_hd__decap_12
XFILLER_144_1339 VPWR VGND VPWR VGND sky130_ef_sc_hd__decap_12
XFILLER_183_1399 VGND VGND VPWR VPWR sky130_fd_sc_hd__fill_1
XFILLER_224_1341 VPWR VGND VPWR VGND sky130_ef_sc_hd__decap_12
XTAP_TAPCELL_ROW_145_1_1280 VGND VPWR sky130_fd_sc_hd__tapvpwrvgnd_1
XTAP_TAPCELL_ROW_175_1610 VGND VPWR sky130_fd_sc_hd__tapvpwrvgnd_1
XFILLER_167_741 VPWR VGND VPWR VGND sky130_ef_sc_hd__decap_12
XTAP_TAPCELL_ROW_175_1621 VGND VPWR sky130_fd_sc_hd__tapvpwrvgnd_1
XFILLER_220_1205 VPWR VGND VPWR VGND sky130_ef_sc_hd__decap_12
XFILLER_224_1385 VPWR VGND VPWR VGND sky130_ef_sc_hd__decap_12
XFILLER_166_251 VGND VGND VPWR VPWR sky130_fd_sc_hd__fill_1
XFILLER_210_881 VPWR VGND VPWR VGND sky130_ef_sc_hd__decap_12
XFILLER_167_785 VPWR VGND VPWR VGND sky130_ef_sc_hd__decap_12
XTAP_TAPCELL_ROW_171_1507 VGND VPWR sky130_fd_sc_hd__tapvpwrvgnd_1
XFILLER_186_77 VGND VGND VPWR VPWR sky130_fd_sc_hd__decap_6
XFILLER_182_755 VGND VGND VPWR VPWR sky130_fd_sc_hd__fill_1
XFILLER_6_979 VGND VGND VPWR VPWR sky130_fd_sc_hd__fill_1
XFILLER_170_917 VGND VGND VPWR VPWR sky130_fd_sc_hd__decap_6
XFILLER_120_1383 VPWR VGND VPWR VGND sky130_ef_sc_hd__decap_12
XFILLER_190_1315 VGND VGND VPWR VPWR sky130_fd_sc_hd__fill_1
XFILLER_155_1435 VGND VGND VPWR VPWR sky130_fd_sc_hd__decap_6
XTAP_TAPCELL_ROW_169_1436 VGND VPWR sky130_fd_sc_hd__tapvpwrvgnd_1
XPHY_EDGE_ROW_17_2_Left_519 VGND VGND VPWR VPWR sky130_fd_sc_hd__decap_3
XFILLER_155_1479 VPWR VGND VPWR VGND sky130_ef_sc_hd__decap_12
XTAP_TAPCELL_ROW_169_1447 VGND VPWR sky130_fd_sc_hd__tapvpwrvgnd_1
XFILLER_7_1201 VPWR VGND VPWR VGND sky130_ef_sc_hd__decap_12
XFILLER_231_1301 VPWR VGND VPWR VGND sky130_ef_sc_hd__decap_12
XFILLER_235_1481 VPWR VGND VPWR VGND sky130_ef_sc_hd__decap_12
XFILLER_1_673 VGND VGND VPWR VPWR sky130_fd_sc_hd__fill_1
XTAP_TAPCELL_ROW_169_1458 VGND VPWR sky130_fd_sc_hd__tapvpwrvgnd_1
XFILLER_249_561 VPWR VGND VPWR VGND sky130_ef_sc_hd__decap_12
XFILLER_7_1245 VPWR VGND VPWR VGND sky130_ef_sc_hd__decap_12
XFILLER_231_1345 VPWR VGND VPWR VGND sky130_ef_sc_hd__decap_12
XFILLER_7_1289 VPWR VGND VPWR VGND sky130_ef_sc_hd__decap_12
XFILLER_114_1165 VPWR VGND VPWR VGND sky130_ef_sc_hd__decap_12
XFILLER_209_447 VGND VGND VPWR VPWR sky130_fd_sc_hd__fill_1
XFILLER_236_233 VPWR VGND VPWR VGND sky130_ef_sc_hd__decap_12
XTAP_TAPCELL_ROW_5_990 VGND VPWR sky130_fd_sc_hd__tapvpwrvgnd_1
XTAP_TAPCELL_ROW_240_3360 VGND VPWR sky130_fd_sc_hd__tapvpwrvgnd_1
XFILLER_40_1351 VGND VGND VPWR VPWR sky130_fd_sc_hd__decap_6
XTAP_TAPCELL_ROW_240_3371 VGND VPWR sky130_fd_sc_hd__tapvpwrvgnd_1
XFILLER_236_277 VPWR VGND VPWR VGND sky130_ef_sc_hd__decap_12
XFILLER_149_1217 VGND VGND VPWR VPWR sky130_fd_sc_hd__fill_1
XFILLER_252_737 VPWR VGND VPWR VGND sky130_ef_sc_hd__decap_12
XFILLER_218_981 VPWR VGND VPWR VGND sky130_ef_sc_hd__decap_12
XFILLER_221_39 VPWR VGND VPWR VGND sky130_ef_sc_hd__decap_12
XFILLER_251_225 VPWR VGND VPWR VGND sky130_ef_sc_hd__decap_12
XFILLER_40_1395 VPWR VGND VPWR VGND sky130_ef_sc_hd__decap_12
X_638_ clknet_3_3__leaf_clk acc_core.adder.cla_blocks\[1\].block.sum\[0\] _046_ VGND
+ VGND VPWR VPWR net69 sky130_fd_sc_hd__dfrtp_1
XFILLER_233_951 VGND VGND VPWR VPWR sky130_fd_sc_hd__fill_1
XFILLER_205_653 VPWR VGND VPWR VGND sky130_ef_sc_hd__decap_12
XFILLER_204_141 VPWR VGND VPWR VGND sky130_ef_sc_hd__decap_12
XFILLER_220_601 VPWR VGND VPWR VGND sky130_ef_sc_hd__decap_12
X_569_ net665 VGND VGND VPWR VPWR _051_ sky130_fd_sc_hd__inv_2
XPHY_EDGE_ROW_131_2_Left_633 VGND VGND VPWR VPWR sky130_fd_sc_hd__decap_3
XFILLER_177_505 VPWR VGND VPWR VGND sky130_ef_sc_hd__decap_12
XTAP_TAPCELL_ROW_253_3710 VGND VPWR sky130_fd_sc_hd__tapvpwrvgnd_1
XFILLER_205_697 VPWR VGND VPWR VGND sky130_ef_sc_hd__decap_12
XTAP_TAPCELL_ROW_253_3721 VGND VPWR sky130_fd_sc_hd__tapvpwrvgnd_1
XFILLER_162_1439 VPWR VGND VPWR VGND sky130_ef_sc_hd__decap_12
XFILLER_220_645 VPWR VGND VPWR VGND sky130_ef_sc_hd__decap_12
XFILLER_242_1441 VPWR VGND VPWR VGND sky130_ef_sc_hd__decap_12
XPHY_EDGE_ROW_76_2_Right_167 VGND VGND VPWR VPWR sky130_fd_sc_hd__decap_3
XFILLER_203_1425 VPWR VGND VPWR VGND sky130_ef_sc_hd__decap_12
XFILLER_242_1485 VPWR VGND VPWR VGND sky130_ef_sc_hd__decap_12
XFILLER_74_3 VPWR VGND VPWR VGND sky130_ef_sc_hd__decap_12
XFILLER_34_1177 VPWR VGND VPWR VGND sky130_ef_sc_hd__decap_12
XTAP_TAPCELL_ROW_234_3197 VGND VPWR sky130_fd_sc_hd__tapvpwrvgnd_1
XFILLER_203_1469 VPWR VGND VPWR VGND sky130_ef_sc_hd__decap_12
XFILLER_8_272 VGND VGND VPWR VPWR sky130_fd_sc_hd__fill_2
XFILLER_51_1491 VGND VGND VPWR VPWR sky130_fd_sc_hd__decap_6
XFILLER_172_221 VPWR VGND VPWR VGND sky130_ef_sc_hd__decap_12
XFILLER_173_777 VGND VGND VPWR VPWR sky130_fd_sc_hd__decap_6
XFILLER_172_265 VPWR VGND VPWR VGND sky130_ef_sc_hd__decap_12
XFILLER_173_1513 VGND VGND VPWR VPWR sky130_fd_sc_hd__fill_2
XFILLER_82_1407 VGND VGND VPWR VPWR sky130_fd_sc_hd__decap_6
XTAP_TAPCELL_ROW_247_3547 VGND VPWR sky130_fd_sc_hd__tapvpwrvgnd_1
XTAP_TAPCELL_ROW_56_2_4088 VGND VPWR sky130_fd_sc_hd__tapvpwrvgnd_1
XTAP_TAPCELL_ROW_247_3558 VGND VPWR sky130_fd_sc_hd__tapvpwrvgnd_1
XFILLER_228_701 VPWR VGND VPWR VGND sky130_ef_sc_hd__decap_12
XFILLER_45_1273 VGND VGND VPWR VPWR sky130_fd_sc_hd__fill_1
XFILLER_171_1281 VGND VGND VPWR VPWR sky130_fd_sc_hd__decap_6
XTAP_TAPCELL_ROW_3_938 VGND VPWR sky130_fd_sc_hd__tapvpwrvgnd_1
XPHY_EDGE_ROW_145_1_Left_400 VGND VGND VPWR VPWR sky130_fd_sc_hd__decap_3
XFILLER_210_1429 VPWR VGND VPWR VGND sky130_ef_sc_hd__decap_12
XTAP_TAPCELL_ROW_3_949 VGND VPWR sky130_fd_sc_hd__tapvpwrvgnd_1
XFILLER_215_417 VPWR VGND VPWR VGND sky130_ef_sc_hd__decap_12
XFILLER_131_39 VPWR VGND VPWR VGND sky130_ef_sc_hd__decap_12
XTAP_TAPCELL_ROW_34_2_3958 VGND VPWR sky130_fd_sc_hd__tapvpwrvgnd_1
XPHY_EDGE_ROW_63_2_Left_565 VGND VGND VPWR VPWR sky130_fd_sc_hd__decap_3
XFILLER_224_973 VGND VGND VPWR VPWR sky130_fd_sc_hd__decap_6
XFILLER_24_15 VPWR VGND VPWR VGND sky130_ef_sc_hd__decap_12
XFILLER_223_461 VPWR VGND VPWR VGND sky130_ef_sc_hd__decap_12
XFILLER_196_825 VPWR VGND VPWR VGND sky130_ef_sc_hd__decap_12
XFILLER_17_1331 VPWR VGND VPWR VGND sky130_ef_sc_hd__decap_12
XFILLER_210_133 VGND VGND VPWR VPWR sky130_fd_sc_hd__decap_6
XFILLER_195_335 VGND VGND VPWR VPWR sky130_fd_sc_hd__fill_1
XFILLER_196_869 VPWR VGND VPWR VGND sky130_ef_sc_hd__decap_12
XFILLER_104_1301 VGND VGND VPWR VPWR sky130_fd_sc_hd__fill_1
XFILLER_210_177 VPWR VGND VPWR VGND sky130_ef_sc_hd__decap_12
XFILLER_13_1217 VGND VGND VPWR VPWR sky130_fd_sc_hd__fill_1
XFILLER_206_1093 VPWR VGND VPWR VGND sky130_ef_sc_hd__decap_12
XTAP_TAPCELL_ROW_153_2_4672 VGND VPWR sky130_fd_sc_hd__tapvpwrvgnd_1
XFILLER_191_541 VPWR VGND VPWR VGND sky130_ef_sc_hd__decap_12
XFILLER_87_1329 VGND VGND VPWR VPWR sky130_fd_sc_hd__fill_1
XFILLER_237_1009 VPWR VGND VPWR VGND sky130_ef_sc_hd__decap_12
XFILLER_191_585 VPWR VGND VPWR VGND sky130_ef_sc_hd__decap_12
XFILLER_137_1165 VPWR VGND VPWR VGND sky130_ef_sc_hd__decap_12
XFILLER_28_1471 VPWR VGND VPWR VGND sky130_ef_sc_hd__decap_12
XPHY_EDGE_ROW_77_1_Left_332 VGND VGND VPWR VPWR sky130_fd_sc_hd__decap_3
XFILLER_115_1441 VGND VGND VPWR VPWR sky130_fd_sc_hd__fill_1
XFILLER_252_1091 VGND VGND VPWR VPWR sky130_fd_sc_hd__fill_1
XFILLER_105_51 VGND VGND VPWR VPWR sky130_fd_sc_hd__decap_4
XFILLER_246_531 VGND VGND VPWR VPWR sky130_fd_sc_hd__fill_1
XFILLER_24_1357 VGND VGND VPWR VPWR sky130_fd_sc_hd__fill_1
XFILLER_4_1429 VPWR VGND VPWR VGND sky130_ef_sc_hd__decap_12
XFILLER_218_233 VPWR VGND VPWR VGND sky130_ef_sc_hd__decap_12
XFILLER_248_1105 VPWR VGND VPWR VGND sky130_ef_sc_hd__decap_12
XFILLER_65_55 VGND VGND VPWR VPWR sky130_fd_sc_hd__fill_1
XFILLER_218_277 VPWR VGND VPWR VGND sky130_ef_sc_hd__decap_12
XFILLER_234_737 VPWR VGND VPWR VGND sky130_ef_sc_hd__decap_12
XFILLER_98_1469 VGND VGND VPWR VPWR sky130_fd_sc_hd__fill_1
XFILLER_248_1149 VPWR VGND VPWR VGND sky130_ef_sc_hd__decap_12
XFILLER_233_225 VPWR VGND VPWR VGND sky130_ef_sc_hd__decap_12
XTAP_TAPCELL_ROW_125_2_4507 VGND VPWR sky130_fd_sc_hd__tapvpwrvgnd_1
XFILLER_215_951 VGND VGND VPWR VPWR sky130_fd_sc_hd__fill_1
XFILLER_199_641 VPWR VGND VPWR VGND sky130_ef_sc_hd__decap_12
XFILLER_2_1197 VGND VGND VPWR VPWR sky130_fd_sc_hd__decap_6
XFILLER_109_1201 VPWR VGND VPWR VGND sky130_ef_sc_hd__decap_12
X_423_ net100 _211_ _129_ VGND VGND VPWR VPWR _212_ sky130_fd_sc_hd__a21oi_1
XFILLER_202_601 VPWR VGND VPWR VGND sky130_ef_sc_hd__decap_12
XFILLER_242_781 VPWR VGND VPWR VGND sky130_ef_sc_hd__decap_12
XFILLER_148_1283 VPWR VGND VPWR VGND sky130_ef_sc_hd__decap_12
XFILLER_199_685 VPWR VGND VPWR VGND sky130_ef_sc_hd__decap_12
XFILLER_57_1177 VPWR VGND VPWR VGND sky130_ef_sc_hd__decap_12
XFILLER_201_111 VGND VGND VPWR VPWR sky130_fd_sc_hd__fill_1
XFILLER_202_645 VPWR VGND VPWR VGND sky130_ef_sc_hd__decap_12
X_354_ _140_ net329 VGND VGND VPWR VPWR _143_ sky130_fd_sc_hd__or2_1
XFILLER_109_1267 VGND VGND VPWR VPWR sky130_fd_sc_hd__decap_6
XFILLER_198_195 VGND VGND VPWR VPWR sky130_fd_sc_hd__fill_1
XFILLER_186_357 VGND VGND VPWR VPWR sky130_fd_sc_hd__decap_6
X_285_ net620 rd_addr\[0\] VGND VGND VPWR VPWR _082_ sky130_fd_sc_hd__nand2_1
XFILLER_35_1497 VGND VGND VPWR VPWR sky130_fd_sc_hd__fill_1
XFILLER_220_1035 VGND VGND VPWR VPWR sky130_fd_sc_hd__fill_1
XFILLER_6_710 VPWR VGND VPWR VGND sky130_ef_sc_hd__decap_12
XFILLER_170_725 VPWR VGND VPWR VGND sky130_ef_sc_hd__decap_12
XFILLER_120_1191 VPWR VGND VPWR VGND sky130_ef_sc_hd__decap_12
XPHY_EDGE_ROW_173_Left_428 VGND VGND VPWR VPWR sky130_fd_sc_hd__decap_3
XFILLER_29_1213 VGND VGND VPWR VPWR sky130_fd_sc_hd__decap_4
XFILLER_170_769 VPWR VGND VPWR VGND sky130_ef_sc_hd__decap_12
XFILLER_68_1295 VGND VGND VPWR VPWR sky130_fd_sc_hd__decap_6
XFILLER_155_1243 VPWR VGND VPWR VGND sky130_ef_sc_hd__decap_12
XFILLER_9_1329 VPWR VGND VPWR VGND sky130_ef_sc_hd__decap_12
XFILLER_116_1227 VPWR VGND VPWR VGND sky130_ef_sc_hd__decap_12
XFILLER_2_993 VPWR VGND VPWR VGND sky130_ef_sc_hd__decap_12
XFILLER_155_1287 VPWR VGND VPWR VGND sky130_ef_sc_hd__decap_12
XTAP_TAPCELL_ROW_242_3411 VGND VPWR sky130_fd_sc_hd__tapvpwrvgnd_1
XTAP_TAPCELL_ROW_242_3422 VGND VPWR sky130_fd_sc_hd__tapvpwrvgnd_1
XFILLER_42_1413 VGND VGND VPWR VPWR sky130_fd_sc_hd__fill_1
XFILLER_249_391 VGND VGND VPWR VPWR sky130_fd_sc_hd__fill_1
XFILLER_232_27 VGND VGND VPWR VPWR sky130_fd_sc_hd__fill_1
XFILLER_231_1175 VGND VGND VPWR VPWR sky130_fd_sc_hd__fill_1
XFILLER_237_553 VGND VGND VPWR VPWR sky130_fd_sc_hd__decap_6
Xinput7 wr_addr[5] VGND VGND VPWR VPWR net7 sky130_fd_sc_hd__clkbuf_1
XTAP_TAPCELL_ROW_8_1070 VGND VPWR sky130_fd_sc_hd__tapvpwrvgnd_1
XFILLER_252_501 VPWR VGND VPWR VGND sky130_ef_sc_hd__decap_12
XTAP_TAPCELL_ROW_8_1081 VGND VPWR sky130_fd_sc_hd__tapvpwrvgnd_1
XTAP_TAPCELL_ROW_20_2_3877 VGND VPWR sky130_fd_sc_hd__tapvpwrvgnd_1
XFILLER_237_597 VPWR VGND VPWR VGND sky130_ef_sc_hd__decap_12
XFILLER_252_545 VPWR VGND VPWR VGND sky130_ef_sc_hd__decap_12
XFILLER_188_1085 VGND VGND VPWR VPWR sky130_fd_sc_hd__decap_6
XPHY_EDGE_ROW_182_Left_437 VGND VGND VPWR VPWR sky130_fd_sc_hd__decap_3
XTAP_TAPCELL_ROW_255_3805 VGND VPWR sky130_fd_sc_hd__tapvpwrvgnd_1
XFILLER_206_973 VGND VGND VPWR VPWR sky130_fd_sc_hd__decap_6
XFILLER_252_589 VPWR VGND VPWR VGND sky130_ef_sc_hd__decap_12
XFILLER_205_461 VPWR VGND VPWR VGND sky130_ef_sc_hd__decap_12
XFILLER_75_1255 VPWR VGND VPWR VGND sky130_ef_sc_hd__decap_12
XFILLER_127_1323 VGND VGND VPWR VPWR sky130_fd_sc_hd__decap_6
XFILLER_162_1203 VPWR VGND VPWR VGND sky130_ef_sc_hd__decap_12
XFILLER_221_921 VPWR VGND VPWR VGND sky130_ef_sc_hd__decap_12
XFILLER_178_825 VPWR VGND VPWR VGND sky130_ef_sc_hd__decap_12
XTAP_TAPCELL_ROW_52_1_1187 VGND VPWR sky130_fd_sc_hd__tapvpwrvgnd_1
XTAP_TAPCELL_ROW_236_3248 VGND VPWR sky130_fd_sc_hd__tapvpwrvgnd_1
XFILLER_36_1239 VGND VGND VPWR VPWR sky130_fd_sc_hd__decap_6
XTAP_TAPCELL_ROW_236_3259 VGND VPWR sky130_fd_sc_hd__tapvpwrvgnd_1
XFILLER_75_1299 VPWR VGND VPWR VGND sky130_ef_sc_hd__decap_12
XFILLER_127_1367 VPWR VGND VPWR VGND sky130_ef_sc_hd__decap_12
XFILLER_162_1247 VPWR VGND VPWR VGND sky130_ef_sc_hd__decap_12
XFILLER_177_335 VGND VGND VPWR VPWR sky130_fd_sc_hd__fill_1
XFILLER_221_965 VPWR VGND VPWR VGND sky130_ef_sc_hd__decap_12
XFILLER_178_869 VPWR VGND VPWR VGND sky130_ef_sc_hd__decap_12
XFILLER_220_475 VGND VGND VPWR VPWR sky130_fd_sc_hd__fill_1
XFILLER_203_1233 VPWR VGND VPWR VGND sky130_ef_sc_hd__decap_12
XFILLER_193_839 VGND VGND VPWR VPWR sky130_fd_sc_hd__fill_1
XPHY_EDGE_ROW_77_2_Right_168 VGND VGND VPWR VPWR sky130_fd_sc_hd__decap_3
XTAP_TAPCELL_ROW_138_2_4585 VGND VPWR sky130_fd_sc_hd__tapvpwrvgnd_1
XFILLER_195_1001 VGND VGND VPWR VPWR sky130_fd_sc_hd__decap_6
XFILLER_173_541 VPWR VGND VPWR VGND sky130_ef_sc_hd__decap_12
XTAP_TAPCELL_ROW_249_3609 VGND VPWR sky130_fd_sc_hd__tapvpwrvgnd_1
XPHY_EDGE_ROW_191_Left_446 VGND VGND VPWR VPWR sky130_fd_sc_hd__decap_3
XFILLER_238_1329 VPWR VGND VPWR VGND sky130_ef_sc_hd__decap_12
XFILLER_195_1045 VPWR VGND VPWR VGND sky130_ef_sc_hd__decap_12
XFILLER_173_585 VPWR VGND VPWR VGND sky130_ef_sc_hd__decap_12
XFILLER_12_1283 VPWR VGND VPWR VGND sky130_ef_sc_hd__decap_12
XFILLER_86_1351 VGND VGND VPWR VPWR sky130_fd_sc_hd__decap_6
XTAP_TAPCELL_ROW_118_2_4461 VGND VPWR sky130_fd_sc_hd__tapvpwrvgnd_1
XFILLER_195_1089 VPWR VGND VPWR VGND sky130_ef_sc_hd__decap_12
XFILLER_82_1215 VPWR VGND VPWR VGND sky130_ef_sc_hd__decap_12
XFILLER_86_1395 VPWR VGND VPWR VGND sky130_ef_sc_hd__decap_12
XFILLER_138_1463 VGND VGND VPWR VPWR sky130_fd_sc_hd__decap_6
XFILLER_173_1343 VGND VGND VPWR VPWR sky130_fd_sc_hd__fill_1
XFILLER_47_1379 VGND VGND VPWR VPWR sky130_fd_sc_hd__decap_6
XFILLER_82_1259 VPWR VGND VPWR VGND sky130_ef_sc_hd__decap_12
XFILLER_134_1327 VPWR VGND VPWR VGND sky130_ef_sc_hd__decap_12
XTAP_TAPCELL_ROW_131_2_4539 VGND VPWR sky130_fd_sc_hd__tapvpwrvgnd_1
XFILLER_247_317 VPWR VGND VPWR VGND sky130_ef_sc_hd__decap_12
XFILLER_19_15 VPWR VGND VPWR VGND sky130_ef_sc_hd__decap_12
XTAP_TAPCELL_ROW_86_2_4272 VGND VPWR sky130_fd_sc_hd__tapvpwrvgnd_1
XFILLER_206_83 VGND VGND VPWR VPWR sky130_fd_sc_hd__fill_1
XFILLER_142_27 VGND VGND VPWR VPWR sky130_fd_sc_hd__fill_1
XFILLER_214_1373 VPWR VGND VPWR VGND sky130_ef_sc_hd__decap_12
XFILLER_228_531 VGND VGND VPWR VPWR sky130_fd_sc_hd__fill_1
XTAP_TAPCELL_ROW_225_2952 VGND VPWR sky130_fd_sc_hd__tapvpwrvgnd_1
XTAP_TAPCELL_ROW_225_2963 VGND VPWR sky130_fd_sc_hd__tapvpwrvgnd_1
XFILLER_255_361 VGND VGND VPWR VPWR sky130_fd_sc_hd__decap_3
XFILLER_249_1425 VPWR VGND VPWR VGND sky130_ef_sc_hd__decap_12
XFILLER_210_1259 VGND VGND VPWR VPWR sky130_fd_sc_hd__fill_1
XFILLER_216_737 VPWR VGND VPWR VGND sky130_ef_sc_hd__decap_12
XFILLER_215_225 VPWR VGND VPWR VGND sky130_ef_sc_hd__decap_12
XTAP_TAPCELL_ROW_221_2849 VGND VPWR sky130_fd_sc_hd__tapvpwrvgnd_1
XFILLER_249_1469 VPWR VGND VPWR VGND sky130_ef_sc_hd__decap_12
XFILLER_93_1311 VPWR VGND VPWR VGND sky130_ef_sc_hd__decap_12
XFILLER_110_1371 VPWR VGND VPWR VGND sky130_ef_sc_hd__decap_12
XFILLER_97_1491 VGND VGND VPWR VPWR sky130_fd_sc_hd__decap_6
XFILLER_167_1169 VGND VGND VPWR VPWR sky130_fd_sc_hd__decap_6
XFILLER_231_729 VPWR VGND VPWR VGND sky130_ef_sc_hd__decap_12
XFILLER_224_781 VPWR VGND VPWR VGND sky130_ef_sc_hd__decap_12
XFILLER_93_1355 VPWR VGND VPWR VGND sky130_ef_sc_hd__decap_12
XFILLER_145_1423 VPWR VGND VPWR VGND sky130_ef_sc_hd__decap_12
XFILLER_184_1483 VGND VGND VPWR VPWR sky130_fd_sc_hd__fill_1
XFILLER_54_1339 VPWR VGND VPWR VGND sky130_ef_sc_hd__decap_12
XFILLER_243_1057 VGND VGND VPWR VPWR sky130_fd_sc_hd__decap_6
XFILLER_106_1407 VGND VGND VPWR VPWR sky130_fd_sc_hd__decap_6
XFILLER_93_1399 VPWR VGND VPWR VGND sky130_ef_sc_hd__decap_12
XFILLER_145_1467 VPWR VGND VPWR VGND sky130_ef_sc_hd__decap_12
XFILLER_168_357 VGND VGND VPWR VPWR sky130_fd_sc_hd__decap_6
Xwire405 net406 VGND VGND VPWR VPWR net405 sky130_fd_sc_hd__clkbuf_1
Xwire416 net417 VGND VGND VPWR VPWR net416 sky130_fd_sc_hd__clkbuf_1
XFILLER_183_305 VPWR VGND VPWR VGND sky130_ef_sc_hd__decap_12
XFILLER_211_497 VGND VGND VPWR VPWR sky130_fd_sc_hd__decap_6
Xwire427 net428 VGND VGND VPWR VPWR net427 sky130_fd_sc_hd__clkbuf_1
XFILLER_196_699 VGND VGND VPWR VPWR sky130_fd_sc_hd__fill_1
XTAP_TAPCELL_ROW_219_2789 VGND VPWR sky130_fd_sc_hd__tapvpwrvgnd_1
Xwire438 net439 VGND VGND VPWR VPWR net438 sky130_fd_sc_hd__clkbuf_1
Xwire449 net450 VGND VGND VPWR VPWR net449 sky130_fd_sc_hd__clkbuf_1
XFILLER_167_57 VPWR VGND VPWR VGND sky130_ef_sc_hd__decap_12
XFILLER_183_349 VPWR VGND VPWR VGND sky130_ef_sc_hd__decap_12
XFILLER_192_861 VGND VGND VPWR VPWR sky130_fd_sc_hd__decap_6
XFILLER_221_1399 VGND VGND VPWR VPWR sky130_fd_sc_hd__fill_1
XFILLER_30_1383 VPWR VGND VPWR VGND sky130_ef_sc_hd__decap_12
XFILLER_174_1129 VPWR VGND VPWR VGND sky130_ef_sc_hd__decap_12
XFILLER_191_393 VPWR VGND VPWR VGND sky130_ef_sc_hd__decap_12
XFILLER_65_1435 VGND VGND VPWR VPWR sky130_fd_sc_hd__decap_6
XFILLER_2_245 VGND VGND VPWR VPWR sky130_fd_sc_hd__decap_6
XFILLER_250_1017 VPWR VGND VPWR VGND sky130_ef_sc_hd__decap_12
XFILLER_254_1197 VGND VGND VPWR VPWR sky130_fd_sc_hd__decap_6
XFILLER_65_1479 VPWR VGND VPWR VGND sky130_ef_sc_hd__decap_12
XFILLER_152_1427 VPWR VGND VPWR VGND sky130_ef_sc_hd__decap_12
XPHY_EDGE_ROW_39_2_Right_130 VGND VGND VPWR VPWR sky130_fd_sc_hd__decap_3
XFILLER_8_1373 VPWR VGND VPWR VGND sky130_ef_sc_hd__decap_12
XFILLER_76_65 VGND VGND VPWR VPWR sky130_fd_sc_hd__decap_6
Xfanout593 net600 VGND VGND VPWR VPWR net593 sky130_fd_sc_hd__dlymetal6s2s_1
XFILLER_219_553 VGND VGND VPWR VPWR sky130_fd_sc_hd__decap_6
XFILLER_24_1165 VPWR VGND VPWR VGND sky130_ef_sc_hd__decap_12
XFILLER_234_501 VPWR VGND VPWR VGND sky130_ef_sc_hd__decap_12
XFILLER_247_895 VGND VGND VPWR VPWR sky130_fd_sc_hd__fill_1
XFILLER_4_1259 VGND VGND VPWR VPWR sky130_fd_sc_hd__fill_1
XFILLER_219_597 VPWR VGND VPWR VGND sky130_ef_sc_hd__decap_12
XFILLER_59_1217 VGND VGND VPWR VPWR sky130_fd_sc_hd__fill_1
XFILLER_185_1225 VGND VGND VPWR VPWR sky130_fd_sc_hd__decap_6
XFILLER_228_1509 VGND VGND VPWR VPWR sky130_fd_sc_hd__decap_6
XFILLER_234_545 VPWR VGND VPWR VGND sky130_ef_sc_hd__decap_12
XFILLER_92_53 VPWR VGND VPWR VGND sky130_ef_sc_hd__decap_12
XFILLER_185_1269 VPWR VGND VPWR VGND sky130_ef_sc_hd__decap_12
XFILLER_234_589 VPWR VGND VPWR VGND sky130_ef_sc_hd__decap_12
XFILLER_203_921 VPWR VGND VPWR VGND sky130_ef_sc_hd__decap_12
XFILLER_221_217 VGND VGND VPWR VPWR sky130_fd_sc_hd__decap_6
X_406_ net199 _193_ _191_ VGND VGND VPWR VPWR _195_ sky130_fd_sc_hd__a21o_1
XFILLER_72_1439 VPWR VGND VPWR VGND sky130_ef_sc_hd__decap_12
XFILLER_124_1507 VGND VGND VPWR VPWR sky130_fd_sc_hd__decap_8
XFILLER_203_965 VPWR VGND VPWR VGND sky130_ef_sc_hd__decap_12
XFILLER_186_121 VPWR VGND VPWR VGND sky130_ef_sc_hd__decap_12
XFILLER_202_475 VGND VGND VPWR VPWR sky130_fd_sc_hd__fill_1
X_337_ net136 VGND VGND VPWR VPWR _126_ sky130_fd_sc_hd__inv_2
XFILLER_186_165 VPWR VGND VPWR VGND sky130_ef_sc_hd__decap_12
XFILLER_175_839 VGND VGND VPWR VPWR sky130_fd_sc_hd__fill_1
XTAP_TAPCELL_ROW_231_3112 VGND VPWR sky130_fd_sc_hd__tapvpwrvgnd_1
XFILLER_179_1007 VGND VGND VPWR VPWR sky130_fd_sc_hd__fill_1
XTAP_TAPCELL_ROW_231_3123 VGND VPWR sky130_fd_sc_hd__tapvpwrvgnd_1
XTAP_TAPCELL_ROW_231_3134 VGND VPWR sky130_fd_sc_hd__tapvpwrvgnd_1
XFILLER_227_27 VPWR VGND VPWR VGND sky130_ef_sc_hd__decap_12
XFILLER_196_1365 VGND VGND VPWR VPWR sky130_fd_sc_hd__decap_6
XTAP_TAPCELL_ROW_104_2_4380 VGND VPWR sky130_fd_sc_hd__tapvpwrvgnd_1
XFILLER_6_595 VGND VGND VPWR VPWR sky130_fd_sc_hd__fill_2
XFILLER_170_533 VPWR VGND VPWR VGND sky130_ef_sc_hd__decap_12
XFILLER_192_1229 VPWR VGND VPWR VGND sky130_ef_sc_hd__decap_12
XTAP_TAPCELL_ROW_229_3063 VGND VPWR sky130_fd_sc_hd__tapvpwrvgnd_1
XFILLER_243_15 VPWR VGND VPWR VGND sky130_ef_sc_hd__decap_12
XFILLER_37_3 VPWR VGND VPWR VGND sky130_ef_sc_hd__decap_12
XTAP_TAPCELL_ROW_229_3074 VGND VPWR sky130_fd_sc_hd__tapvpwrvgnd_1
XFILLER_229_317 VPWR VGND VPWR VGND sky130_ef_sc_hd__decap_12
XFILLER_211_1513 VGND VGND VPWR VPWR sky130_fd_sc_hd__fill_2
XTAP_TAPCELL_ROW_6_1018 VGND VPWR sky130_fd_sc_hd__tapvpwrvgnd_1
XFILLER_244_309 VPWR VGND VPWR VGND sky130_ef_sc_hd__decap_12
XTAP_TAPCELL_ROW_6_1029 VGND VPWR sky130_fd_sc_hd__tapvpwrvgnd_1
XFILLER_237_361 VPWR VGND VPWR VGND sky130_ef_sc_hd__decap_12
XFILLER_253_821 VPWR VGND VPWR VGND sky130_ef_sc_hd__decap_12
XFILLER_253_865 VPWR VGND VPWR VGND sky130_ef_sc_hd__decap_12
XTAP_TAPCELL_ROW_64_2_4139 VGND VPWR sky130_fd_sc_hd__tapvpwrvgnd_1
XFILLER_213_729 VPWR VGND VPWR VGND sky130_ef_sc_hd__decap_12
XFILLER_206_781 VPWR VGND VPWR VGND sky130_ef_sc_hd__decap_12
XTAP_TAPCELL_ROW_29_2_3931 VGND VPWR sky130_fd_sc_hd__tapvpwrvgnd_1
XFILLER_14_1301 VGND VGND VPWR VPWR sky130_fd_sc_hd__fill_1
XFILLER_165_305 VGND VGND VPWR VPWR sky130_fd_sc_hd__decap_3
XFILLER_178_699 VGND VGND VPWR VPWR sky130_fd_sc_hd__fill_1
XTAP_TAPCELL_ROW_193_2093 VGND VPWR sky130_fd_sc_hd__tapvpwrvgnd_1
XFILLER_165_349 VPWR VGND VPWR VGND sky130_ef_sc_hd__decap_12
XFILLER_21_27 VPWR VGND VPWR VGND sky130_ef_sc_hd__decap_12
XFILLER_88_1413 VGND VGND VPWR VPWR sky130_fd_sc_hd__fill_1
XFILLER_181_809 VPWR VGND VPWR VGND sky130_ef_sc_hd__decap_12
XFILLER_203_1063 VGND VGND VPWR VPWR sky130_fd_sc_hd__fill_1
XPHY_EDGE_ROW_78_2_Right_169 VGND VGND VPWR VPWR sky130_fd_sc_hd__decap_3
XFILLER_174_861 VGND VGND VPWR VPWR sky130_fd_sc_hd__decap_6
XTAP_TAPCELL_ROW_214_2653 VGND VPWR sky130_fd_sc_hd__tapvpwrvgnd_1
XFILLER_137_27 VPWR VGND VPWR VGND sky130_ef_sc_hd__decap_12
XTAP_TAPCELL_ROW_214_2664 VGND VPWR sky130_fd_sc_hd__tapvpwrvgnd_1
XTAP_TAPCELL_ROW_214_2675 VGND VPWR sky130_fd_sc_hd__tapvpwrvgnd_1
XFILLER_173_393 VPWR VGND VPWR VGND sky130_ef_sc_hd__decap_12
XFILLER_175_1449 VGND VGND VPWR VPWR sky130_fd_sc_hd__decap_6
XFILLER_138_1271 VPWR VGND VPWR VGND sky130_ef_sc_hd__decap_12
XFILLER_217_93 VPWR VGND VPWR VGND sky130_ef_sc_hd__decap_12
XFILLER_47_1165 VPWR VGND VPWR VGND sky130_ef_sc_hd__decap_12
XFILLER_153_15 VPWR VGND VPWR VGND sky130_ef_sc_hd__decap_12
XFILLER_251_1337 VGND VGND VPWR VPWR sky130_fd_sc_hd__decap_6
XFILLER_248_637 VGND VGND VPWR VPWR sky130_fd_sc_hd__decap_6
XFILLER_247_125 VPWR VGND VPWR VGND sky130_ef_sc_hd__decap_12
XFILLER_25_1441 VGND VGND VPWR VPWR sky130_fd_sc_hd__fill_1
XFILLER_5_1513 VGND VGND VPWR VPWR sky130_fd_sc_hd__fill_2
XTAP_TAPCELL_ROW_161_2_4723 VGND VPWR sky130_fd_sc_hd__tapvpwrvgnd_1
XFILLER_247_169 VPWR VGND VPWR VGND sky130_ef_sc_hd__decap_12
XFILLER_216_501 VPWR VGND VPWR VGND sky130_ef_sc_hd__decap_12
XFILLER_233_81 VPWR VGND VPWR VGND sky130_ef_sc_hd__decap_12
XFILLER_229_895 VGND VGND VPWR VPWR sky130_fd_sc_hd__fill_1
XFILLER_249_1233 VPWR VGND VPWR VGND sky130_ef_sc_hd__decap_12
XFILLER_216_545 VPWR VGND VPWR VGND sky130_ef_sc_hd__decap_12
XFILLER_189_909 VPWR VGND VPWR VGND sky130_ef_sc_hd__decap_12
XFILLER_245_1119 VGND VGND VPWR VPWR sky130_fd_sc_hd__fill_1
XFILLER_3_1281 VGND VGND VPWR VPWR sky130_fd_sc_hd__decap_6
XFILLER_102_41 VPWR VGND VPWR VGND sky130_ef_sc_hd__decap_12
XFILLER_182_1409 VPWR VGND VPWR VGND sky130_ef_sc_hd__decap_12
XFILLER_216_589 VPWR VGND VPWR VGND sky130_ef_sc_hd__decap_12
XFILLER_19_1201 VPWR VGND VPWR VGND sky130_ef_sc_hd__decap_12
XFILLER_188_419 VGND VGND VPWR VPWR sky130_fd_sc_hd__fill_1
XFILLER_203_217 VGND VGND VPWR VPWR sky130_fd_sc_hd__decap_6
XFILLER_231_559 VGND VGND VPWR VPWR sky130_fd_sc_hd__fill_1
XFILLER_58_1283 VPWR VGND VPWR VGND sky130_ef_sc_hd__decap_12
XFILLER_145_1231 VPWR VGND VPWR VGND sky130_ef_sc_hd__decap_12
XFILLER_197_953 VPWR VGND VPWR VGND sky130_ef_sc_hd__decap_12
XFILLER_168_121 VPWR VGND VPWR VGND sky130_ef_sc_hd__decap_12
XFILLER_19_1267 VGND VGND VPWR VPWR sky130_fd_sc_hd__decap_6
XFILLER_106_1215 VPWR VGND VPWR VGND sky130_ef_sc_hd__decap_12
XFILLER_141_3 VPWR VGND VPWR VGND sky130_ef_sc_hd__decap_12
XFILLER_239_3 VPWR VGND VPWR VGND sky130_ef_sc_hd__decap_12
XFILLER_145_1275 VPWR VGND VPWR VGND sky130_ef_sc_hd__decap_12
XFILLER_211_261 VPWR VGND VPWR VGND sky130_ef_sc_hd__decap_12
XPHY_EDGE_ROW_26_2_Left_528 VGND VGND VPWR VPWR sky130_fd_sc_hd__decap_3
XFILLER_168_165 VPWR VGND VPWR VGND sky130_ef_sc_hd__decap_12
XFILLER_106_1259 VPWR VGND VPWR VGND sky130_ef_sc_hd__decap_12
XFILLER_184_625 VPWR VGND VPWR VGND sky130_ef_sc_hd__decap_12
XFILLER_7_18 VPWR VGND VPWR VGND sky130_ef_sc_hd__decap_12
XFILLER_183_113 VPWR VGND VPWR VGND sky130_ef_sc_hd__decap_12
Xwire224 net225 VGND VGND VPWR VPWR net224 sky130_fd_sc_hd__clkbuf_1
Xwire235 net236 VGND VGND VPWR VPWR net235 sky130_fd_sc_hd__clkbuf_1
XFILLER_200_979 VGND VGND VPWR VPWR sky130_fd_sc_hd__fill_1
Xwire257 net258 VGND VGND VPWR VPWR net257 sky130_fd_sc_hd__clkbuf_1
XFILLER_184_669 VPWR VGND VPWR VGND sky130_ef_sc_hd__decap_12
Xwire268 net269 VGND VGND VPWR VPWR net268 sky130_fd_sc_hd__clkbuf_1
Xwire279 net280 VGND VGND VPWR VPWR net279 sky130_fd_sc_hd__clkbuf_1
XFILLER_193_1505 VGND VGND VPWR VPWR sky130_fd_sc_hd__decap_6
XFILLER_178_1073 VPWR VGND VPWR VGND sky130_ef_sc_hd__decap_12
XFILLER_30_1191 VPWR VGND VPWR VGND sky130_ef_sc_hd__decap_12
XFILLER_194_77 VGND VGND VPWR VPWR sky130_fd_sc_hd__decap_6
XFILLER_65_1243 VPWR VGND VPWR VGND sky130_ef_sc_hd__decap_12
XFILLER_117_1311 VPWR VGND VPWR VGND sky130_ef_sc_hd__decap_12
XFILLER_156_1371 VPWR VGND VPWR VGND sky130_ef_sc_hd__decap_12
XFILLER_239_615 VGND VGND VPWR VPWR sky130_fd_sc_hd__fill_1
XFILLER_26_1227 VPWR VGND VPWR VGND sky130_ef_sc_hd__decap_12
XTAP_TAPCELL_ROW_189_1984 VGND VPWR sky130_fd_sc_hd__tapvpwrvgnd_1
XFILLER_65_1287 VPWR VGND VPWR VGND sky130_ef_sc_hd__decap_12
XFILLER_117_1355 VPWR VGND VPWR VGND sky130_ef_sc_hd__decap_12
XPHY_EDGE_ROW_140_2_Left_642 VGND VGND VPWR VPWR sky130_fd_sc_hd__decap_3
XTAP_TAPCELL_ROW_189_1995 VGND VPWR sky130_fd_sc_hd__tapvpwrvgnd_1
XFILLER_113_1219 VPWR VGND VPWR VGND sky130_ef_sc_hd__decap_12
XFILLER_117_1399 VPWR VGND VPWR VGND sky130_ef_sc_hd__decap_12
XFILLER_226_309 VPWR VGND VPWR VGND sky130_ef_sc_hd__decap_12
XFILLER_219_361 VPWR VGND VPWR VGND sky130_ef_sc_hd__decap_12
XFILLER_235_821 VPWR VGND VPWR VGND sky130_ef_sc_hd__decap_12
XTAP_TAPCELL_ROW_35_2_3963 VGND VPWR sky130_fd_sc_hd__tapvpwrvgnd_1
XFILLER_235_865 VPWR VGND VPWR VGND sky130_ef_sc_hd__decap_12
XFILLER_185_1033 VPWR VGND VPWR VGND sky130_ef_sc_hd__decap_12
XFILLER_228_1317 VPWR VGND VPWR VGND sky130_ef_sc_hd__decap_12
XFILLER_250_813 VPWR VGND VPWR VGND sky130_ef_sc_hd__decap_12
XFILLER_185_1077 VPWR VGND VPWR VGND sky130_ef_sc_hd__decap_12
XFILLER_37_1323 VGND VGND VPWR VPWR sky130_fd_sc_hd__decap_6
XFILLER_72_1203 VPWR VGND VPWR VGND sky130_ef_sc_hd__decap_12
XFILLER_76_1383 VPWR VGND VPWR VGND sky130_ef_sc_hd__decap_12
XFILLER_128_1451 VPWR VGND VPWR VGND sky130_ef_sc_hd__decap_12
XFILLER_163_1331 VPWR VGND VPWR VGND sky130_ef_sc_hd__decap_12
XFILLER_187_441 VGND VGND VPWR VPWR sky130_fd_sc_hd__decap_6
XFILLER_37_1367 VPWR VGND VPWR VGND sky130_ef_sc_hd__decap_12
XFILLER_72_1247 VPWR VGND VPWR VGND sky130_ef_sc_hd__decap_12
XFILLER_124_1315 VPWR VGND VPWR VGND sky130_ef_sc_hd__decap_12
XFILLER_226_1085 VGND VGND VPWR VPWR sky130_fd_sc_hd__decap_6
XFILLER_128_1495 VPWR VGND VPWR VGND sky130_ef_sc_hd__decap_12
XFILLER_230_581 VGND VGND VPWR VPWR sky130_fd_sc_hd__decap_6
XFILLER_187_485 VPWR VGND VPWR VGND sky130_ef_sc_hd__decap_12
XFILLER_124_1359 VPWR VGND VPWR VGND sky130_ef_sc_hd__decap_12
XFILLER_238_15 VPWR VGND VPWR VGND sky130_ef_sc_hd__decap_12
XFILLER_198_1427 VGND VGND VPWR VPWR sky130_fd_sc_hd__fill_1
Xinput10 wr_data[0] VGND VGND VPWR VPWR net10 sky130_fd_sc_hd__clkbuf_1
XFILLER_200_1203 VGND VGND VPWR VPWR sky130_fd_sc_hd__fill_1
Xinput21 wr_data[1] VGND VGND VPWR VPWR net21 sky130_fd_sc_hd__clkbuf_1
Xinput32 wr_data[2] VGND VGND VPWR VPWR net32 sky130_fd_sc_hd__clkbuf_1
XFILLER_239_1413 VPWR VGND VPWR VGND sky130_ef_sc_hd__decap_12
Xmax_cap513 net514 VGND VGND VPWR VPWR net513 sky130_fd_sc_hd__clkbuf_1
XTAP_TAPCELL_ROW_47_1_1182 VGND VPWR sky130_fd_sc_hd__tapvpwrvgnd_1
Xmax_cap524 net67 VGND VGND VPWR VPWR net524 sky130_fd_sc_hd__clkbuf_1
XFILLER_239_1457 VPWR VGND VPWR VGND sky130_ef_sc_hd__decap_12
Xmax_cap535 net55 VGND VGND VPWR VPWR net535 sky130_fd_sc_hd__clkbuf_1
XFILLER_196_1173 VPWR VGND VPWR VGND sky130_ef_sc_hd__decap_12
Xmax_cap546 net45 VGND VGND VPWR VPWR net546 sky130_fd_sc_hd__clkbuf_1
XFILLER_171_853 VPWR VGND VPWR VGND sky130_ef_sc_hd__decap_12
XFILLER_192_1037 VPWR VGND VPWR VGND sky130_ef_sc_hd__decap_12
XFILLER_170_363 VGND VGND VPWR VPWR sky130_fd_sc_hd__fill_1
XFILLER_171_897 VPWR VGND VPWR VGND sky130_ef_sc_hd__decap_12
XFILLER_233_1001 VGND VGND VPWR VPWR sky130_fd_sc_hd__decap_6
XFILLER_48_1463 VGND VGND VPWR VPWR sky130_fd_sc_hd__decap_6
XPHY_EDGE_ROW_72_2_Left_574 VGND VGND VPWR VPWR sky130_fd_sc_hd__decap_3
XFILLER_83_1343 VPWR VGND VPWR VGND sky130_ef_sc_hd__decap_12
XFILLER_135_1411 VPWR VGND VPWR VGND sky130_ef_sc_hd__decap_12
XFILLER_44_1327 VPWR VGND VPWR VGND sky130_ef_sc_hd__decap_12
XFILLER_233_1045 VPWR VGND VPWR VGND sky130_ef_sc_hd__decap_12
XFILLER_83_1387 VPWR VGND VPWR VGND sky130_ef_sc_hd__decap_12
XFILLER_135_1455 VPWR VGND VPWR VGND sky130_ef_sc_hd__decap_12
XFILLER_229_125 VPWR VGND VPWR VGND sky130_ef_sc_hd__decap_12
XFILLER_233_1089 VPWR VGND VPWR VGND sky130_ef_sc_hd__decap_12
XFILLER_135_1499 VPWR VGND VPWR VGND sky130_ef_sc_hd__decap_12
XFILLER_229_169 VPWR VGND VPWR VGND sky130_ef_sc_hd__decap_12
XFILLER_245_629 VPWR VGND VPWR VGND sky130_ef_sc_hd__decap_12
XFILLER_211_1343 VGND VGND VPWR VPWR sky130_fd_sc_hd__fill_1
XFILLER_238_681 VPWR VGND VPWR VGND sky130_ef_sc_hd__decap_12
XFILLER_244_139 VGND VGND VPWR VPWR sky130_fd_sc_hd__fill_1
XFILLER_203_51 VGND VGND VPWR VPWR sky130_fd_sc_hd__decap_4
XPHY_EDGE_ROW_24_1_Left_279 VGND VGND VPWR VPWR sky130_fd_sc_hd__decap_3
XTAP_TAPCELL_ROW_126_2_4512 VGND VPWR sky130_fd_sc_hd__tapvpwrvgnd_1
XFILLER_168_1253 VGND VGND VPWR VPWR sky130_fd_sc_hd__decap_6
XFILLER_253_673 VPWR VGND VPWR VGND sky130_ef_sc_hd__decap_12
XFILLER_16_27 VGND VGND VPWR VPWR sky130_fd_sc_hd__fill_1
XTAP_TAPCELL_ROW_203_2354 VGND VPWR sky130_fd_sc_hd__tapvpwrvgnd_1
XFILLER_20_1371 VPWR VGND VPWR VGND sky130_ef_sc_hd__decap_12
XTAP_TAPCELL_ROW_203_2365 VGND VPWR sky130_fd_sc_hd__tapvpwrvgnd_1
XFILLER_240_301 VGND VGND VPWR VPWR sky130_fd_sc_hd__decap_6
XTAP_TAPCELL_ROW_203_2376 VGND VPWR sky130_fd_sc_hd__tapvpwrvgnd_1
XFILLER_197_205 VPWR VGND VPWR VGND sky130_ef_sc_hd__decap_12
XFILLER_168_1297 VPWR VGND VPWR VGND sky130_ef_sc_hd__decap_12
XFILLER_240_345 VPWR VGND VPWR VGND sky130_ef_sc_hd__decap_12
XFILLER_55_1423 VPWR VGND VPWR VGND sky130_ef_sc_hd__decap_12
XFILLER_90_1303 VPWR VGND VPWR VGND sky130_ef_sc_hd__decap_12
XFILLER_213_559 VGND VGND VPWR VPWR sky130_fd_sc_hd__fill_1
XFILLER_244_1141 VGND VGND VPWR VPWR sky130_fd_sc_hd__decap_6
XFILLER_94_1483 VPWR VGND VPWR VGND sky130_ef_sc_hd__decap_12
XFILLER_179_953 VPWR VGND VPWR VGND sky130_ef_sc_hd__decap_12
XTAP_TAPCELL_ROW_195_2144 VGND VPWR sky130_fd_sc_hd__tapvpwrvgnd_1
XFILLER_197_249 VPWR VGND VPWR VGND sky130_ef_sc_hd__decap_12
XTAP_TAPCELL_ROW_195_2155 VGND VPWR sky130_fd_sc_hd__tapvpwrvgnd_1
XFILLER_16_1407 VGND VGND VPWR VPWR sky130_fd_sc_hd__decap_6
XFILLER_200_209 VPWR VGND VPWR VGND sky130_ef_sc_hd__decap_12
XFILLER_240_1005 VPWR VGND VPWR VGND sky130_ef_sc_hd__decap_12
XFILLER_240_389 VPWR VGND VPWR VGND sky130_ef_sc_hd__decap_12
XFILLER_55_1467 VPWR VGND VPWR VGND sky130_ef_sc_hd__decap_12
XFILLER_142_1415 VPWR VGND VPWR VGND sky130_ef_sc_hd__decap_12
XFILLER_244_1185 VPWR VGND VPWR VGND sky130_ef_sc_hd__decap_12
XFILLER_32_15 VPWR VGND VPWR VGND sky130_ef_sc_hd__decap_12
XFILLER_194_923 VGND VGND VPWR VPWR sky130_fd_sc_hd__fill_1
XTAP_TAPCELL_ROW_216_2704 VGND VPWR sky130_fd_sc_hd__tapvpwrvgnd_1
XFILLER_166_625 VPWR VGND VPWR VGND sky130_ef_sc_hd__decap_12
XFILLER_240_1049 VPWR VGND VPWR VGND sky130_ef_sc_hd__decap_12
XTAP_TAPCELL_ROW_216_2715 VGND VPWR sky130_fd_sc_hd__tapvpwrvgnd_1
XFILLER_148_15 VPWR VGND VPWR VGND sky130_ef_sc_hd__decap_12
XFILLER_165_113 VPWR VGND VPWR VGND sky130_ef_sc_hd__decap_12
XFILLER_205_1169 VGND VGND VPWR VPWR sky130_fd_sc_hd__decap_6
XTAP_TAPCELL_ROW_216_2726 VGND VPWR sky130_fd_sc_hd__tapvpwrvgnd_1
XPHY_EDGE_ROW_86_1_Left_341 VGND VGND VPWR VPWR sky130_fd_sc_hd__decap_3
XFILLER_166_669 VPWR VGND VPWR VGND sky130_ef_sc_hd__decap_12
XFILLER_222_1483 VGND VGND VPWR VPWR sky130_fd_sc_hd__fill_1
XFILLER_5_819 VGND VGND VPWR VPWR sky130_fd_sc_hd__decap_6
XTAP_TAPCELL_ROW_94_1_1229 VGND VPWR sky130_fd_sc_hd__tapvpwrvgnd_1
XFILLER_181_617 VPWR VGND VPWR VGND sky130_ef_sc_hd__decap_12
XFILLER_175_1213 VPWR VGND VPWR VGND sky130_ef_sc_hd__decap_12
XFILLER_179_1393 VGND VGND VPWR VPWR sky130_fd_sc_hd__decap_6
XFILLER_101_1189 VPWR VGND VPWR VGND sky130_ef_sc_hd__decap_12
XFILLER_175_1257 VPWR VGND VPWR VGND sky130_ef_sc_hd__decap_12
XFILLER_251_1101 VPWR VGND VPWR VGND sky130_ef_sc_hd__decap_12
XFILLER_153_1511 VGND VGND VPWR VPWR sky130_fd_sc_hd__decap_4
XFILLER_248_401 VPWR VGND VPWR VGND sky130_ef_sc_hd__decap_12
XFILLER_62_1427 VPWR VGND VPWR VGND sky130_ef_sc_hd__decap_12
XFILLER_251_1145 VPWR VGND VPWR VGND sky130_ef_sc_hd__decap_12
XFILLER_248_445 VPWR VGND VPWR VGND sky130_ef_sc_hd__decap_12
XFILLER_212_1129 VPWR VGND VPWR VGND sky130_ef_sc_hd__decap_12
XFILLER_251_1189 VPWR VGND VPWR VGND sky130_ef_sc_hd__decap_12
XFILLER_208_309 VPWR VGND VPWR VGND sky130_ef_sc_hd__decap_12
XFILLER_248_489 VPWR VGND VPWR VGND sky130_ef_sc_hd__decap_12
XFILLER_5_1343 VGND VGND VPWR VPWR sky130_fd_sc_hd__fill_1
XFILLER_189_3 VPWR VGND VPWR VGND sky130_ef_sc_hd__decap_12
XFILLER_217_821 VPWR VGND VPWR VGND sky130_ef_sc_hd__decap_12
XTAP_TAPCELL_ROW_21_2_3882 VGND VPWR sky130_fd_sc_hd__tapvpwrvgnd_1
XTAP_TAPCELL_ROW_180_1734 VGND VPWR sky130_fd_sc_hd__tapvpwrvgnd_1
XFILLER_113_51 VGND VGND VPWR VPWR sky130_fd_sc_hd__decap_4
XTAP_TAPCELL_ROW_180_1745 VGND VPWR sky130_fd_sc_hd__tapvpwrvgnd_1
XTAP_TAPCELL_ROW_180_1756 VGND VPWR sky130_fd_sc_hd__tapvpwrvgnd_1
XFILLER_217_865 VPWR VGND VPWR VGND sky130_ef_sc_hd__decap_12
XFILLER_250_109 VPWR VGND VPWR VGND sky130_ef_sc_hd__decap_12
XFILLER_249_1063 VGND VGND VPWR VPWR sky130_fd_sc_hd__fill_1
XFILLER_186_1353 VPWR VGND VPWR VGND sky130_ef_sc_hd__decap_12
XFILLER_232_813 VPWR VGND VPWR VGND sky130_ef_sc_hd__decap_12
XFILLER_243_161 VGND VGND VPWR VPWR sky130_fd_sc_hd__decap_6
XFILLER_73_55 VGND VGND VPWR VPWR sky130_fd_sc_hd__fill_1
XFILLER_182_1217 VPWR VGND VPWR VGND sky130_ef_sc_hd__decap_12
XFILLER_186_1397 VPWR VGND VPWR VGND sky130_ef_sc_hd__decap_12
XFILLER_189_55 VGND VGND VPWR VPWR sky130_fd_sc_hd__fill_1
XFILLER_169_441 VGND VGND VPWR VPWR sky130_fd_sc_hd__decap_6
XFILLER_34_1507 VGND VGND VPWR VPWR sky130_fd_sc_hd__decap_8
XFILLER_223_1225 VGND VGND VPWR VPWR sky130_fd_sc_hd__decap_6
XFILLER_212_581 VGND VGND VPWR VPWR sky130_fd_sc_hd__decap_6
XFILLER_197_783 VGND VGND VPWR VPWR sky130_fd_sc_hd__fill_1
XFILLER_169_485 VPWR VGND VPWR VGND sky130_ef_sc_hd__decap_12
XTAP_TAPCELL_ROW_178_1685 VGND VPWR sky130_fd_sc_hd__tapvpwrvgnd_1
XFILLER_185_945 VGND VGND VPWR VPWR sky130_fd_sc_hd__decap_6
XFILLER_223_1269 VPWR VGND VPWR VGND sky130_ef_sc_hd__decap_12
XTAP_TAPCELL_ROW_178_1696 VGND VPWR sky130_fd_sc_hd__tapvpwrvgnd_1
XFILLER_184_433 VPWR VGND VPWR VGND sky130_ef_sc_hd__decap_12
XTAP_TAPCELL_ROW_139_2_4590 VGND VPWR sky130_fd_sc_hd__tapvpwrvgnd_1
XFILLER_8_657 VPWR VGND VPWR VGND sky130_ef_sc_hd__decap_12
XFILLER_185_989 VPWR VGND VPWR VGND sky130_ef_sc_hd__decap_12
XFILLER_7_145 VGND VGND VPWR VPWR sky130_fd_sc_hd__fill_2
XFILLER_184_477 VPWR VGND VPWR VGND sky130_ef_sc_hd__decap_12
XFILLER_7_167 VGND VGND VPWR VPWR sky130_fd_sc_hd__fill_1
XFILLER_171_105 VGND VGND VPWR VPWR sky130_fd_sc_hd__decap_6
XTAP_TAPCELL_ROW_152_2_4668 VGND VPWR sky130_fd_sc_hd__tapvpwrvgnd_1
XFILLER_208_29 VPWR VGND VPWR VGND sky130_ef_sc_hd__decap_12
XFILLER_193_1313 VPWR VGND VPWR VGND sky130_ef_sc_hd__decap_12
XFILLER_171_149 VPWR VGND VPWR VGND sky130_ef_sc_hd__decap_12
XFILLER_197_1493 VPWR VGND VPWR VGND sky130_ef_sc_hd__decap_12
XFILLER_98_41 VPWR VGND VPWR VGND sky130_ef_sc_hd__decap_12
XFILLER_217_1007 VGND VGND VPWR VPWR sky130_fd_sc_hd__fill_1
XFILLER_193_1357 VPWR VGND VPWR VGND sky130_ef_sc_hd__decap_12
XTAP_TAPCELL_ROW_226_3000 VGND VPWR sky130_fd_sc_hd__tapvpwrvgnd_1
XTAP_TAPCELL_ROW_132_2_4544 VGND VPWR sky130_fd_sc_hd__tapvpwrvgnd_1
XFILLER_234_1365 VGND VGND VPWR VPWR sky130_fd_sc_hd__decap_6
XFILLER_6_1129 VPWR VGND VPWR VGND sky130_ef_sc_hd__decap_12
XFILLER_230_1229 VPWR VGND VPWR VGND sky130_ef_sc_hd__decap_12
XFILLER_227_629 VPWR VGND VPWR VGND sky130_ef_sc_hd__decap_12
XFILLER_255_949 VGND VGND VPWR VPWR sky130_fd_sc_hd__decap_3
XTAP_TAPCELL_ROW_99_2_4349 VGND VPWR sky130_fd_sc_hd__tapvpwrvgnd_1
XFILLER_226_139 VGND VGND VPWR VPWR sky130_fd_sc_hd__fill_1
XFILLER_240_27 VGND VGND VPWR VPWR sky130_fd_sc_hd__fill_1
XFILLER_235_673 VPWR VGND VPWR VGND sky130_ef_sc_hd__decap_12
XFILLER_222_301 VGND VGND VPWR VPWR sky130_fd_sc_hd__decap_6
XFILLER_179_205 VPWR VGND VPWR VGND sky130_ef_sc_hd__decap_12
XFILLER_228_1147 VGND VGND VPWR VPWR sky130_fd_sc_hd__fill_1
XFILLER_250_643 VGND VGND VPWR VPWR sky130_fd_sc_hd__fill_1
XFILLER_222_345 VPWR VGND VPWR VGND sky130_ef_sc_hd__decap_12
XFILLER_179_249 VPWR VGND VPWR VGND sky130_ef_sc_hd__decap_12
XFILLER_76_1191 VPWR VGND VPWR VGND sky130_ef_sc_hd__decap_12
XFILLER_195_709 VPWR VGND VPWR VGND sky130_ef_sc_hd__decap_12
XFILLER_241_1325 VPWR VGND VPWR VGND sky130_ef_sc_hd__decap_12
XFILLER_222_389 VPWR VGND VPWR VGND sky130_ef_sc_hd__decap_12
XFILLER_176_923 VGND VGND VPWR VPWR sky130_fd_sc_hd__fill_1
XFILLER_202_1309 VGND VGND VPWR VPWR sky130_fd_sc_hd__decap_6
XFILLER_249_69 VPWR VGND VPWR VGND sky130_ef_sc_hd__decap_12
XFILLER_241_1369 VPWR VGND VPWR VGND sky130_ef_sc_hd__decap_12
XFILLER_187_293 VPWR VGND VPWR VGND sky130_ef_sc_hd__decap_12
XFILLER_124_1189 VGND VGND VPWR VPWR sky130_fd_sc_hd__fill_1
XFILLER_8_83 VGND VGND VPWR VPWR sky130_fd_sc_hd__fill_1
XFILLER_159_1219 VPWR VGND VPWR VGND sky130_ef_sc_hd__decap_12
XFILLER_118_29 VPWR VGND VPWR VGND sky130_ef_sc_hd__decap_12
Xmax_cap332 net333 VGND VGND VPWR VPWR net332 sky130_fd_sc_hd__clkbuf_1
XFILLER_190_469 VGND VGND VPWR VPWR sky130_fd_sc_hd__decap_6
XFILLER_239_1287 VGND VGND VPWR VPWR sky130_fd_sc_hd__fill_1
XPHY_EDGE_ROW_60_1_Right_716 VGND VGND VPWR VPWR sky130_fd_sc_hd__decap_3
XFILLER_252_1421 VGND VGND VPWR VPWR sky130_fd_sc_hd__decap_6
XFILLER_48_1271 VPWR VGND VPWR VGND sky130_ef_sc_hd__decap_12
XFILLER_252_1465 VPWR VGND VPWR VGND sky130_ef_sc_hd__decap_12
XTAP_TAPCELL_ROW_209_2530 VGND VPWR sky130_fd_sc_hd__tapvpwrvgnd_1
XFILLER_246_905 VPWR VGND VPWR VGND sky130_ef_sc_hd__decap_12
XTAP_TAPCELL_ROW_209_2541 VGND VPWR sky130_fd_sc_hd__tapvpwrvgnd_1
XFILLER_213_1449 VGND VGND VPWR VPWR sky130_fd_sc_hd__decap_6
XFILLER_246_949 VPWR VGND VPWR VGND sky130_ef_sc_hd__decap_12
XTAP_TAPCELL_ROW_205_2416 VGND VPWR sky130_fd_sc_hd__tapvpwrvgnd_1
XFILLER_27_15 VPWR VGND VPWR VGND sky130_ef_sc_hd__decap_12
XTAP_TAPCELL_ROW_205_2427 VGND VPWR sky130_fd_sc_hd__tapvpwrvgnd_1
XFILLER_214_83 VGND VGND VPWR VPWR sky130_fd_sc_hd__fill_1
XFILLER_150_27 VGND VGND VPWR VPWR sky130_fd_sc_hd__fill_1
XFILLER_246_1203 VGND VGND VPWR VPWR sky130_fd_sc_hd__fill_1
XTAP_TAPCELL_ROW_197_2206 VGND VPWR sky130_fd_sc_hd__tapvpwrvgnd_1
XFILLER_214_813 VPWR VGND VPWR VGND sky130_ef_sc_hd__decap_12
XFILLER_232_109 VPWR VGND VPWR VGND sky130_ef_sc_hd__decap_12
XFILLER_254_993 VPWR VGND VPWR VGND sky130_ef_sc_hd__decap_12
XTAP_TAPCELL_ROW_1_877 VGND VPWR sky130_fd_sc_hd__tapvpwrvgnd_1
XTAP_TAPCELL_ROW_197_2217 VGND VPWR sky130_fd_sc_hd__tapvpwrvgnd_1
XFILLER_168_1061 VPWR VGND VPWR VGND sky130_ef_sc_hd__decap_12
XFILLER_225_161 VGND VGND VPWR VPWR sky130_fd_sc_hd__decap_6
XTAP_TAPCELL_ROW_1_888 VGND VPWR sky130_fd_sc_hd__tapvpwrvgnd_1
XTAP_TAPCELL_ROW_1_899 VGND VPWR sky130_fd_sc_hd__tapvpwrvgnd_1
XFILLER_198_525 VGND VGND VPWR VPWR sky130_fd_sc_hd__decap_6
XFILLER_0_1273 VPWR VGND VPWR VGND sky130_ef_sc_hd__decap_12
XFILLER_241_665 VGND VGND VPWR VPWR sky130_fd_sc_hd__decap_6
XFILLER_240_153 VPWR VGND VPWR VGND sky130_ef_sc_hd__decap_12
XFILLER_55_1231 VPWR VGND VPWR VGND sky130_ef_sc_hd__decap_12
XFILLER_198_569 VPWR VGND VPWR VGND sky130_ef_sc_hd__decap_12
XFILLER_43_47 VGND VGND VPWR VPWR sky130_fd_sc_hd__decap_3
XFILLER_201_529 VPWR VGND VPWR VGND sky130_ef_sc_hd__decap_12
XFILLER_16_1215 VPWR VGND VPWR VGND sky130_ef_sc_hd__decap_12
XFILLER_179_783 VGND VGND VPWR VPWR sky130_fd_sc_hd__fill_1
XFILLER_240_197 VPWR VGND VPWR VGND sky130_ef_sc_hd__decap_12
XFILLER_55_1275 VPWR VGND VPWR VGND sky130_ef_sc_hd__decap_12
XFILLER_107_1343 VPWR VGND VPWR VGND sky130_ef_sc_hd__decap_12
XFILLER_90_1177 VPWR VGND VPWR VGND sky130_ef_sc_hd__decap_12
XFILLER_142_1245 VGND VGND VPWR VPWR sky130_fd_sc_hd__fill_1
XFILLER_159_69 VGND VGND VPWR VPWR sky130_fd_sc_hd__fill_2
XFILLER_167_945 VGND VGND VPWR VPWR sky130_fd_sc_hd__decap_6
XFILLER_220_1409 VPWR VGND VPWR VGND sky130_ef_sc_hd__decap_12
XFILLER_16_1259 VPWR VGND VPWR VGND sky130_ef_sc_hd__decap_12
XFILLER_166_433 VPWR VGND VPWR VGND sky130_ef_sc_hd__decap_12
XFILLER_107_1387 VPWR VGND VPWR VGND sky130_ef_sc_hd__decap_12
XFILLER_167_989 VPWR VGND VPWR VGND sky130_ef_sc_hd__decap_12
XFILLER_166_477 VPWR VGND VPWR VGND sky130_ef_sc_hd__decap_12
XFILLER_182_937 VPWR VGND VPWR VGND sky130_ef_sc_hd__decap_12
XTAP_TAPCELL_ROW_173_1560 VGND VPWR sky130_fd_sc_hd__tapvpwrvgnd_1
XFILLER_181_447 VGND VGND VPWR VPWR sky130_fd_sc_hd__fill_1
XFILLER_175_57 VPWR VGND VPWR VGND sky130_ef_sc_hd__decap_12
XFILLER_104_3 VPWR VGND VPWR VGND sky130_ef_sc_hd__decap_12
XFILLER_175_1021 VPWR VGND VPWR VGND sky130_ef_sc_hd__decap_12
XFILLER_4_19 VGND VGND VPWR VPWR sky130_fd_sc_hd__decap_8
XFILLER_190_981 VPWR VGND VPWR VGND sky130_ef_sc_hd__decap_12
XFILLER_175_1065 VPWR VGND VPWR VGND sky130_ef_sc_hd__decap_12
XFILLER_1_833 VGND VGND VPWR VPWR sky130_fd_sc_hd__fill_1
XTAP_TAPCELL_ROW_117_2_4457 VGND VPWR sky130_fd_sc_hd__tapvpwrvgnd_1
XFILLER_27_1311 VPWR VGND VPWR VGND sky130_ef_sc_hd__decap_12
XFILLER_66_1371 VPWR VGND VPWR VGND sky130_ef_sc_hd__decap_12
XTAP_TAPCELL_ROW_186_1910 VGND VPWR sky130_fd_sc_hd__tapvpwrvgnd_1
XFILLER_249_721 VGND VGND VPWR VPWR sky130_fd_sc_hd__decap_6
XFILLER_231_1505 VGND VGND VPWR VPWR sky130_fd_sc_hd__decap_6
XFILLER_27_1355 VPWR VGND VPWR VGND sky130_ef_sc_hd__decap_12
XFILLER_114_1303 VPWR VGND VPWR VGND sky130_ef_sc_hd__decap_12
XFILLER_249_765 VPWR VGND VPWR VGND sky130_ef_sc_hd__decap_12
XFILLER_0_365 VGND VGND VPWR VPWR sky130_fd_sc_hd__fill_2
XFILLER_118_1483 VPWR VGND VPWR VGND sky130_ef_sc_hd__decap_12
XFILLER_216_1073 VPWR VGND VPWR VGND sky130_ef_sc_hd__decap_12
XFILLER_7_1449 VGND VGND VPWR VPWR sky130_fd_sc_hd__decap_6
XFILLER_248_253 VPWR VGND VPWR VGND sky130_ef_sc_hd__decap_12
XFILLER_23_1219 VPWR VGND VPWR VGND sky130_ef_sc_hd__decap_12
XFILLER_153_1385 VGND VGND VPWR VPWR sky130_fd_sc_hd__fill_1
XTAP_TAPCELL_ROW_182_1807 VGND VPWR sky130_fd_sc_hd__tapvpwrvgnd_1
XFILLER_27_1399 VPWR VGND VPWR VGND sky130_ef_sc_hd__decap_12
XFILLER_209_629 VPWR VGND VPWR VGND sky130_ef_sc_hd__decap_12
XTAP_TAPCELL_ROW_167_1386 VGND VPWR sky130_fd_sc_hd__tapvpwrvgnd_1
XTAP_TAPCELL_ROW_167_1397 VGND VPWR sky130_fd_sc_hd__tapvpwrvgnd_1
XFILLER_208_139 VGND VGND VPWR VPWR sky130_fd_sc_hd__fill_1
X_654_ clknet_3_4__leaf_clk acc_core.adder.cla_blocks\[5\].block.sum\[0\] _062_ VGND
+ VGND VPWR VPWR net55 sky130_fd_sc_hd__dfrtp_1
XFILLER_84_65 VGND VGND VPWR VPWR sky130_fd_sc_hd__decap_6
XFILLER_229_1401 VPWR VGND VPWR VGND sky130_ef_sc_hd__decap_12
XTAP_TAPCELL_ROW_65_2_4144 VGND VPWR sky130_fd_sc_hd__tapvpwrvgnd_1
XFILLER_217_673 VPWR VGND VPWR VGND sky130_ef_sc_hd__decap_12
XFILLER_251_429 VPWR VGND VPWR VGND sky130_ef_sc_hd__decap_12
XFILLER_189_503 VGND VGND VPWR VPWR sky130_fd_sc_hd__fill_1
XFILLER_204_301 VGND VGND VPWR VPWR sky130_fd_sc_hd__decap_6
XFILLER_186_1161 VPWR VGND VPWR VGND sky130_ef_sc_hd__decap_12
X_585_ net669 VGND VGND VPWR VPWR _067_ sky130_fd_sc_hd__inv_2
XFILLER_232_643 VGND VGND VPWR VPWR sky130_fd_sc_hd__fill_1
XFILLER_204_345 VPWR VGND VPWR VGND sky130_ef_sc_hd__decap_12
XFILLER_220_805 VGND VGND VPWR VPWR sky130_fd_sc_hd__decap_6
XFILLER_177_709 VPWR VGND VPWR VGND sky130_ef_sc_hd__decap_12
XFILLER_38_1451 VPWR VGND VPWR VGND sky130_ef_sc_hd__decap_12
XFILLER_73_1331 VPWR VGND VPWR VGND sky130_ef_sc_hd__decap_12
XFILLER_147_1189 VPWR VGND VPWR VGND sky130_ef_sc_hd__decap_12
XFILLER_204_389 VPWR VGND VPWR VGND sky130_ef_sc_hd__decap_12
XFILLER_160_1301 VGND VGND VPWR VPWR sky130_fd_sc_hd__fill_1
XFILLER_220_849 VPWR VGND VPWR VGND sky130_ef_sc_hd__decap_12
XFILLER_34_1315 VPWR VGND VPWR VGND sky130_ef_sc_hd__decap_12
XFILLER_223_1033 VPWR VGND VPWR VGND sky130_ef_sc_hd__decap_12
XFILLER_38_1495 VPWR VGND VPWR VGND sky130_ef_sc_hd__decap_12
XFILLER_125_1443 VPWR VGND VPWR VGND sky130_ef_sc_hd__decap_12
XFILLER_199_1511 VGND VGND VPWR VPWR sky130_fd_sc_hd__fill_1
XFILLER_8_410 VGND VGND VPWR VPWR sky130_fd_sc_hd__decap_3
XFILLER_34_1359 VPWR VGND VPWR VGND sky130_ef_sc_hd__decap_12
XFILLER_8_421 VGND VGND VPWR VPWR sky130_fd_sc_hd__fill_2
XFILLER_169_293 VPWR VGND VPWR VGND sky130_ef_sc_hd__decap_12
XFILLER_185_753 VPWR VGND VPWR VGND sky130_ef_sc_hd__decap_12
XFILLER_223_1077 VPWR VGND VPWR VGND sky130_ef_sc_hd__decap_12
XTAP_TAPCELL_ROW_251_3660 VGND VPWR sky130_fd_sc_hd__tapvpwrvgnd_1
XFILLER_9_977 VGND VGND VPWR VPWR sky130_fd_sc_hd__decap_3
XFILLER_121_1329 VGND VGND VPWR VPWR sky130_fd_sc_hd__fill_1
XFILLER_219_39 VPWR VGND VPWR VGND sky130_ef_sc_hd__decap_12
XTAP_TAPCELL_ROW_251_3671 VGND VPWR sky130_fd_sc_hd__tapvpwrvgnd_1
XFILLER_185_797 VPWR VGND VPWR VGND sky130_ef_sc_hd__decap_12
XFILLER_8_498 VPWR VGND VPWR VGND sky130_ef_sc_hd__decap_12
XFILLER_172_469 VGND VGND VPWR VPWR sky130_fd_sc_hd__decap_6
XFILLER_193_1121 VPWR VGND VPWR VGND sky130_ef_sc_hd__decap_12
XFILLER_236_1427 VGND VGND VPWR VPWR sky130_fd_sc_hd__fill_1
XFILLER_235_27 VPWR VGND VPWR VGND sky130_ef_sc_hd__decap_12
XFILLER_45_1411 VPWR VGND VPWR VGND sky130_ef_sc_hd__decap_12
XFILLER_84_1471 VPWR VGND VPWR VGND sky130_ef_sc_hd__decap_12
XFILLER_45_1455 VPWR VGND VPWR VGND sky130_ef_sc_hd__decap_12
XFILLER_234_1173 VPWR VGND VPWR VGND sky130_ef_sc_hd__decap_12
XFILLER_228_905 VPWR VGND VPWR VGND sky130_ef_sc_hd__decap_12
XFILLER_80_1357 VGND VGND VPWR VPWR sky130_fd_sc_hd__fill_1
XFILLER_255_713 VPWR VGND VPWR VGND sky130_ef_sc_hd__decap_12
XTAP_TAPCELL_ROW_245_3497 VGND VPWR sky130_fd_sc_hd__tapvpwrvgnd_1
XFILLER_251_15 VPWR VGND VPWR VGND sky130_ef_sc_hd__decap_12
XFILLER_45_1499 VPWR VGND VPWR VGND sky130_ef_sc_hd__decap_12
XFILLER_230_1037 VPWR VGND VPWR VGND sky130_ef_sc_hd__decap_12
XFILLER_228_949 VPWR VGND VPWR VGND sky130_ef_sc_hd__decap_12
XFILLER_132_1469 VGND VGND VPWR VPWR sky130_fd_sc_hd__fill_1
XFILLER_255_757 VPWR VGND VPWR VGND sky130_ef_sc_hd__decap_12
XFILLER_254_245 VGND VGND VPWR VPWR sky130_fd_sc_hd__decap_6
XPHY_EDGE_ROW_103_2_Left_605 VGND VGND VPWR VPWR sky130_fd_sc_hd__decap_3
XFILLER_214_109 VPWR VGND VPWR VGND sky130_ef_sc_hd__decap_12
XFILLER_254_289 VPWR VGND VPWR VGND sky130_ef_sc_hd__decap_12
XFILLER_236_993 VPWR VGND VPWR VGND sky130_ef_sc_hd__decap_12
XFILLER_39_1204 VPWR VGND VPWR VGND sky130_ef_sc_hd__decap_12
XFILLER_165_1201 VGND VGND VPWR VPWR sky130_fd_sc_hd__decap_3
XFILLER_207_161 VGND VGND VPWR VPWR sky130_fd_sc_hd__decap_6
XFILLER_169_1381 VPWR VGND VPWR VGND sky130_ef_sc_hd__decap_12
XFILLER_165_1245 VPWR VGND VPWR VGND sky130_ef_sc_hd__decap_12
XFILLER_223_665 VGND VGND VPWR VPWR sky130_fd_sc_hd__decap_6
XFILLER_222_153 VPWR VGND VPWR VGND sky130_ef_sc_hd__decap_12
XFILLER_165_1289 VPWR VGND VPWR VGND sky130_ef_sc_hd__decap_12
XFILLER_195_517 VPWR VGND VPWR VGND sky130_ef_sc_hd__decap_12
XFILLER_200_41 VPWR VGND VPWR VGND sky130_ef_sc_hd__decap_12
XFILLER_52_1415 VPWR VGND VPWR VGND sky130_ef_sc_hd__decap_12
XFILLER_241_1133 VPWR VGND VPWR VGND sky130_ef_sc_hd__decap_12
XFILLER_206_1253 VGND VGND VPWR VPWR sky130_fd_sc_hd__decap_6
XFILLER_222_197 VPWR VGND VPWR VGND sky130_ef_sc_hd__decap_12
XFILLER_200_85 VPWR VGND VPWR VGND sky130_ef_sc_hd__decap_12
XFILLER_13_39 VPWR VGND VPWR VGND sky130_ef_sc_hd__decap_12
XFILLER_91_1497 VGND VGND VPWR VPWR sky130_fd_sc_hd__fill_1
XFILLER_202_1117 VPWR VGND VPWR VGND sky130_ef_sc_hd__decap_12
XFILLER_241_1177 VPWR VGND VPWR VGND sky130_ef_sc_hd__decap_12
XFILLER_206_1297 VPWR VGND VPWR VGND sky130_ef_sc_hd__decap_12
XFILLER_129_39 VPWR VGND VPWR VGND sky130_ef_sc_hd__decap_12
XFILLER_190_233 VPWR VGND VPWR VGND sky130_ef_sc_hd__decap_12
XFILLER_85_1213 VGND VGND VPWR VPWR sky130_fd_sc_hd__decap_4
XFILLER_176_1341 VPWR VGND VPWR VGND sky130_ef_sc_hd__decap_12
Xmax_cap140 net141 VGND VGND VPWR VPWR net140 sky130_fd_sc_hd__clkbuf_1
XFILLER_102_1295 VGND VGND VPWR VPWR sky130_fd_sc_hd__decap_6
XFILLER_11_1189 VPWR VGND VPWR VGND sky130_ef_sc_hd__decap_12
Xmax_cap151 net152 VGND VGND VPWR VPWR net151 sky130_fd_sc_hd__clkbuf_1
XFILLER_172_981 VPWR VGND VPWR VGND sky130_ef_sc_hd__decap_12
XFILLER_190_277 VPWR VGND VPWR VGND sky130_ef_sc_hd__decap_12
Xmax_cap162 net163 VGND VGND VPWR VPWR net162 sky130_fd_sc_hd__clkbuf_1
XFILLER_145_27 VPWR VGND VPWR VGND sky130_ef_sc_hd__decap_12
Xmax_cap173 _117_ VGND VGND VPWR VPWR net173 sky130_fd_sc_hd__clkbuf_1
XFILLER_172_1205 VPWR VGND VPWR VGND sky130_ef_sc_hd__decap_12
XFILLER_176_1385 VPWR VGND VPWR VGND sky130_ef_sc_hd__decap_12
Xmax_cap184 net185 VGND VGND VPWR VPWR net184 sky130_fd_sc_hd__clkbuf_1
XFILLER_63_1511 VGND VGND VPWR VPWR sky130_fd_sc_hd__decap_4
XPHY_EDGE_ROW_61_1_Right_717 VGND VGND VPWR VPWR sky130_fd_sc_hd__decap_3
Xmax_cap195 _214_ VGND VGND VPWR VPWR net195 sky130_fd_sc_hd__clkbuf_1
XTAP_TAPCELL_ROW_89_1_1224 VGND VPWR sky130_fd_sc_hd__tapvpwrvgnd_1
XFILLER_213_1213 VPWR VGND VPWR VGND sky130_ef_sc_hd__decap_12
XFILLER_252_1273 VPWR VGND VPWR VGND sky130_ef_sc_hd__decap_12
XTAP_TAPCELL_ROW_103_1_1238 VGND VPWR sky130_fd_sc_hd__tapvpwrvgnd_1
XFILLER_217_1393 VGND VGND VPWR VPWR sky130_fd_sc_hd__decap_6
XFILLER_225_93 VPWR VGND VPWR VGND sky130_ef_sc_hd__decap_12
XFILLER_246_713 VPWR VGND VPWR VGND sky130_ef_sc_hd__decap_12
XFILLER_161_15 VPWR VGND VPWR VGND sky130_ef_sc_hd__decap_12
XFILLER_213_1257 VPWR VGND VPWR VGND sky130_ef_sc_hd__decap_12
XPHY_EDGE_ROW_35_2_Left_537 VGND VGND VPWR VPWR sky130_fd_sc_hd__decap_3
XFILLER_245_223 VGND VGND VPWR VPWR sky130_fd_sc_hd__fill_1
XFILLER_246_757 VPWR VGND VPWR VGND sky130_ef_sc_hd__decap_12
XFILLER_248_1309 VGND VGND VPWR VPWR sky130_fd_sc_hd__decap_6
XTAP_TAPCELL_ROW_51_2_4063 VGND VPWR sky130_fd_sc_hd__tapvpwrvgnd_1
XFILLER_233_429 VPWR VGND VPWR VGND sky130_ef_sc_hd__decap_12
XFILLER_241_81 VPWR VGND VPWR VGND sky130_ef_sc_hd__decap_12
XFILLER_183_1301 VPWR VGND VPWR VGND sky130_ef_sc_hd__decap_12
XFILLER_187_1481 VPWR VGND VPWR VGND sky130_ef_sc_hd__decap_12
XFILLER_214_643 VGND VGND VPWR VPWR sky130_fd_sc_hd__fill_1
XFILLER_183_1345 VPWR VGND VPWR VGND sky130_ef_sc_hd__decap_12
XFILLER_198_333 VPWR VGND VPWR VGND sky130_ef_sc_hd__decap_12
XFILLER_202_805 VGND VGND VPWR VPWR sky130_fd_sc_hd__decap_6
X_370_ _152_ net247 net248 VGND VGND VPWR VPWR _159_ sky130_fd_sc_hd__a21oi_1
XFILLER_92_1239 VGND VGND VPWR VPWR sky130_fd_sc_hd__decap_6
XFILLER_241_473 VPWR VGND VPWR VGND sky130_ef_sc_hd__decap_12
XFILLER_199_889 VGND VGND VPWR VPWR sky130_fd_sc_hd__decap_6
XFILLER_110_41 VPWR VGND VPWR VGND sky130_ef_sc_hd__decap_12
XFILLER_198_377 VPWR VGND VPWR VGND sky130_ef_sc_hd__decap_12
XFILLER_202_849 VPWR VGND VPWR VGND sky130_ef_sc_hd__decap_12
XTAP_TAPCELL_ROW_175_1600 VGND VPWR sky130_fd_sc_hd__tapvpwrvgnd_1
XFILLER_201_337 VPWR VGND VPWR VGND sky130_ef_sc_hd__decap_12
XTAP_TAPCELL_ROW_175_1611 VGND VPWR sky130_fd_sc_hd__tapvpwrvgnd_1
XFILLER_224_1353 VPWR VGND VPWR VGND sky130_ef_sc_hd__decap_12
XTAP_TAPCELL_ROW_175_1622 VGND VPWR sky130_fd_sc_hd__tapvpwrvgnd_1
XFILLER_167_753 VPWR VGND VPWR VGND sky130_ef_sc_hd__decap_12
XFILLER_220_1217 VPWR VGND VPWR VGND sky130_ef_sc_hd__decap_12
XFILLER_221_3 VPWR VGND VPWR VGND sky130_ef_sc_hd__decap_12
XFILLER_224_1397 VPWR VGND VPWR VGND sky130_ef_sc_hd__decap_12
XFILLER_182_701 VPWR VGND VPWR VGND sky130_ef_sc_hd__decap_12
XTAP_TAPCELL_ROW_171_1508 VGND VPWR sky130_fd_sc_hd__tapvpwrvgnd_1
XFILLER_210_893 VPWR VGND VPWR VGND sky130_ef_sc_hd__decap_12
XFILLER_6_925 VPWR VGND VPWR VGND sky130_ef_sc_hd__decap_12
XFILLER_167_797 VPWR VGND VPWR VGND sky130_ef_sc_hd__decap_12
XFILLER_120_1351 VGND VGND VPWR VPWR sky130_fd_sc_hd__decap_6
XFILLER_194_1441 VPWR VGND VPWR VGND sky130_ef_sc_hd__decap_12
XPHY_EDGE_ROW_49_1_Left_304 VGND VGND VPWR VPWR sky130_fd_sc_hd__decap_3
XFILLER_120_1395 VPWR VGND VPWR VGND sky130_ef_sc_hd__decap_12
XFILLER_194_1485 VPWR VGND VPWR VGND sky130_ef_sc_hd__decap_12
XPHY_EDGE_ROW_101_1_Left_356 VGND VGND VPWR VPWR sky130_fd_sc_hd__decap_3
XFILLER_1_641 VGND VGND VPWR VPWR sky130_fd_sc_hd__fill_2
XTAP_TAPCELL_ROW_169_1437 VGND VPWR sky130_fd_sc_hd__tapvpwrvgnd_1
XTAP_TAPCELL_ROW_169_1448 VGND VPWR sky130_fd_sc_hd__tapvpwrvgnd_1
XFILLER_7_1213 VPWR VGND VPWR VGND sky130_ef_sc_hd__decap_12
XFILLER_1_663 VGND VGND VPWR VPWR sky130_fd_sc_hd__fill_2
XTAP_TAPCELL_ROW_169_1459 VGND VPWR sky130_fd_sc_hd__tapvpwrvgnd_1
XFILLER_231_1313 VPWR VGND VPWR VGND sky130_ef_sc_hd__decap_12
XFILLER_235_1493 VPWR VGND VPWR VGND sky130_ef_sc_hd__decap_12
XFILLER_249_573 VPWR VGND VPWR VGND sky130_ef_sc_hd__decap_12
XFILLER_7_1257 VPWR VGND VPWR VGND sky130_ef_sc_hd__decap_12
XFILLER_231_1357 VPWR VGND VPWR VGND sky130_ef_sc_hd__decap_12
XFILLER_236_245 VGND VGND VPWR VPWR sky130_fd_sc_hd__decap_6
XTAP_TAPCELL_ROW_5_991 VGND VPWR sky130_fd_sc_hd__tapvpwrvgnd_1
XFILLER_114_1177 VPWR VGND VPWR VGND sky130_ef_sc_hd__decap_12
XTAP_TAPCELL_ROW_240_3361 VGND VPWR sky130_fd_sc_hd__tapvpwrvgnd_1
XTAP_TAPCELL_ROW_240_3372 VGND VPWR sky130_fd_sc_hd__tapvpwrvgnd_1
XFILLER_131_1491 VGND VGND VPWR VPWR sky130_fd_sc_hd__decap_6
XFILLER_236_289 VPWR VGND VPWR VGND sky130_ef_sc_hd__decap_12
XFILLER_218_993 VPWR VGND VPWR VGND sky130_ef_sc_hd__decap_12
XFILLER_252_749 VGND VGND VPWR VPWR sky130_fd_sc_hd__decap_6
X_637_ clknet_3_3__leaf_clk acc_core.adder.cla_blocks\[0\].block.sum\[3\] _045_ VGND
+ VGND VPWR VPWR net68 sky130_fd_sc_hd__dfrtp_1
XFILLER_229_1231 VGND VGND VPWR VPWR sky130_fd_sc_hd__fill_1
XFILLER_251_237 VPWR VGND VPWR VGND sky130_ef_sc_hd__decap_12
XFILLER_205_665 VGND VGND VPWR VPWR sky130_fd_sc_hd__decap_6
X_568_ net665 VGND VGND VPWR VPWR _050_ sky130_fd_sc_hd__inv_2
XFILLER_162_1407 VGND VGND VPWR VPWR sky130_fd_sc_hd__decap_6
XFILLER_204_153 VPWR VGND VPWR VGND sky130_ef_sc_hd__decap_12
XFILLER_220_613 VPWR VGND VPWR VGND sky130_ef_sc_hd__decap_12
XTAP_TAPCELL_ROW_253_3711 VGND VPWR sky130_fd_sc_hd__tapvpwrvgnd_1
XFILLER_177_517 VPWR VGND VPWR VGND sky130_ef_sc_hd__decap_12
XTAP_TAPCELL_ROW_253_3722 VGND VPWR sky130_fd_sc_hd__tapvpwrvgnd_1
XPHY_EDGE_ROW_81_2_Left_583 VGND VGND VPWR VPWR sky130_fd_sc_hd__decap_3
XFILLER_204_197 VPWR VGND VPWR VGND sky130_ef_sc_hd__decap_12
X_499_ net96 net140 VGND VGND VPWR VPWR acc_core.adder.cla_blocks\[5\].block.sum\[0\]
+ sky130_fd_sc_hd__xor2_1
XFILLER_220_657 VPWR VGND VPWR VGND sky130_ef_sc_hd__decap_12
XFILLER_242_1453 VPWR VGND VPWR VGND sky130_ef_sc_hd__decap_12
XFILLER_9_741 VPWR VGND VPWR VGND sky130_ef_sc_hd__decap_12
XFILLER_125_1273 VGND VGND VPWR VPWR sky130_fd_sc_hd__fill_1
XFILLER_203_1437 VPWR VGND VPWR VGND sky130_ef_sc_hd__decap_12
XFILLER_242_1497 VPWR VGND VPWR VGND sky130_ef_sc_hd__decap_12
XFILLER_185_561 VPWR VGND VPWR VGND sky130_ef_sc_hd__decap_12
XTAP_TAPCELL_ROW_234_3198 VGND VPWR sky130_fd_sc_hd__tapvpwrvgnd_1
XFILLER_34_1189 VGND VGND VPWR VPWR sky130_fd_sc_hd__fill_1
XFILLER_8_251 VGND VGND VPWR VPWR sky130_fd_sc_hd__fill_1
XFILLER_9_785 VPWR VGND VPWR VGND sky130_ef_sc_hd__decap_12
XFILLER_69_1219 VPWR VGND VPWR VGND sky130_ef_sc_hd__decap_12
XFILLER_246_15 VPWR VGND VPWR VGND sky130_ef_sc_hd__decap_12
XFILLER_67_3 VPWR VGND VPWR VGND sky130_ef_sc_hd__decap_12
XFILLER_172_233 VPWR VGND VPWR VGND sky130_ef_sc_hd__decap_12
XFILLER_172_277 VPWR VGND VPWR VGND sky130_ef_sc_hd__decap_12
XPHY_EDGE_ROW_33_1_Left_288 VGND VGND VPWR VPWR sky130_fd_sc_hd__decap_3
XTAP_TAPCELL_ROW_247_3548 VGND VPWR sky130_fd_sc_hd__tapvpwrvgnd_1
XTAP_TAPCELL_ROW_247_3559 VGND VPWR sky130_fd_sc_hd__tapvpwrvgnd_1
XTAP_TAPCELL_ROW_56_2_4089 VGND VPWR sky130_fd_sc_hd__tapvpwrvgnd_1
XFILLER_228_713 VPWR VGND VPWR VGND sky130_ef_sc_hd__decap_12
XFILLER_80_1165 VPWR VGND VPWR VGND sky130_ef_sc_hd__decap_12
XFILLER_189_1009 VPWR VGND VPWR VGND sky130_ef_sc_hd__decap_12
XTAP_TAPCELL_ROW_3_939 VGND VPWR sky130_fd_sc_hd__tapvpwrvgnd_1
XFILLER_227_223 VGND VGND VPWR VPWR sky130_fd_sc_hd__fill_1
XFILLER_228_757 VPWR VGND VPWR VGND sky130_ef_sc_hd__decap_12
XPHY_EDGE_ROW_95_1_Left_350 VGND VGND VPWR VPWR sky130_fd_sc_hd__decap_3
XFILLER_243_727 VGND VGND VPWR VPWR sky130_fd_sc_hd__fill_1
XFILLER_215_429 VPWR VGND VPWR VGND sky130_ef_sc_hd__decap_12
XTAP_TAPCELL_ROW_34_2_3959 VGND VPWR sky130_fd_sc_hd__tapvpwrvgnd_1
XFILLER_208_1315 VGND VGND VPWR VPWR sky130_fd_sc_hd__fill_1
XFILLER_211_51 VGND VGND VPWR VPWR sky130_fd_sc_hd__decap_4
XFILLER_24_27 VGND VGND VPWR VPWR sky130_fd_sc_hd__fill_1
XFILLER_223_473 VPWR VGND VPWR VGND sky130_ef_sc_hd__decap_12
XFILLER_196_837 VPWR VGND VPWR VGND sky130_ef_sc_hd__decap_12
XFILLER_17_1343 VPWR VGND VPWR VGND sky130_ef_sc_hd__decap_12
XFILLER_206_1061 VPWR VGND VPWR VGND sky130_ef_sc_hd__decap_12
XFILLER_52_1245 VGND VGND VPWR VPWR sky130_fd_sc_hd__fill_1
XFILLER_108_1471 VPWR VGND VPWR VGND sky130_ef_sc_hd__decap_12
XFILLER_17_1387 VPWR VGND VPWR VGND sky130_ef_sc_hd__decap_12
XFILLER_210_189 VGND VGND VPWR VPWR sky130_fd_sc_hd__decap_6
XFILLER_40_15 VPWR VGND VPWR VGND sky130_ef_sc_hd__decap_12
XFILLER_104_1357 VGND VGND VPWR VPWR sky130_fd_sc_hd__fill_1
XFILLER_156_15 VPWR VGND VPWR VGND sky130_ef_sc_hd__decap_12
XFILLER_40_59 VGND VGND VPWR VPWR sky130_fd_sc_hd__decap_8
XTAP_TAPCELL_ROW_153_2_4673 VGND VPWR sky130_fd_sc_hd__tapvpwrvgnd_1
XFILLER_191_553 VGND VGND VPWR VPWR sky130_fd_sc_hd__decap_6
XFILLER_191_597 VPWR VGND VPWR VGND sky130_ef_sc_hd__decap_12
XFILLER_219_1455 VGND VGND VPWR VPWR sky130_fd_sc_hd__fill_1
XFILLER_6_7 VPWR VGND VPWR VGND sky130_ef_sc_hd__decap_12
XFILLER_172_1035 VGND VGND VPWR VPWR sky130_fd_sc_hd__fill_1
XPHY_EDGE_ROW_62_1_Right_718 VGND VGND VPWR VPWR sky130_fd_sc_hd__decap_3
XFILLER_137_1177 VPWR VGND VPWR VGND sky130_ef_sc_hd__decap_12
XFILLER_24_1303 VPWR VGND VPWR VGND sky130_ef_sc_hd__decap_12
XFILLER_28_1483 VPWR VGND VPWR VGND sky130_ef_sc_hd__decap_12
XFILLER_213_1021 VPWR VGND VPWR VGND sky130_ef_sc_hd__decap_12
XFILLER_63_1385 VGND VGND VPWR VPWR sky130_fd_sc_hd__fill_1
XFILLER_98_1415 VPWR VGND VPWR VGND sky130_ef_sc_hd__decap_12
XFILLER_213_1065 VPWR VGND VPWR VGND sky130_ef_sc_hd__decap_12
XFILLER_218_245 VGND VGND VPWR VPWR sky130_fd_sc_hd__decap_6
XFILLER_115_1497 VGND VGND VPWR VPWR sky130_fd_sc_hd__fill_1
XFILLER_248_1117 VPWR VGND VPWR VGND sky130_ef_sc_hd__decap_12
XFILLER_246_587 VGND VGND VPWR VPWR sky130_fd_sc_hd__fill_1
XFILLER_171_3 VPWR VGND VPWR VGND sky130_ef_sc_hd__decap_12
XFILLER_218_289 VPWR VGND VPWR VGND sky130_ef_sc_hd__decap_12
XFILLER_234_749 VGND VGND VPWR VPWR sky130_fd_sc_hd__decap_6
XFILLER_233_237 VPWR VGND VPWR VGND sky130_ef_sc_hd__decap_12
X_422_ _128_ net336 VGND VGND VPWR VPWR _211_ sky130_fd_sc_hd__and2b_1
XFILLER_121_51 VGND VGND VPWR VPWR sky130_fd_sc_hd__decap_4
XFILLER_199_653 VPWR VGND VPWR VGND sky130_ef_sc_hd__decap_12
XFILLER_109_1213 VGND VGND VPWR VPWR sky130_fd_sc_hd__decap_4
XFILLER_198_141 VPWR VGND VPWR VGND sky130_ef_sc_hd__decap_12
XFILLER_202_613 VPWR VGND VPWR VGND sky130_ef_sc_hd__decap_12
XFILLER_242_793 VPWR VGND VPWR VGND sky130_ef_sc_hd__decap_12
XFILLER_148_1295 VGND VGND VPWR VPWR sky130_fd_sc_hd__decap_6
XFILLER_183_1175 VGND VGND VPWR VPWR sky130_fd_sc_hd__fill_1
XFILLER_241_281 VPWR VGND VPWR VGND sky130_ef_sc_hd__decap_12
XFILLER_57_1189 VPWR VGND VPWR VGND sky130_ef_sc_hd__decap_12
X_353_ net593 net571 net541 VGND VGND VPWR VPWR _142_ sky130_fd_sc_hd__and3_1
XFILLER_81_55 VGND VGND VPWR VPWR sky130_fd_sc_hd__fill_1
XFILLER_199_697 VPWR VGND VPWR VGND sky130_ef_sc_hd__decap_12
XFILLER_70_1301 VGND VGND VPWR VPWR sky130_fd_sc_hd__fill_1
XFILLER_202_657 VPWR VGND VPWR VGND sky130_ef_sc_hd__decap_12
XFILLER_35_1443 VPWR VGND VPWR VGND sky130_ef_sc_hd__decap_12
XFILLER_197_55 VGND VGND VPWR VPWR sky130_fd_sc_hd__fill_1
XFILLER_224_1161 VPWR VGND VPWR VGND sky130_ef_sc_hd__decap_12
X_284_ net664 VGND VGND VPWR VPWR _000_ sky130_fd_sc_hd__inv_2
XFILLER_122_1413 VGND VGND VPWR VPWR sky130_fd_sc_hd__fill_1
XFILLER_201_167 VGND VGND VPWR VPWR sky130_fd_sc_hd__fill_1
XFILLER_167_561 VPWR VGND VPWR VGND sky130_ef_sc_hd__decap_12
XFILLER_31_1329 VGND VGND VPWR VPWR sky130_fd_sc_hd__fill_1
XFILLER_6_722 VGND VGND VPWR VPWR sky130_fd_sc_hd__decap_3
XFILLER_182_531 VGND VGND VPWR VPWR sky130_fd_sc_hd__fill_1
XFILLER_237_1511 VGND VGND VPWR VPWR sky130_fd_sc_hd__fill_1
XFILLER_170_737 VPWR VGND VPWR VGND sky130_ef_sc_hd__decap_12
XFILLER_216_29 VPWR VGND VPWR VGND sky130_ef_sc_hd__decap_12
XFILLER_2_961 VPWR VGND VPWR VGND sky130_ef_sc_hd__decap_12
XFILLER_155_1255 VPWR VGND VPWR VGND sky130_ef_sc_hd__decap_12
XFILLER_81_1441 VGND VGND VPWR VPWR sky130_fd_sc_hd__fill_1
XFILLER_116_1239 VGND VGND VPWR VPWR sky130_fd_sc_hd__decap_6
XTAP_TAPCELL_ROW_242_3412 VGND VPWR sky130_fd_sc_hd__tapvpwrvgnd_1
XFILLER_7_1021 VPWR VGND VPWR VGND sky130_ef_sc_hd__decap_12
XFILLER_155_1299 VPWR VGND VPWR VGND sky130_ef_sc_hd__decap_12
XTAP_TAPCELL_ROW_242_3423 VGND VPWR sky130_fd_sc_hd__tapvpwrvgnd_1
XFILLER_231_1121 VPWR VGND VPWR VGND sky130_ef_sc_hd__decap_12
XFILLER_7_1065 VPWR VGND VPWR VGND sky130_ef_sc_hd__decap_12
XFILLER_209_223 VGND VGND VPWR VPWR sky130_fd_sc_hd__fill_1
Xinput8 wr_addr[6] VGND VGND VPWR VPWR net8 sky130_fd_sc_hd__clkbuf_1
XFILLER_42_1469 VGND VGND VPWR VPWR sky130_fd_sc_hd__fill_1
XTAP_TAPCELL_ROW_8_1071 VGND VPWR sky130_fd_sc_hd__tapvpwrvgnd_1
XTAP_TAPCELL_ROW_8_1082 VGND VPWR sky130_fd_sc_hd__tapvpwrvgnd_1
XFILLER_252_513 VPWR VGND VPWR VGND sky130_ef_sc_hd__decap_12
XFILLER_225_727 VGND VGND VPWR VPWR sky130_fd_sc_hd__fill_1
XFILLER_252_557 VPWR VGND VPWR VGND sky130_ef_sc_hd__decap_12
XFILLER_75_1201 VPWR VGND VPWR VGND sky130_ef_sc_hd__decap_12
XTAP_TAPCELL_ROW_255_3806 VGND VPWR sky130_fd_sc_hd__tapvpwrvgnd_1
XFILLER_205_473 VPWR VGND VPWR VGND sky130_ef_sc_hd__decap_12
XFILLER_166_1373 VPWR VGND VPWR VGND sky130_ef_sc_hd__decap_12
XFILLER_75_1267 VGND VGND VPWR VPWR sky130_fd_sc_hd__decap_6
XFILLER_162_1215 VPWR VGND VPWR VGND sky130_ef_sc_hd__decap_12
XFILLER_221_933 VPWR VGND VPWR VGND sky130_ef_sc_hd__decap_12
XFILLER_178_837 VPWR VGND VPWR VGND sky130_ef_sc_hd__decap_12
XFILLER_220_421 VPWR VGND VPWR VGND sky130_ef_sc_hd__decap_12
XTAP_TAPCELL_ROW_236_3249 VGND VPWR sky130_fd_sc_hd__tapvpwrvgnd_1
XFILLER_221_977 VPWR VGND VPWR VGND sky130_ef_sc_hd__decap_12
XFILLER_127_1379 VGND VGND VPWR VPWR sky130_fd_sc_hd__decap_6
XFILLER_162_1259 VPWR VGND VPWR VGND sky130_ef_sc_hd__decap_12
XFILLER_203_1201 VPWR VGND VPWR VGND sky130_ef_sc_hd__decap_12
XFILLER_242_1261 VPWR VGND VPWR VGND sky130_ef_sc_hd__decap_12
XFILLER_207_1381 VPWR VGND VPWR VGND sky130_ef_sc_hd__decap_12
XFILLER_203_1245 VPWR VGND VPWR VGND sky130_ef_sc_hd__decap_12
XFILLER_186_881 VPWR VGND VPWR VGND sky130_ef_sc_hd__decap_12
XFILLER_185_391 VGND VGND VPWR VPWR sky130_fd_sc_hd__fill_1
XFILLER_203_1289 VPWR VGND VPWR VGND sky130_ef_sc_hd__decap_12
XFILLER_173_553 VGND VGND VPWR VPWR sky130_fd_sc_hd__decap_6
XFILLER_10_18 VGND VGND VPWR VPWR sky130_fd_sc_hd__decap_8
XFILLER_10_29 VPWR VGND VPWR VGND sky130_ef_sc_hd__decap_12
XFILLER_195_1057 VGND VGND VPWR VPWR sky130_fd_sc_hd__decap_6
XFILLER_173_597 VPWR VGND VPWR VGND sky130_ef_sc_hd__decap_12
XFILLER_12_1295 VGND VGND VPWR VPWR sky130_fd_sc_hd__decap_6
XTAP_TAPCELL_ROW_118_2_4462 VGND VPWR sky130_fd_sc_hd__tapvpwrvgnd_1
XFILLER_126_29 VPWR VGND VPWR VGND sky130_ef_sc_hd__decap_12
XFILLER_82_1227 VPWR VGND VPWR VGND sky130_ef_sc_hd__decap_12
XTAP_TAPCELL_ROW_86_2_4273 VGND VPWR sky130_fd_sc_hd__tapvpwrvgnd_1
XFILLER_134_1339 VPWR VGND VPWR VGND sky130_ef_sc_hd__decap_12
XFILLER_173_1399 VGND VGND VPWR VPWR sky130_fd_sc_hd__fill_1
XFILLER_247_329 VGND VGND VPWR VPWR sky130_fd_sc_hd__decap_6
XFILLER_19_27 VPWR VGND VPWR VGND sky130_ef_sc_hd__decap_12
XFILLER_214_1341 VPWR VGND VPWR VGND sky130_ef_sc_hd__decap_12
XFILLER_210_1205 VPWR VGND VPWR VGND sky130_ef_sc_hd__decap_12
XFILLER_214_1385 VPWR VGND VPWR VGND sky130_ef_sc_hd__decap_12
XTAP_TAPCELL_ROW_225_2953 VGND VPWR sky130_fd_sc_hd__tapvpwrvgnd_1
XTAP_TAPCELL_ROW_225_2964 VGND VPWR sky130_fd_sc_hd__tapvpwrvgnd_1
XFILLER_228_587 VGND VGND VPWR VPWR sky130_fd_sc_hd__fill_1
XFILLER_249_1437 VPWR VGND VPWR VGND sky130_ef_sc_hd__decap_12
XFILLER_216_749 VGND VGND VPWR VPWR sky130_fd_sc_hd__decap_6
XTAP_TAPCELL_ROW_221_2839 VGND VPWR sky130_fd_sc_hd__tapvpwrvgnd_1
XFILLER_35_15 VPWR VGND VPWR VGND sky130_ef_sc_hd__decap_12
XFILLER_215_237 VPWR VGND VPWR VGND sky130_ef_sc_hd__decap_12
XFILLER_222_83 VGND VGND VPWR VPWR sky130_fd_sc_hd__fill_1
XFILLER_93_1323 VGND VGND VPWR VPWR sky130_fd_sc_hd__decap_6
XFILLER_110_1383 VPWR VGND VPWR VGND sky130_ef_sc_hd__decap_12
XFILLER_196_601 VPWR VGND VPWR VGND sky130_ef_sc_hd__decap_12
XFILLER_224_793 VPWR VGND VPWR VGND sky130_ef_sc_hd__decap_12
XFILLER_93_1367 VPWR VGND VPWR VGND sky130_ef_sc_hd__decap_12
XFILLER_145_1435 VGND VGND VPWR VPWR sky130_fd_sc_hd__decap_6
XFILLER_180_1315 VGND VGND VPWR VPWR sky130_fd_sc_hd__fill_1
XFILLER_223_281 VPWR VGND VPWR VGND sky130_ef_sc_hd__decap_12
XFILLER_195_111 VGND VGND VPWR VPWR sky130_fd_sc_hd__fill_1
XFILLER_196_645 VPWR VGND VPWR VGND sky130_ef_sc_hd__decap_12
XFILLER_145_1479 VPWR VGND VPWR VGND sky130_ef_sc_hd__decap_12
XFILLER_221_1301 VPWR VGND VPWR VGND sky130_ef_sc_hd__decap_12
Xwire406 net407 VGND VGND VPWR VPWR net406 sky130_fd_sc_hd__clkbuf_1
XFILLER_225_1481 VPWR VGND VPWR VGND sky130_ef_sc_hd__decap_12
XFILLER_51_47 VGND VGND VPWR VPWR sky130_fd_sc_hd__fill_2
Xwire417 net418 VGND VGND VPWR VPWR net417 sky130_fd_sc_hd__clkbuf_1
XFILLER_183_317 VPWR VGND VPWR VGND sky130_ef_sc_hd__decap_12
Xwire428 net429 VGND VGND VPWR VPWR net428 sky130_fd_sc_hd__clkbuf_1
XFILLER_221_1345 VPWR VGND VPWR VGND sky130_ef_sc_hd__decap_12
Xwire439 net440 VGND VGND VPWR VPWR net439 sky130_fd_sc_hd__clkbuf_1
XFILLER_104_1165 VPWR VGND VPWR VGND sky130_ef_sc_hd__decap_12
XFILLER_167_69 VPWR VGND VPWR VGND sky130_ef_sc_hd__decap_12
XFILLER_30_1351 VGND VGND VPWR VPWR sky130_fd_sc_hd__decap_6
XFILLER_139_1217 VGND VGND VPWR VPWR sky130_fd_sc_hd__fill_1
XFILLER_191_361 VPWR VGND VPWR VGND sky130_ef_sc_hd__decap_12
XFILLER_30_1395 VPWR VGND VPWR VGND sky130_ef_sc_hd__decap_12
XFILLER_183_57 VPWR VGND VPWR VGND sky130_ef_sc_hd__decap_12
XFILLER_191_1455 VGND VGND VPWR VPWR sky130_fd_sc_hd__fill_1
XFILLER_250_1029 VGND VGND VPWR VPWR sky130_fd_sc_hd__decap_6
XFILLER_238_307 VGND VGND VPWR VPWR sky130_fd_sc_hd__fill_1
XFILLER_152_1439 VPWR VGND VPWR VGND sky130_ef_sc_hd__decap_12
XFILLER_8_1341 VPWR VGND VPWR VGND sky130_ef_sc_hd__decap_12
XFILLER_232_1441 VPWR VGND VPWR VGND sky130_ef_sc_hd__decap_12
XPHY_EDGE_ROW_63_1_Right_719 VGND VGND VPWR VPWR sky130_fd_sc_hd__decap_3
XFILLER_4_1205 VPWR VGND VPWR VGND sky130_ef_sc_hd__decap_12
XFILLER_247_841 VPWR VGND VPWR VGND sky130_ef_sc_hd__decap_12
XFILLER_8_1385 VPWR VGND VPWR VGND sky130_ef_sc_hd__decap_12
XFILLER_232_1485 VPWR VGND VPWR VGND sky130_ef_sc_hd__decap_12
Xfanout594 net597 VGND VGND VPWR VPWR net594 sky130_fd_sc_hd__buf_2
XFILLER_24_1177 VPWR VGND VPWR VGND sky130_ef_sc_hd__decap_12
XFILLER_98_1245 VGND VGND VPWR VPWR sky130_fd_sc_hd__fill_1
XFILLER_207_727 VGND VGND VPWR VPWR sky130_fd_sc_hd__fill_1
XFILLER_234_513 VPWR VGND VPWR VGND sky130_ef_sc_hd__decap_12
XFILLER_41_1491 VGND VGND VPWR VPWR sky130_fd_sc_hd__decap_6
XFILLER_234_557 VPWR VGND VPWR VGND sky130_ef_sc_hd__decap_12
XFILLER_92_65 VGND VGND VPWR VPWR sky130_fd_sc_hd__decap_6
XFILLER_72_1407 VGND VGND VPWR VPWR sky130_fd_sc_hd__decap_6
XFILLER_199_461 VPWR VGND VPWR VGND sky130_ef_sc_hd__decap_12
XFILLER_203_933 VPWR VGND VPWR VGND sky130_ef_sc_hd__decap_12
X_405_ _191_ _193_ VGND VGND VPWR VPWR _194_ sky130_fd_sc_hd__nand2b_1
XFILLER_202_421 VPWR VGND VPWR VGND sky130_ef_sc_hd__decap_12
XFILLER_203_977 VPWR VGND VPWR VGND sky130_ef_sc_hd__decap_12
XFILLER_186_133 VGND VGND VPWR VPWR sky130_fd_sc_hd__decap_6
X_336_ _120_ _124_ VGND VGND VPWR VPWR _125_ sky130_fd_sc_hd__or2_1
XFILLER_35_1273 VGND VGND VPWR VPWR sky130_fd_sc_hd__fill_1
XFILLER_168_881 VPWR VGND VPWR VGND sky130_ef_sc_hd__decap_12
XFILLER_186_177 VPWR VGND VPWR VGND sky130_ef_sc_hd__decap_12
XTAP_TAPCELL_ROW_231_3113 VGND VPWR sky130_fd_sc_hd__tapvpwrvgnd_1
XTAP_TAPCELL_ROW_231_3124 VGND VPWR sky130_fd_sc_hd__tapvpwrvgnd_1
XTAP_TAPCELL_ROW_231_3135 VGND VPWR sky130_fd_sc_hd__tapvpwrvgnd_1
XFILLER_167_391 VGND VGND VPWR VPWR sky130_fd_sc_hd__fill_1
XFILLER_200_1429 VPWR VGND VPWR VGND sky130_ef_sc_hd__decap_12
XFILLER_170_501 VPWR VGND VPWR VGND sky130_ef_sc_hd__decap_12
XPHY_EDGE_ROW_112_2_Left_614 VGND VGND VPWR VPWR sky130_fd_sc_hd__decap_3
XFILLER_183_895 VGND VGND VPWR VPWR sky130_fd_sc_hd__fill_1
XFILLER_227_39 VPWR VGND VPWR VGND sky130_ef_sc_hd__decap_12
XTAP_TAPCELL_ROW_104_2_4381 VGND VPWR sky130_fd_sc_hd__tapvpwrvgnd_1
XFILLER_170_545 VPWR VGND VPWR VGND sky130_ef_sc_hd__decap_12
XFILLER_9_1105 VPWR VGND VPWR VGND sky130_ef_sc_hd__decap_12
XFILLER_170_589 VPWR VGND VPWR VGND sky130_ef_sc_hd__decap_12
XTAP_TAPCELL_ROW_229_3064 VGND VPWR sky130_fd_sc_hd__tapvpwrvgnd_1
XTAP_TAPCELL_ROW_229_3075 VGND VPWR sky130_fd_sc_hd__tapvpwrvgnd_1
XFILLER_243_27 VPWR VGND VPWR VGND sky130_ef_sc_hd__decap_12
XFILLER_9_1149 VPWR VGND VPWR VGND sky130_ef_sc_hd__decap_12
XFILLER_229_329 VGND VGND VPWR VPWR sky130_fd_sc_hd__decap_6
XFILLER_2_41 VPWR VGND VPWR VGND sky130_ef_sc_hd__decap_12
XTAP_TAPCELL_ROW_6_1019 VGND VPWR sky130_fd_sc_hd__tapvpwrvgnd_1
XFILLER_2_85 VPWR VGND VPWR VGND sky130_ef_sc_hd__decap_12
XFILLER_237_373 VPWR VGND VPWR VGND sky130_ef_sc_hd__decap_12
XFILLER_253_833 VGND VGND VPWR VPWR sky130_fd_sc_hd__decap_6
XFILLER_252_321 VPWR VGND VPWR VGND sky130_ef_sc_hd__decap_12
XFILLER_77_1329 VGND VGND VPWR VPWR sky130_fd_sc_hd__fill_1
XFILLER_253_877 VPWR VGND VPWR VGND sky130_ef_sc_hd__decap_12
XFILLER_227_1009 VPWR VGND VPWR VGND sky130_ef_sc_hd__decap_12
XFILLER_252_365 VPWR VGND VPWR VGND sky130_ef_sc_hd__decap_12
XFILLER_178_601 VPWR VGND VPWR VGND sky130_ef_sc_hd__decap_12
XFILLER_90_1507 VGND VGND VPWR VPWR sky130_fd_sc_hd__decap_8
XFILLER_206_793 VPWR VGND VPWR VGND sky130_ef_sc_hd__decap_12
XFILLER_205_281 VPWR VGND VPWR VGND sky130_ef_sc_hd__decap_12
XFILLER_221_741 VPWR VGND VPWR VGND sky130_ef_sc_hd__decap_12
XFILLER_177_111 VGND VGND VPWR VPWR sky130_fd_sc_hd__fill_1
XFILLER_178_645 VPWR VGND VPWR VGND sky130_ef_sc_hd__decap_12
XFILLER_127_1165 VPWR VGND VPWR VGND sky130_ef_sc_hd__decap_12
XTAP_TAPCELL_ROW_44_2_4016 VGND VPWR sky130_fd_sc_hd__tapvpwrvgnd_1
XFILLER_220_251 VGND VGND VPWR VPWR sky130_fd_sc_hd__fill_1
XFILLER_221_785 VPWR VGND VPWR VGND sky130_ef_sc_hd__decap_12
XFILLER_18_1471 VPWR VGND VPWR VGND sky130_ef_sc_hd__decap_12
XFILLER_193_615 VGND VGND VPWR VPWR sky130_fd_sc_hd__fill_1
XFILLER_105_1441 VGND VGND VPWR VPWR sky130_fd_sc_hd__fill_1
XTAP_TAPCELL_ROW_193_2083 VGND VPWR sky130_fd_sc_hd__tapvpwrvgnd_1
XFILLER_242_1091 VGND VGND VPWR VPWR sky130_fd_sc_hd__fill_1
XTAP_TAPCELL_ROW_193_2094 VGND VPWR sky130_fd_sc_hd__tapvpwrvgnd_1
XFILLER_197_1119 VGND VGND VPWR VPWR sky130_fd_sc_hd__fill_1
XFILLER_14_1357 VGND VGND VPWR VPWR sky130_fd_sc_hd__fill_1
XPHY_EDGE_ROW_44_2_Left_546 VGND VGND VPWR VPWR sky130_fd_sc_hd__decap_3
XFILLER_21_39 VPWR VGND VPWR VGND sky130_ef_sc_hd__decap_12
XFILLER_238_1105 VPWR VGND VPWR VGND sky130_ef_sc_hd__decap_12
XFILLER_180_309 VPWR VGND VPWR VGND sky130_ef_sc_hd__decap_12
XTAP_TAPCELL_ROW_214_2654 VGND VPWR sky130_fd_sc_hd__tapvpwrvgnd_1
XTAP_TAPCELL_ROW_214_2665 VGND VPWR sky130_fd_sc_hd__tapvpwrvgnd_1
XFILLER_137_39 VPWR VGND VPWR VGND sky130_ef_sc_hd__decap_12
XFILLER_173_361 VPWR VGND VPWR VGND sky130_ef_sc_hd__decap_12
XFILLER_88_1469 VGND VGND VPWR VPWR sky130_fd_sc_hd__fill_1
XTAP_TAPCELL_ROW_214_2676 VGND VPWR sky130_fd_sc_hd__tapvpwrvgnd_1
XFILLER_238_1149 VPWR VGND VPWR VGND sky130_ef_sc_hd__decap_12
XFILLER_255_1441 VPWR VGND VPWR VGND sky130_ef_sc_hd__decap_12
XFILLER_255_1485 VPWR VGND VPWR VGND sky130_ef_sc_hd__decap_12
XFILLER_138_1283 VPWR VGND VPWR VGND sky130_ef_sc_hd__decap_12
XFILLER_47_1177 VPWR VGND VPWR VGND sky130_ef_sc_hd__decap_12
XFILLER_153_27 VPWR VGND VPWR VGND sky130_ef_sc_hd__decap_12
XFILLER_247_137 VPWR VGND VPWR VGND sky130_ef_sc_hd__decap_12
XFILLER_229_841 VPWR VGND VPWR VGND sky130_ef_sc_hd__decap_12
XFILLER_249_1201 VPWR VGND VPWR VGND sky130_ef_sc_hd__decap_12
XFILLER_244_811 VGND VGND VPWR VPWR sky130_fd_sc_hd__fill_1
XFILLER_210_1035 VGND VGND VPWR VPWR sky130_fd_sc_hd__fill_1
XFILLER_25_1497 VGND VGND VPWR VPWR sky130_fd_sc_hd__fill_1
XFILLER_216_513 VPWR VGND VPWR VGND sky130_ef_sc_hd__decap_12
XFILLER_46_47 VGND VGND VPWR VPWR sky130_fd_sc_hd__fill_1
XFILLER_233_93 VPWR VGND VPWR VGND sky130_ef_sc_hd__decap_12
XFILLER_255_181 VPWR VGND VPWR VGND sky130_ef_sc_hd__decap_12
XFILLER_249_1245 VPWR VGND VPWR VGND sky130_ef_sc_hd__decap_12
XFILLER_216_557 VPWR VGND VPWR VGND sky130_ef_sc_hd__decap_12
XFILLER_249_1289 VPWR VGND VPWR VGND sky130_ef_sc_hd__decap_12
XTAP_TAPCELL_ROW_141_2_4600 VGND VPWR sky130_fd_sc_hd__tapvpwrvgnd_1
XFILLER_231_505 VPWR VGND VPWR VGND sky130_ef_sc_hd__decap_12
XFILLER_102_53 VPWR VGND VPWR VGND sky130_ef_sc_hd__decap_12
XFILLER_110_1191 VPWR VGND VPWR VGND sky130_ef_sc_hd__decap_12
XPHY_EDGE_ROW_58_1_Left_313 VGND VGND VPWR VPWR sky130_fd_sc_hd__decap_3
XFILLER_19_1213 VGND VGND VPWR VPWR sky130_fd_sc_hd__decap_4
XFILLER_197_921 VPWR VGND VPWR VGND sky130_ef_sc_hd__decap_12
XFILLER_58_1295 VGND VGND VPWR VPWR sky130_fd_sc_hd__decap_6
XFILLER_145_1243 VPWR VGND VPWR VGND sky130_ef_sc_hd__decap_12
XFILLER_197_965 VPWR VGND VPWR VGND sky130_ef_sc_hd__decap_12
XPHY_EDGE_ROW_110_1_Left_365 VGND VGND VPWR VPWR sky130_fd_sc_hd__decap_3
XFILLER_168_133 VGND VGND VPWR VPWR sky130_fd_sc_hd__decap_6
XFILLER_106_1227 VPWR VGND VPWR VGND sky130_ef_sc_hd__decap_12
XFILLER_200_925 VPWR VGND VPWR VGND sky130_ef_sc_hd__decap_12
XFILLER_145_1287 VPWR VGND VPWR VGND sky130_ef_sc_hd__decap_12
XFILLER_196_475 VGND VGND VPWR VPWR sky130_fd_sc_hd__fill_1
XFILLER_211_273 VGND VGND VPWR VPWR sky130_fd_sc_hd__decap_6
XFILLER_134_3 VPWR VGND VPWR VGND sky130_ef_sc_hd__decap_12
XFILLER_32_1413 VGND VGND VPWR VPWR sky130_fd_sc_hd__fill_1
XFILLER_168_177 VPWR VGND VPWR VGND sky130_ef_sc_hd__decap_12
Xwire225 net226 VGND VGND VPWR VPWR net225 sky130_fd_sc_hd__clkbuf_1
XFILLER_184_637 VGND VGND VPWR VPWR sky130_fd_sc_hd__decap_6
Xwire236 net237 VGND VGND VPWR VPWR net236 sky130_fd_sc_hd__clkbuf_1
XFILLER_183_125 VPWR VGND VPWR VGND sky130_ef_sc_hd__decap_12
Xwire247 _154_ VGND VGND VPWR VPWR net247 sky130_fd_sc_hd__clkbuf_1
Xwire258 net259 VGND VGND VPWR VPWR net258 sky130_fd_sc_hd__clkbuf_1
XFILLER_221_1175 VGND VGND VPWR VPWR sky130_fd_sc_hd__fill_1
Xwire269 net270 VGND VGND VPWR VPWR net269 sky130_fd_sc_hd__clkbuf_1
XFILLER_183_169 VPWR VGND VPWR VGND sky130_ef_sc_hd__decap_12
XFILLER_192_681 VPWR VGND VPWR VGND sky130_ef_sc_hd__decap_12
XFILLER_178_1085 VGND VGND VPWR VPWR sky130_fd_sc_hd__decap_6
XFILLER_3_533 VGND VGND VPWR VPWR sky130_fd_sc_hd__fill_2
XTAP_TAPCELL_ROW_57_2_4094 VGND VPWR sky130_fd_sc_hd__tapvpwrvgnd_1
XFILLER_3_555 VGND VGND VPWR VPWR sky130_fd_sc_hd__fill_1
XFILLER_65_1255 VPWR VGND VPWR VGND sky130_ef_sc_hd__decap_12
XFILLER_117_1323 VGND VGND VPWR VPWR sky130_fd_sc_hd__decap_6
XFILLER_152_1203 VPWR VGND VPWR VGND sky130_ef_sc_hd__decap_12
XFILLER_156_1383 VPWR VGND VPWR VGND sky130_ef_sc_hd__decap_12
XTAP_TAPCELL_ROW_189_1985 VGND VPWR sky130_fd_sc_hd__tapvpwrvgnd_1
XFILLER_26_1239 VGND VGND VPWR VPWR sky130_fd_sc_hd__decap_6
XTAP_TAPCELL_ROW_189_1996 VGND VPWR sky130_fd_sc_hd__tapvpwrvgnd_1
XFILLER_65_1299 VPWR VGND VPWR VGND sky130_ef_sc_hd__decap_12
XFILLER_117_1367 VPWR VGND VPWR VGND sky130_ef_sc_hd__decap_12
XFILLER_152_1247 VPWR VGND VPWR VGND sky130_ef_sc_hd__decap_12
XPHY_EDGE_ROW_90_2_Left_592 VGND VGND VPWR VPWR sky130_fd_sc_hd__decap_3
XFILLER_247_671 VGND VGND VPWR VPWR sky130_fd_sc_hd__fill_1
XFILLER_4_1035 VGND VGND VPWR VPWR sky130_fd_sc_hd__fill_1
XFILLER_219_373 VPWR VGND VPWR VGND sky130_ef_sc_hd__decap_12
XFILLER_235_833 VGND VGND VPWR VPWR sky130_fd_sc_hd__decap_6
XFILLER_185_1001 VGND VGND VPWR VPWR sky130_fd_sc_hd__decap_6
XFILLER_234_321 VPWR VGND VPWR VGND sky130_ef_sc_hd__decap_12
XTAP_TAPCELL_ROW_35_2_3964 VGND VPWR sky130_fd_sc_hd__tapvpwrvgnd_1
XFILLER_235_877 VPWR VGND VPWR VGND sky130_ef_sc_hd__decap_12
XFILLER_234_365 VPWR VGND VPWR VGND sky130_ef_sc_hd__decap_12
XFILLER_185_1045 VPWR VGND VPWR VGND sky130_ef_sc_hd__decap_12
XFILLER_228_1329 VPWR VGND VPWR VGND sky130_ef_sc_hd__decap_12
XFILLER_250_825 VPWR VGND VPWR VGND sky130_ef_sc_hd__decap_12
XFILLER_76_1351 VGND VGND VPWR VPWR sky130_fd_sc_hd__decap_6
XFILLER_185_1089 VPWR VGND VPWR VGND sky130_ef_sc_hd__decap_12
XFILLER_250_869 VPWR VGND VPWR VGND sky130_ef_sc_hd__decap_12
XPHY_EDGE_ROW_42_1_Left_297 VGND VGND VPWR VPWR sky130_fd_sc_hd__decap_3
XFILLER_72_1215 VPWR VGND VPWR VGND sky130_ef_sc_hd__decap_12
XFILLER_203_741 VPWR VGND VPWR VGND sky130_ef_sc_hd__decap_12
XFILLER_76_1395 VPWR VGND VPWR VGND sky130_ef_sc_hd__decap_12
XFILLER_163_1343 VPWR VGND VPWR VGND sky130_ef_sc_hd__decap_12
XFILLER_128_1463 VGND VGND VPWR VPWR sky130_fd_sc_hd__decap_6
XFILLER_202_251 VGND VGND VPWR VPWR sky130_fd_sc_hd__fill_1
XFILLER_37_1379 VGND VGND VPWR VPWR sky130_fd_sc_hd__decap_6
XFILLER_72_1259 VPWR VGND VPWR VGND sky130_ef_sc_hd__decap_12
XFILLER_124_1327 VPWR VGND VPWR VGND sky130_ef_sc_hd__decap_12
XFILLER_203_785 VPWR VGND VPWR VGND sky130_ef_sc_hd__decap_12
XFILLER_163_1387 VPWR VGND VPWR VGND sky130_ef_sc_hd__decap_12
XFILLER_175_615 VGND VGND VPWR VPWR sky130_fd_sc_hd__fill_1
X_319_ _097_ net176 VGND VGND VPWR VPWR _108_ sky130_fd_sc_hd__nor2_1
XFILLER_187_497 VGND VGND VPWR VPWR sky130_fd_sc_hd__decap_6
XFILLER_238_27 VGND VGND VPWR VPWR sky130_fd_sc_hd__fill_1
Xinput11 wr_data[10] VGND VGND VPWR VPWR net11 sky130_fd_sc_hd__clkbuf_1
Xinput22 wr_data[20] VGND VGND VPWR VPWR net22 sky130_fd_sc_hd__clkbuf_1
XFILLER_204_1373 VPWR VGND VPWR VGND sky130_ef_sc_hd__decap_12
Xinput33 wr_data[30] VGND VGND VPWR VPWR net33 sky130_fd_sc_hd__clkbuf_1
XFILLER_239_1425 VPWR VGND VPWR VGND sky130_ef_sc_hd__decap_12
XFILLER_196_1141 VGND VGND VPWR VPWR sky130_fd_sc_hd__decap_6
Xmax_cap514 net515 VGND VGND VPWR VPWR net514 sky130_fd_sc_hd__clkbuf_1
XFILLER_171_821 VPWR VGND VPWR VGND sky130_ef_sc_hd__decap_12
XFILLER_200_1259 VGND VGND VPWR VPWR sky130_fd_sc_hd__fill_1
Xmax_cap525 net66 VGND VGND VPWR VPWR net525 sky130_fd_sc_hd__clkbuf_1
Xmax_cap536 net53 VGND VGND VPWR VPWR net536 sky130_fd_sc_hd__clkbuf_1
Xmax_cap547 net548 VGND VGND VPWR VPWR net547 sky130_fd_sc_hd__clkbuf_1
XFILLER_192_1005 VPWR VGND VPWR VGND sky130_ef_sc_hd__decap_12
XFILLER_239_1469 VPWR VGND VPWR VGND sky130_ef_sc_hd__decap_12
XFILLER_196_1185 VPWR VGND VPWR VGND sky130_ef_sc_hd__decap_12
XFILLER_254_15 VPWR VGND VPWR VGND sky130_ef_sc_hd__decap_12
XFILLER_171_865 VPWR VGND VPWR VGND sky130_ef_sc_hd__decap_12
Xmax_cap569 net43 VGND VGND VPWR VPWR net569 sky130_fd_sc_hd__clkbuf_1
XFILLER_83_1311 VPWR VGND VPWR VGND sky130_ef_sc_hd__decap_12
XFILLER_100_1371 VPWR VGND VPWR VGND sky130_ef_sc_hd__decap_12
XFILLER_87_1491 VGND VGND VPWR VPWR sky130_fd_sc_hd__decap_6
XFILLER_192_1049 VPWR VGND VPWR VGND sky130_ef_sc_hd__decap_12
XFILLER_83_1355 VPWR VGND VPWR VGND sky130_ef_sc_hd__decap_12
XFILLER_135_1423 VPWR VGND VPWR VGND sky130_ef_sc_hd__decap_12
XFILLER_174_1483 VGND VGND VPWR VPWR sky130_fd_sc_hd__fill_1
XFILLER_44_1339 VPWR VGND VPWR VGND sky130_ef_sc_hd__decap_12
XFILLER_233_1057 VGND VGND VPWR VPWR sky130_fd_sc_hd__decap_6
XFILLER_83_1399 VPWR VGND VPWR VGND sky130_ef_sc_hd__decap_12
XFILLER_135_1467 VPWR VGND VPWR VGND sky130_ef_sc_hd__decap_12
XFILLER_229_137 VPWR VGND VPWR VGND sky130_ef_sc_hd__decap_12
XFILLER_250_1371 VGND VGND VPWR VPWR sky130_fd_sc_hd__fill_1
XFILLER_226_811 VGND VGND VPWR VPWR sky130_fd_sc_hd__fill_1
XFILLER_238_693 VGND VGND VPWR VPWR sky130_fd_sc_hd__decap_6
XFILLER_237_181 VPWR VGND VPWR VGND sky130_ef_sc_hd__decap_12
XTAP_TAPCELL_ROW_207_2480 VGND VPWR sky130_fd_sc_hd__tapvpwrvgnd_1
XFILLER_253_641 VPWR VGND VPWR VGND sky130_ef_sc_hd__decap_12
XTAP_TAPCELL_ROW_126_2_4513 VGND VPWR sky130_fd_sc_hd__tapvpwrvgnd_1
XFILLER_211_1399 VGND VGND VPWR VPWR sky130_fd_sc_hd__fill_1
XTAP_TAPCELL_ROW_203_2355 VGND VPWR sky130_fd_sc_hd__tapvpwrvgnd_1
XFILLER_246_1429 VPWR VGND VPWR VGND sky130_ef_sc_hd__decap_12
XFILLER_213_505 VPWR VGND VPWR VGND sky130_ef_sc_hd__decap_12
XFILLER_253_685 VPWR VGND VPWR VGND sky130_ef_sc_hd__decap_12
XTAP_TAPCELL_ROW_203_2366 VGND VPWR sky130_fd_sc_hd__tapvpwrvgnd_1
XFILLER_20_1383 VPWR VGND VPWR VGND sky130_ef_sc_hd__decap_12
XTAP_TAPCELL_ROW_203_2377 VGND VPWR sky130_fd_sc_hd__tapvpwrvgnd_1
XFILLER_94_1451 VPWR VGND VPWR VGND sky130_ef_sc_hd__decap_12
XTAP_TAPCELL_ROW_199_2270 VGND VPWR sky130_fd_sc_hd__tapvpwrvgnd_1
XFILLER_179_921 VPWR VGND VPWR VGND sky130_ef_sc_hd__decap_12
XFILLER_197_217 VGND VGND VPWR VPWR sky130_fd_sc_hd__decap_6
XFILLER_252_195 VGND VGND VPWR VPWR sky130_fd_sc_hd__fill_1
XFILLER_240_357 VGND VGND VPWR VPWR sky130_fd_sc_hd__decap_6
XFILLER_55_1435 VGND VGND VPWR VPWR sky130_fd_sc_hd__decap_6
XFILLER_90_1315 VPWR VGND VPWR VGND sky130_ef_sc_hd__decap_12
XTAP_TAPCELL_ROW_195_2145 VGND VPWR sky130_fd_sc_hd__tapvpwrvgnd_1
XFILLER_94_1495 VPWR VGND VPWR VGND sky130_ef_sc_hd__decap_12
XTAP_TAPCELL_ROW_195_2156 VGND VPWR sky130_fd_sc_hd__tapvpwrvgnd_1
XFILLER_179_965 VPWR VGND VPWR VGND sky130_ef_sc_hd__decap_12
XFILLER_240_1017 VPWR VGND VPWR VGND sky130_ef_sc_hd__decap_12
XFILLER_55_1479 VPWR VGND VPWR VGND sky130_ef_sc_hd__decap_12
XFILLER_90_1359 VPWR VGND VPWR VGND sky130_ef_sc_hd__decap_12
XFILLER_142_1427 VPWR VGND VPWR VGND sky130_ef_sc_hd__decap_12
XFILLER_244_1197 VGND VGND VPWR VPWR sky130_fd_sc_hd__decap_6
XFILLER_32_27 VGND VGND VPWR VPWR sky130_fd_sc_hd__fill_1
XFILLER_178_475 VGND VGND VPWR VPWR sky130_fd_sc_hd__fill_1
XTAP_TAPCELL_ROW_216_2705 VGND VPWR sky130_fd_sc_hd__tapvpwrvgnd_1
XTAP_TAPCELL_ROW_216_2716 VGND VPWR sky130_fd_sc_hd__tapvpwrvgnd_1
XFILLER_166_637 VGND VGND VPWR VPWR sky130_fd_sc_hd__decap_6
XTAP_TAPCELL_ROW_216_2727 VGND VPWR sky130_fd_sc_hd__tapvpwrvgnd_1
XFILLER_32_49 VGND VGND VPWR VPWR sky130_fd_sc_hd__fill_1
XTAP_TAPCELL_ROW_74_2_4200 VGND VPWR sky130_fd_sc_hd__tapvpwrvgnd_1
XFILLER_148_27 VGND VGND VPWR VPWR sky130_fd_sc_hd__fill_1
XFILLER_165_125 VPWR VGND VPWR VGND sky130_ef_sc_hd__decap_12
XFILLER_194_979 VGND VGND VPWR VPWR sky130_fd_sc_hd__fill_1
XFILLER_14_1165 VPWR VGND VPWR VGND sky130_ef_sc_hd__decap_12
XFILLER_165_169 VPWR VGND VPWR VGND sky130_ef_sc_hd__decap_12
XFILLER_181_629 VPWR VGND VPWR VGND sky130_ef_sc_hd__decap_12
XFILLER_174_681 VPWR VGND VPWR VGND sky130_ef_sc_hd__decap_12
XFILLER_49_1217 VGND VGND VPWR VPWR sky130_fd_sc_hd__fill_1
XFILLER_180_139 VGND VGND VPWR VPWR sky130_fd_sc_hd__fill_1
XFILLER_175_1225 VGND VGND VPWR VPWR sky130_fd_sc_hd__decap_6
XFILLER_218_1509 VGND VGND VPWR VPWR sky130_fd_sc_hd__decap_6
XFILLER_164_15 VPWR VGND VPWR VGND sky130_ef_sc_hd__decap_12
XFILLER_175_1269 VPWR VGND VPWR VGND sky130_ef_sc_hd__decap_12
XFILLER_251_1113 VGND VGND VPWR VPWR sky130_fd_sc_hd__decap_6
XFILLER_248_413 VGND VGND VPWR VPWR sky130_fd_sc_hd__decap_6
XFILLER_251_1157 VPWR VGND VPWR VGND sky130_ef_sc_hd__decap_12
XFILLER_62_1439 VPWR VGND VPWR VGND sky130_ef_sc_hd__decap_12
XFILLER_114_1507 VGND VGND VPWR VPWR sky130_fd_sc_hd__decap_8
XFILLER_248_457 VPWR VGND VPWR VGND sky130_ef_sc_hd__decap_12
XFILLER_169_1007 VGND VGND VPWR VPWR sky130_fd_sc_hd__fill_1
XTAP_TAPCELL_ROW_184_1860 VGND VPWR sky130_fd_sc_hd__tapvpwrvgnd_1
XFILLER_229_671 VGND VGND VPWR VPWR sky130_fd_sc_hd__fill_1
XTAP_TAPCELL_ROW_21_2_3883 VGND VPWR sky130_fd_sc_hd__tapvpwrvgnd_1
XFILLER_217_833 VGND VGND VPWR VPWR sky130_fd_sc_hd__decap_6
XFILLER_216_321 VPWR VGND VPWR VGND sky130_ef_sc_hd__decap_12
XTAP_TAPCELL_ROW_180_1735 VGND VPWR sky130_fd_sc_hd__tapvpwrvgnd_1
XFILLER_5_1399 VGND VGND VPWR VPWR sky130_fd_sc_hd__fill_1
XTAP_TAPCELL_ROW_180_1746 VGND VPWR sky130_fd_sc_hd__tapvpwrvgnd_1
XTAP_TAPCELL_ROW_180_1757 VGND VPWR sky130_fd_sc_hd__tapvpwrvgnd_1
XFILLER_217_877 VPWR VGND VPWR VGND sky130_ef_sc_hd__decap_12
XFILLER_216_365 VPWR VGND VPWR VGND sky130_ef_sc_hd__decap_12
XFILLER_186_1365 VGND VGND VPWR VPWR sky130_fd_sc_hd__decap_6
XFILLER_232_825 VPWR VGND VPWR VGND sky130_ef_sc_hd__decap_12
XFILLER_251_3 VPWR VGND VPWR VGND sky130_ef_sc_hd__decap_12
XFILLER_189_729 VPWR VGND VPWR VGND sky130_ef_sc_hd__decap_12
XFILLER_182_1229 VPWR VGND VPWR VGND sky130_ef_sc_hd__decap_12
XFILLER_231_335 VGND VGND VPWR VPWR sky130_fd_sc_hd__fill_1
Xwire90 _234_ VGND VGND VPWR VPWR net90 sky130_fd_sc_hd__clkbuf_1
XFILLER_232_869 VPWR VGND VPWR VGND sky130_ef_sc_hd__decap_12
XFILLER_184_401 VPWR VGND VPWR VGND sky130_ef_sc_hd__decap_12
XTAP_TAPCELL_ROW_178_1686 VGND VPWR sky130_fd_sc_hd__tapvpwrvgnd_1
XFILLER_169_497 VGND VGND VPWR VPWR sky130_fd_sc_hd__decap_6
XFILLER_200_755 VGND VGND VPWR VPWR sky130_fd_sc_hd__fill_1
XTAP_TAPCELL_ROW_178_1697 VGND VPWR sky130_fd_sc_hd__tapvpwrvgnd_1
XFILLER_7_113 VPWR VGND VPWR VGND sky130_ef_sc_hd__decap_12
XTAP_TAPCELL_ROW_139_2_4591 VGND VPWR sky130_fd_sc_hd__tapvpwrvgnd_1
XFILLER_184_445 VPWR VGND VPWR VGND sky130_ef_sc_hd__decap_12
XFILLER_201_1513 VGND VGND VPWR VPWR sky130_fd_sc_hd__fill_2
XFILLER_8_669 VPWR VGND VPWR VGND sky130_ef_sc_hd__decap_12
XFILLER_184_489 VPWR VGND VPWR VGND sky130_ef_sc_hd__decap_12
XFILLER_4_820 VGND VGND VPWR VPWR sky130_fd_sc_hd__fill_2
XTAP_TAPCELL_ROW_152_2_4669 VGND VPWR sky130_fd_sc_hd__tapvpwrvgnd_1
XFILLER_4_831 VPWR VGND VPWR VGND sky130_ef_sc_hd__decap_12
XFILLER_193_1325 VPWR VGND VPWR VGND sky130_ef_sc_hd__decap_12
XFILLER_98_53 VPWR VGND VPWR VGND sky130_ef_sc_hd__decap_12
XFILLER_193_1369 VPWR VGND VPWR VGND sky130_ef_sc_hd__decap_12
XPHY_EDGE_ROW_5_Left_261 VGND VGND VPWR VPWR sky130_fd_sc_hd__decap_3
XTAP_TAPCELL_ROW_121_1_1256 VGND VPWR sky130_fd_sc_hd__tapvpwrvgnd_1
XTAP_TAPCELL_ROW_132_2_4545 VGND VPWR sky130_fd_sc_hd__tapvpwrvgnd_1
XFILLER_156_1191 VPWR VGND VPWR VGND sky130_ef_sc_hd__decap_12
XFILLER_224_29 VPWR VGND VPWR VGND sky130_ef_sc_hd__decap_12
XFILLER_208_811 VGND VGND VPWR VPWR sky130_fd_sc_hd__fill_1
XFILLER_78_1413 VGND VGND VPWR VPWR sky130_fd_sc_hd__fill_1
XFILLER_219_181 VPWR VGND VPWR VGND sky130_ef_sc_hd__decap_12
XFILLER_235_641 VPWR VGND VPWR VGND sky130_ef_sc_hd__decap_12
XFILLER_235_685 VPWR VGND VPWR VGND sky130_ef_sc_hd__decap_12
XTAP_TAPCELL_ROW_80_2_4232 VGND VPWR sky130_fd_sc_hd__tapvpwrvgnd_1
XTAP_TAPCELL_ROW_79_2_4226 VGND VPWR sky130_fd_sc_hd__tapvpwrvgnd_1
XFILLER_179_217 VGND VGND VPWR VPWR sky130_fd_sc_hd__decap_6
XFILLER_234_195 VGND VGND VPWR VPWR sky130_fd_sc_hd__fill_1
XFILLER_222_357 VGND VGND VPWR VPWR sky130_fd_sc_hd__decap_6
XFILLER_249_15 VPWR VGND VPWR VGND sky130_ef_sc_hd__decap_12
XFILLER_97_3 VPWR VGND VPWR VGND sky130_ef_sc_hd__decap_12
XFILLER_250_699 VGND VGND VPWR VPWR sky130_fd_sc_hd__fill_1
XFILLER_128_1271 VPWR VGND VPWR VGND sky130_ef_sc_hd__decap_12
XFILLER_37_1165 VPWR VGND VPWR VGND sky130_ef_sc_hd__decap_12
XFILLER_194_209 VPWR VGND VPWR VGND sky130_ef_sc_hd__decap_12
XFILLER_241_1337 VGND VGND VPWR VPWR sky130_fd_sc_hd__decap_6
XFILLER_187_261 VPWR VGND VPWR VGND sky130_ef_sc_hd__decap_12
XFILLER_198_1203 VGND VGND VPWR VPWR sky130_fd_sc_hd__fill_1
XTAP_TAPCELL_ROW_190_2020 VGND VPWR sky130_fd_sc_hd__tapvpwrvgnd_1
XFILLER_15_1441 VGND VGND VPWR VPWR sky130_fd_sc_hd__fill_1
XFILLER_176_979 VGND VGND VPWR VPWR sky130_fd_sc_hd__fill_1
XFILLER_239_1233 VPWR VGND VPWR VGND sky130_ef_sc_hd__decap_12
Xmax_cap333 _137_ VGND VGND VPWR VPWR net333 sky130_fd_sc_hd__clkbuf_1
XFILLER_235_1119 VGND VGND VPWR VPWR sky130_fd_sc_hd__fill_1
XFILLER_171_673 VPWR VGND VPWR VGND sky130_ef_sc_hd__decap_12
XFILLER_172_1409 VPWR VGND VPWR VGND sky130_ef_sc_hd__decap_12
XFILLER_48_1283 VPWR VGND VPWR VGND sky130_ef_sc_hd__decap_12
XFILLER_135_1231 VPWR VGND VPWR VGND sky130_ef_sc_hd__decap_12
XFILLER_134_29 VPWR VGND VPWR VGND sky130_ef_sc_hd__decap_12
XTAP_TAPCELL_ROW_209_2520 VGND VPWR sky130_fd_sc_hd__tapvpwrvgnd_1
XFILLER_252_1477 VGND VGND VPWR VPWR sky130_fd_sc_hd__decap_6
XTAP_TAPCELL_ROW_209_2531 VGND VPWR sky130_fd_sc_hd__tapvpwrvgnd_1
XFILLER_135_1275 VPWR VGND VPWR VGND sky130_ef_sc_hd__decap_12
XFILLER_246_917 VGND VGND VPWR VPWR sky130_fd_sc_hd__decap_6
XFILLER_245_405 VPWR VGND VPWR VGND sky130_ef_sc_hd__decap_12
XTAP_TAPCELL_ROW_205_2417 VGND VPWR sky130_fd_sc_hd__tapvpwrvgnd_1
XFILLER_27_27 VPWR VGND VPWR VGND sky130_ef_sc_hd__decap_12
XTAP_TAPCELL_ROW_205_2428 VGND VPWR sky130_fd_sc_hd__tapvpwrvgnd_1
XFILLER_245_449 VPWR VGND VPWR VGND sky130_ef_sc_hd__decap_12
XPHY_EDGE_ROW_214_Right_59 VGND VGND VPWR VPWR sky130_fd_sc_hd__decap_3
XFILLER_254_961 VPWR VGND VPWR VGND sky130_ef_sc_hd__decap_12
XTAP_TAPCELL_ROW_197_2207 VGND VPWR sky130_fd_sc_hd__tapvpwrvgnd_1
XFILLER_183_1505 VGND VGND VPWR VPWR sky130_fd_sc_hd__decap_6
XTAP_TAPCELL_ROW_1_878 VGND VPWR sky130_fd_sc_hd__tapvpwrvgnd_1
XFILLER_214_825 VPWR VGND VPWR VGND sky130_ef_sc_hd__decap_12
XTAP_TAPCELL_ROW_1_889 VGND VPWR sky130_fd_sc_hd__tapvpwrvgnd_1
XFILLER_168_1073 VPWR VGND VPWR VGND sky130_ef_sc_hd__decap_12
XFILLER_246_1259 VGND VGND VPWR VPWR sky130_fd_sc_hd__fill_1
XFILLER_240_121 VPWR VGND VPWR VGND sky130_ef_sc_hd__decap_12
XFILLER_20_1191 VPWR VGND VPWR VGND sky130_ef_sc_hd__decap_12
XFILLER_213_335 VGND VGND VPWR VPWR sky130_fd_sc_hd__fill_1
XFILLER_43_15 VPWR VGND VPWR VGND sky130_ef_sc_hd__decap_12
XFILLER_214_869 VPWR VGND VPWR VGND sky130_ef_sc_hd__decap_12
XFILLER_0_1285 VGND VGND VPWR VPWR sky130_fd_sc_hd__decap_3
XFILLER_230_83 VGND VGND VPWR VPWR sky130_fd_sc_hd__fill_1
XFILLER_240_165 VPWR VGND VPWR VGND sky130_ef_sc_hd__decap_12
XFILLER_55_1243 VPWR VGND VPWR VGND sky130_ef_sc_hd__decap_12
XFILLER_107_1311 VPWR VGND VPWR VGND sky130_ef_sc_hd__decap_12
XFILLER_159_15 VPWR VGND VPWR VGND sky130_ef_sc_hd__decap_12
XFILLER_146_1371 VPWR VGND VPWR VGND sky130_ef_sc_hd__decap_12
XFILLER_16_1227 VPWR VGND VPWR VGND sky130_ef_sc_hd__decap_12
XFILLER_166_401 VPWR VGND VPWR VGND sky130_ef_sc_hd__decap_12
XFILLER_55_1287 VPWR VGND VPWR VGND sky130_ef_sc_hd__decap_12
XFILLER_107_1355 VPWR VGND VPWR VGND sky130_ef_sc_hd__decap_12
XFILLER_90_1189 VGND VGND VPWR VPWR sky130_fd_sc_hd__fill_1
XFILLER_103_1219 VPWR VGND VPWR VGND sky130_ef_sc_hd__decap_12
XFILLER_166_445 VPWR VGND VPWR VGND sky130_ef_sc_hd__decap_12
XFILLER_182_905 VPWR VGND VPWR VGND sky130_ef_sc_hd__decap_12
XFILLER_107_1399 VPWR VGND VPWR VGND sky130_ef_sc_hd__decap_12
XFILLER_239_81 VPWR VGND VPWR VGND sky130_ef_sc_hd__decap_12
XPHY_EDGE_ROW_223_Right_68 VGND VGND VPWR VPWR sky130_fd_sc_hd__decap_3
XFILLER_166_489 VPWR VGND VPWR VGND sky130_ef_sc_hd__decap_12
XTAP_TAPCELL_ROW_173_1550 VGND VPWR sky130_fd_sc_hd__tapvpwrvgnd_1
XTAP_TAPCELL_ROW_173_1561 VGND VPWR sky130_fd_sc_hd__tapvpwrvgnd_1
XFILLER_182_949 VPWR VGND VPWR VGND sky130_ef_sc_hd__decap_12
XFILLER_5_639 VPWR VGND VPWR VGND sky130_ef_sc_hd__decap_12
XFILLER_175_69 VPWR VGND VPWR VGND sky130_ef_sc_hd__decap_12
XFILLER_175_1033 VPWR VGND VPWR VGND sky130_ef_sc_hd__decap_12
XFILLER_218_1317 VPWR VGND VPWR VGND sky130_ef_sc_hd__decap_12
XFILLER_108_41 VPWR VGND VPWR VGND sky130_ef_sc_hd__decap_12
XFILLER_190_993 VPWR VGND VPWR VGND sky130_ef_sc_hd__decap_12
XFILLER_190_1509 VGND VGND VPWR VPWR sky130_fd_sc_hd__decap_6
XTAP_TAPCELL_ROW_117_2_4458 VGND VPWR sky130_fd_sc_hd__tapvpwrvgnd_1
XFILLER_175_1077 VPWR VGND VPWR VGND sky130_ef_sc_hd__decap_12
XFILLER_62_1203 VPWR VGND VPWR VGND sky130_ef_sc_hd__decap_12
XTAP_TAPCELL_ROW_186_1900 VGND VPWR sky130_fd_sc_hd__tapvpwrvgnd_1
XFILLER_27_1323 VGND VGND VPWR VPWR sky130_fd_sc_hd__decap_6
XTAP_TAPCELL_ROW_186_1911 VGND VPWR sky130_fd_sc_hd__tapvpwrvgnd_1
XFILLER_66_1383 VPWR VGND VPWR VGND sky130_ef_sc_hd__decap_12
XFILLER_118_1451 VPWR VGND VPWR VGND sky130_ef_sc_hd__decap_12
XFILLER_153_1331 VPWR VGND VPWR VGND sky130_ef_sc_hd__decap_12
XFILLER_248_221 VPWR VGND VPWR VGND sky130_ef_sc_hd__decap_12
XFILLER_62_1247 VPWR VGND VPWR VGND sky130_ef_sc_hd__decap_12
XFILLER_27_1367 VPWR VGND VPWR VGND sky130_ef_sc_hd__decap_12
XFILLER_114_1315 VPWR VGND VPWR VGND sky130_ef_sc_hd__decap_12
XFILLER_191_57 VPWR VGND VPWR VGND sky130_ef_sc_hd__decap_12
XFILLER_216_1085 VGND VGND VPWR VPWR sky130_fd_sc_hd__decap_6
XFILLER_249_777 VGND VGND VPWR VPWR sky130_fd_sc_hd__decap_6
XFILLER_118_1495 VPWR VGND VPWR VGND sky130_ef_sc_hd__decap_12
XTAP_TAPCELL_ROW_182_1808 VGND VPWR sky130_fd_sc_hd__tapvpwrvgnd_1
XFILLER_248_265 VPWR VGND VPWR VGND sky130_ef_sc_hd__decap_12
XFILLER_114_1359 VPWR VGND VPWR VGND sky130_ef_sc_hd__decap_12
XPHY_EDGE_ROW_232_Right_77 VGND VGND VPWR VPWR sky130_fd_sc_hd__decap_3
XTAP_TAPCELL_ROW_167_1387 VGND VPWR sky130_fd_sc_hd__tapvpwrvgnd_1
XFILLER_188_1427 VGND VGND VPWR VPWR sky130_fd_sc_hd__fill_1
XTAP_TAPCELL_ROW_167_1398 VGND VPWR sky130_fd_sc_hd__tapvpwrvgnd_1
X_653_ clknet_3_7__leaf_clk acc_core.adder.cla_blocks\[4\].block.sum\[3\] _061_ VGND
+ VGND VPWR VPWR net53 sky130_fd_sc_hd__dfrtp_1
XFILLER_217_641 VPWR VGND VPWR VGND sky130_ef_sc_hd__decap_12
XTAP_TAPCELL_ROW_65_2_4145 VGND VPWR sky130_fd_sc_hd__tapvpwrvgnd_1
XFILLER_229_1413 VPWR VGND VPWR VGND sky130_ef_sc_hd__decap_12
XFILLER_217_685 VPWR VGND VPWR VGND sky130_ef_sc_hd__decap_12
X_584_ net669 VGND VGND VPWR VPWR _066_ sky130_fd_sc_hd__inv_2
XFILLER_229_1457 VPWR VGND VPWR VGND sky130_ef_sc_hd__decap_12
XPHY_EDGE_ROW_121_2_Left_623 VGND VGND VPWR VPWR sky130_fd_sc_hd__decap_3
XFILLER_186_1173 VPWR VGND VPWR VGND sky130_ef_sc_hd__decap_12
XFILLER_216_195 VGND VGND VPWR VPWR sky130_fd_sc_hd__fill_1
XFILLER_182_1037 VPWR VGND VPWR VGND sky130_ef_sc_hd__decap_12
XFILLER_204_357 VGND VGND VPWR VPWR sky130_fd_sc_hd__decap_6
XFILLER_189_559 VGND VGND VPWR VPWR sky130_fd_sc_hd__fill_1
XFILLER_223_1001 VGND VGND VPWR VPWR sky130_fd_sc_hd__decap_6
XFILLER_38_1463 VGND VGND VPWR VPWR sky130_fd_sc_hd__decap_6
XFILLER_73_1343 VPWR VGND VPWR VGND sky130_ef_sc_hd__decap_12
XFILLER_125_1411 VPWR VGND VPWR VGND sky130_ef_sc_hd__decap_12
XFILLER_232_699 VGND VGND VPWR VPWR sky130_fd_sc_hd__fill_1
XFILLER_164_1471 VPWR VGND VPWR VGND sky130_ef_sc_hd__decap_12
XFILLER_176_209 VPWR VGND VPWR VGND sky130_ef_sc_hd__decap_12
XFILLER_34_1327 VPWR VGND VPWR VGND sky130_ef_sc_hd__decap_12
XFILLER_169_261 VPWR VGND VPWR VGND sky130_ef_sc_hd__decap_12
XFILLER_73_1387 VPWR VGND VPWR VGND sky130_ef_sc_hd__decap_12
XFILLER_185_721 VGND VGND VPWR VPWR sky130_fd_sc_hd__decap_6
XFILLER_223_1045 VPWR VGND VPWR VGND sky130_ef_sc_hd__decap_12
XFILLER_125_1455 VPWR VGND VPWR VGND sky130_ef_sc_hd__decap_12
XPHY_EDGE_ROW_241_Right_86 VGND VGND VPWR VPWR sky130_fd_sc_hd__decap_3
XFILLER_160_1357 VGND VGND VPWR VPWR sky130_fd_sc_hd__fill_1
XTAP_TAPCELL_ROW_251_3650 VGND VPWR sky130_fd_sc_hd__tapvpwrvgnd_1
XFILLER_185_765 VPWR VGND VPWR VGND sky130_ef_sc_hd__decap_12
XTAP_TAPCELL_ROW_251_3661 VGND VPWR sky130_fd_sc_hd__tapvpwrvgnd_1
XFILLER_125_1499 VPWR VGND VPWR VGND sky130_ef_sc_hd__decap_12
XFILLER_223_1089 VPWR VGND VPWR VGND sky130_ef_sc_hd__decap_12
XTAP_TAPCELL_ROW_251_3672 VGND VPWR sky130_fd_sc_hd__tapvpwrvgnd_1
XFILLER_184_253 VPWR VGND VPWR VGND sky130_ef_sc_hd__decap_12
XFILLER_201_1343 VGND VGND VPWR VPWR sky130_fd_sc_hd__fill_1
XFILLER_193_1133 VPWR VGND VPWR VGND sky130_ef_sc_hd__decap_12
XFILLER_10_1371 VPWR VGND VPWR VGND sky130_ef_sc_hd__decap_12
XFILLER_235_39 VPWR VGND VPWR VGND sky130_ef_sc_hd__decap_12
XFILLER_4_694 VGND VGND VPWR VPWR sky130_fd_sc_hd__fill_2
XFILLER_193_1177 VPWR VGND VPWR VGND sky130_ef_sc_hd__decap_12
XFILLER_45_1423 VPWR VGND VPWR VGND sky130_ef_sc_hd__decap_12
XFILLER_80_1303 VPWR VGND VPWR VGND sky130_ef_sc_hd__decap_12
XFILLER_234_1141 VGND VGND VPWR VPWR sky130_fd_sc_hd__decap_6
XFILLER_84_1483 VPWR VGND VPWR VGND sky130_ef_sc_hd__decap_12
XPHY_EDGE_ROW_250_Right_95 VGND VGND VPWR VPWR sky130_fd_sc_hd__decap_3
XFILLER_45_1467 VPWR VGND VPWR VGND sky130_ef_sc_hd__decap_12
XFILLER_132_1415 VPWR VGND VPWR VGND sky130_ef_sc_hd__decap_12
XFILLER_230_1005 VPWR VGND VPWR VGND sky130_ef_sc_hd__decap_12
XFILLER_234_1185 VPWR VGND VPWR VGND sky130_ef_sc_hd__decap_12
XFILLER_228_917 VGND VGND VPWR VPWR sky130_fd_sc_hd__decap_6
XTAP_TAPCELL_ROW_245_3487 VGND VPWR sky130_fd_sc_hd__tapvpwrvgnd_1
XTAP_TAPCELL_ROW_245_3498 VGND VPWR sky130_fd_sc_hd__tapvpwrvgnd_1
XFILLER_227_405 VPWR VGND VPWR VGND sky130_ef_sc_hd__decap_12
XFILLER_255_725 VGND VGND VPWR VPWR sky130_fd_sc_hd__decap_3
XFILLER_251_27 VPWR VGND VPWR VGND sky130_ef_sc_hd__decap_12
XFILLER_230_1049 VPWR VGND VPWR VGND sky130_ef_sc_hd__decap_12
XFILLER_12_3 VGND VGND VPWR VPWR sky130_fd_sc_hd__decap_8
XFILLER_227_449 VPWR VGND VPWR VGND sky130_ef_sc_hd__decap_12
XFILLER_255_769 VPWR VGND VPWR VGND sky130_ef_sc_hd__decap_12
XFILLER_243_909 VPWR VGND VPWR VGND sky130_ef_sc_hd__decap_12
XFILLER_212_1483 VGND VGND VPWR VPWR sky130_fd_sc_hd__fill_1
XFILLER_236_961 VPWR VGND VPWR VGND sky130_ef_sc_hd__decap_12
XFILLER_247_1513 VGND VGND VPWR VPWR sky130_fd_sc_hd__fill_2
XFILLER_242_419 VGND VGND VPWR VPWR sky130_fd_sc_hd__fill_1
XPHY_EDGE_ROW_53_2_Left_555 VGND VGND VPWR VPWR sky130_fd_sc_hd__decap_3
XFILLER_39_1216 VGND VGND VPWR VPWR sky130_fd_sc_hd__fill_2
XFILLER_251_953 VPWR VGND VPWR VGND sky130_ef_sc_hd__decap_12
XFILLER_169_1393 VGND VGND VPWR VPWR sky130_fd_sc_hd__decap_6
XFILLER_222_121 VPWR VGND VPWR VGND sky130_ef_sc_hd__decap_12
XFILLER_165_1257 VGND VGND VPWR VPWR sky130_fd_sc_hd__decap_3
XFILLER_241_1101 VPWR VGND VPWR VGND sky130_ef_sc_hd__decap_12
XFILLER_91_1443 VPWR VGND VPWR VGND sky130_ef_sc_hd__decap_12
XFILLER_211_839 VGND VGND VPWR VPWR sky130_fd_sc_hd__fill_1
XFILLER_222_165 VPWR VGND VPWR VGND sky130_ef_sc_hd__decap_12
XFILLER_245_1281 VGND VGND VPWR VPWR sky130_fd_sc_hd__decap_6
XFILLER_143_1511 VGND VGND VPWR VPWR sky130_fd_sc_hd__decap_4
XFILLER_195_529 VPWR VGND VPWR VGND sky130_ef_sc_hd__decap_12
XFILLER_200_53 VPWR VGND VPWR VGND sky130_ef_sc_hd__decap_12
XPHY_EDGE_ROW_154_1_Right_810 VGND VGND VPWR VPWR sky130_fd_sc_hd__decap_3
XFILLER_52_1427 VPWR VGND VPWR VGND sky130_ef_sc_hd__decap_12
XFILLER_188_581 VGND VGND VPWR VPWR sky130_fd_sc_hd__decap_6
XFILLER_241_1145 VPWR VGND VPWR VGND sky130_ef_sc_hd__decap_12
XFILLER_200_97 VPWR VGND VPWR VGND sky130_ef_sc_hd__decap_12
XFILLER_202_1129 VPWR VGND VPWR VGND sky130_ef_sc_hd__decap_12
XFILLER_241_1189 VPWR VGND VPWR VGND sky130_ef_sc_hd__decap_12
XFILLER_209_51 VGND VGND VPWR VPWR sky130_fd_sc_hd__decap_4
XFILLER_190_245 VGND VGND VPWR VPWR sky130_fd_sc_hd__decap_6
Xmax_cap130 net131 VGND VGND VPWR VPWR net130 sky130_fd_sc_hd__clkbuf_1
Xmax_cap141 _227_ VGND VGND VPWR VPWR net141 sky130_fd_sc_hd__clkbuf_1
XFILLER_239_1063 VGND VGND VPWR VPWR sky130_fd_sc_hd__fill_1
XFILLER_176_1353 VPWR VGND VPWR VGND sky130_ef_sc_hd__decap_12
Xmax_cap152 _175_ VGND VGND VPWR VPWR net152 sky130_fd_sc_hd__clkbuf_1
XFILLER_172_993 VPWR VGND VPWR VGND sky130_ef_sc_hd__decap_12
XFILLER_190_289 VPWR VGND VPWR VGND sky130_ef_sc_hd__decap_12
Xmax_cap174 _114_ VGND VGND VPWR VPWR net174 sky130_fd_sc_hd__clkbuf_1
XFILLER_145_39 VPWR VGND VPWR VGND sky130_ef_sc_hd__decap_12
XFILLER_172_1217 VPWR VGND VPWR VGND sky130_ef_sc_hd__decap_12
Xmax_cap196 _213_ VGND VGND VPWR VPWR net196 sky130_fd_sc_hd__clkbuf_1
XFILLER_176_1397 VPWR VGND VPWR VGND sky130_ef_sc_hd__decap_12
XFILLER_252_1241 VPWR VGND VPWR VGND sky130_ef_sc_hd__decap_12
XPHY_EDGE_ROW_67_1_Left_322 VGND VGND VPWR VPWR sky130_fd_sc_hd__decap_3
XFILLER_38_15 VPWR VGND VPWR VGND sky130_ef_sc_hd__decap_12
XFILLER_24_1507 VGND VGND VPWR VPWR sky130_fd_sc_hd__decap_8
XFILLER_213_1225 VGND VGND VPWR VPWR sky130_fd_sc_hd__decap_6
XFILLER_252_1285 VPWR VGND VPWR VGND sky130_ef_sc_hd__decap_12
XFILLER_246_725 VPWR VGND VPWR VGND sky130_ef_sc_hd__decap_12
XFILLER_161_27 VPWR VGND VPWR VGND sky130_ef_sc_hd__decap_12
XFILLER_213_1269 VPWR VGND VPWR VGND sky130_ef_sc_hd__decap_12
XFILLER_246_769 VPWR VGND VPWR VGND sky130_ef_sc_hd__decap_12
XFILLER_6_1483 VGND VGND VPWR VPWR sky130_fd_sc_hd__fill_1
XFILLER_245_279 VGND VGND VPWR VPWR sky130_fd_sc_hd__fill_1
XFILLER_241_93 VPWR VGND VPWR VGND sky130_ef_sc_hd__decap_12
XFILLER_183_1313 VPWR VGND VPWR VGND sky130_ef_sc_hd__decap_12
XFILLER_198_301 VGND VGND VPWR VPWR sky130_fd_sc_hd__decap_6
XFILLER_187_1493 VPWR VGND VPWR VGND sky130_ef_sc_hd__decap_12
XFILLER_241_441 VGND VGND VPWR VPWR sky130_fd_sc_hd__decap_6
XFILLER_207_1007 VGND VGND VPWR VPWR sky130_fd_sc_hd__fill_1
XFILLER_183_1357 VPWR VGND VPWR VGND sky130_ef_sc_hd__decap_12
XFILLER_198_345 VPWR VGND VPWR VGND sky130_ef_sc_hd__decap_12
XFILLER_0_1093 VPWR VGND VPWR VGND sky130_ef_sc_hd__decap_12
XFILLER_201_305 VPWR VGND VPWR VGND sky130_ef_sc_hd__decap_12
XFILLER_241_485 VPWR VGND VPWR VGND sky130_ef_sc_hd__decap_12
XFILLER_214_699 VGND VGND VPWR VPWR sky130_fd_sc_hd__fill_1
XFILLER_110_53 VPWR VGND VPWR VGND sky130_ef_sc_hd__decap_12
XFILLER_198_389 VPWR VGND VPWR VGND sky130_ef_sc_hd__decap_12
XFILLER_167_721 VGND VGND VPWR VPWR sky130_fd_sc_hd__decap_6
XTAP_TAPCELL_ROW_175_1601 VGND VPWR sky130_fd_sc_hd__tapvpwrvgnd_1
XTAP_TAPCELL_ROW_175_1612 VGND VPWR sky130_fd_sc_hd__tapvpwrvgnd_1
XFILLER_201_349 VPWR VGND VPWR VGND sky130_ef_sc_hd__decap_12
XTAP_TAPCELL_ROW_175_1623 VGND VPWR sky130_fd_sc_hd__tapvpwrvgnd_1
XFILLER_224_1365 VGND VGND VPWR VPWR sky130_fd_sc_hd__decap_6
XFILLER_210_861 VGND VGND VPWR VPWR sky130_fd_sc_hd__decap_6
XFILLER_167_765 VPWR VGND VPWR VGND sky130_ef_sc_hd__decap_12
XFILLER_220_1229 VPWR VGND VPWR VGND sky130_ef_sc_hd__decap_12
XFILLER_166_253 VPWR VGND VPWR VGND sky130_ef_sc_hd__decap_12
XTAP_TAPCELL_ROW_171_1509 VGND VPWR sky130_fd_sc_hd__tapvpwrvgnd_1
XFILLER_182_713 VPWR VGND VPWR VGND sky130_ef_sc_hd__decap_12
XFILLER_6_937 VPWR VGND VPWR VGND sky130_ef_sc_hd__decap_12
XFILLER_214_3 VPWR VGND VPWR VGND sky130_ef_sc_hd__decap_12
XFILLER_181_223 VGND VGND VPWR VPWR sky130_fd_sc_hd__fill_1
XFILLER_119_51 VGND VGND VPWR VPWR sky130_fd_sc_hd__decap_4
XFILLER_182_757 VPWR VGND VPWR VGND sky130_ef_sc_hd__decap_12
XFILLER_194_1453 VPWR VGND VPWR VGND sky130_ef_sc_hd__decap_12
XFILLER_79_55 VGND VGND VPWR VPWR sky130_fd_sc_hd__fill_1
XFILLER_218_1147 VGND VGND VPWR VPWR sky130_fd_sc_hd__fill_1
XFILLER_190_1317 VPWR VGND VPWR VGND sky130_ef_sc_hd__decap_12
XFILLER_194_1497 VPWR VGND VPWR VGND sky130_ef_sc_hd__decap_12
XTAP_TAPCELL_ROW_169_1438 VGND VPWR sky130_fd_sc_hd__tapvpwrvgnd_1
XTAP_TAPCELL_ROW_169_1449 VGND VPWR sky130_fd_sc_hd__tapvpwrvgnd_1
XFILLER_249_541 VPWR VGND VPWR VGND sky130_ef_sc_hd__decap_12
XFILLER_66_1191 VPWR VGND VPWR VGND sky130_ef_sc_hd__decap_12
XFILLER_0_141 VPWR VGND VPWR VGND sky130_ef_sc_hd__decap_12
XFILLER_7_1225 VGND VGND VPWR VPWR sky130_fd_sc_hd__decap_6
XFILLER_231_1325 VPWR VGND VPWR VGND sky130_ef_sc_hd__decap_12
XFILLER_209_405 VPWR VGND VPWR VGND sky130_ef_sc_hd__decap_12
XFILLER_249_585 VPWR VGND VPWR VGND sky130_ef_sc_hd__decap_12
XFILLER_7_1269 VPWR VGND VPWR VGND sky130_ef_sc_hd__decap_12
XFILLER_231_1369 VPWR VGND VPWR VGND sky130_ef_sc_hd__decap_12
XFILLER_209_449 VPWR VGND VPWR VGND sky130_ef_sc_hd__decap_12
XTAP_TAPCELL_ROW_5_992 VGND VPWR sky130_fd_sc_hd__tapvpwrvgnd_1
XFILLER_225_909 VPWR VGND VPWR VGND sky130_ef_sc_hd__decap_12
XFILLER_114_1189 VGND VGND VPWR VPWR sky130_fd_sc_hd__fill_1
XFILLER_218_961 VPWR VGND VPWR VGND sky130_ef_sc_hd__decap_12
XTAP_TAPCELL_ROW_240_3362 VGND VPWR sky130_fd_sc_hd__tapvpwrvgnd_1
XTAP_TAPCELL_ROW_240_3373 VGND VPWR sky130_fd_sc_hd__tapvpwrvgnd_1
XFILLER_149_1219 VPWR VGND VPWR VGND sky130_ef_sc_hd__decap_12
XFILLER_224_419 VGND VGND VPWR VPWR sky130_fd_sc_hd__fill_1
XFILLER_251_205 VPWR VGND VPWR VGND sky130_ef_sc_hd__decap_12
XTAP_TAPCELL_ROW_116_1_1251 VGND VPWR sky130_fd_sc_hd__tapvpwrvgnd_1
X_636_ clknet_3_3__leaf_clk acc_core.adder.cla_blocks\[0\].block.sum\[2\] _044_ VGND
+ VGND VPWR VPWR net65 sky130_fd_sc_hd__dfrtp_1
XFILLER_251_249 VPWR VGND VPWR VGND sky130_ef_sc_hd__decap_12
XFILLER_233_953 VPWR VGND VPWR VGND sky130_ef_sc_hd__decap_12
XFILLER_204_121 VPWR VGND VPWR VGND sky130_ef_sc_hd__decap_12
X_567_ net665 VGND VGND VPWR VPWR _049_ sky130_fd_sc_hd__inv_2
XFILLER_229_1287 VGND VGND VPWR VPWR sky130_fd_sc_hd__fill_1
XFILLER_204_165 VPWR VGND VPWR VGND sky130_ef_sc_hd__decap_12
XTAP_TAPCELL_ROW_253_3712 VGND VPWR sky130_fd_sc_hd__tapvpwrvgnd_1
XFILLER_220_625 VPWR VGND VPWR VGND sky130_ef_sc_hd__decap_12
XTAP_TAPCELL_ROW_253_3723 VGND VPWR sky130_fd_sc_hd__tapvpwrvgnd_1
XFILLER_242_1421 VGND VGND VPWR VPWR sky130_fd_sc_hd__decap_6
XFILLER_38_1271 VPWR VGND VPWR VGND sky130_ef_sc_hd__decap_12
X_498_ net142 net84 VGND VGND VPWR VPWR acc_core.adder.cla_blocks\[5\].block.sum\[1\]
+ sky130_fd_sc_hd__xor2_1
XFILLER_177_529 VPWR VGND VPWR VGND sky130_ef_sc_hd__decap_12
XFILLER_220_669 VPWR VGND VPWR VGND sky130_ef_sc_hd__decap_12
XFILLER_242_1465 VPWR VGND VPWR VGND sky130_ef_sc_hd__decap_12
XFILLER_9_753 VGND VGND VPWR VPWR sky130_fd_sc_hd__decap_3
XFILLER_203_1449 VGND VGND VPWR VPWR sky130_fd_sc_hd__decap_6
XFILLER_160_1165 VPWR VGND VPWR VGND sky130_ef_sc_hd__decap_12
XFILLER_185_573 VPWR VGND VPWR VGND sky130_ef_sc_hd__decap_12
XTAP_TAPCELL_ROW_234_3199 VGND VPWR sky130_fd_sc_hd__tapvpwrvgnd_1
XFILLER_9_797 VPWR VGND VPWR VGND sky130_ef_sc_hd__decap_12
XPHY_EDGE_ROW_229_Left_484 VGND VGND VPWR VPWR sky130_fd_sc_hd__decap_3
XFILLER_8_285 VGND VGND VPWR VPWR sky130_fd_sc_hd__fill_2
XFILLER_246_27 VGND VGND VPWR VPWR sky130_fd_sc_hd__fill_1
XFILLER_172_245 VGND VGND VPWR VPWR sky130_fd_sc_hd__decap_6
XFILLER_236_1203 VGND VGND VPWR VPWR sky130_fd_sc_hd__fill_1
XFILLER_5_30 VPWR VGND VPWR VGND sky130_ef_sc_hd__decap_12
XFILLER_172_289 VPWR VGND VPWR VGND sky130_ef_sc_hd__decap_12
XTAP_TAPCELL_ROW_247_3549 VGND VPWR sky130_fd_sc_hd__tapvpwrvgnd_1
XFILLER_45_1231 VPWR VGND VPWR VGND sky130_ef_sc_hd__decap_12
XFILLER_45_1275 VPWR VGND VPWR VGND sky130_ef_sc_hd__decap_12
XFILLER_228_725 VPWR VGND VPWR VGND sky130_ef_sc_hd__decap_12
XFILLER_80_1177 VPWR VGND VPWR VGND sky130_ef_sc_hd__decap_12
XFILLER_132_1245 VGND VGND VPWR VPWR sky130_fd_sc_hd__fill_1
XFILLER_210_1409 VPWR VGND VPWR VGND sky130_ef_sc_hd__decap_12
XFILLER_255_533 VPWR VGND VPWR VGND sky130_ef_sc_hd__decap_12
XPHY_EDGE_ROW_238_Left_493 VGND VGND VPWR VPWR sky130_fd_sc_hd__decap_3
XFILLER_228_769 VPWR VGND VPWR VGND sky130_ef_sc_hd__decap_12
XFILLER_227_279 VGND VGND VPWR VPWR sky130_fd_sc_hd__fill_1
XFILLER_247_1343 VGND VGND VPWR VPWR sky130_fd_sc_hd__fill_1
XFILLER_165_1021 VPWR VGND VPWR VGND sky130_ef_sc_hd__decap_12
XFILLER_223_441 VGND VGND VPWR VPWR sky130_fd_sc_hd__decap_6
XFILLER_196_805 VGND VGND VPWR VPWR sky130_fd_sc_hd__decap_6
XFILLER_251_783 VGND VGND VPWR VPWR sky130_fd_sc_hd__fill_1
XFILLER_165_1065 VGND VGND VPWR VPWR sky130_fd_sc_hd__decap_8
XFILLER_223_485 VPWR VGND VPWR VGND sky130_ef_sc_hd__decap_12
XFILLER_17_1311 VPWR VGND VPWR VGND sky130_ef_sc_hd__decap_12
XFILLER_56_1371 VPWR VGND VPWR VGND sky130_ef_sc_hd__decap_12
XFILLER_196_849 VPWR VGND VPWR VGND sky130_ef_sc_hd__decap_12
XTAP_TAPCELL_ROW_14_2_3836 VGND VPWR sky130_fd_sc_hd__tapvpwrvgnd_1
XFILLER_195_337 VPWR VGND VPWR VGND sky130_ef_sc_hd__decap_12
XFILLER_221_1505 VGND VGND VPWR VPWR sky130_fd_sc_hd__decap_6
XFILLER_91_1273 VGND VGND VPWR VPWR sky130_fd_sc_hd__fill_1
XFILLER_17_1355 VPWR VGND VPWR VGND sky130_ef_sc_hd__decap_12
XFILLER_104_1303 VPWR VGND VPWR VGND sky130_ef_sc_hd__decap_12
XPHY_EDGE_ROW_155_1_Right_811 VGND VGND VPWR VPWR sky130_fd_sc_hd__decap_3
XFILLER_108_1483 VPWR VGND VPWR VGND sky130_ef_sc_hd__decap_12
XFILLER_206_1073 VPWR VGND VPWR VGND sky130_ef_sc_hd__decap_12
XFILLER_13_1219 VPWR VGND VPWR VGND sky130_ef_sc_hd__decap_12
XFILLER_143_1385 VGND VGND VPWR VPWR sky130_fd_sc_hd__fill_1
XFILLER_17_1399 VPWR VGND VPWR VGND sky130_ef_sc_hd__decap_12
XFILLER_40_27 VGND VGND VPWR VPWR sky130_fd_sc_hd__fill_1
XTAP_TAPCELL_ROW_153_2_4674 VGND VPWR sky130_fd_sc_hd__tapvpwrvgnd_1
XFILLER_156_27 VGND VGND VPWR VPWR sky130_fd_sc_hd__fill_1
XFILLER_219_1401 VPWR VGND VPWR VGND sky130_ef_sc_hd__decap_12
XFILLER_176_1161 VPWR VGND VPWR VGND sky130_ef_sc_hd__decap_12
XTAP_TAPCELL_ROW_133_2_4550 VGND VPWR sky130_fd_sc_hd__tapvpwrvgnd_1
XFILLER_172_15 VPWR VGND VPWR VGND sky130_ef_sc_hd__decap_12
XFILLER_63_1331 VPWR VGND VPWR VGND sky130_ef_sc_hd__decap_12
XFILLER_28_1451 VPWR VGND VPWR VGND sky130_ef_sc_hd__decap_12
XFILLER_137_1189 VPWR VGND VPWR VGND sky130_ef_sc_hd__decap_12
XFILLER_150_1301 VGND VGND VPWR VPWR sky130_fd_sc_hd__fill_1
XFILLER_24_1315 VPWR VGND VPWR VGND sky130_ef_sc_hd__decap_12
XFILLER_28_1495 VPWR VGND VPWR VGND sky130_ef_sc_hd__decap_12
XFILLER_115_1443 VPWR VGND VPWR VGND sky130_ef_sc_hd__decap_12
XFILLER_213_1033 VPWR VGND VPWR VGND sky130_ef_sc_hd__decap_12
XFILLER_252_1093 VPWR VGND VPWR VGND sky130_ef_sc_hd__decap_12
XFILLER_4_1409 VPWR VGND VPWR VGND sky130_ef_sc_hd__decap_12
XFILLER_189_1511 VGND VGND VPWR VPWR sky130_fd_sc_hd__fill_1
XFILLER_246_533 VPWR VGND VPWR VGND sky130_ef_sc_hd__decap_12
XFILLER_24_1359 VPWR VGND VPWR VGND sky130_ef_sc_hd__decap_12
XFILLER_213_1077 VPWR VGND VPWR VGND sky130_ef_sc_hd__decap_12
XFILLER_98_1427 VPWR VGND VPWR VGND sky130_ef_sc_hd__decap_12
XFILLER_207_909 VPWR VGND VPWR VGND sky130_ef_sc_hd__decap_12
XFILLER_111_1329 VGND VGND VPWR VPWR sky130_fd_sc_hd__fill_1
XFILLER_65_57 VPWR VGND VPWR VGND sky130_ef_sc_hd__decap_12
XFILLER_206_419 VGND VGND VPWR VPWR sky130_fd_sc_hd__fill_1
XFILLER_233_205 VPWR VGND VPWR VGND sky130_ef_sc_hd__decap_12
XFILLER_248_1129 VPWR VGND VPWR VGND sky130_ef_sc_hd__decap_12
XFILLER_164_3 VPWR VGND VPWR VGND sky130_ef_sc_hd__decap_12
XFILLER_233_249 VPWR VGND VPWR VGND sky130_ef_sc_hd__decap_12
X_421_ net105 net119 net170 net126 VGND VGND VPWR VPWR _210_ sky130_fd_sc_hd__a211o_1
XFILLER_215_953 VPWR VGND VPWR VGND sky130_ef_sc_hd__decap_12
XFILLER_183_1121 VPWR VGND VPWR VGND sky130_ef_sc_hd__decap_12
XFILLER_226_1427 VGND VGND VPWR VPWR sky130_fd_sc_hd__fill_1
XFILLER_199_665 VGND VGND VPWR VPWR sky130_fd_sc_hd__decap_6
XFILLER_230_923 VGND VGND VPWR VPWR sky130_fd_sc_hd__fill_1
X_352_ net331 VGND VGND VPWR VPWR _141_ sky130_fd_sc_hd__inv_2
XFILLER_198_153 VPWR VGND VPWR VGND sky130_ef_sc_hd__decap_12
XFILLER_202_625 VPWR VGND VPWR VGND sky130_ef_sc_hd__decap_12
XFILLER_201_113 VPWR VGND VPWR VGND sky130_ef_sc_hd__decap_12
XFILLER_35_1411 VPWR VGND VPWR VGND sky130_ef_sc_hd__decap_12
XFILLER_241_293 VPWR VGND VPWR VGND sky130_ef_sc_hd__decap_12
XFILLER_74_1471 VPWR VGND VPWR VGND sky130_ef_sc_hd__decap_12
XFILLER_198_197 VPWR VGND VPWR VGND sky130_ef_sc_hd__decap_12
XFILLER_202_669 VPWR VGND VPWR VGND sky130_ef_sc_hd__decap_12
X_283_ net623 VGND VGND VPWR VPWR web0 sky130_fd_sc_hd__inv_2
XFILLER_161_1441 VGND VGND VPWR VPWR sky130_fd_sc_hd__fill_1
XFILLER_35_1455 VPWR VGND VPWR VGND sky130_ef_sc_hd__decap_12
XFILLER_224_1173 VPWR VGND VPWR VGND sky130_ef_sc_hd__decap_12
XFILLER_70_1357 VGND VGND VPWR VPWR sky130_fd_sc_hd__fill_1
XFILLER_6_701 VGND VGND VPWR VPWR sky130_fd_sc_hd__decap_6
XFILLER_167_573 VPWR VGND VPWR VGND sky130_ef_sc_hd__decap_12
XFILLER_220_1037 VPWR VGND VPWR VGND sky130_ef_sc_hd__decap_12
XFILLER_35_1499 VPWR VGND VPWR VGND sky130_ef_sc_hd__decap_12
XFILLER_122_1469 VGND VGND VPWR VPWR sky130_fd_sc_hd__fill_1
XFILLER_5_211 VGND VGND VPWR VPWR sky130_fd_sc_hd__fill_2
XFILLER_5_222 VGND VGND VPWR VPWR sky130_fd_sc_hd__fill_2
XFILLER_5_266 VPWR VGND VPWR VGND sky130_ef_sc_hd__decap_12
XFILLER_182_587 VGND VGND VPWR VPWR sky130_fd_sc_hd__fill_1
XFILLER_170_749 VGND VGND VPWR VPWR sky130_fd_sc_hd__decap_6
XFILLER_194_1261 VPWR VGND VPWR VGND sky130_ef_sc_hd__decap_12
XFILLER_2_973 VGND VGND VPWR VPWR sky130_fd_sc_hd__decap_6
XFILLER_155_1267 VGND VGND VPWR VPWR sky130_fd_sc_hd__decap_6
XFILLER_190_1147 VGND VGND VPWR VPWR sky130_fd_sc_hd__fill_1
XTAP_TAPCELL_ROW_242_3413 VGND VPWR sky130_fd_sc_hd__tapvpwrvgnd_1
XFILLER_42_1415 VPWR VGND VPWR VGND sky130_ef_sc_hd__decap_12
XTAP_TAPCELL_ROW_242_3424 VGND VPWR sky130_fd_sc_hd__tapvpwrvgnd_1
XFILLER_7_1033 VPWR VGND VPWR VGND sky130_ef_sc_hd__decap_12
XFILLER_231_1133 VPWR VGND VPWR VGND sky130_ef_sc_hd__decap_12
XFILLER_81_1497 VGND VGND VPWR VPWR sky130_fd_sc_hd__fill_1
XFILLER_249_393 VPWR VGND VPWR VGND sky130_ef_sc_hd__decap_12
XFILLER_232_29 VPWR VGND VPWR VGND sky130_ef_sc_hd__decap_12
XFILLER_7_1077 VPWR VGND VPWR VGND sky130_ef_sc_hd__decap_12
XFILLER_231_1177 VPWR VGND VPWR VGND sky130_ef_sc_hd__decap_12
Xinput9 wr_addr[7] VGND VGND VPWR VPWR net9 sky130_fd_sc_hd__clkbuf_1
XTAP_TAPCELL_ROW_8_1072 VGND VPWR sky130_fd_sc_hd__tapvpwrvgnd_1
XTAP_TAPCELL_ROW_8_1083 VGND VPWR sky130_fd_sc_hd__tapvpwrvgnd_1
XFILLER_209_279 VGND VGND VPWR VPWR sky130_fd_sc_hd__fill_1
XFILLER_252_525 VGND VGND VPWR VPWR sky130_fd_sc_hd__decap_6
XFILLER_75_1213 VGND VGND VPWR VPWR sky130_fd_sc_hd__decap_4
XFILLER_252_569 VPWR VGND VPWR VGND sky130_ef_sc_hd__decap_12
XFILLER_205_441 VGND VGND VPWR VPWR sky130_fd_sc_hd__decap_6
XTAP_TAPCELL_ROW_255_3807 VGND VPWR sky130_fd_sc_hd__tapvpwrvgnd_1
X_619_ clknet_3_7__leaf_clk dout0\[17\] _027_ VGND VGND VPWR VPWR dout0_q\[17\] sky130_fd_sc_hd__dfrtp_1
XFILLER_166_1341 VPWR VGND VPWR VGND sky130_ef_sc_hd__decap_12
XFILLER_178_805 VGND VGND VPWR VPWR sky130_fd_sc_hd__decap_6
XFILLER_233_783 VGND VGND VPWR VPWR sky130_fd_sc_hd__fill_1
XFILLER_205_485 VPWR VGND VPWR VGND sky130_ef_sc_hd__decap_12
XFILLER_166_1385 VPWR VGND VPWR VGND sky130_ef_sc_hd__decap_12
XFILLER_221_945 VGND VGND VPWR VPWR sky130_fd_sc_hd__decap_6
XFILLER_162_1227 VPWR VGND VPWR VGND sky130_ef_sc_hd__decap_12
XFILLER_53_1511 VGND VGND VPWR VPWR sky130_fd_sc_hd__decap_4
XFILLER_178_849 VPWR VGND VPWR VGND sky130_ef_sc_hd__decap_12
XFILLER_220_433 VPWR VGND VPWR VGND sky130_ef_sc_hd__decap_12
XFILLER_177_337 VPWR VGND VPWR VGND sky130_ef_sc_hd__decap_12
XFILLER_221_989 VPWR VGND VPWR VGND sky130_ef_sc_hd__decap_12
XFILLER_203_1213 VPWR VGND VPWR VGND sky130_ef_sc_hd__decap_12
XFILLER_220_477 VPWR VGND VPWR VGND sky130_ef_sc_hd__decap_12
XFILLER_242_1273 VPWR VGND VPWR VGND sky130_ef_sc_hd__decap_12
XFILLER_207_1393 VGND VGND VPWR VPWR sky130_fd_sc_hd__decap_6
XFILLER_192_307 VGND VGND VPWR VPWR sky130_fd_sc_hd__fill_1
XFILLER_9_561 VGND VGND VPWR VPWR sky130_fd_sc_hd__fill_1
XFILLER_186_893 VPWR VGND VPWR VGND sky130_ef_sc_hd__decap_12
XFILLER_203_1257 VPWR VGND VPWR VGND sky130_ef_sc_hd__decap_12
XFILLER_238_1309 VGND VGND VPWR VPWR sky130_fd_sc_hd__decap_6
XFILLER_173_1301 VPWR VGND VPWR VGND sky130_ef_sc_hd__decap_12
XTAP_TAPCELL_ROW_118_2_4463 VGND VPWR sky130_fd_sc_hd__tapvpwrvgnd_1
XFILLER_177_1481 VPWR VGND VPWR VGND sky130_ef_sc_hd__decap_12
XFILLER_173_1345 VPWR VGND VPWR VGND sky130_ef_sc_hd__decap_12
XFILLER_82_1239 VGND VGND VPWR VPWR sky130_fd_sc_hd__decap_6
XFILLER_206_41 VPWR VGND VPWR VGND sky130_ef_sc_hd__decap_12
XPHY_EDGE_ROW_246_Left_501 VGND VGND VPWR VPWR sky130_fd_sc_hd__decap_3
XFILLER_206_85 VPWR VGND VPWR VGND sky130_ef_sc_hd__decap_12
XFILLER_214_1353 VPWR VGND VPWR VGND sky130_ef_sc_hd__decap_12
XFILLER_19_39 VPWR VGND VPWR VGND sky130_ef_sc_hd__decap_12
XFILLER_142_29 VPWR VGND VPWR VGND sky130_ef_sc_hd__decap_12
XFILLER_228_533 VPWR VGND VPWR VGND sky130_ef_sc_hd__decap_12
XFILLER_210_1217 VPWR VGND VPWR VGND sky130_ef_sc_hd__decap_12
XFILLER_214_1397 VPWR VGND VPWR VGND sky130_ef_sc_hd__decap_12
XTAP_TAPCELL_ROW_225_2954 VGND VPWR sky130_fd_sc_hd__tapvpwrvgnd_1
XTAP_TAPCELL_ROW_225_2965 VGND VPWR sky130_fd_sc_hd__tapvpwrvgnd_1
XFILLER_243_503 VGND VGND VPWR VPWR sky130_fd_sc_hd__fill_1
XTAP_TAPCELL_ROW_23_1_1158 VGND VPWR sky130_fd_sc_hd__tapvpwrvgnd_1
XFILLER_215_205 VPWR VGND VPWR VGND sky130_ef_sc_hd__decap_12
XFILLER_249_1449 VGND VGND VPWR VPWR sky130_fd_sc_hd__decap_6
XTAP_TAPCELL_ROW_66_2_4150 VGND VPWR sky130_fd_sc_hd__tapvpwrvgnd_1
XFILLER_110_1351 VGND VGND VPWR VPWR sky130_fd_sc_hd__decap_6
XFILLER_35_27 VPWR VGND VPWR VGND sky130_ef_sc_hd__decap_12
XFILLER_215_249 VPWR VGND VPWR VGND sky130_ef_sc_hd__decap_12
XFILLER_231_709 VPWR VGND VPWR VGND sky130_ef_sc_hd__decap_12
XFILLER_110_1395 VPWR VGND VPWR VGND sky130_ef_sc_hd__decap_12
XFILLER_184_1441 VPWR VGND VPWR VGND sky130_ef_sc_hd__decap_12
XFILLER_212_923 VGND VGND VPWR VPWR sky130_fd_sc_hd__fill_1
XFILLER_184_1485 VPWR VGND VPWR VGND sky130_ef_sc_hd__decap_12
XFILLER_196_613 VPWR VGND VPWR VGND sky130_ef_sc_hd__decap_12
XFILLER_93_1379 VGND VGND VPWR VPWR sky130_fd_sc_hd__decap_6
XPHY_EDGE_ROW_16_2_Left_518 VGND VGND VPWR VPWR sky130_fd_sc_hd__decap_3
XFILLER_223_293 VPWR VGND VPWR VGND sky130_ef_sc_hd__decap_12
XPHY_EDGE_ROW_255_Left_510 VGND VGND VPWR VPWR sky130_fd_sc_hd__decap_3
XFILLER_51_15 VPWR VGND VPWR VGND sky130_ef_sc_hd__decap_12
XFILLER_196_657 VPWR VGND VPWR VGND sky130_ef_sc_hd__decap_12
XFILLER_221_1313 VPWR VGND VPWR VGND sky130_ef_sc_hd__decap_12
Xwire407 net408 VGND VGND VPWR VPWR net407 sky130_fd_sc_hd__clkbuf_1
Xwire418 net419 VGND VGND VPWR VPWR net418 sky130_fd_sc_hd__clkbuf_1
XFILLER_167_15 VPWR VGND VPWR VGND sky130_ef_sc_hd__decap_12
XFILLER_195_167 VGND VGND VPWR VPWR sky130_fd_sc_hd__fill_1
XFILLER_225_1493 VPWR VGND VPWR VGND sky130_ef_sc_hd__decap_12
Xwire429 net430 VGND VGND VPWR VPWR net429 sky130_fd_sc_hd__clkbuf_1
XPHY_EDGE_ROW_156_1_Right_812 VGND VGND VPWR VPWR sky130_fd_sc_hd__decap_3
XFILLER_183_329 VGND VGND VPWR VPWR sky130_fd_sc_hd__decap_6
XFILLER_221_1357 VPWR VGND VPWR VGND sky130_ef_sc_hd__decap_12
XPHY_EDGE_ROW_99_2_Right_190 VGND VGND VPWR VPWR sky130_fd_sc_hd__decap_3
XFILLER_104_1177 VPWR VGND VPWR VGND sky130_ef_sc_hd__decap_12
XFILLER_3_704 VGND VGND VPWR VPWR sky130_fd_sc_hd__fill_1
XFILLER_247_81 VPWR VGND VPWR VGND sky130_ef_sc_hd__decap_12
XFILLER_121_1491 VGND VGND VPWR VPWR sky130_fd_sc_hd__decap_6
XFILLER_191_373 VPWR VGND VPWR VGND sky130_ef_sc_hd__decap_12
XFILLER_3_737 VGND VGND VPWR VPWR sky130_fd_sc_hd__fill_2
XFILLER_191_1401 VPWR VGND VPWR VGND sky130_ef_sc_hd__decap_12
XFILLER_219_1231 VGND VGND VPWR VPWR sky130_fd_sc_hd__fill_1
XPHY_EDGE_ROW_130_2_Left_632 VGND VGND VPWR VPWR sky130_fd_sc_hd__decap_3
XFILLER_152_1407 VGND VGND VPWR VPWR sky130_fd_sc_hd__decap_6
XFILLER_183_69 VPWR VGND VPWR VGND sky130_ef_sc_hd__decap_12
XFILLER_239_809 VPWR VGND VPWR VGND sky130_ef_sc_hd__decap_12
XFILLER_116_41 VPWR VGND VPWR VGND sky130_ef_sc_hd__decap_12
XPHY_EDGE_ROW_173_Right_18 VGND VGND VPWR VPWR sky130_fd_sc_hd__decap_3
XFILLER_8_1353 VPWR VGND VPWR VGND sky130_ef_sc_hd__decap_12
XFILLER_232_1453 VPWR VGND VPWR VGND sky130_ef_sc_hd__decap_12
XFILLER_247_853 VPWR VGND VPWR VGND sky130_ef_sc_hd__decap_12
XFILLER_4_1217 VPWR VGND VPWR VGND sky130_ef_sc_hd__decap_12
Xfanout595 net597 VGND VGND VPWR VPWR net595 sky130_fd_sc_hd__clkbuf_2
XFILLER_115_1273 VGND VGND VPWR VPWR sky130_fd_sc_hd__fill_1
XFILLER_8_1397 VPWR VGND VPWR VGND sky130_ef_sc_hd__decap_12
XFILLER_232_1497 VPWR VGND VPWR VGND sky130_ef_sc_hd__decap_12
XFILLER_246_363 VGND VGND VPWR VPWR sky130_fd_sc_hd__fill_1
XFILLER_247_897 VPWR VGND VPWR VGND sky130_ef_sc_hd__decap_12
XFILLER_24_1189 VGND VGND VPWR VPWR sky130_fd_sc_hd__fill_1
XFILLER_234_525 VGND VGND VPWR VPWR sky130_fd_sc_hd__decap_6
XFILLER_59_1219 VPWR VGND VPWR VGND sky130_ef_sc_hd__decap_12
XFILLER_234_569 VPWR VGND VPWR VGND sky130_ef_sc_hd__decap_12
XFILLER_215_783 VGND VGND VPWR VPWR sky130_fd_sc_hd__fill_1
X_404_ net590 net588 net567 VGND VGND VPWR VPWR _193_ sky130_fd_sc_hd__a21o_1
XFILLER_199_473 VPWR VGND VPWR VGND sky130_ef_sc_hd__decap_12
XFILLER_203_945 VGND VGND VPWR VPWR sky130_fd_sc_hd__decap_6
XPHY_EDGE_ROW_182_Right_27 VGND VGND VPWR VPWR sky130_fd_sc_hd__decap_3
XFILLER_202_433 VPWR VGND VPWR VGND sky130_ef_sc_hd__decap_12
X_335_ _121_ net495 VGND VGND VPWR VPWR _124_ sky130_fd_sc_hd__or2_1
XFILLER_203_989 VPWR VGND VPWR VGND sky130_ef_sc_hd__decap_12
XFILLER_202_477 VPWR VGND VPWR VGND sky130_ef_sc_hd__decap_12
XFILLER_174_307 VGND VGND VPWR VPWR sky130_fd_sc_hd__fill_1
XFILLER_179_1009 VPWR VGND VPWR VGND sky130_ef_sc_hd__decap_12
XTAP_TAPCELL_ROW_231_3114 VGND VPWR sky130_fd_sc_hd__tapvpwrvgnd_1
XFILLER_70_1165 VPWR VGND VPWR VGND sky130_ef_sc_hd__decap_12
XFILLER_168_893 VPWR VGND VPWR VGND sky130_ef_sc_hd__decap_12
XFILLER_186_189 VGND VGND VPWR VPWR sky130_fd_sc_hd__decap_6
XTAP_TAPCELL_ROW_231_3125 VGND VPWR sky130_fd_sc_hd__tapvpwrvgnd_1
XFILLER_183_841 VPWR VGND VPWR VGND sky130_ef_sc_hd__decap_12
XFILLER_41_70 VGND VGND VPWR VPWR sky130_fd_sc_hd__fill_1
XFILLER_170_513 VPWR VGND VPWR VGND sky130_ef_sc_hd__decap_12
XFILLER_157_1329 VGND VGND VPWR VPWR sky130_fd_sc_hd__fill_1
XPHY_EDGE_ROW_62_2_Left_564 VGND VGND VPWR VPWR sky130_fd_sc_hd__decap_3
XFILLER_170_557 VPWR VGND VPWR VGND sky130_ef_sc_hd__decap_12
XFILLER_9_1117 VGND VGND VPWR VPWR sky130_fd_sc_hd__decap_3
XPHY_EDGE_ROW_191_Right_36 VGND VGND VPWR VPWR sky130_fd_sc_hd__decap_3
XFILLER_194_1091 VGND VGND VPWR VPWR sky130_fd_sc_hd__fill_1
XTAP_TAPCELL_ROW_229_3065 VGND VPWR sky130_fd_sc_hd__tapvpwrvgnd_1
XTAP_TAPCELL_ROW_229_3076 VGND VPWR sky130_fd_sc_hd__tapvpwrvgnd_1
XFILLER_243_39 VPWR VGND VPWR VGND sky130_ef_sc_hd__decap_12
XFILLER_2_53 VPWR VGND VPWR VGND sky130_ef_sc_hd__decap_12
XFILLER_42_1245 VGND VGND VPWR VPWR sky130_fd_sc_hd__fill_1
XPHY_EDGE_ROW_14_1_Left_269 VGND VGND VPWR VPWR sky130_fd_sc_hd__decap_3
XFILLER_2_97 VPWR VGND VPWR VGND sky130_ef_sc_hd__decap_12
XFILLER_225_503 VGND VGND VPWR VPWR sky130_fd_sc_hd__fill_1
XFILLER_237_385 VGND VGND VPWR VPWR sky130_fd_sc_hd__decap_6
XFILLER_252_333 VPWR VGND VPWR VGND sky130_ef_sc_hd__decap_12
XFILLER_213_709 VPWR VGND VPWR VGND sky130_ef_sc_hd__decap_12
XFILLER_253_889 VGND VGND VPWR VPWR sky130_fd_sc_hd__decap_6
XPHY_EDGE_ROW_139_1_Left_394 VGND VGND VPWR VPWR sky130_fd_sc_hd__decap_3
XFILLER_252_377 VPWR VGND VPWR VGND sky130_ef_sc_hd__decap_12
XFILLER_178_613 VPWR VGND VPWR VGND sky130_ef_sc_hd__decap_12
XFILLER_209_1455 VGND VGND VPWR VPWR sky130_fd_sc_hd__fill_1
XFILLER_205_293 VPWR VGND VPWR VGND sky130_ef_sc_hd__decap_12
XFILLER_221_753 VPWR VGND VPWR VGND sky130_ef_sc_hd__decap_12
XTAP_TAPCELL_ROW_44_2_4017 VGND VPWR sky130_fd_sc_hd__tapvpwrvgnd_1
XFILLER_178_657 VPWR VGND VPWR VGND sky130_ef_sc_hd__decap_12
XFILLER_127_1177 VPWR VGND VPWR VGND sky130_ef_sc_hd__decap_12
XPHY_EDGE_ROW_76_1_Left_331 VGND VGND VPWR VPWR sky130_fd_sc_hd__decap_3
XFILLER_14_1303 VPWR VGND VPWR VGND sky130_ef_sc_hd__decap_12
XFILLER_221_797 VPWR VGND VPWR VGND sky130_ef_sc_hd__decap_12
XFILLER_177_167 VGND VGND VPWR VPWR sky130_fd_sc_hd__fill_1
XFILLER_203_1021 VPWR VGND VPWR VGND sky130_ef_sc_hd__decap_12
XFILLER_18_1483 VPWR VGND VPWR VGND sky130_ef_sc_hd__decap_12
XTAP_TAPCELL_ROW_193_2084 VGND VPWR sky130_fd_sc_hd__tapvpwrvgnd_1
XFILLER_53_1385 VGND VGND VPWR VPWR sky130_fd_sc_hd__fill_1
XTAP_TAPCELL_ROW_193_2095 VGND VPWR sky130_fd_sc_hd__tapvpwrvgnd_1
XTAP_TAPCELL_ROW_218_2780 VGND VPWR sky130_fd_sc_hd__tapvpwrvgnd_1
XFILLER_203_1065 VPWR VGND VPWR VGND sky130_ef_sc_hd__decap_12
XFILLER_88_1415 VPWR VGND VPWR VGND sky130_ef_sc_hd__decap_12
XFILLER_105_1497 VGND VGND VPWR VPWR sky130_fd_sc_hd__fill_1
XTAP_TAPCELL_ROW_214_2655 VGND VPWR sky130_fd_sc_hd__tapvpwrvgnd_1
XFILLER_238_1117 VPWR VGND VPWR VGND sky130_ef_sc_hd__decap_12
XTAP_TAPCELL_ROW_214_2666 VGND VPWR sky130_fd_sc_hd__tapvpwrvgnd_1
XFILLER_173_373 VPWR VGND VPWR VGND sky130_ef_sc_hd__decap_12
XFILLER_217_51 VGND VGND VPWR VPWR sky130_fd_sc_hd__decap_4
XFILLER_255_1453 VGND VGND VPWR VPWR sky130_fd_sc_hd__decap_3
XFILLER_255_1497 VPWR VGND VPWR VGND sky130_ef_sc_hd__decap_12
XFILLER_138_1295 VGND VGND VPWR VPWR sky130_fd_sc_hd__decap_6
XFILLER_153_39 VPWR VGND VPWR VGND sky130_ef_sc_hd__decap_12
XFILLER_173_1175 VGND VGND VPWR VPWR sky130_fd_sc_hd__fill_1
XFILLER_247_105 VGND VGND VPWR VPWR sky130_fd_sc_hd__decap_6
XFILLER_47_1189 VPWR VGND VPWR VGND sky130_ef_sc_hd__decap_12
XFILLER_60_1301 VGND VGND VPWR VPWR sky130_fd_sc_hd__fill_1
XFILLER_25_1443 VPWR VGND VPWR VGND sky130_ef_sc_hd__decap_12
XFILLER_214_1161 VPWR VGND VPWR VGND sky130_ef_sc_hd__decap_12
XFILLER_247_149 VPWR VGND VPWR VGND sky130_ef_sc_hd__decap_12
XFILLER_99_1511 VGND VGND VPWR VPWR sky130_fd_sc_hd__decap_4
XFILLER_229_853 VPWR VGND VPWR VGND sky130_ef_sc_hd__decap_12
XFILLER_112_1413 VGND VGND VPWR VPWR sky130_fd_sc_hd__fill_1
XFILLER_46_15 VPWR VGND VPWR VGND sky130_ef_sc_hd__decap_12
XFILLER_249_1213 VPWR VGND VPWR VGND sky130_ef_sc_hd__decap_12
XFILLER_21_1329 VGND VGND VPWR VPWR sky130_fd_sc_hd__fill_1
XFILLER_228_363 VGND VGND VPWR VPWR sky130_fd_sc_hd__fill_1
XFILLER_229_897 VPWR VGND VPWR VGND sky130_ef_sc_hd__decap_12
XFILLER_216_525 VGND VGND VPWR VPWR sky130_fd_sc_hd__decap_6
XFILLER_255_193 VGND VGND VPWR VPWR sky130_fd_sc_hd__decap_3
XFILLER_249_1257 VPWR VGND VPWR VGND sky130_ef_sc_hd__decap_12
XFILLER_244_867 VGND VGND VPWR VPWR sky130_fd_sc_hd__fill_1
XFILLER_216_569 VPWR VGND VPWR VGND sky130_ef_sc_hd__decap_12
XTAP_TAPCELL_ROW_141_2_4601 VGND VPWR sky130_fd_sc_hd__tapvpwrvgnd_1
XFILLER_227_1511 VGND VGND VPWR VPWR sky130_fd_sc_hd__fill_1
XFILLER_231_517 VPWR VGND VPWR VGND sky130_ef_sc_hd__decap_12
XFILLER_102_65 VGND VGND VPWR VPWR sky130_fd_sc_hd__decap_6
XFILLER_197_933 VPWR VGND VPWR VGND sky130_ef_sc_hd__decap_12
XFILLER_93_1165 VPWR VGND VPWR VGND sky130_ef_sc_hd__decap_12
XFILLER_196_421 VPWR VGND VPWR VGND sky130_ef_sc_hd__decap_12
XFILLER_62_58 VPWR VGND VPWR VGND sky130_ef_sc_hd__decap_12
XFILLER_145_1255 VPWR VGND VPWR VGND sky130_ef_sc_hd__decap_12
XFILLER_197_977 VPWR VGND VPWR VGND sky130_ef_sc_hd__decap_12
XFILLER_71_1441 VGND VGND VPWR VPWR sky130_fd_sc_hd__fill_1
XFILLER_106_1239 VGND VGND VPWR VPWR sky130_fd_sc_hd__decap_6
XFILLER_200_937 VPWR VGND VPWR VGND sky130_ef_sc_hd__decap_12
XFILLER_145_1299 VPWR VGND VPWR VGND sky130_ef_sc_hd__decap_12
XFILLER_221_1121 VPWR VGND VPWR VGND sky130_ef_sc_hd__decap_12
XFILLER_168_189 VGND VGND VPWR VPWR sky130_fd_sc_hd__decap_6
Xwire226 net227 VGND VGND VPWR VPWR net226 sky130_fd_sc_hd__clkbuf_1
Xwire237 net238 VGND VGND VPWR VPWR net237 sky130_fd_sc_hd__clkbuf_1
XFILLER_7_339 VGND VGND VPWR VPWR sky130_fd_sc_hd__decap_8
Xwire248 _151_ VGND VGND VPWR VPWR net248 sky130_fd_sc_hd__clkbuf_1
XFILLER_127_3 VPWR VGND VPWR VGND sky130_ef_sc_hd__decap_12
XFILLER_165_841 VPWR VGND VPWR VGND sky130_ef_sc_hd__decap_12
XFILLER_183_137 VPWR VGND VPWR VGND sky130_ef_sc_hd__decap_12
Xwire259 net260 VGND VGND VPWR VPWR net259 sky130_fd_sc_hd__clkbuf_1
XFILLER_32_1469 VGND VGND VPWR VPWR sky130_fd_sc_hd__fill_1
XPHY_EDGE_ROW_157_1_Right_813 VGND VGND VPWR VPWR sky130_fd_sc_hd__decap_3
XFILLER_180_811 VGND VGND VPWR VPWR sky130_fd_sc_hd__fill_1
XFILLER_11_51 VGND VGND VPWR VPWR sky130_fd_sc_hd__decap_4
XFILLER_192_693 VGND VGND VPWR VPWR sky130_fd_sc_hd__decap_6
XFILLER_191_181 VPWR VGND VPWR VGND sky130_ef_sc_hd__decap_12
XFILLER_65_1201 VPWR VGND VPWR VGND sky130_ef_sc_hd__decap_12
XFILLER_127_51 VGND VGND VPWR VPWR sky130_fd_sc_hd__decap_4
XTAP_TAPCELL_ROW_57_2_4095 VGND VPWR sky130_fd_sc_hd__tapvpwrvgnd_1
XFILLER_191_1231 VGND VGND VPWR VPWR sky130_fd_sc_hd__fill_1
XFILLER_156_1351 VGND VGND VPWR VPWR sky130_fd_sc_hd__decap_6
XFILLER_65_1267 VGND VGND VPWR VPWR sky130_fd_sc_hd__decap_6
XFILLER_87_55 VGND VGND VPWR VPWR sky130_fd_sc_hd__fill_1
XFILLER_152_1215 VPWR VGND VPWR VGND sky130_ef_sc_hd__decap_12
XTAP_TAPCELL_ROW_189_1975 VGND VPWR sky130_fd_sc_hd__tapvpwrvgnd_1
XFILLER_239_617 VPWR VGND VPWR VGND sky130_ef_sc_hd__decap_12
XFILLER_156_1395 VPWR VGND VPWR VGND sky130_ef_sc_hd__decap_12
XTAP_TAPCELL_ROW_189_1986 VGND VPWR sky130_fd_sc_hd__tapvpwrvgnd_1
XTAP_TAPCELL_ROW_189_1997 VGND VPWR sky130_fd_sc_hd__tapvpwrvgnd_1
XFILLER_117_1379 VGND VGND VPWR VPWR sky130_fd_sc_hd__decap_6
XFILLER_152_1259 VPWR VGND VPWR VGND sky130_ef_sc_hd__decap_12
XFILLER_8_1161 VPWR VGND VPWR VGND sky130_ef_sc_hd__decap_12
XFILLER_232_1261 VPWR VGND VPWR VGND sky130_ef_sc_hd__decap_12
XFILLER_207_503 VGND VGND VPWR VPWR sky130_fd_sc_hd__fill_1
XFILLER_219_385 VGND VGND VPWR VPWR sky130_fd_sc_hd__decap_6
XFILLER_234_333 VPWR VGND VPWR VGND sky130_ef_sc_hd__decap_12
XTAP_TAPCELL_ROW_35_2_3965 VGND VPWR sky130_fd_sc_hd__tapvpwrvgnd_1
XFILLER_235_889 VGND VGND VPWR VPWR sky130_fd_sc_hd__decap_6
XFILLER_234_377 VPWR VGND VPWR VGND sky130_ef_sc_hd__decap_12
XFILLER_185_1057 VGND VGND VPWR VPWR sky130_fd_sc_hd__decap_6
XFILLER_250_837 VPWR VGND VPWR VGND sky130_ef_sc_hd__decap_12
XFILLER_163_1311 VPWR VGND VPWR VGND sky130_ef_sc_hd__decap_12
XFILLER_199_281 VPWR VGND VPWR VGND sky130_ef_sc_hd__decap_12
XFILLER_72_1227 VPWR VGND VPWR VGND sky130_ef_sc_hd__decap_12
XFILLER_203_753 VPWR VGND VPWR VGND sky130_ef_sc_hd__decap_12
XFILLER_163_1355 VPWR VGND VPWR VGND sky130_ef_sc_hd__decap_12
XFILLER_124_1339 VPWR VGND VPWR VGND sky130_ef_sc_hd__decap_12
XFILLER_203_797 VPWR VGND VPWR VGND sky130_ef_sc_hd__decap_12
XFILLER_163_1399 VPWR VGND VPWR VGND sky130_ef_sc_hd__decap_12
X_318_ net179 _106_ VGND VGND VPWR VPWR _107_ sky130_fd_sc_hd__or2_1
XFILLER_204_1341 VPWR VGND VPWR VGND sky130_ef_sc_hd__decap_12
XFILLER_198_1429 VPWR VGND VPWR VGND sky130_ef_sc_hd__decap_12
Xinput12 wr_data[11] VGND VGND VPWR VPWR net12 sky130_fd_sc_hd__clkbuf_1
XFILLER_200_1205 VPWR VGND VPWR VGND sky130_ef_sc_hd__decap_12
Xinput23 wr_data[21] VGND VGND VPWR VPWR net23 sky130_fd_sc_hd__clkbuf_1
Xinput34 wr_data[31] VGND VGND VPWR VPWR net34 sky130_fd_sc_hd__clkbuf_1
XFILLER_204_1385 VPWR VGND VPWR VGND sky130_ef_sc_hd__decap_12
Xmax_cap515 net516 VGND VGND VPWR VPWR net515 sky130_fd_sc_hd__clkbuf_1
XFILLER_183_671 VGND VGND VPWR VPWR sky130_fd_sc_hd__fill_1
XFILLER_239_1437 VPWR VGND VPWR VGND sky130_ef_sc_hd__decap_12
Xmax_cap526 net64 VGND VGND VPWR VPWR net526 sky130_fd_sc_hd__clkbuf_1
XFILLER_171_833 VGND VGND VPWR VPWR sky130_fd_sc_hd__decap_6
Xmax_cap537 net52 VGND VGND VPWR VPWR net537 sky130_fd_sc_hd__clkbuf_1
XFILLER_170_321 VPWR VGND VPWR VGND sky130_ef_sc_hd__decap_12
Xmax_cap559 net69 VGND VGND VPWR VPWR net559 sky130_fd_sc_hd__clkbuf_1
XFILLER_192_1017 VPWR VGND VPWR VGND sky130_ef_sc_hd__decap_12
XFILLER_196_1197 VGND VGND VPWR VPWR sky130_fd_sc_hd__decap_6
XFILLER_254_27 VGND VGND VPWR VPWR sky130_fd_sc_hd__fill_1
XFILLER_171_877 VPWR VGND VPWR VGND sky130_ef_sc_hd__decap_12
XFILLER_42_3 VPWR VGND VPWR VGND sky130_ef_sc_hd__decap_12
XFILLER_83_1323 VGND VGND VPWR VPWR sky130_fd_sc_hd__decap_6
XFILLER_100_1383 VPWR VGND VPWR VGND sky130_ef_sc_hd__decap_12
XFILLER_170_365 VPWR VGND VPWR VGND sky130_ef_sc_hd__decap_12
XFILLER_83_1367 VPWR VGND VPWR VGND sky130_ef_sc_hd__decap_12
XFILLER_135_1435 VGND VGND VPWR VPWR sky130_fd_sc_hd__decap_6
XFILLER_170_1315 VGND VGND VPWR VPWR sky130_fd_sc_hd__fill_1
XFILLER_229_105 VGND VGND VPWR VPWR sky130_fd_sc_hd__decap_6
XPHY_EDGE_ROW_179_Left_434 VGND VGND VPWR VPWR sky130_fd_sc_hd__decap_3
XFILLER_135_1479 VPWR VGND VPWR VGND sky130_ef_sc_hd__decap_12
XFILLER_211_1301 VPWR VGND VPWR VGND sky130_ef_sc_hd__decap_12
XFILLER_229_149 VPWR VGND VPWR VGND sky130_ef_sc_hd__decap_12
XFILLER_245_609 VGND VGND VPWR VPWR sky130_fd_sc_hd__decap_6
XFILLER_215_1481 VPWR VGND VPWR VGND sky130_ef_sc_hd__decap_12
XFILLER_211_1345 VPWR VGND VPWR VGND sky130_ef_sc_hd__decap_12
XTAP_TAPCELL_ROW_207_2470 VGND VPWR sky130_fd_sc_hd__tapvpwrvgnd_1
XTAP_TAPCELL_ROW_207_2481 VGND VPWR sky130_fd_sc_hd__tapvpwrvgnd_1
XFILLER_237_193 VPWR VGND VPWR VGND sky130_ef_sc_hd__decap_12
XFILLER_0_1401 VPWR VGND VPWR VGND sky130_ef_sc_hd__decap_12
XFILLER_253_653 VPWR VGND VPWR VGND sky130_ef_sc_hd__decap_12
XFILLER_226_867 VGND VGND VPWR VPWR sky130_fd_sc_hd__fill_1
XFILLER_20_1351 VGND VGND VPWR VPWR sky130_fd_sc_hd__decap_6
XFILLER_252_141 VPWR VGND VPWR VGND sky130_ef_sc_hd__decap_12
XFILLER_16_29 VPWR VGND VPWR VGND sky130_ef_sc_hd__decap_12
XTAP_TAPCELL_ROW_203_2356 VGND VPWR sky130_fd_sc_hd__tapvpwrvgnd_1
XFILLER_129_1217 VGND VGND VPWR VPWR sky130_fd_sc_hd__fill_1
XTAP_TAPCELL_ROW_203_2367 VGND VPWR sky130_fd_sc_hd__tapvpwrvgnd_1
XFILLER_213_517 VPWR VGND VPWR VGND sky130_ef_sc_hd__decap_12
XTAP_TAPCELL_ROW_199_2260 VGND VPWR sky130_fd_sc_hd__tapvpwrvgnd_1
XTAP_TAPCELL_ROW_203_2378 VGND VPWR sky130_fd_sc_hd__tapvpwrvgnd_1
XFILLER_253_697 VPWR VGND VPWR VGND sky130_ef_sc_hd__decap_12
XTAP_TAPCELL_ROW_199_2271 VGND VPWR sky130_fd_sc_hd__tapvpwrvgnd_1
XFILLER_20_1395 VPWR VGND VPWR VGND sky130_ef_sc_hd__decap_12
XFILLER_94_1463 VGND VGND VPWR VPWR sky130_fd_sc_hd__decap_6
XFILLER_179_933 VPWR VGND VPWR VGND sky130_ef_sc_hd__decap_12
XFILLER_178_421 VPWR VGND VPWR VGND sky130_ef_sc_hd__decap_12
XTAP_TAPCELL_ROW_195_2146 VGND VPWR sky130_fd_sc_hd__tapvpwrvgnd_1
XFILLER_90_1327 VPWR VGND VPWR VGND sky130_ef_sc_hd__decap_12
XTAP_TAPCELL_ROW_195_2157 VGND VPWR sky130_fd_sc_hd__tapvpwrvgnd_1
XFILLER_181_1455 VGND VGND VPWR VPWR sky130_fd_sc_hd__fill_1
XPHY_EDGE_ROW_188_Left_443 VGND VGND VPWR VPWR sky130_fd_sc_hd__decap_3
XTAP_TAPCELL_ROW_18_1_1153 VGND VPWR sky130_fd_sc_hd__tapvpwrvgnd_1
XFILLER_179_977 VPWR VGND VPWR VGND sky130_ef_sc_hd__decap_12
XFILLER_221_561 VPWR VGND VPWR VGND sky130_ef_sc_hd__decap_12
XFILLER_240_1029 VGND VGND VPWR VPWR sky130_fd_sc_hd__decap_6
XFILLER_194_925 VPWR VGND VPWR VGND sky130_ef_sc_hd__decap_12
XFILLER_142_1439 VPWR VGND VPWR VGND sky130_ef_sc_hd__decap_12
XTAP_TAPCELL_ROW_216_2706 VGND VPWR sky130_fd_sc_hd__tapvpwrvgnd_1
XTAP_TAPCELL_ROW_216_2717 VGND VPWR sky130_fd_sc_hd__tapvpwrvgnd_1
XTAP_TAPCELL_ROW_216_2728 VGND VPWR sky130_fd_sc_hd__tapvpwrvgnd_1
XFILLER_222_1441 VPWR VGND VPWR VGND sky130_ef_sc_hd__decap_12
XTAP_TAPCELL_ROW_74_2_4201 VGND VPWR sky130_fd_sc_hd__tapvpwrvgnd_1
XFILLER_165_137 VGND VGND VPWR VPWR sky130_fd_sc_hd__decap_3
XFILLER_222_1485 VPWR VGND VPWR VGND sky130_ef_sc_hd__decap_12
XFILLER_14_1177 VPWR VGND VPWR VGND sky130_ef_sc_hd__decap_12
XFILLER_4_309 VGND VGND VPWR VPWR sky130_fd_sc_hd__decap_4
XFILLER_88_1245 VGND VGND VPWR VPWR sky130_fd_sc_hd__fill_1
XFILLER_174_693 VGND VGND VPWR VPWR sky130_fd_sc_hd__decap_6
XFILLER_31_1491 VGND VGND VPWR VPWR sky130_fd_sc_hd__decap_6
XFILLER_173_181 VPWR VGND VPWR VGND sky130_ef_sc_hd__decap_12
XFILLER_228_83 VGND VGND VPWR VPWR sky130_fd_sc_hd__fill_1
XFILLER_164_27 VGND VGND VPWR VPWR sky130_fd_sc_hd__fill_1
XFILLER_255_1261 VPWR VGND VPWR VGND sky130_ef_sc_hd__decap_12
XPHY_EDGE_ROW_197_Left_452 VGND VGND VPWR VPWR sky130_fd_sc_hd__decap_3
XFILLER_62_1407 VGND VGND VPWR VPWR sky130_fd_sc_hd__decap_6
XFILLER_251_1169 VGND VGND VPWR VPWR sky130_fd_sc_hd__decap_6
XFILLER_5_1301 VPWR VGND VPWR VGND sky130_ef_sc_hd__decap_12
XFILLER_9_1481 VGND VGND VPWR VPWR sky130_fd_sc_hd__decap_3
XFILLER_180_15 VPWR VGND VPWR VGND sky130_ef_sc_hd__decap_12
XFILLER_248_469 VGND VGND VPWR VPWR sky130_fd_sc_hd__decap_6
XTAP_TAPCELL_ROW_184_1850 VGND VPWR sky130_fd_sc_hd__tapvpwrvgnd_1
XFILLER_25_1273 VGND VGND VPWR VPWR sky130_fd_sc_hd__fill_1
XFILLER_5_1345 VPWR VGND VPWR VGND sky130_ef_sc_hd__decap_12
XTAP_TAPCELL_ROW_184_1861 VGND VPWR sky130_fd_sc_hd__tapvpwrvgnd_1
XFILLER_249_1021 VPWR VGND VPWR VGND sky130_ef_sc_hd__decap_12
XTAP_TAPCELL_ROW_180_1736 VGND VPWR sky130_fd_sc_hd__tapvpwrvgnd_1
XTAP_TAPCELL_ROW_180_1747 VGND VPWR sky130_fd_sc_hd__tapvpwrvgnd_1
XFILLER_216_333 VPWR VGND VPWR VGND sky130_ef_sc_hd__decap_12
XFILLER_99_1385 VGND VGND VPWR VPWR sky130_fd_sc_hd__fill_1
XTAP_TAPCELL_ROW_180_1758 VGND VPWR sky130_fd_sc_hd__tapvpwrvgnd_1
XFILLER_249_1065 VPWR VGND VPWR VGND sky130_ef_sc_hd__decap_12
XFILLER_217_889 VGND VGND VPWR VPWR sky130_fd_sc_hd__decap_6
XFILLER_216_377 VPWR VGND VPWR VGND sky130_ef_sc_hd__decap_12
XFILLER_73_57 VPWR VGND VPWR VGND sky130_ef_sc_hd__decap_12
XFILLER_232_837 VPWR VGND VPWR VGND sky130_ef_sc_hd__decap_12
Xwire80 net81 VGND VGND VPWR VPWR net80 sky130_fd_sc_hd__clkbuf_1
Xwire91 _233_ VGND VGND VPWR VPWR net91 sky130_fd_sc_hd__clkbuf_1
XFILLER_189_57 VPWR VGND VPWR VGND sky130_ef_sc_hd__decap_12
XFILLER_244_3 VPWR VGND VPWR VGND sky130_ef_sc_hd__decap_12
XFILLER_197_741 VPWR VGND VPWR VGND sky130_ef_sc_hd__decap_12
XFILLER_200_701 VPWR VGND VPWR VGND sky130_ef_sc_hd__decap_12
XFILLER_240_881 VPWR VGND VPWR VGND sky130_ef_sc_hd__decap_12
XFILLER_196_251 VGND VGND VPWR VPWR sky130_fd_sc_hd__fill_1
XFILLER_197_785 VPWR VGND VPWR VGND sky130_ef_sc_hd__decap_12
XFILLER_184_413 VGND VGND VPWR VPWR sky130_fd_sc_hd__decap_6
XTAP_TAPCELL_ROW_178_1687 VGND VPWR sky130_fd_sc_hd__tapvpwrvgnd_1
XTAP_TAPCELL_ROW_178_1698 VGND VPWR sky130_fd_sc_hd__tapvpwrvgnd_1
XFILLER_7_125 VPWR VGND VPWR VGND sky130_ef_sc_hd__decap_12
XFILLER_184_457 VPWR VGND VPWR VGND sky130_ef_sc_hd__decap_12
XFILLER_7_169 VGND VGND VPWR VPWR sky130_fd_sc_hd__fill_2
XFILLER_4_810 VGND VGND VPWR VPWR sky130_fd_sc_hd__fill_2
XPHY_EDGE_ROW_158_1_Right_814 VGND VGND VPWR VPWR sky130_fd_sc_hd__decap_3
XFILLER_158_1413 VGND VGND VPWR VPWR sky130_fd_sc_hd__fill_1
XFILLER_67_1329 VGND VGND VPWR VPWR sky130_fd_sc_hd__fill_1
XFILLER_193_1337 VGND VGND VPWR VPWR sky130_fd_sc_hd__decap_6
XFILLER_217_1009 VPWR VGND VPWR VGND sky130_ef_sc_hd__decap_12
XFILLER_98_65 VGND VGND VPWR VPWR sky130_fd_sc_hd__decap_6
XFILLER_3_364 VGND VGND VPWR VPWR sky130_fd_sc_hd__fill_1
XFILLER_80_1507 VGND VGND VPWR VPWR sky130_fd_sc_hd__decap_8
XTAP_TAPCELL_ROW_132_2_4546 VGND VPWR sky130_fd_sc_hd__tapvpwrvgnd_1
XFILLER_117_1165 VPWR VGND VPWR VGND sky130_ef_sc_hd__decap_12
XFILLER_239_447 VGND VGND VPWR VPWR sky130_fd_sc_hd__fill_1
XFILLER_227_609 VGND VGND VPWR VPWR sky130_fd_sc_hd__decap_6
XFILLER_248_981 VPWR VGND VPWR VGND sky130_ef_sc_hd__decap_12
XPHY_EDGE_ROW_201_Left_456 VGND VGND VPWR VPWR sky130_fd_sc_hd__decap_3
XFILLER_232_1091 VGND VGND VPWR VPWR sky130_fd_sc_hd__fill_1
XFILLER_187_1119 VGND VGND VPWR VPWR sky130_fd_sc_hd__fill_1
XFILLER_240_29 VPWR VGND VPWR VGND sky130_ef_sc_hd__decap_12
XFILLER_208_867 VGND VGND VPWR VPWR sky130_fd_sc_hd__fill_1
XFILLER_219_193 VPWR VGND VPWR VGND sky130_ef_sc_hd__decap_12
XFILLER_235_653 VPWR VGND VPWR VGND sky130_ef_sc_hd__decap_12
XFILLER_228_1105 VPWR VGND VPWR VGND sky130_ef_sc_hd__decap_12
XFILLER_234_141 VPWR VGND VPWR VGND sky130_ef_sc_hd__decap_12
XFILLER_250_601 VPWR VGND VPWR VGND sky130_ef_sc_hd__decap_12
XFILLER_78_1469 VGND VGND VPWR VPWR sky130_fd_sc_hd__fill_1
XTAP_TAPCELL_ROW_80_2_4233 VGND VPWR sky130_fd_sc_hd__tapvpwrvgnd_1
XFILLER_235_697 VPWR VGND VPWR VGND sky130_ef_sc_hd__decap_12
XTAP_TAPCELL_ROW_79_2_4227 VGND VPWR sky130_fd_sc_hd__tapvpwrvgnd_1
XFILLER_228_1149 VPWR VGND VPWR VGND sky130_ef_sc_hd__decap_12
XFILLER_250_645 VPWR VGND VPWR VGND sky130_ef_sc_hd__decap_12
XFILLER_203_561 VPWR VGND VPWR VGND sky130_ef_sc_hd__decap_12
XFILLER_249_27 VPWR VGND VPWR VGND sky130_ef_sc_hd__decap_12
XFILLER_128_1283 VPWR VGND VPWR VGND sky130_ef_sc_hd__decap_12
XFILLER_37_1177 VPWR VGND VPWR VGND sky130_ef_sc_hd__decap_12
XFILLER_176_925 VPWR VGND VPWR VGND sky130_ef_sc_hd__decap_12
XFILLER_187_273 VGND VGND VPWR VPWR sky130_fd_sc_hd__decap_6
XFILLER_8_41 VPWR VGND VPWR VGND sky130_ef_sc_hd__decap_12
XTAP_TAPCELL_ROW_190_2010 VGND VPWR sky130_fd_sc_hd__tapvpwrvgnd_1
XTAP_TAPCELL_ROW_190_2021 VGND VPWR sky130_fd_sc_hd__tapvpwrvgnd_1
XPHY_EDGE_ROW_210_Left_465 VGND VGND VPWR VPWR sky130_fd_sc_hd__decap_3
XFILLER_8_85 VPWR VGND VPWR VGND sky130_ef_sc_hd__decap_12
XFILLER_198_1259 VGND VGND VPWR VPWR sky130_fd_sc_hd__fill_1
XFILLER_239_1201 VPWR VGND VPWR VGND sky130_ef_sc_hd__decap_12
XFILLER_200_1035 VGND VGND VPWR VPWR sky130_fd_sc_hd__fill_1
XFILLER_15_1497 VGND VGND VPWR VPWR sky130_fd_sc_hd__fill_1
XFILLER_7_670 VGND VGND VPWR VPWR sky130_fd_sc_hd__fill_2
XFILLER_239_1245 VPWR VGND VPWR VGND sky130_ef_sc_hd__decap_12
Xmax_cap334 _136_ VGND VGND VPWR VPWR net334 sky130_fd_sc_hd__clkbuf_1
XFILLER_171_641 VPWR VGND VPWR VGND sky130_ef_sc_hd__decap_12
XFILLER_239_1289 VPWR VGND VPWR VGND sky130_ef_sc_hd__decap_12
XFILLER_171_685 VPWR VGND VPWR VGND sky130_ef_sc_hd__decap_12
XFILLER_100_1191 VPWR VGND VPWR VGND sky130_ef_sc_hd__decap_12
XFILLER_170_195 VGND VGND VPWR VPWR sky130_fd_sc_hd__fill_1
XFILLER_48_1295 VGND VGND VPWR VPWR sky130_fd_sc_hd__decap_6
XFILLER_135_1243 VPWR VGND VPWR VGND sky130_ef_sc_hd__decap_12
XTAP_TAPCELL_ROW_209_2521 VGND VPWR sky130_fd_sc_hd__tapvpwrvgnd_1
XPHY_EDGE_ROW_25_2_Left_527 VGND VGND VPWR VPWR sky130_fd_sc_hd__decap_3
XTAP_TAPCELL_ROW_209_2532 VGND VPWR sky130_fd_sc_hd__tapvpwrvgnd_1
XFILLER_135_1287 VPWR VGND VPWR VGND sky130_ef_sc_hd__decap_12
XFILLER_214_41 VPWR VGND VPWR VGND sky130_ef_sc_hd__decap_12
XFILLER_245_417 VPWR VGND VPWR VGND sky130_ef_sc_hd__decap_12
XFILLER_22_1413 VGND VGND VPWR VPWR sky130_fd_sc_hd__fill_1
XPHY_EDGE_ROW_120_1_Right_776 VGND VGND VPWR VPWR sky130_fd_sc_hd__decap_3
XTAP_TAPCELL_ROW_205_2407 VGND VPWR sky130_fd_sc_hd__tapvpwrvgnd_1
XTAP_TAPCELL_ROW_205_2418 VGND VPWR sky130_fd_sc_hd__tapvpwrvgnd_1
XTAP_TAPCELL_ROW_205_2429 VGND VPWR sky130_fd_sc_hd__tapvpwrvgnd_1
XFILLER_214_85 VPWR VGND VPWR VGND sky130_ef_sc_hd__decap_12
XFILLER_27_39 VPWR VGND VPWR VGND sky130_ef_sc_hd__decap_12
XFILLER_150_29 VPWR VGND VPWR VGND sky130_ef_sc_hd__decap_12
XFILLER_211_1175 VGND VGND VPWR VPWR sky130_fd_sc_hd__fill_1
XFILLER_254_973 VGND VGND VPWR VPWR sky130_fd_sc_hd__decap_6
XFILLER_246_1205 VPWR VGND VPWR VGND sky130_ef_sc_hd__decap_12
XTAP_TAPCELL_ROW_197_2208 VGND VPWR sky130_fd_sc_hd__tapvpwrvgnd_1
XFILLER_253_461 VPWR VGND VPWR VGND sky130_ef_sc_hd__decap_12
XTAP_TAPCELL_ROW_1_879 VGND VPWR sky130_fd_sc_hd__tapvpwrvgnd_1
XFILLER_214_837 VPWR VGND VPWR VGND sky130_ef_sc_hd__decap_12
XFILLER_168_1085 VGND VGND VPWR VPWR sky130_fd_sc_hd__decap_6
XFILLER_240_133 VGND VGND VPWR VPWR sky130_fd_sc_hd__decap_6
XFILLER_43_27 VPWR VGND VPWR VGND sky130_ef_sc_hd__decap_12
XFILLER_94_1271 VPWR VGND VPWR VGND sky130_ef_sc_hd__decap_12
XFILLER_179_741 VPWR VGND VPWR VGND sky130_ef_sc_hd__decap_12
XFILLER_159_27 VPWR VGND VPWR VGND sky130_ef_sc_hd__decap_12
XFILLER_240_177 VPWR VGND VPWR VGND sky130_ef_sc_hd__decap_12
XFILLER_55_1255 VPWR VGND VPWR VGND sky130_ef_sc_hd__decap_12
XFILLER_107_1323 VGND VGND VPWR VPWR sky130_fd_sc_hd__decap_6
XFILLER_142_1203 VPWR VGND VPWR VGND sky130_ef_sc_hd__decap_12
XFILLER_222_881 VPWR VGND VPWR VGND sky130_ef_sc_hd__decap_12
XFILLER_146_1383 VPWR VGND VPWR VGND sky130_ef_sc_hd__decap_12
XFILLER_178_251 VGND VGND VPWR VPWR sky130_fd_sc_hd__fill_1
XFILLER_179_785 VPWR VGND VPWR VGND sky130_ef_sc_hd__decap_12
XFILLER_16_1239 VGND VGND VPWR VPWR sky130_fd_sc_hd__decap_6
XFILLER_166_413 VGND VGND VPWR VPWR sky130_fd_sc_hd__decap_6
XFILLER_55_1299 VPWR VGND VPWR VGND sky130_ef_sc_hd__decap_12
XFILLER_142_1247 VPWR VGND VPWR VGND sky130_ef_sc_hd__decap_12
XFILLER_221_391 VGND VGND VPWR VPWR sky130_fd_sc_hd__fill_1
XFILLER_107_1367 VPWR VGND VPWR VGND sky130_ef_sc_hd__decap_12
XFILLER_194_755 VGND VGND VPWR VPWR sky130_fd_sc_hd__fill_1
XFILLER_166_457 VPWR VGND VPWR VGND sky130_ef_sc_hd__decap_12
XFILLER_182_917 VGND VGND VPWR VPWR sky130_fd_sc_hd__decap_6
XFILLER_181_405 VPWR VGND VPWR VGND sky130_ef_sc_hd__decap_12
XFILLER_239_93 VPWR VGND VPWR VGND sky130_ef_sc_hd__decap_12
XTAP_TAPCELL_ROW_173_1551 VGND VPWR sky130_fd_sc_hd__tapvpwrvgnd_1
XFILLER_175_15 VPWR VGND VPWR VGND sky130_ef_sc_hd__decap_12
XTAP_TAPCELL_ROW_173_1562 VGND VPWR sky130_fd_sc_hd__tapvpwrvgnd_1
XFILLER_175_1001 VGND VGND VPWR VPWR sky130_fd_sc_hd__decap_6
XFILLER_181_449 VPWR VGND VPWR VGND sky130_ef_sc_hd__decap_12
XFILLER_190_961 VPWR VGND VPWR VGND sky130_ef_sc_hd__decap_12
XFILLER_175_1045 VPWR VGND VPWR VGND sky130_ef_sc_hd__decap_12
XFILLER_218_1329 VPWR VGND VPWR VGND sky130_ef_sc_hd__decap_12
XFILLER_108_53 VPWR VGND VPWR VGND sky130_ef_sc_hd__decap_12
XFILLER_255_81 VGND VGND VPWR VPWR sky130_fd_sc_hd__decap_3
XFILLER_66_1351 VGND VGND VPWR VPWR sky130_fd_sc_hd__decap_6
XTAP_TAPCELL_ROW_117_2_4459 VGND VPWR sky130_fd_sc_hd__tapvpwrvgnd_1
XFILLER_175_1089 VPWR VGND VPWR VGND sky130_ef_sc_hd__decap_12
XTAP_TAPCELL_ROW_186_1901 VGND VPWR sky130_fd_sc_hd__tapvpwrvgnd_1
XTAP_TAPCELL_ROW_186_1912 VGND VPWR sky130_fd_sc_hd__tapvpwrvgnd_1
XFILLER_62_1215 VPWR VGND VPWR VGND sky130_ef_sc_hd__decap_12
XFILLER_66_1395 VPWR VGND VPWR VGND sky130_ef_sc_hd__decap_12
XFILLER_118_1463 VGND VGND VPWR VPWR sky130_fd_sc_hd__decap_6
XFILLER_153_1343 VPWR VGND VPWR VGND sky130_ef_sc_hd__decap_12
XFILLER_248_233 VPWR VGND VPWR VGND sky130_ef_sc_hd__decap_12
XFILLER_62_1259 VPWR VGND VPWR VGND sky130_ef_sc_hd__decap_12
XFILLER_27_1379 VGND VGND VPWR VPWR sky130_fd_sc_hd__decap_6
XFILLER_114_1327 VPWR VGND VPWR VGND sky130_ef_sc_hd__decap_12
XFILLER_191_69 VPWR VGND VPWR VGND sky130_ef_sc_hd__decap_12
XTAP_TAPCELL_ROW_182_1809 VGND VPWR sky130_fd_sc_hd__tapvpwrvgnd_1
XFILLER_194_3 VPWR VGND VPWR VGND sky130_ef_sc_hd__decap_12
XFILLER_209_609 VGND VGND VPWR VPWR sky130_fd_sc_hd__decap_6
XFILLER_124_41 VPWR VGND VPWR VGND sky130_ef_sc_hd__decap_12
XFILLER_153_1387 VPWR VGND VPWR VGND sky130_ef_sc_hd__decap_12
XFILLER_248_277 VPWR VGND VPWR VGND sky130_ef_sc_hd__decap_12
XTAP_TAPCELL_ROW_167_1388 VGND VPWR sky130_fd_sc_hd__tapvpwrvgnd_1
XTAP_TAPCELL_ROW_167_1399 VGND VPWR sky130_fd_sc_hd__tapvpwrvgnd_1
X_652_ clknet_3_7__leaf_clk acc_core.adder.cla_blocks\[4\].block.sum\[2\] _060_ VGND
+ VGND VPWR VPWR net52 sky130_fd_sc_hd__dfrtp_1
XFILLER_245_951 VGND VGND VPWR VPWR sky130_fd_sc_hd__fill_1
XFILLER_5_1175 VGND VGND VPWR VPWR sky130_fd_sc_hd__fill_1
XFILLER_217_653 VPWR VGND VPWR VGND sky130_ef_sc_hd__decap_12
XTAP_TAPCELL_ROW_65_2_4146 VGND VPWR sky130_fd_sc_hd__tapvpwrvgnd_1
XFILLER_216_141 VPWR VGND VPWR VGND sky130_ef_sc_hd__decap_12
XFILLER_229_1425 VPWR VGND VPWR VGND sky130_ef_sc_hd__decap_12
XFILLER_186_1141 VGND VGND VPWR VPWR sky130_fd_sc_hd__decap_6
XFILLER_232_601 VPWR VGND VPWR VGND sky130_ef_sc_hd__decap_12
X_583_ net669 VGND VGND VPWR VPWR _065_ sky130_fd_sc_hd__inv_2
XFILLER_189_505 VPWR VGND VPWR VGND sky130_ef_sc_hd__decap_12
XFILLER_217_697 VPWR VGND VPWR VGND sky130_ef_sc_hd__decap_12
XFILLER_182_1005 VPWR VGND VPWR VGND sky130_ef_sc_hd__decap_12
XFILLER_186_1185 VPWR VGND VPWR VGND sky130_ef_sc_hd__decap_12
XFILLER_229_1469 VPWR VGND VPWR VGND sky130_ef_sc_hd__decap_12
XFILLER_231_111 VGND VGND VPWR VPWR sky130_fd_sc_hd__fill_1
XFILLER_232_645 VPWR VGND VPWR VGND sky130_ef_sc_hd__decap_12
XPHY_EDGE_ROW_71_2_Left_573 VGND VGND VPWR VPWR sky130_fd_sc_hd__decap_3
XFILLER_73_1311 VPWR VGND VPWR VGND sky130_ef_sc_hd__decap_12
XFILLER_77_1491 VGND VGND VPWR VPWR sky130_fd_sc_hd__decap_6
XFILLER_182_1049 VPWR VGND VPWR VGND sky130_ef_sc_hd__decap_12
XTAP_TAPCELL_ROW_45_2_4022 VGND VPWR sky130_fd_sc_hd__tapvpwrvgnd_1
XFILLER_73_1355 VPWR VGND VPWR VGND sky130_ef_sc_hd__decap_12
XFILLER_160_1303 VPWR VGND VPWR VGND sky130_ef_sc_hd__decap_12
XFILLER_125_1423 VPWR VGND VPWR VGND sky130_ef_sc_hd__decap_12
XFILLER_164_1483 VPWR VGND VPWR VGND sky130_ef_sc_hd__decap_12
XFILLER_169_273 VGND VGND VPWR VPWR sky130_fd_sc_hd__decap_6
XFILLER_34_1339 VPWR VGND VPWR VGND sky130_ef_sc_hd__decap_12
XFILLER_200_531 VGND VGND VPWR VPWR sky130_fd_sc_hd__fill_1
XFILLER_73_1399 VPWR VGND VPWR VGND sky130_ef_sc_hd__decap_12
XFILLER_125_1467 VPWR VGND VPWR VGND sky130_ef_sc_hd__decap_12
XFILLER_199_1513 VGND VGND VPWR VPWR sky130_fd_sc_hd__fill_2
XFILLER_223_1057 VGND VGND VPWR VPWR sky130_fd_sc_hd__decap_6
XFILLER_184_221 VPWR VGND VPWR VGND sky130_ef_sc_hd__decap_12
XTAP_TAPCELL_ROW_251_3651 VGND VPWR sky130_fd_sc_hd__tapvpwrvgnd_1
XTAP_TAPCELL_ROW_251_3662 VGND VPWR sky130_fd_sc_hd__tapvpwrvgnd_1
XFILLER_185_777 VGND VGND VPWR VPWR sky130_fd_sc_hd__decap_6
XTAP_TAPCELL_ROW_251_3673 VGND VPWR sky130_fd_sc_hd__tapvpwrvgnd_1
XFILLER_240_1371 VGND VGND VPWR VPWR sky130_fd_sc_hd__fill_1
XFILLER_184_265 VPWR VGND VPWR VGND sky130_ef_sc_hd__decap_12
XPHY_EDGE_ROW_23_1_Left_278 VGND VGND VPWR VPWR sky130_fd_sc_hd__decap_3
XFILLER_193_1101 VPWR VGND VPWR VGND sky130_ef_sc_hd__decap_12
XFILLER_197_1281 VGND VGND VPWR VPWR sky130_fd_sc_hd__decap_6
XFILLER_201_1399 VGND VGND VPWR VPWR sky130_fd_sc_hd__fill_1
XPHY_EDGE_ROW_159_1_Right_815 VGND VGND VPWR VPWR sky130_fd_sc_hd__decap_3
XFILLER_236_1429 VPWR VGND VPWR VGND sky130_ef_sc_hd__decap_12
XFILLER_193_1145 VPWR VGND VPWR VGND sky130_ef_sc_hd__decap_12
XFILLER_10_1383 VPWR VGND VPWR VGND sky130_ef_sc_hd__decap_12
XFILLER_3_161 VGND VGND VPWR VPWR sky130_fd_sc_hd__decap_6
XFILLER_165_81 VGND VGND VPWR VPWR sky130_fd_sc_hd__decap_3
XFILLER_3_172 VPWR VGND VPWR VGND sky130_ef_sc_hd__decap_12
XFILLER_84_1451 VPWR VGND VPWR VGND sky130_ef_sc_hd__decap_12
XFILLER_193_1189 VPWR VGND VPWR VGND sky130_ef_sc_hd__decap_12
XFILLER_45_1435 VGND VGND VPWR VPWR sky130_fd_sc_hd__decap_6
XFILLER_80_1315 VPWR VGND VPWR VGND sky130_ef_sc_hd__decap_12
XFILLER_84_1495 VPWR VGND VPWR VGND sky130_ef_sc_hd__decap_12
XTAP_TAPCELL_ROW_245_3488 VGND VPWR sky130_fd_sc_hd__tapvpwrvgnd_1
XFILLER_45_1479 VPWR VGND VPWR VGND sky130_ef_sc_hd__decap_12
XFILLER_80_1359 VPWR VGND VPWR VGND sky130_ef_sc_hd__decap_12
XFILLER_132_1427 VPWR VGND VPWR VGND sky130_ef_sc_hd__decap_12
XFILLER_230_1017 VPWR VGND VPWR VGND sky130_ef_sc_hd__decap_12
XTAP_TAPCELL_ROW_245_3499 VGND VPWR sky130_fd_sc_hd__tapvpwrvgnd_1
XFILLER_234_1197 VGND VGND VPWR VPWR sky130_fd_sc_hd__decap_6
XPHY_EDGE_ROW_85_1_Left_340 VGND VGND VPWR VPWR sky130_fd_sc_hd__decap_3
Xhold1 valid_d1 VGND VGND VPWR VPWR net688 sky130_fd_sc_hd__dlygate4sd3_1
XFILLER_227_417 VPWR VGND VPWR VGND sky130_ef_sc_hd__decap_12
XFILLER_251_39 VPWR VGND VPWR VGND sky130_ef_sc_hd__decap_12
XFILLER_236_973 VGND VGND VPWR VPWR sky130_fd_sc_hd__decap_6
XFILLER_235_461 VPWR VGND VPWR VGND sky130_ef_sc_hd__decap_12
XFILLER_251_921 VPWR VGND VPWR VGND sky130_ef_sc_hd__decap_12
XFILLER_208_1509 VGND VGND VPWR VPWR sky130_fd_sc_hd__decap_6
XFILLER_251_965 VPWR VGND VPWR VGND sky130_ef_sc_hd__decap_12
XFILLER_91_1411 VPWR VGND VPWR VGND sky130_ef_sc_hd__decap_12
XFILLER_222_133 VGND VGND VPWR VPWR sky130_fd_sc_hd__decap_6
XPHY_EDGE_ROW_8_Right_8 VGND VGND VPWR VPWR sky130_fd_sc_hd__decap_3
XFILLER_250_475 VGND VGND VPWR VPWR sky130_fd_sc_hd__fill_1
XFILLER_222_177 VPWR VGND VPWR VGND sky130_ef_sc_hd__decap_12
XFILLER_241_1113 VGND VGND VPWR VPWR sky130_fd_sc_hd__decap_6
XFILLER_91_1455 VPWR VGND VPWR VGND sky130_ef_sc_hd__decap_12
XFILLER_204_881 VPWR VGND VPWR VGND sky130_ef_sc_hd__decap_12
XFILLER_200_65 VPWR VGND VPWR VGND sky130_ef_sc_hd__decap_12
XFILLER_52_1439 VPWR VGND VPWR VGND sky130_ef_sc_hd__decap_12
XFILLER_104_1507 VGND VGND VPWR VPWR sky130_fd_sc_hd__decap_8
XFILLER_203_391 VGND VGND VPWR VPWR sky130_fd_sc_hd__fill_1
XFILLER_241_1157 VPWR VGND VPWR VGND sky130_ef_sc_hd__decap_12
XFILLER_91_1499 VPWR VGND VPWR VGND sky130_ef_sc_hd__decap_12
XFILLER_176_755 VGND VGND VPWR VPWR sky130_fd_sc_hd__fill_1
Xmax_cap131 _196_ VGND VGND VPWR VPWR net131 sky130_fd_sc_hd__clkbuf_1
XFILLER_172_961 VPWR VGND VPWR VGND sky130_ef_sc_hd__decap_12
XFILLER_176_1365 VGND VGND VPWR VPWR sky130_fd_sc_hd__decap_6
XFILLER_1_109 VGND VGND VPWR VPWR sky130_fd_sc_hd__decap_3
Xmax_cap175 net176 VGND VGND VPWR VPWR net175 sky130_fd_sc_hd__clkbuf_1
Xmax_cap186 _261_ VGND VGND VPWR VPWR net186 sky130_fd_sc_hd__clkbuf_1
Xmax_cap197 net198 VGND VGND VPWR VPWR net197 sky130_fd_sc_hd__clkbuf_1
XFILLER_172_1229 VPWR VGND VPWR VGND sky130_ef_sc_hd__decap_12
XTAP_TAPCELL_ROW_71_2_4178 VGND VPWR sky130_fd_sc_hd__tapvpwrvgnd_1
XFILLER_252_1253 VGND VGND VPWR VPWR sky130_fd_sc_hd__decap_6
XFILLER_225_51 VGND VGND VPWR VPWR sky130_fd_sc_hd__decap_4
XFILLER_38_27 VGND VGND VPWR VPWR sky130_fd_sc_hd__fill_1
XFILLER_252_1297 VPWR VGND VPWR VGND sky130_ef_sc_hd__decap_12
XFILLER_246_737 VPWR VGND VPWR VGND sky130_ef_sc_hd__decap_12
XFILLER_161_39 VPWR VGND VPWR VGND sky130_ef_sc_hd__decap_12
XFILLER_245_225 VPWR VGND VPWR VGND sky130_ef_sc_hd__decap_12
XPHY_EDGE_ROW_121_1_Right_777 VGND VGND VPWR VPWR sky130_fd_sc_hd__decap_3
XFILLER_2_1315 VGND VGND VPWR VPWR sky130_fd_sc_hd__fill_1
XFILLER_227_951 VGND VGND VPWR VPWR sky130_fd_sc_hd__fill_1
XTAP_TAPCELL_ROW_36_2_3970 VGND VPWR sky130_fd_sc_hd__tapvpwrvgnd_1
XFILLER_214_601 VPWR VGND VPWR VGND sky130_ef_sc_hd__decap_12
XFILLER_54_15 VPWR VGND VPWR VGND sky130_ef_sc_hd__decap_12
XFILLER_254_781 VPWR VGND VPWR VGND sky130_ef_sc_hd__decap_12
XFILLER_213_111 VGND VGND VPWR VPWR sky130_fd_sc_hd__fill_1
XFILLER_246_1035 VGND VGND VPWR VPWR sky130_fd_sc_hd__fill_1
XFILLER_183_1325 VPWR VGND VPWR VGND sky130_ef_sc_hd__decap_12
XFILLER_214_645 VPWR VGND VPWR VGND sky130_ef_sc_hd__decap_12
XFILLER_0_1061 VGND VGND VPWR VPWR sky130_fd_sc_hd__decap_3
XFILLER_183_1369 VPWR VGND VPWR VGND sky130_ef_sc_hd__decap_12
XFILLER_198_357 VGND VGND VPWR VPWR sky130_fd_sc_hd__decap_6
XFILLER_201_317 VPWR VGND VPWR VGND sky130_ef_sc_hd__decap_12
XFILLER_241_497 VGND VGND VPWR VPWR sky130_fd_sc_hd__decap_6
XFILLER_9_209 VPWR VGND VPWR VGND sky130_ef_sc_hd__decap_12
XFILLER_110_65 VGND VGND VPWR VPWR sky130_fd_sc_hd__decap_6
XTAP_TAPCELL_ROW_175_1602 VGND VPWR sky130_fd_sc_hd__tapvpwrvgnd_1
XFILLER_146_1191 VPWR VGND VPWR VGND sky130_ef_sc_hd__decap_12
XTAP_TAPCELL_ROW_175_1613 VGND VPWR sky130_fd_sc_hd__tapvpwrvgnd_1
XFILLER_166_221 VPWR VGND VPWR VGND sky130_ef_sc_hd__decap_12
XFILLER_167_777 VGND VGND VPWR VPWR sky130_fd_sc_hd__decap_6
XFILLER_166_265 VPWR VGND VPWR VGND sky130_ef_sc_hd__decap_12
XFILLER_5_404 VGND VGND VPWR VPWR sky130_fd_sc_hd__fill_1
XFILLER_182_725 VPWR VGND VPWR VGND sky130_ef_sc_hd__decap_12
XFILLER_6_949 VPWR VGND VPWR VGND sky130_ef_sc_hd__decap_12
XFILLER_68_1413 VGND VGND VPWR VPWR sky130_fd_sc_hd__fill_1
XFILLER_182_769 VPWR VGND VPWR VGND sky130_ef_sc_hd__decap_12
XFILLER_194_1421 VGND VGND VPWR VPWR sky130_fd_sc_hd__decap_6
XFILLER_207_3 VPWR VGND VPWR VGND sky130_ef_sc_hd__decap_12
XFILLER_181_279 VGND VGND VPWR VPWR sky130_fd_sc_hd__fill_1
XFILLER_194_1465 VPWR VGND VPWR VGND sky130_ef_sc_hd__decap_12
XFILLER_190_1329 VPWR VGND VPWR VGND sky130_ef_sc_hd__decap_12
XTAP_TAPCELL_ROW_169_1439 VGND VPWR sky130_fd_sc_hd__tapvpwrvgnd_1
XFILLER_135_51 VGND VGND VPWR VPWR sky130_fd_sc_hd__decap_4
XFILLER_0_153 VPWR VGND VPWR VGND sky130_ef_sc_hd__decap_12
XFILLER_249_553 VGND VGND VPWR VPWR sky130_fd_sc_hd__decap_6
XFILLER_118_1271 VPWR VGND VPWR VGND sky130_ef_sc_hd__decap_12
XFILLER_27_1165 VPWR VGND VPWR VGND sky130_ef_sc_hd__decap_12
XFILLER_231_1337 VGND VGND VPWR VPWR sky130_fd_sc_hd__decap_6
XFILLER_95_55 VGND VGND VPWR VPWR sky130_fd_sc_hd__fill_1
XFILLER_209_417 VPWR VGND VPWR VGND sky130_ef_sc_hd__decap_12
XFILLER_0_197 VPWR VGND VPWR VGND sky130_ef_sc_hd__decap_12
XFILLER_249_597 VPWR VGND VPWR VGND sky130_ef_sc_hd__decap_12
XTAP_TAPCELL_ROW_41_1_1176 VGND VPWR sky130_fd_sc_hd__tapvpwrvgnd_1
XFILLER_188_1203 VGND VGND VPWR VPWR sky130_fd_sc_hd__fill_1
XTAP_TAPCELL_ROW_5_993 VGND VPWR sky130_fd_sc_hd__tapvpwrvgnd_1
XTAP_TAPCELL_ROW_240_3352 VGND VPWR sky130_fd_sc_hd__tapvpwrvgnd_1
XTAP_TAPCELL_ROW_240_3363 VGND VPWR sky130_fd_sc_hd__tapvpwrvgnd_1
XTAP_TAPCELL_ROW_240_3374 VGND VPWR sky130_fd_sc_hd__tapvpwrvgnd_1
XFILLER_218_973 VGND VGND VPWR VPWR sky130_fd_sc_hd__decap_6
X_635_ clknet_3_3__leaf_clk acc_core.adder.cla_blocks\[0\].block.sum\[1\] _043_ VGND
+ VGND VPWR VPWR net54 sky130_fd_sc_hd__dfrtp_1
XFILLER_217_461 VPWR VGND VPWR VGND sky130_ef_sc_hd__decap_12
XFILLER_251_217 VGND VGND VPWR VPWR sky130_fd_sc_hd__decap_6
XFILLER_233_921 VPWR VGND VPWR VGND sky130_ef_sc_hd__decap_12
XFILLER_229_1233 VPWR VGND VPWR VGND sky130_ef_sc_hd__decap_12
XFILLER_233_965 VPWR VGND VPWR VGND sky130_ef_sc_hd__decap_12
X_566_ net663 VGND VGND VPWR VPWR _048_ sky130_fd_sc_hd__inv_2
XFILLER_189_335 VGND VGND VPWR VPWR sky130_fd_sc_hd__fill_1
XFILLER_204_133 VGND VGND VPWR VPWR sky130_fd_sc_hd__decap_6
XFILLER_225_1119 VGND VGND VPWR VPWR sky130_fd_sc_hd__fill_1
XFILLER_232_475 VGND VGND VPWR VPWR sky130_fd_sc_hd__fill_1
XTAP_TAPCELL_ROW_253_3713 VGND VPWR sky130_fd_sc_hd__tapvpwrvgnd_1
XFILLER_204_177 VPWR VGND VPWR VGND sky130_ef_sc_hd__decap_12
XTAP_TAPCELL_ROW_253_3724 VGND VPWR sky130_fd_sc_hd__tapvpwrvgnd_1
X_497_ _218_ net77 VGND VGND VPWR VPWR acc_core.adder.cla_blocks\[5\].block.sum\[2\]
+ sky130_fd_sc_hd__xnor2_1
XFILLER_220_637 VGND VGND VPWR VPWR sky130_fd_sc_hd__decap_6
XFILLER_38_1283 VPWR VGND VPWR VGND sky130_ef_sc_hd__decap_12
XFILLER_125_1231 VPWR VGND VPWR VGND sky130_ef_sc_hd__decap_12
XFILLER_242_1477 VGND VGND VPWR VPWR sky130_fd_sc_hd__decap_6
XFILLER_185_541 VPWR VGND VPWR VGND sky130_ef_sc_hd__decap_12
XFILLER_125_1275 VPWR VGND VPWR VGND sky130_ef_sc_hd__decap_12
XFILLER_160_1177 VPWR VGND VPWR VGND sky130_ef_sc_hd__decap_12
XFILLER_199_1343 VGND VGND VPWR VPWR sky130_fd_sc_hd__fill_1
XFILLER_201_895 VGND VGND VPWR VPWR sky130_fd_sc_hd__fill_1
XFILLER_8_253 VGND VGND VPWR VPWR sky130_fd_sc_hd__fill_1
XFILLER_185_585 VPWR VGND VPWR VGND sky130_ef_sc_hd__decap_12
XFILLER_5_42 VPWR VGND VPWR VGND sky130_ef_sc_hd__decap_12
XFILLER_173_1505 VGND VGND VPWR VPWR sky130_fd_sc_hd__decap_6
XFILLER_4_470 VGND VGND VPWR VPWR sky130_fd_sc_hd__fill_1
XFILLER_236_1259 VGND VGND VPWR VPWR sky130_fd_sc_hd__fill_1
XFILLER_10_1191 VPWR VGND VPWR VGND sky130_ef_sc_hd__decap_12
XFILLER_45_1243 VPWR VGND VPWR VGND sky130_ef_sc_hd__decap_12
XFILLER_136_1371 VPWR VGND VPWR VGND sky130_ef_sc_hd__decap_12
XFILLER_255_501 VGND VGND VPWR VPWR sky130_fd_sc_hd__decap_3
XFILLER_45_1287 VPWR VGND VPWR VGND sky130_ef_sc_hd__decap_12
XFILLER_228_737 VPWR VGND VPWR VGND sky130_ef_sc_hd__decap_12
XFILLER_80_1189 VGND VGND VPWR VPWR sky130_fd_sc_hd__fill_1
XFILLER_227_225 VPWR VGND VPWR VGND sky130_ef_sc_hd__decap_12
XFILLER_255_545 VPWR VGND VPWR VGND sky130_ef_sc_hd__decap_12
XFILLER_209_951 VGND VGND VPWR VPWR sky130_fd_sc_hd__fill_1
XFILLER_243_729 VPWR VGND VPWR VGND sky130_ef_sc_hd__decap_12
XFILLER_255_589 VPWR VGND VPWR VGND sky130_ef_sc_hd__decap_12
XFILLER_236_781 VPWR VGND VPWR VGND sky130_ef_sc_hd__decap_12
XTAP_TAPCELL_ROW_223_2893 VGND VPWR sky130_fd_sc_hd__tapvpwrvgnd_1
XFILLER_165_1033 VGND VGND VPWR VPWR sky130_fd_sc_hd__decap_3
XFILLER_208_1317 VPWR VGND VPWR VGND sky130_ef_sc_hd__decap_12
XFILLER_1_1381 VPWR VGND VPWR VGND sky130_ef_sc_hd__decap_12
XFILLER_180_1509 VGND VGND VPWR VPWR sky130_fd_sc_hd__decap_6
XFILLER_247_1399 VGND VGND VPWR VPWR sky130_fd_sc_hd__fill_1
XFILLER_24_29 VPWR VGND VPWR VGND sky130_ef_sc_hd__decap_12
XFILLER_211_615 VGND VGND VPWR VPWR sky130_fd_sc_hd__fill_1
XFILLER_195_305 VPWR VGND VPWR VGND sky130_ef_sc_hd__decap_12
XFILLER_223_497 VGND VGND VPWR VPWR sky130_fd_sc_hd__decap_6
XFILLER_52_1203 VPWR VGND VPWR VGND sky130_ef_sc_hd__decap_12
XFILLER_17_1323 VGND VGND VPWR VPWR sky130_fd_sc_hd__decap_6
XFILLER_56_1383 VPWR VGND VPWR VGND sky130_ef_sc_hd__decap_12
XTAP_TAPCELL_ROW_14_2_3837 VGND VPWR sky130_fd_sc_hd__tapvpwrvgnd_1
XFILLER_108_1451 VPWR VGND VPWR VGND sky130_ef_sc_hd__decap_12
XFILLER_143_1331 VPWR VGND VPWR VGND sky130_ef_sc_hd__decap_12
XFILLER_195_349 VPWR VGND VPWR VGND sky130_ef_sc_hd__decap_12
XFILLER_52_1247 VPWR VGND VPWR VGND sky130_ef_sc_hd__decap_12
XFILLER_17_1367 VPWR VGND VPWR VGND sky130_ef_sc_hd__decap_12
XFILLER_104_1315 VPWR VGND VPWR VGND sky130_ef_sc_hd__decap_12
XFILLER_108_1495 VPWR VGND VPWR VGND sky130_ef_sc_hd__decap_12
XFILLER_206_1085 VGND VGND VPWR VPWR sky130_fd_sc_hd__decap_6
XFILLER_104_1359 VPWR VGND VPWR VGND sky130_ef_sc_hd__decap_12
XFILLER_178_1427 VGND VGND VPWR VPWR sky130_fd_sc_hd__fill_1
XTAP_TAPCELL_ROW_153_2_4675 VGND VPWR sky130_fd_sc_hd__tapvpwrvgnd_1
XFILLER_219_1413 VPWR VGND VPWR VGND sky130_ef_sc_hd__decap_12
XFILLER_254_1315 VGND VGND VPWR VPWR sky130_fd_sc_hd__fill_1
XFILLER_176_1173 VPWR VGND VPWR VGND sky130_ef_sc_hd__decap_12
XFILLER_219_1457 VPWR VGND VPWR VGND sky130_ef_sc_hd__decap_12
XFILLER_49_15 VPWR VGND VPWR VGND sky130_ef_sc_hd__decap_12
XFILLER_236_83 VGND VGND VPWR VPWR sky130_fd_sc_hd__fill_1
XTAP_TAPCELL_ROW_133_2_4551 VGND VPWR sky130_fd_sc_hd__tapvpwrvgnd_1
XFILLER_172_1037 VPWR VGND VPWR VGND sky130_ef_sc_hd__decap_12
XFILLER_172_27 VGND VGND VPWR VPWR sky130_fd_sc_hd__fill_1
XFILLER_63_1343 VPWR VGND VPWR VGND sky130_ef_sc_hd__decap_12
XFILLER_28_1463 VGND VGND VPWR VPWR sky130_fd_sc_hd__decap_6
XFILLER_115_1411 VPWR VGND VPWR VGND sky130_ef_sc_hd__decap_12
XFILLER_213_1001 VGND VGND VPWR VPWR sky130_fd_sc_hd__decap_6
XFILLER_252_1061 VPWR VGND VPWR VGND sky130_ef_sc_hd__decap_12
XFILLER_154_1471 VPWR VGND VPWR VGND sky130_ef_sc_hd__decap_12
XFILLER_246_501 VPWR VGND VPWR VGND sky130_ef_sc_hd__decap_12
XFILLER_24_1327 VPWR VGND VPWR VGND sky130_ef_sc_hd__decap_12
XFILLER_213_1045 VPWR VGND VPWR VGND sky130_ef_sc_hd__decap_12
XFILLER_63_1387 VPWR VGND VPWR VGND sky130_ef_sc_hd__decap_12
XFILLER_115_1455 VPWR VGND VPWR VGND sky130_ef_sc_hd__decap_12
XFILLER_150_1357 VGND VGND VPWR VPWR sky130_fd_sc_hd__fill_1
XFILLER_246_545 VPWR VGND VPWR VGND sky130_ef_sc_hd__decap_12
XFILLER_213_1089 VPWR VGND VPWR VGND sky130_ef_sc_hd__decap_12
XFILLER_98_1439 VPWR VGND VPWR VGND sky130_ef_sc_hd__decap_12
XFILLER_115_1499 VPWR VGND VPWR VGND sky130_ef_sc_hd__decap_12
XFILLER_246_589 VPWR VGND VPWR VGND sky130_ef_sc_hd__decap_12
XPHY_EDGE_ROW_122_1_Right_778 VGND VGND VPWR VPWR sky130_fd_sc_hd__decap_3
XFILLER_65_69 VGND VGND VPWR VPWR sky130_fd_sc_hd__fill_2
XFILLER_233_217 VGND VGND VPWR VPWR sky130_fd_sc_hd__decap_6
XFILLER_215_921 VPWR VGND VPWR VGND sky130_ef_sc_hd__decap_12
X_420_ net106 net120 net126 VGND VGND VPWR VPWR _209_ sky130_fd_sc_hd__a21oi_1
XFILLER_215_965 VPWR VGND VPWR VGND sky130_ef_sc_hd__decap_12
XFILLER_198_121 VPWR VGND VPWR VGND sky130_ef_sc_hd__decap_12
XFILLER_183_1133 VPWR VGND VPWR VGND sky130_ef_sc_hd__decap_12
XFILLER_157_3 VPWR VGND VPWR VGND sky130_ef_sc_hd__decap_12
XFILLER_214_475 VGND VGND VPWR VPWR sky130_fd_sc_hd__fill_1
XFILLER_241_261 VPWR VGND VPWR VGND sky130_ef_sc_hd__decap_12
X_351_ net593 net571 net542 VGND VGND VPWR VPWR _140_ sky130_fd_sc_hd__a21oi_1
XFILLER_183_1177 VPWR VGND VPWR VGND sky130_ef_sc_hd__decap_12
XFILLER_198_165 VPWR VGND VPWR VGND sky130_ef_sc_hd__decap_12
XFILLER_81_57 VPWR VGND VPWR VGND sky130_ef_sc_hd__decap_12
XFILLER_187_839 VGND VGND VPWR VPWR sky130_fd_sc_hd__fill_1
XFILLER_202_637 VGND VGND VPWR VPWR sky130_fd_sc_hd__decap_6
XFILLER_201_125 VPWR VGND VPWR VGND sky130_ef_sc_hd__decap_12
XFILLER_70_1303 VPWR VGND VPWR VGND sky130_ef_sc_hd__decap_12
XFILLER_35_1423 VPWR VGND VPWR VGND sky130_ef_sc_hd__decap_12
XFILLER_74_1483 VPWR VGND VPWR VGND sky130_ef_sc_hd__decap_12
XFILLER_224_1141 VGND VGND VPWR VPWR sky130_fd_sc_hd__decap_6
XFILLER_230_979 VGND VGND VPWR VPWR sky130_fd_sc_hd__fill_1
XFILLER_197_57 VPWR VGND VPWR VGND sky130_ef_sc_hd__decap_12
XFILLER_167_541 VPWR VGND VPWR VGND sky130_ef_sc_hd__decap_12
XFILLER_201_169 VPWR VGND VPWR VGND sky130_ef_sc_hd__decap_12
XFILLER_220_1005 VPWR VGND VPWR VGND sky130_ef_sc_hd__decap_12
XFILLER_35_1467 VPWR VGND VPWR VGND sky130_ef_sc_hd__decap_12
XFILLER_122_1415 VPWR VGND VPWR VGND sky130_ef_sc_hd__decap_12
XFILLER_224_1185 VPWR VGND VPWR VGND sky130_ef_sc_hd__decap_12
XFILLER_210_681 VPWR VGND VPWR VGND sky130_ef_sc_hd__decap_12
XFILLER_161_1497 VGND VGND VPWR VPWR sky130_fd_sc_hd__fill_1
XFILLER_167_585 VPWR VGND VPWR VGND sky130_ef_sc_hd__decap_12
XFILLER_220_1049 VPWR VGND VPWR VGND sky130_ef_sc_hd__decap_12
XPHY_EDGE_ROW_102_2_Left_604 VGND VGND VPWR VPWR sky130_fd_sc_hd__decap_3
XFILLER_182_533 VPWR VGND VPWR VGND sky130_ef_sc_hd__decap_12
XFILLER_202_1483 VGND VGND VPWR VPWR sky130_fd_sc_hd__fill_1
XFILLER_237_1513 VGND VGND VPWR VPWR sky130_fd_sc_hd__fill_2
XFILLER_5_278 VGND VGND VPWR VPWR sky130_fd_sc_hd__fill_2
XFILLER_5_289 VGND VGND VPWR VPWR sky130_fd_sc_hd__fill_1
XFILLER_194_1273 VPWR VGND VPWR VGND sky130_ef_sc_hd__decap_12
XFILLER_7_1001 VGND VGND VPWR VPWR sky130_fd_sc_hd__decap_6
XFILLER_231_1101 VPWR VGND VPWR VGND sky130_ef_sc_hd__decap_12
XFILLER_81_1443 VPWR VGND VPWR VGND sky130_ef_sc_hd__decap_12
XFILLER_133_1511 VGND VGND VPWR VPWR sky130_fd_sc_hd__decap_4
XTAP_TAPCELL_ROW_242_3414 VGND VPWR sky130_fd_sc_hd__tapvpwrvgnd_1
XFILLER_235_1281 VGND VGND VPWR VPWR sky130_fd_sc_hd__decap_6
XTAP_TAPCELL_ROW_242_3425 VGND VPWR sky130_fd_sc_hd__tapvpwrvgnd_1
XPHY_EDGE_ROW_84_1_Right_740 VGND VGND VPWR VPWR sky130_fd_sc_hd__decap_3
XFILLER_249_361 VPWR VGND VPWR VGND sky130_ef_sc_hd__decap_12
XFILLER_42_1427 VPWR VGND VPWR VGND sky130_ef_sc_hd__decap_12
XFILLER_7_1045 VPWR VGND VPWR VGND sky130_ef_sc_hd__decap_12
XFILLER_231_1145 VPWR VGND VPWR VGND sky130_ef_sc_hd__decap_12
XFILLER_209_225 VPWR VGND VPWR VGND sky130_ef_sc_hd__decap_12
XFILLER_7_1089 VPWR VGND VPWR VGND sky130_ef_sc_hd__decap_12
XFILLER_231_1189 VPWR VGND VPWR VGND sky130_ef_sc_hd__decap_12
XTAP_TAPCELL_ROW_8_1073 VGND VPWR sky130_fd_sc_hd__tapvpwrvgnd_1
XTAP_TAPCELL_ROW_8_1084 VGND VPWR sky130_fd_sc_hd__tapvpwrvgnd_1
XFILLER_225_729 VPWR VGND VPWR VGND sky130_ef_sc_hd__decap_12
XFILLER_218_781 VPWR VGND VPWR VGND sky130_ef_sc_hd__decap_12
X_618_ clknet_3_7__leaf_clk dout0\[16\] _026_ VGND VGND VPWR VPWR dout0_q\[16\] sky130_fd_sc_hd__dfrtp_1
XTAP_TAPCELL_ROW_255_3808 VGND VPWR sky130_fd_sc_hd__tapvpwrvgnd_1
XFILLER_229_1063 VGND VGND VPWR VPWR sky130_fd_sc_hd__fill_1
XFILLER_166_1353 VPWR VGND VPWR VGND sky130_ef_sc_hd__decap_12
XFILLER_220_401 VPWR VGND VPWR VGND sky130_ef_sc_hd__decap_12
X_549_ net668 VGND VGND VPWR VPWR _031_ sky130_fd_sc_hd__inv_2
XFILLER_177_305 VPWR VGND VPWR VGND sky130_ef_sc_hd__decap_12
XFILLER_166_1397 VPWR VGND VPWR VGND sky130_ef_sc_hd__decap_12
XFILLER_205_497 VGND VGND VPWR VPWR sky130_fd_sc_hd__decap_6
XFILLER_162_1239 VGND VGND VPWR VPWR sky130_fd_sc_hd__decap_6
XFILLER_242_1241 VPWR VGND VPWR VGND sky130_ef_sc_hd__decap_12
XFILLER_220_445 VPWR VGND VPWR VGND sky130_ef_sc_hd__decap_12
XFILLER_177_349 VPWR VGND VPWR VGND sky130_ef_sc_hd__decap_12
XFILLER_193_809 VPWR VGND VPWR VGND sky130_ef_sc_hd__decap_12
XFILLER_14_1507 VGND VGND VPWR VPWR sky130_fd_sc_hd__decap_8
XFILLER_186_861 VGND VGND VPWR VPWR sky130_fd_sc_hd__decap_6
XFILLER_203_1225 VGND VGND VPWR VPWR sky130_fd_sc_hd__decap_6
XFILLER_242_1285 VPWR VGND VPWR VGND sky130_ef_sc_hd__decap_12
XFILLER_220_489 VPWR VGND VPWR VGND sky130_ef_sc_hd__decap_12
XPHY_EDGE_ROW_34_2_Left_536 VGND VGND VPWR VPWR sky130_fd_sc_hd__decap_3
XFILLER_72_3 VPWR VGND VPWR VGND sky130_ef_sc_hd__decap_12
XFILLER_203_1269 VPWR VGND VPWR VGND sky130_ef_sc_hd__decap_12
XFILLER_185_393 VPWR VGND VPWR VGND sky130_ef_sc_hd__decap_12
XPHY_EDGE_ROW_159_2_Left_661 VGND VGND VPWR VPWR sky130_fd_sc_hd__decap_3
XFILLER_173_1313 VPWR VGND VPWR VGND sky130_ef_sc_hd__decap_12
XTAP_TAPCELL_ROW_118_2_4464 VGND VPWR sky130_fd_sc_hd__tapvpwrvgnd_1
XFILLER_177_1493 VPWR VGND VPWR VGND sky130_ef_sc_hd__decap_12
XFILLER_173_1357 VPWR VGND VPWR VGND sky130_ef_sc_hd__decap_12
XPHY_EDGE_ROW_20_2_Right_111 VGND VGND VPWR VPWR sky130_fd_sc_hd__decap_3
XFILLER_206_53 VPWR VGND VPWR VGND sky130_ef_sc_hd__decap_12
XFILLER_253_1381 VPWR VGND VPWR VGND sky130_ef_sc_hd__decap_12
XFILLER_228_501 VPWR VGND VPWR VGND sky130_ef_sc_hd__decap_12
XFILLER_206_97 VPWR VGND VPWR VGND sky130_ef_sc_hd__decap_12
XFILLER_214_1365 VGND VGND VPWR VPWR sky130_fd_sc_hd__decap_6
XFILLER_228_545 VPWR VGND VPWR VGND sky130_ef_sc_hd__decap_12
XFILLER_210_1229 VPWR VGND VPWR VGND sky130_ef_sc_hd__decap_12
XTAP_TAPCELL_ROW_225_2955 VGND VPWR sky130_fd_sc_hd__tapvpwrvgnd_1
XTAP_TAPCELL_ROW_225_2966 VGND VPWR sky130_fd_sc_hd__tapvpwrvgnd_1
XTAP_TAPCELL_ROW_111_2_4418 VGND VPWR sky130_fd_sc_hd__tapvpwrvgnd_1
XTAP_TAPCELL_ROW_66_2_4151 VGND VPWR sky130_fd_sc_hd__tapvpwrvgnd_1
XFILLER_222_41 VPWR VGND VPWR VGND sky130_ef_sc_hd__decap_12
XFILLER_228_589 VPWR VGND VPWR VGND sky130_ef_sc_hd__decap_12
XFILLER_215_217 VGND VGND VPWR VPWR sky130_fd_sc_hd__decap_6
XFILLER_222_85 VPWR VGND VPWR VGND sky130_ef_sc_hd__decap_12
XFILLER_243_559 VGND VGND VPWR VPWR sky130_fd_sc_hd__fill_1
XPHY_EDGE_ROW_48_1_Left_303 VGND VGND VPWR VPWR sky130_fd_sc_hd__decap_3
XFILLER_35_39 VPWR VGND VPWR VGND sky130_ef_sc_hd__decap_12
XFILLER_184_1453 VPWR VGND VPWR VGND sky130_ef_sc_hd__decap_12
XFILLER_230_209 VPWR VGND VPWR VGND sky130_ef_sc_hd__decap_12
XFILLER_223_261 VPWR VGND VPWR VGND sky130_ef_sc_hd__decap_12
XPHY_EDGE_ROW_100_1_Left_355 VGND VGND VPWR VPWR sky130_fd_sc_hd__decap_3
XFILLER_180_1317 VPWR VGND VPWR VGND sky130_ef_sc_hd__decap_12
XFILLER_208_1147 VGND VGND VPWR VPWR sky130_fd_sc_hd__fill_1
XFILLER_169_839 VGND VGND VPWR VPWR sky130_fd_sc_hd__fill_1
XFILLER_184_1497 VPWR VGND VPWR VGND sky130_ef_sc_hd__decap_12
XFILLER_196_625 VPWR VGND VPWR VGND sky130_ef_sc_hd__decap_12
XFILLER_195_113 VPWR VGND VPWR VGND sky130_ef_sc_hd__decap_12
XFILLER_212_979 VGND VGND VPWR VPWR sky130_fd_sc_hd__fill_1
XFILLER_56_1191 VPWR VGND VPWR VGND sky130_ef_sc_hd__decap_12
XFILLER_51_27 VPWR VGND VPWR VGND sky130_ef_sc_hd__decap_12
XFILLER_196_669 VPWR VGND VPWR VGND sky130_ef_sc_hd__decap_12
Xwire408 net409 VGND VGND VPWR VPWR net408 sky130_fd_sc_hd__clkbuf_1
XFILLER_221_1325 VPWR VGND VPWR VGND sky130_ef_sc_hd__decap_12
Xwire419 net420 VGND VGND VPWR VPWR net419 sky130_fd_sc_hd__clkbuf_1
XFILLER_167_27 VPWR VGND VPWR VGND sky130_ef_sc_hd__decap_12
XFILLER_221_1369 VPWR VGND VPWR VGND sky130_ef_sc_hd__decap_12
XFILLER_104_1189 VGND VGND VPWR VPWR sky130_fd_sc_hd__fill_1
XFILLER_139_1219 VPWR VGND VPWR VGND sky130_ef_sc_hd__decap_12
XFILLER_247_93 VPWR VGND VPWR VGND sky130_ef_sc_hd__decap_12
XFILLER_183_15 VPWR VGND VPWR VGND sky130_ef_sc_hd__decap_12
XFILLER_191_385 VGND VGND VPWR VPWR sky130_fd_sc_hd__decap_6
XFILLER_191_1413 VPWR VGND VPWR VGND sky130_ef_sc_hd__decap_12
XFILLER_191_1457 VPWR VGND VPWR VGND sky130_ef_sc_hd__decap_12
XFILLER_219_1287 VGND VGND VPWR VPWR sky130_fd_sc_hd__fill_1
XPHY_EDGE_ROW_80_2_Left_582 VGND VGND VPWR VPWR sky130_fd_sc_hd__decap_3
XFILLER_116_53 VPWR VGND VPWR VGND sky130_ef_sc_hd__decap_12
XFILLER_238_309 VPWR VGND VPWR VGND sky130_ef_sc_hd__decap_12
XFILLER_232_1421 VGND VGND VPWR VPWR sky130_fd_sc_hd__decap_6
XFILLER_28_1271 VPWR VGND VPWR VGND sky130_ef_sc_hd__decap_12
XFILLER_247_821 VPWR VGND VPWR VGND sky130_ef_sc_hd__decap_12
XFILLER_8_1365 VGND VGND VPWR VPWR sky130_fd_sc_hd__decap_6
XFILLER_232_1465 VPWR VGND VPWR VGND sky130_ef_sc_hd__decap_12
XFILLER_98_1203 VPWR VGND VPWR VGND sky130_ef_sc_hd__decap_12
XFILLER_247_865 VPWR VGND VPWR VGND sky130_ef_sc_hd__decap_12
Xfanout596 net597 VGND VGND VPWR VPWR net596 sky130_fd_sc_hd__clkbuf_2
XFILLER_4_1229 VPWR VGND VPWR VGND sky130_ef_sc_hd__decap_12
XFILLER_150_1165 VPWR VGND VPWR VGND sky130_ef_sc_hd__decap_12
XFILLER_98_1247 VPWR VGND VPWR VGND sky130_ef_sc_hd__decap_12
XFILLER_132_41 VPWR VGND VPWR VGND sky130_ef_sc_hd__decap_12
XFILLER_207_729 VPWR VGND VPWR VGND sky130_ef_sc_hd__decap_12
XPHY_EDGE_ROW_123_1_Right_779 VGND VGND VPWR VPWR sky130_fd_sc_hd__decap_3
XPHY_EDGE_ROW_32_1_Left_287 VGND VGND VPWR VPWR sky130_fd_sc_hd__decap_3
XFILLER_226_1203 VGND VGND VPWR VPWR sky130_fd_sc_hd__fill_1
XFILLER_199_441 VGND VGND VPWR VPWR sky130_fd_sc_hd__decap_6
X_403_ net569 net590 net589 VGND VGND VPWR VPWR _192_ sky130_fd_sc_hd__and3_1
XFILLER_202_401 VPWR VGND VPWR VGND sky130_ef_sc_hd__decap_12
XFILLER_242_581 VGND VGND VPWR VPWR sky130_fd_sc_hd__decap_6
XTAP_TAPCELL_ROW_36_1_1171 VGND VPWR sky130_fd_sc_hd__tapvpwrvgnd_1
XFILLER_199_485 VPWR VGND VPWR VGND sky130_ef_sc_hd__decap_12
XFILLER_202_445 VPWR VGND VPWR VGND sky130_ef_sc_hd__decap_12
X_334_ net594 dout0_q\[18\] net537 VGND VGND VPWR VPWR _123_ sky130_fd_sc_hd__and3_1
XFILLER_35_1231 VPWR VGND VPWR VGND sky130_ef_sc_hd__decap_12
XTAP_TAPCELL_ROW_235_3240 VGND VPWR sky130_fd_sc_hd__tapvpwrvgnd_1
XFILLER_175_809 VPWR VGND VPWR VGND sky130_ef_sc_hd__decap_12
XFILLER_168_861 VGND VGND VPWR VPWR sky130_fd_sc_hd__decap_6
XFILLER_202_489 VPWR VGND VPWR VGND sky130_ef_sc_hd__decap_12
XTAP_TAPCELL_ROW_124_2_4496 VGND VPWR sky130_fd_sc_hd__tapvpwrvgnd_1
XFILLER_35_1275 VPWR VGND VPWR VGND sky130_ef_sc_hd__decap_12
XTAP_TAPCELL_ROW_231_3115 VGND VPWR sky130_fd_sc_hd__tapvpwrvgnd_1
XTAP_TAPCELL_ROW_231_3126 VGND VPWR sky130_fd_sc_hd__tapvpwrvgnd_1
XFILLER_200_1409 VPWR VGND VPWR VGND sky130_ef_sc_hd__decap_12
XFILLER_70_1177 VPWR VGND VPWR VGND sky130_ef_sc_hd__decap_12
XFILLER_122_1245 VGND VGND VPWR VPWR sky130_fd_sc_hd__fill_1
XFILLER_167_393 VPWR VGND VPWR VGND sky130_ef_sc_hd__decap_12
XFILLER_183_853 VPWR VGND VPWR VGND sky130_ef_sc_hd__decap_12
XFILLER_182_363 VGND VGND VPWR VPWR sky130_fd_sc_hd__fill_1
XFILLER_183_897 VPWR VGND VPWR VGND sky130_ef_sc_hd__decap_12
XFILLER_6_587 VGND VGND VPWR VPWR sky130_fd_sc_hd__fill_1
XFILLER_170_525 VGND VGND VPWR VPWR sky130_fd_sc_hd__decap_6
XFILLER_237_1343 VGND VGND VPWR VPWR sky130_fd_sc_hd__fill_1
XFILLER_170_569 VPWR VGND VPWR VGND sky130_ef_sc_hd__decap_12
XTAP_TAPCELL_ROW_229_3055 VGND VPWR sky130_fd_sc_hd__tapvpwrvgnd_1
XTAP_TAPCELL_ROW_229_3066 VGND VPWR sky130_fd_sc_hd__tapvpwrvgnd_1
XTAP_TAPCELL_ROW_229_3077 VGND VPWR sky130_fd_sc_hd__tapvpwrvgnd_1
XFILLER_46_1371 VPWR VGND VPWR VGND sky130_ef_sc_hd__decap_12
XFILLER_173_81 VPWR VGND VPWR VGND sky130_ef_sc_hd__decap_12
XFILLER_81_1273 VGND VGND VPWR VPWR sky130_fd_sc_hd__fill_1
XFILLER_211_1505 VGND VGND VPWR VPWR sky130_fd_sc_hd__decap_6
XPHY_EDGE_ROW_85_1_Right_741 VGND VGND VPWR VPWR sky130_fd_sc_hd__decap_3
XFILLER_2_65 VPWR VGND VPWR VGND sky130_ef_sc_hd__decap_12
XFILLER_133_1385 VGND VGND VPWR VPWR sky130_fd_sc_hd__fill_1
XFILLER_252_301 VGND VGND VPWR VPWR sky130_fd_sc_hd__decap_6
XFILLER_225_559 VGND VGND VPWR VPWR sky130_fd_sc_hd__fill_1
XFILLER_252_345 VPWR VGND VPWR VGND sky130_ef_sc_hd__decap_12
XFILLER_209_1401 VPWR VGND VPWR VGND sky130_ef_sc_hd__decap_12
XTAP_TAPCELL_ROW_220_2830 VGND VPWR sky130_fd_sc_hd__tapvpwrvgnd_1
XFILLER_212_209 VPWR VGND VPWR VGND sky130_ef_sc_hd__decap_12
XFILLER_252_389 VPWR VGND VPWR VGND sky130_ef_sc_hd__decap_12
XFILLER_248_1483 VGND VGND VPWR VPWR sky130_fd_sc_hd__fill_1
XTAP_TAPCELL_ROW_83_1_1218 VGND VPWR sky130_fd_sc_hd__tapvpwrvgnd_1
XFILLER_166_1161 VPWR VGND VPWR VGND sky130_ef_sc_hd__decap_12
XFILLER_205_261 VPWR VGND VPWR VGND sky130_ef_sc_hd__decap_12
XFILLER_221_721 VGND VGND VPWR VPWR sky130_fd_sc_hd__decap_6
XFILLER_178_625 VPWR VGND VPWR VGND sky130_ef_sc_hd__decap_12
XFILLER_177_113 VPWR VGND VPWR VGND sky130_ef_sc_hd__decap_12
XFILLER_221_765 VPWR VGND VPWR VGND sky130_ef_sc_hd__decap_12
XFILLER_53_1331 VPWR VGND VPWR VGND sky130_ef_sc_hd__decap_12
XTAP_TAPCELL_ROW_44_2_4018 VGND VPWR sky130_fd_sc_hd__tapvpwrvgnd_1
XFILLER_178_669 VPWR VGND VPWR VGND sky130_ef_sc_hd__decap_12
XFILLER_18_1451 VPWR VGND VPWR VGND sky130_ef_sc_hd__decap_12
XFILLER_220_253 VPWR VGND VPWR VGND sky130_ef_sc_hd__decap_12
XFILLER_127_1189 VPWR VGND VPWR VGND sky130_ef_sc_hd__decap_12
XFILLER_140_1301 VGND VGND VPWR VPWR sky130_fd_sc_hd__fill_1
XFILLER_193_617 VPWR VGND VPWR VGND sky130_ef_sc_hd__decap_12
XFILLER_14_1315 VPWR VGND VPWR VGND sky130_ef_sc_hd__decap_12
XFILLER_18_1495 VPWR VGND VPWR VGND sky130_ef_sc_hd__decap_12
XFILLER_105_1443 VPWR VGND VPWR VGND sky130_ef_sc_hd__decap_12
XTAP_TAPCELL_ROW_193_2085 VGND VPWR sky130_fd_sc_hd__tapvpwrvgnd_1
XFILLER_203_1033 VPWR VGND VPWR VGND sky130_ef_sc_hd__decap_12
XFILLER_242_1093 VPWR VGND VPWR VGND sky130_ef_sc_hd__decap_12
XTAP_TAPCELL_ROW_218_2770 VGND VPWR sky130_fd_sc_hd__tapvpwrvgnd_1
XFILLER_179_1511 VGND VGND VPWR VPWR sky130_fd_sc_hd__fill_1
XTAP_TAPCELL_ROW_193_2096 VGND VPWR sky130_fd_sc_hd__tapvpwrvgnd_1
XTAP_TAPCELL_ROW_218_2781 VGND VPWR sky130_fd_sc_hd__tapvpwrvgnd_1
XFILLER_14_1359 VPWR VGND VPWR VGND sky130_ef_sc_hd__decap_12
XFILLER_88_1427 VPWR VGND VPWR VGND sky130_ef_sc_hd__decap_12
XFILLER_203_1077 VPWR VGND VPWR VGND sky130_ef_sc_hd__decap_12
XFILLER_101_1329 VGND VGND VPWR VPWR sky130_fd_sc_hd__fill_1
XTAP_TAPCELL_ROW_214_2656 VGND VPWR sky130_fd_sc_hd__tapvpwrvgnd_1
XTAP_TAPCELL_ROW_214_2667 VGND VPWR sky130_fd_sc_hd__tapvpwrvgnd_1
XFILLER_238_1129 VPWR VGND VPWR VGND sky130_ef_sc_hd__decap_12
XFILLER_173_385 VGND VGND VPWR VPWR sky130_fd_sc_hd__decap_6
XFILLER_173_1121 VPWR VGND VPWR VGND sky130_ef_sc_hd__decap_12
XFILLER_216_1427 VGND VGND VPWR VPWR sky130_fd_sc_hd__fill_1
XFILLER_25_1411 VPWR VGND VPWR VGND sky130_ef_sc_hd__decap_12
XFILLER_64_1471 VPWR VGND VPWR VGND sky130_ef_sc_hd__decap_12
XPHY_EDGE_ROW_21_2_Right_112 VGND VGND VPWR VPWR sky130_fd_sc_hd__decap_3
XFILLER_229_821 VPWR VGND VPWR VGND sky130_ef_sc_hd__decap_12
XFILLER_5_1505 VGND VGND VPWR VPWR sky130_fd_sc_hd__decap_6
XFILLER_151_1441 VGND VGND VPWR VPWR sky130_fd_sc_hd__fill_1
XFILLER_25_1455 VPWR VGND VPWR VGND sky130_ef_sc_hd__decap_12
XFILLER_214_1173 VPWR VGND VPWR VGND sky130_ef_sc_hd__decap_12
XFILLER_233_51 VGND VGND VPWR VPWR sky130_fd_sc_hd__decap_4
XFILLER_60_1357 VGND VGND VPWR VPWR sky130_fd_sc_hd__fill_1
XFILLER_229_865 VPWR VGND VPWR VGND sky130_ef_sc_hd__decap_12
XFILLER_244_813 VPWR VGND VPWR VGND sky130_ef_sc_hd__decap_12
XFILLER_46_27 VGND VGND VPWR VPWR sky130_fd_sc_hd__fill_1
XFILLER_210_1037 VPWR VGND VPWR VGND sky130_ef_sc_hd__decap_12
XFILLER_25_1499 VPWR VGND VPWR VGND sky130_ef_sc_hd__decap_12
XFILLER_249_1225 VGND VGND VPWR VPWR sky130_fd_sc_hd__decap_6
XFILLER_112_1469 VGND VGND VPWR VPWR sky130_fd_sc_hd__fill_1
XFILLER_249_1269 VPWR VGND VPWR VGND sky130_ef_sc_hd__decap_12
XTAP_TAPCELL_ROW_141_2_4602 VGND VPWR sky130_fd_sc_hd__tapvpwrvgnd_1
XFILLER_145_1201 VPWR VGND VPWR VGND sky130_ef_sc_hd__decap_12
XFILLER_231_529 VPWR VGND VPWR VGND sky130_ef_sc_hd__decap_12
XFILLER_184_1261 VPWR VGND VPWR VGND sky130_ef_sc_hd__decap_12
XFILLER_62_26 VGND VGND VPWR VPWR sky130_fd_sc_hd__fill_2
XFILLER_224_581 VGND VGND VPWR VPWR sky130_fd_sc_hd__decap_6
XFILLER_197_945 VGND VGND VPWR VPWR sky130_fd_sc_hd__decap_6
XFILLER_93_1177 VPWR VGND VPWR VGND sky130_ef_sc_hd__decap_12
XFILLER_178_15 VPWR VGND VPWR VGND sky130_ef_sc_hd__decap_12
XFILLER_196_433 VPWR VGND VPWR VGND sky130_ef_sc_hd__decap_12
XFILLER_200_905 VPWR VGND VPWR VGND sky130_ef_sc_hd__decap_12
XFILLER_145_1267 VGND VGND VPWR VPWR sky130_fd_sc_hd__decap_6
XFILLER_180_1147 VGND VGND VPWR VPWR sky130_fd_sc_hd__fill_1
XFILLER_197_989 VPWR VGND VPWR VGND sky130_ef_sc_hd__decap_12
XFILLER_196_477 VPWR VGND VPWR VGND sky130_ef_sc_hd__decap_12
XFILLER_200_949 VPWR VGND VPWR VGND sky130_ef_sc_hd__decap_12
XFILLER_32_1415 VPWR VGND VPWR VGND sky130_ef_sc_hd__decap_12
XFILLER_183_105 VGND VGND VPWR VPWR sky130_fd_sc_hd__decap_6
Xwire227 net228 VGND VGND VPWR VPWR net227 sky130_fd_sc_hd__clkbuf_1
XFILLER_221_1133 VPWR VGND VPWR VGND sky130_ef_sc_hd__decap_12
Xwire238 net239 VGND VGND VPWR VPWR net238 sky130_fd_sc_hd__clkbuf_1
XFILLER_71_1497 VGND VGND VPWR VPWR sky130_fd_sc_hd__fill_1
Xwire249 net250 VGND VGND VPWR VPWR net249 sky130_fd_sc_hd__clkbuf_1
XFILLER_165_853 VPWR VGND VPWR VGND sky130_ef_sc_hd__decap_12
XFILLER_183_149 VPWR VGND VPWR VGND sky130_ef_sc_hd__decap_12
XFILLER_221_1177 VPWR VGND VPWR VGND sky130_ef_sc_hd__decap_12
XFILLER_165_897 VPWR VGND VPWR VGND sky130_ef_sc_hd__decap_12
XFILLER_191_193 VPWR VGND VPWR VGND sky130_ef_sc_hd__decap_12
XFILLER_180_867 VGND VGND VPWR VPWR sky130_fd_sc_hd__fill_1
XFILLER_65_1213 VGND VGND VPWR VPWR sky130_fd_sc_hd__decap_4
XTAP_TAPCELL_ROW_57_2_4096 VGND VPWR sky130_fd_sc_hd__tapvpwrvgnd_1
XTAP_TAPCELL_ROW_189_1976 VGND VPWR sky130_fd_sc_hd__tapvpwrvgnd_1
XFILLER_239_629 VPWR VGND VPWR VGND sky130_ef_sc_hd__decap_12
XFILLER_152_1227 VPWR VGND VPWR VGND sky130_ef_sc_hd__decap_12
XTAP_TAPCELL_ROW_189_1987 VGND VPWR sky130_fd_sc_hd__tapvpwrvgnd_1
XFILLER_43_1511 VGND VGND VPWR VPWR sky130_fd_sc_hd__decap_4
XTAP_TAPCELL_ROW_189_1998 VGND VPWR sky130_fd_sc_hd__tapvpwrvgnd_1
XFILLER_191_1287 VGND VGND VPWR VPWR sky130_fd_sc_hd__fill_1
XFILLER_238_139 VGND VGND VPWR VPWR sky130_fd_sc_hd__fill_1
XFILLER_8_1173 VPWR VGND VPWR VGND sky130_ef_sc_hd__decap_12
XFILLER_143_51 VGND VGND VPWR VPWR sky130_fd_sc_hd__decap_4
XFILLER_232_1273 VPWR VGND VPWR VGND sky130_ef_sc_hd__decap_12
XFILLER_247_673 VPWR VGND VPWR VGND sky130_ef_sc_hd__decap_12
XTAP_TAPCELL_ROW_5_1010 VGND VPWR sky130_fd_sc_hd__tapvpwrvgnd_1
XFILLER_4_1037 VPWR VGND VPWR VGND sky130_ef_sc_hd__decap_12
XFILLER_234_301 VGND VGND VPWR VPWR sky130_fd_sc_hd__decap_6
XTAP_TAPCELL_ROW_35_2_3966 VGND VPWR sky130_fd_sc_hd__tapvpwrvgnd_1
XFILLER_207_559 VGND VGND VPWR VPWR sky130_fd_sc_hd__fill_1
XFILLER_228_1309 VGND VGND VPWR VPWR sky130_fd_sc_hd__decap_6
XFILLER_234_345 VPWR VGND VPWR VGND sky130_ef_sc_hd__decap_12
XFILLER_250_805 VGND VGND VPWR VPWR sky130_fd_sc_hd__decap_6
XFILLER_234_389 VPWR VGND VPWR VGND sky130_ef_sc_hd__decap_12
XFILLER_250_849 VPWR VGND VPWR VGND sky130_ef_sc_hd__decap_12
XFILLER_167_1481 VPWR VGND VPWR VGND sky130_ef_sc_hd__decap_12
XFILLER_188_923 VGND VGND VPWR VPWR sky130_fd_sc_hd__fill_1
XFILLER_203_721 VGND VGND VPWR VPWR sky130_fd_sc_hd__decap_6
XFILLER_163_1323 VGND VGND VPWR VPWR sky130_fd_sc_hd__decap_6
XTAP_TAPCELL_ROW_15_2_3842 VGND VPWR sky130_fd_sc_hd__tapvpwrvgnd_1
XFILLER_199_293 VPWR VGND VPWR VGND sky130_ef_sc_hd__decap_12
XFILLER_72_1239 VGND VGND VPWR VPWR sky130_fd_sc_hd__decap_6
XFILLER_203_765 VPWR VGND VPWR VGND sky130_ef_sc_hd__decap_12
XFILLER_163_1367 VPWR VGND VPWR VGND sky130_ef_sc_hd__decap_12
XFILLER_202_253 VPWR VGND VPWR VGND sky130_ef_sc_hd__decap_12
X_317_ net505 _105_ VGND VGND VPWR VPWR _106_ sky130_fd_sc_hd__or2_1
XFILLER_175_617 VPWR VGND VPWR VGND sky130_ef_sc_hd__decap_12
XTAP_TAPCELL_ROW_144_1_1279 VGND VPWR sky130_fd_sc_hd__tapvpwrvgnd_1
XFILLER_204_1353 VPWR VGND VPWR VGND sky130_ef_sc_hd__decap_12
XFILLER_238_29 VPWR VGND VPWR VGND sky130_ef_sc_hd__decap_12
Xinput13 wr_data[12] VGND VGND VPWR VPWR net13 sky130_fd_sc_hd__clkbuf_1
Xinput24 wr_data[22] VGND VGND VPWR VPWR net24 sky130_fd_sc_hd__clkbuf_1
XFILLER_200_1217 VPWR VGND VPWR VGND sky130_ef_sc_hd__decap_12
Xinput35 wr_data[3] VGND VGND VPWR VPWR net35 sky130_fd_sc_hd__clkbuf_1
XTAP_TAPCELL_ROW_154_2_4680 VGND VPWR sky130_fd_sc_hd__tapvpwrvgnd_1
XFILLER_204_1397 VPWR VGND VPWR VGND sky130_ef_sc_hd__decap_12
Xmax_cap505 _104_ VGND VGND VPWR VPWR net505 sky130_fd_sc_hd__clkbuf_1
XFILLER_6_362 VGND VGND VPWR VPWR sky130_fd_sc_hd__fill_2
Xmax_cap527 net63 VGND VGND VPWR VPWR net527 sky130_fd_sc_hd__clkbuf_1
XFILLER_239_1449 VGND VGND VPWR VPWR sky130_fd_sc_hd__decap_6
Xmax_cap538 net51 VGND VGND VPWR VPWR net538 sky130_fd_sc_hd__clkbuf_1
Xmax_cap549 net74 VGND VGND VPWR VPWR net549 sky130_fd_sc_hd__clkbuf_1
XFILLER_100_1351 VGND VGND VPWR VPWR sky130_fd_sc_hd__decap_6
XFILLER_170_333 VPWR VGND VPWR VGND sky130_ef_sc_hd__decap_12
XFILLER_192_1029 VGND VGND VPWR VPWR sky130_fd_sc_hd__decap_6
XFILLER_171_889 VGND VGND VPWR VPWR sky130_fd_sc_hd__decap_6
XFILLER_174_1441 VPWR VGND VPWR VGND sky130_ef_sc_hd__decap_12
XFILLER_100_1395 VPWR VGND VPWR VGND sky130_ef_sc_hd__decap_12
XFILLER_170_377 VPWR VGND VPWR VGND sky130_ef_sc_hd__decap_12
XFILLER_35_3 VPWR VGND VPWR VGND sky130_ef_sc_hd__decap_12
XFILLER_174_1485 VPWR VGND VPWR VGND sky130_ef_sc_hd__decap_12
XFILLER_83_1379 VGND VGND VPWR VPWR sky130_fd_sc_hd__decap_6
XTAP_TAPCELL_ROW_146_2_4628 VGND VPWR sky130_fd_sc_hd__tapvpwrvgnd_1
XFILLER_211_1313 VPWR VGND VPWR VGND sky130_ef_sc_hd__decap_12
XFILLER_250_1373 VPWR VGND VPWR VGND sky130_ef_sc_hd__decap_12
XFILLER_215_1493 VPWR VGND VPWR VGND sky130_ef_sc_hd__decap_12
XFILLER_244_109 VPWR VGND VPWR VGND sky130_ef_sc_hd__decap_12
XPHY_EDGE_ROW_86_1_Right_742 VGND VGND VPWR VPWR sky130_fd_sc_hd__decap_3
XFILLER_226_813 VPWR VGND VPWR VGND sky130_ef_sc_hd__decap_12
XFILLER_211_1357 VPWR VGND VPWR VGND sky130_ef_sc_hd__decap_12
XFILLER_237_161 VGND VGND VPWR VPWR sky130_fd_sc_hd__decap_6
XTAP_TAPCELL_ROW_207_2471 VGND VPWR sky130_fd_sc_hd__tapvpwrvgnd_1
XTAP_TAPCELL_ROW_207_2482 VGND VPWR sky130_fd_sc_hd__tapvpwrvgnd_1
XFILLER_246_1409 VPWR VGND VPWR VGND sky130_ef_sc_hd__decap_12
XFILLER_0_1413 VPWR VGND VPWR VGND sky130_ef_sc_hd__decap_12
XFILLER_253_665 VGND VGND VPWR VPWR sky130_fd_sc_hd__decap_6
XFILLER_252_153 VPWR VGND VPWR VGND sky130_ef_sc_hd__decap_12
XTAP_TAPCELL_ROW_199_2250 VGND VPWR sky130_fd_sc_hd__tapvpwrvgnd_1
XTAP_TAPCELL_ROW_203_2357 VGND VPWR sky130_fd_sc_hd__tapvpwrvgnd_1
XFILLER_111_1491 VGND VGND VPWR VPWR sky130_fd_sc_hd__decap_6
XTAP_TAPCELL_ROW_203_2368 VGND VPWR sky130_fd_sc_hd__tapvpwrvgnd_1
XFILLER_0_1457 VPWR VGND VPWR VGND sky130_ef_sc_hd__decap_12
XTAP_TAPCELL_ROW_199_2261 VGND VPWR sky130_fd_sc_hd__tapvpwrvgnd_1
XTAP_TAPCELL_ROW_203_2379 VGND VPWR sky130_fd_sc_hd__tapvpwrvgnd_1
XFILLER_213_529 VPWR VGND VPWR VGND sky130_ef_sc_hd__decap_12
XFILLER_209_1231 VGND VGND VPWR VPWR sky130_fd_sc_hd__fill_1
XFILLER_181_1401 VPWR VGND VPWR VGND sky130_ef_sc_hd__decap_12
XFILLER_206_581 VGND VGND VPWR VPWR sky130_fd_sc_hd__decap_6
XFILLER_252_197 VPWR VGND VPWR VGND sky130_ef_sc_hd__decap_12
XFILLER_179_945 VGND VGND VPWR VPWR sky130_fd_sc_hd__decap_6
XTAP_TAPCELL_ROW_195_2147 VGND VPWR sky130_fd_sc_hd__tapvpwrvgnd_1
XFILLER_178_433 VPWR VGND VPWR VGND sky130_ef_sc_hd__decap_12
XFILLER_90_1339 VPWR VGND VPWR VGND sky130_ef_sc_hd__decap_12
XTAP_TAPCELL_ROW_195_2158 VGND VPWR sky130_fd_sc_hd__tapvpwrvgnd_1
XFILLER_142_1407 VGND VGND VPWR VPWR sky130_fd_sc_hd__decap_6
XFILLER_179_989 VPWR VGND VPWR VGND sky130_ef_sc_hd__decap_12
XFILLER_221_573 VPWR VGND VPWR VGND sky130_ef_sc_hd__decap_12
XFILLER_32_29 VPWR VGND VPWR VGND sky130_ef_sc_hd__decap_12
XFILLER_178_477 VPWR VGND VPWR VGND sky130_ef_sc_hd__decap_12
XTAP_TAPCELL_ROW_216_2707 VGND VPWR sky130_fd_sc_hd__tapvpwrvgnd_1
XFILLER_194_937 VPWR VGND VPWR VGND sky130_ef_sc_hd__decap_12
XTAP_TAPCELL_ROW_216_2718 VGND VPWR sky130_fd_sc_hd__tapvpwrvgnd_1
XTAP_TAPCELL_ROW_216_2729 VGND VPWR sky130_fd_sc_hd__tapvpwrvgnd_1
XFILLER_148_29 VPWR VGND VPWR VGND sky130_ef_sc_hd__decap_12
XFILLER_222_1453 VPWR VGND VPWR VGND sky130_ef_sc_hd__decap_12
XFILLER_193_447 VGND VGND VPWR VPWR sky130_fd_sc_hd__fill_1
XFILLER_181_609 VGND VGND VPWR VPWR sky130_fd_sc_hd__decap_6
XFILLER_105_1273 VGND VGND VPWR VPWR sky130_fd_sc_hd__fill_1
XFILLER_222_1497 VPWR VGND VPWR VGND sky130_ef_sc_hd__decap_12
XFILLER_14_1189 VGND VGND VPWR VPWR sky130_fd_sc_hd__fill_1
XFILLER_49_1219 VPWR VGND VPWR VGND sky130_ef_sc_hd__decap_12
XFILLER_173_193 VPWR VGND VPWR VGND sky130_ef_sc_hd__decap_12
XTAP_TAPCELL_ROW_171_1490 VGND VPWR sky130_fd_sc_hd__tapvpwrvgnd_1
XFILLER_255_1273 VPWR VGND VPWR VGND sky130_ef_sc_hd__decap_12
XFILLER_0_527 VGND VGND VPWR VPWR sky130_fd_sc_hd__fill_2
XTAP_TAPCELL_ROW_41_2_3998 VGND VPWR sky130_fd_sc_hd__tapvpwrvgnd_1
XFILLER_57_15 VPWR VGND VPWR VGND sky130_ef_sc_hd__decap_12
XFILLER_244_83 VGND VGND VPWR VPWR sky130_fd_sc_hd__fill_1
XFILLER_5_1313 VPWR VGND VPWR VGND sky130_ef_sc_hd__decap_12
XPHY_EDGE_ROW_22_2_Right_113 VGND VGND VPWR VPWR sky130_fd_sc_hd__decap_3
XFILLER_180_27 VGND VGND VPWR VPWR sky130_fd_sc_hd__fill_1
XTAP_TAPCELL_ROW_184_1840 VGND VPWR sky130_fd_sc_hd__tapvpwrvgnd_1
XTAP_TAPCELL_ROW_184_1851 VGND VPWR sky130_fd_sc_hd__tapvpwrvgnd_1
XFILLER_99_1331 VPWR VGND VPWR VGND sky130_ef_sc_hd__decap_12
XFILLER_169_1009 VPWR VGND VPWR VGND sky130_ef_sc_hd__decap_12
XTAP_TAPCELL_ROW_184_1862 VGND VPWR sky130_fd_sc_hd__tapvpwrvgnd_1
XFILLER_60_1165 VPWR VGND VPWR VGND sky130_ef_sc_hd__decap_12
XFILLER_229_673 VPWR VGND VPWR VGND sky130_ef_sc_hd__decap_12
XFILLER_5_1357 VPWR VGND VPWR VGND sky130_ef_sc_hd__decap_12
XFILLER_216_301 VGND VGND VPWR VPWR sky130_fd_sc_hd__decap_6
XFILLER_249_1033 VPWR VGND VPWR VGND sky130_ef_sc_hd__decap_12
XTAP_TAPCELL_ROW_180_1737 VGND VPWR sky130_fd_sc_hd__tapvpwrvgnd_1
XFILLER_244_643 VGND VGND VPWR VPWR sky130_fd_sc_hd__fill_1
XFILLER_95_1217 VGND VGND VPWR VPWR sky130_fd_sc_hd__fill_1
XTAP_TAPCELL_ROW_180_1748 VGND VPWR sky130_fd_sc_hd__tapvpwrvgnd_1
XPHY_EDGE_ROW_111_2_Left_613 VGND VGND VPWR VPWR sky130_fd_sc_hd__decap_3
XFILLER_216_345 VPWR VGND VPWR VGND sky130_ef_sc_hd__decap_12
XFILLER_232_805 VGND VGND VPWR VPWR sky130_fd_sc_hd__decap_6
XFILLER_189_709 VPWR VGND VPWR VGND sky130_ef_sc_hd__decap_12
XFILLER_249_1077 VPWR VGND VPWR VGND sky130_ef_sc_hd__decap_12
XFILLER_147_1329 VGND VGND VPWR VPWR sky130_fd_sc_hd__fill_1
XFILLER_216_389 VPWR VGND VPWR VGND sky130_ef_sc_hd__decap_12
XFILLER_73_69 VGND VGND VPWR VPWR sky130_fd_sc_hd__fill_2
XFILLER_232_849 VPWR VGND VPWR VGND sky130_ef_sc_hd__decap_12
XFILLER_231_337 VPWR VGND VPWR VGND sky130_ef_sc_hd__decap_12
XFILLER_189_69 VPWR VGND VPWR VGND sky130_ef_sc_hd__decap_12
XFILLER_184_1091 VGND VGND VPWR VPWR sky130_fd_sc_hd__fill_1
XFILLER_160_1507 VGND VGND VPWR VPWR sky130_fd_sc_hd__decap_8
XFILLER_197_753 VPWR VGND VPWR VGND sky130_ef_sc_hd__decap_12
XFILLER_200_713 VPWR VGND VPWR VGND sky130_ef_sc_hd__decap_12
XFILLER_240_893 VPWR VGND VPWR VGND sky130_ef_sc_hd__decap_12
XFILLER_237_3 VPWR VGND VPWR VGND sky130_ef_sc_hd__decap_12
XFILLER_197_797 VPWR VGND VPWR VGND sky130_ef_sc_hd__decap_12
XTAP_TAPCELL_ROW_178_1688 VGND VPWR sky130_fd_sc_hd__tapvpwrvgnd_1
XTAP_TAPCELL_ROW_178_1699 VGND VPWR sky130_fd_sc_hd__tapvpwrvgnd_1
XFILLER_200_757 VPWR VGND VPWR VGND sky130_ef_sc_hd__decap_12
XFILLER_32_1245 VGND VGND VPWR VPWR sky130_fd_sc_hd__fill_1
XFILLER_7_137 VGND VGND VPWR VPWR sky130_fd_sc_hd__decap_8
XFILLER_184_469 VGND VGND VPWR VPWR sky130_fd_sc_hd__decap_6
XFILLER_158_1469 VGND VGND VPWR VPWR sky130_fd_sc_hd__fill_1
XTAP_TAPCELL_ROW_132_2_4547 VGND VPWR sky130_fd_sc_hd__tapvpwrvgnd_1
XFILLER_117_1177 VPWR VGND VPWR VGND sky130_ef_sc_hd__decap_12
XFILLER_226_109 VPWR VGND VPWR VGND sky130_ef_sc_hd__decap_12
XFILLER_208_813 VPWR VGND VPWR VGND sky130_ef_sc_hd__decap_12
XFILLER_248_993 VPWR VGND VPWR VGND sky130_ef_sc_hd__decap_12
XFILLER_43_1385 VGND VGND VPWR VPWR sky130_fd_sc_hd__fill_1
XFILLER_219_161 VGND VGND VPWR VPWR sky130_fd_sc_hd__decap_6
XPHY_EDGE_ROW_43_2_Left_545 VGND VGND VPWR VPWR sky130_fd_sc_hd__decap_3
XFILLER_78_1415 VPWR VGND VPWR VGND sky130_ef_sc_hd__decap_12
XFILLER_235_665 VGND VGND VPWR VPWR sky130_fd_sc_hd__decap_6
XFILLER_228_1117 VPWR VGND VPWR VGND sky130_ef_sc_hd__decap_12
XFILLER_234_153 VPWR VGND VPWR VGND sky130_ef_sc_hd__decap_12
XFILLER_250_613 VPWR VGND VPWR VGND sky130_ef_sc_hd__decap_12
XTAP_TAPCELL_ROW_80_2_4234 VGND VPWR sky130_fd_sc_hd__tapvpwrvgnd_1
XTAP_TAPCELL_ROW_79_2_4228 VGND VPWR sky130_fd_sc_hd__tapvpwrvgnd_1
XFILLER_165_1429 VPWR VGND VPWR VGND sky130_ef_sc_hd__decap_12
XFILLER_234_197 VPWR VGND VPWR VGND sky130_ef_sc_hd__decap_12
XFILLER_250_657 VPWR VGND VPWR VGND sky130_ef_sc_hd__decap_12
XFILLER_203_573 VPWR VGND VPWR VGND sky130_ef_sc_hd__decap_12
XFILLER_249_39 VPWR VGND VPWR VGND sky130_ef_sc_hd__decap_12
XFILLER_128_1295 VGND VGND VPWR VPWR sky130_fd_sc_hd__decap_6
XFILLER_37_1189 VPWR VGND VPWR VGND sky130_ef_sc_hd__decap_12
XFILLER_176_937 VPWR VGND VPWR VGND sky130_ef_sc_hd__decap_12
XFILLER_50_1301 VGND VGND VPWR VPWR sky130_fd_sc_hd__fill_1
XTAP_TAPCELL_ROW_190_2011 VGND VPWR sky130_fd_sc_hd__tapvpwrvgnd_1
XTAP_TAPCELL_ROW_190_2022 VGND VPWR sky130_fd_sc_hd__tapvpwrvgnd_1
XFILLER_198_1205 VPWR VGND VPWR VGND sky130_ef_sc_hd__decap_12
XFILLER_8_53 VPWR VGND VPWR VGND sky130_ef_sc_hd__decap_12
XFILLER_15_1443 VPWR VGND VPWR VGND sky130_ef_sc_hd__decap_12
XFILLER_175_447 VGND VGND VPWR VPWR sky130_fd_sc_hd__fill_1
XFILLER_204_1161 VPWR VGND VPWR VGND sky130_ef_sc_hd__decap_12
XFILLER_89_1511 VGND VGND VPWR VPWR sky130_fd_sc_hd__decap_4
XFILLER_102_1413 VGND VGND VPWR VPWR sky130_fd_sc_hd__fill_1
XTAP_TAPCELL_ROW_78_1_1213 VGND VPWR sky130_fd_sc_hd__tapvpwrvgnd_1
XFILLER_8_97 VPWR VGND VPWR VGND sky130_ef_sc_hd__decap_12
XFILLER_11_1329 VGND VGND VPWR VPWR sky130_fd_sc_hd__fill_1
XFILLER_184_981 VPWR VGND VPWR VGND sky130_ef_sc_hd__decap_12
XFILLER_239_1213 VPWR VGND VPWR VGND sky130_ef_sc_hd__decap_12
Xwire580 dout0_q\[7\] VGND VGND VPWR VPWR net580 sky130_fd_sc_hd__clkbuf_1
XFILLER_239_1257 VPWR VGND VPWR VGND sky130_ef_sc_hd__decap_12
Xmax_cap335 _134_ VGND VGND VPWR VPWR net335 sky130_fd_sc_hd__clkbuf_1
XFILLER_6_192 VGND VGND VPWR VPWR sky130_fd_sc_hd__fill_1
XFILLER_171_653 VPWR VGND VPWR VGND sky130_ef_sc_hd__decap_12
XFILLER_170_141 VPWR VGND VPWR VGND sky130_ef_sc_hd__decap_12
XFILLER_217_1511 VGND VGND VPWR VPWR sky130_fd_sc_hd__fill_1
XPHY_EDGE_ROW_57_1_Left_312 VGND VGND VPWR VPWR sky130_fd_sc_hd__decap_3
XFILLER_171_697 VPWR VGND VPWR VGND sky130_ef_sc_hd__decap_12
XFILLER_83_1165 VPWR VGND VPWR VGND sky130_ef_sc_hd__decap_12
XFILLER_135_1255 VPWR VGND VPWR VGND sky130_ef_sc_hd__decap_12
XTAP_TAPCELL_ROW_209_2522 VGND VPWR sky130_fd_sc_hd__tapvpwrvgnd_1
XTAP_TAPCELL_ROW_209_2533 VGND VPWR sky130_fd_sc_hd__tapvpwrvgnd_1
XFILLER_61_1441 VGND VGND VPWR VPWR sky130_fd_sc_hd__fill_1
XFILLER_135_1299 VPWR VGND VPWR VGND sky130_ef_sc_hd__decap_12
XTAP_TAPCELL_ROW_205_2408 VGND VPWR sky130_fd_sc_hd__tapvpwrvgnd_1
XFILLER_211_1121 VPWR VGND VPWR VGND sky130_ef_sc_hd__decap_12
XFILLER_214_53 VPWR VGND VPWR VGND sky130_ef_sc_hd__decap_12
XFILLER_245_429 VPWR VGND VPWR VGND sky130_ef_sc_hd__decap_12
XTAP_TAPCELL_ROW_205_2419 VGND VPWR sky130_fd_sc_hd__tapvpwrvgnd_1
XFILLER_214_97 VPWR VGND VPWR VGND sky130_ef_sc_hd__decap_12
XPHY_EDGE_ROW_87_1_Right_743 VGND VGND VPWR VPWR sky130_fd_sc_hd__decap_3
XFILLER_226_643 VGND VGND VPWR VPWR sky130_fd_sc_hd__fill_1
XFILLER_22_1469 VGND VGND VPWR VPWR sky130_fd_sc_hd__fill_1
XFILLER_214_805 VGND VGND VPWR VPWR sky130_fd_sc_hd__decap_6
XTAP_TAPCELL_ROW_197_2209 VGND VPWR sky130_fd_sc_hd__tapvpwrvgnd_1
XFILLER_246_1217 VPWR VGND VPWR VGND sky130_ef_sc_hd__decap_12
XFILLER_253_473 VPWR VGND VPWR VGND sky130_ef_sc_hd__decap_12
XFILLER_214_849 VPWR VGND VPWR VGND sky130_ef_sc_hd__decap_12
XFILLER_230_41 VPWR VGND VPWR VGND sky130_ef_sc_hd__decap_12
XFILLER_55_1201 VPWR VGND VPWR VGND sky130_ef_sc_hd__decap_12
XFILLER_213_337 VPWR VGND VPWR VGND sky130_ef_sc_hd__decap_12
XFILLER_230_85 VPWR VGND VPWR VGND sky130_ef_sc_hd__decap_12
XFILLER_43_39 VGND VGND VPWR VPWR sky130_fd_sc_hd__decap_8
XFILLER_94_1283 VPWR VGND VPWR VGND sky130_ef_sc_hd__decap_12
XFILLER_146_1351 VGND VGND VPWR VPWR sky130_fd_sc_hd__decap_6
XFILLER_179_753 VPWR VGND VPWR VGND sky130_ef_sc_hd__decap_12
XFILLER_181_1231 VGND VGND VPWR VPWR sky130_fd_sc_hd__fill_1
XFILLER_55_1267 VGND VGND VPWR VPWR sky130_fd_sc_hd__decap_6
XFILLER_142_1215 VPWR VGND VPWR VGND sky130_ef_sc_hd__decap_12
XFILLER_159_39 VPWR VGND VPWR VGND sky130_ef_sc_hd__decap_12
XFILLER_194_701 VPWR VGND VPWR VGND sky130_ef_sc_hd__decap_12
XFILLER_240_189 VGND VGND VPWR VPWR sky130_fd_sc_hd__decap_6
XFILLER_222_893 VPWR VGND VPWR VGND sky130_ef_sc_hd__decap_12
XFILLER_146_1395 VPWR VGND VPWR VGND sky130_ef_sc_hd__decap_12
XFILLER_179_797 VPWR VGND VPWR VGND sky130_ef_sc_hd__decap_12
XFILLER_107_1379 VGND VGND VPWR VPWR sky130_fd_sc_hd__decap_6
XFILLER_142_1259 VPWR VGND VPWR VGND sky130_ef_sc_hd__decap_12
XFILLER_222_1261 VPWR VGND VPWR VGND sky130_ef_sc_hd__decap_12
XFILLER_166_469 VGND VGND VPWR VPWR sky130_fd_sc_hd__decap_6
XTAP_TAPCELL_ROW_173_1552 VGND VPWR sky130_fd_sc_hd__tapvpwrvgnd_1
XFILLER_181_417 VPWR VGND VPWR VGND sky130_ef_sc_hd__decap_12
XTAP_TAPCELL_ROW_173_1563 VGND VPWR sky130_fd_sc_hd__tapvpwrvgnd_1
XFILLER_175_27 VPWR VGND VPWR VGND sky130_ef_sc_hd__decap_12
XFILLER_190_973 VGND VGND VPWR VPWR sky130_fd_sc_hd__decap_6
XFILLER_175_1057 VGND VGND VPWR VPWR sky130_fd_sc_hd__decap_6
XFILLER_108_65 VGND VGND VPWR VPWR sky130_fd_sc_hd__decap_6
XPHY_EDGE_ROW_41_1_Left_296 VGND VGND VPWR VPWR sky130_fd_sc_hd__decap_3
XFILLER_153_1311 VPWR VGND VPWR VGND sky130_ef_sc_hd__decap_12
XTAP_TAPCELL_ROW_186_1902 VGND VPWR sky130_fd_sc_hd__tapvpwrvgnd_1
XFILLER_191_15 VPWR VGND VPWR VGND sky130_ef_sc_hd__decap_12
XFILLER_157_1491 VGND VGND VPWR VPWR sky130_fd_sc_hd__decap_6
XTAP_TAPCELL_ROW_186_1913 VGND VPWR sky130_fd_sc_hd__tapvpwrvgnd_1
XFILLER_192_1371 VGND VGND VPWR VPWR sky130_fd_sc_hd__fill_1
XFILLER_62_1227 VPWR VGND VPWR VGND sky130_ef_sc_hd__decap_12
XFILLER_0_357 VGND VGND VPWR VPWR sky130_fd_sc_hd__fill_1
XFILLER_153_1355 VPWR VGND VPWR VGND sky130_ef_sc_hd__decap_12
XFILLER_248_245 VGND VGND VPWR VPWR sky130_fd_sc_hd__decap_6
XFILLER_114_1339 VPWR VGND VPWR VGND sky130_ef_sc_hd__decap_12
XFILLER_153_1399 VPWR VGND VPWR VGND sky130_ef_sc_hd__decap_12
XFILLER_5_1121 VPWR VGND VPWR VGND sky130_ef_sc_hd__decap_12
XFILLER_124_53 VPWR VGND VPWR VGND sky130_ef_sc_hd__decap_12
XFILLER_208_109 VPWR VGND VPWR VGND sky130_ef_sc_hd__decap_12
XFILLER_248_289 VPWR VGND VPWR VGND sky130_ef_sc_hd__decap_12
XTAP_TAPCELL_ROW_167_1389 VGND VPWR sky130_fd_sc_hd__tapvpwrvgnd_1
XFILLER_187_3 VPWR VGND VPWR VGND sky130_ef_sc_hd__decap_12
XFILLER_188_1429 VPWR VGND VPWR VGND sky130_ef_sc_hd__decap_12
XPHY_EDGE_ROW_23_2_Right_114 VGND VGND VPWR VPWR sky130_fd_sc_hd__decap_3
X_651_ clknet_3_6__leaf_clk acc_core.adder.cla_blocks\[4\].block.sum\[1\] _059_ VGND
+ VGND VPWR VPWR net51 sky130_fd_sc_hd__dfrtp_1
XFILLER_1_1007 VGND VGND VPWR VPWR sky130_fd_sc_hd__fill_1
XFILLER_217_665 VGND VGND VPWR VPWR sky130_fd_sc_hd__decap_6
XTAP_TAPCELL_ROW_65_2_4147 VGND VPWR sky130_fd_sc_hd__tapvpwrvgnd_1
X_582_ net669 VGND VGND VPWR VPWR _064_ sky130_fd_sc_hd__inv_2
XFILLER_17_51 VGND VGND VPWR VPWR sky130_fd_sc_hd__decap_4
XFILLER_216_153 VPWR VGND VPWR VGND sky130_ef_sc_hd__decap_12
XFILLER_229_1437 VPWR VGND VPWR VGND sky130_ef_sc_hd__decap_12
XFILLER_232_613 VPWR VGND VPWR VGND sky130_ef_sc_hd__decap_12
XFILLER_140_41 VPWR VGND VPWR VGND sky130_ef_sc_hd__decap_12
XFILLER_189_517 VPWR VGND VPWR VGND sky130_ef_sc_hd__decap_12
XFILLER_182_1017 VPWR VGND VPWR VGND sky130_ef_sc_hd__decap_12
XFILLER_216_197 VPWR VGND VPWR VGND sky130_ef_sc_hd__decap_12
XFILLER_186_1197 VGND VGND VPWR VPWR sky130_fd_sc_hd__decap_6
XFILLER_232_657 VPWR VGND VPWR VGND sky130_ef_sc_hd__decap_12
XFILLER_73_1323 VGND VGND VPWR VPWR sky130_fd_sc_hd__decap_6
XFILLER_164_1451 VPWR VGND VPWR VGND sky130_ef_sc_hd__decap_12
XFILLER_231_167 VGND VGND VPWR VPWR sky130_fd_sc_hd__fill_1
XTAP_TAPCELL_ROW_45_2_4023 VGND VPWR sky130_fd_sc_hd__tapvpwrvgnd_1
XFILLER_73_1367 VPWR VGND VPWR VGND sky130_ef_sc_hd__decap_12
XFILLER_125_1435 VGND VGND VPWR VPWR sky130_fd_sc_hd__decap_6
XFILLER_160_1315 VPWR VGND VPWR VGND sky130_ef_sc_hd__decap_12
XFILLER_197_561 VPWR VGND VPWR VGND sky130_ef_sc_hd__decap_12
XFILLER_9_925 VPWR VGND VPWR VGND sky130_ef_sc_hd__decap_12
XFILLER_164_1495 VPWR VGND VPWR VGND sky130_ef_sc_hd__decap_12
XFILLER_33_61 VGND VGND VPWR VPWR sky130_fd_sc_hd__fill_1
XFILLER_125_1479 VPWR VGND VPWR VGND sky130_ef_sc_hd__decap_12
XFILLER_160_1359 VPWR VGND VPWR VGND sky130_ef_sc_hd__decap_12
XTAP_TAPCELL_ROW_251_3652 VGND VPWR sky130_fd_sc_hd__tapvpwrvgnd_1
XFILLER_184_233 VPWR VGND VPWR VGND sky130_ef_sc_hd__decap_12
XFILLER_201_1301 VPWR VGND VPWR VGND sky130_ef_sc_hd__decap_12
XTAP_TAPCELL_ROW_251_3663 VGND VPWR sky130_fd_sc_hd__tapvpwrvgnd_1
XFILLER_205_1481 VPWR VGND VPWR VGND sky130_ef_sc_hd__decap_12
XTAP_TAPCELL_ROW_251_3674 VGND VPWR sky130_fd_sc_hd__tapvpwrvgnd_1
XFILLER_200_587 VGND VGND VPWR VPWR sky130_fd_sc_hd__fill_1
XFILLER_166_981 VPWR VGND VPWR VGND sky130_ef_sc_hd__decap_12
XFILLER_184_277 VPWR VGND VPWR VGND sky130_ef_sc_hd__decap_12
XFILLER_201_1345 VPWR VGND VPWR VGND sky130_ef_sc_hd__decap_12
XFILLER_181_951 VGND VGND VPWR VPWR sky130_fd_sc_hd__fill_1
XFILLER_193_1113 VGND VGND VPWR VPWR sky130_fd_sc_hd__decap_6
XFILLER_10_1351 VGND VGND VPWR VPWR sky130_fd_sc_hd__decap_6
XFILLER_119_1217 VGND VGND VPWR VPWR sky130_fd_sc_hd__fill_1
XTAP_TAPCELL_ROW_139_1_1274 VGND VPWR sky130_fd_sc_hd__tapvpwrvgnd_1
XFILLER_193_1157 VPWR VGND VPWR VGND sky130_ef_sc_hd__decap_12
XFILLER_10_1395 VPWR VGND VPWR VGND sky130_ef_sc_hd__decap_12
XFILLER_84_1463 VGND VGND VPWR VPWR sky130_fd_sc_hd__decap_6
XFILLER_3_184 VGND VGND VPWR VPWR sky130_fd_sc_hd__fill_2
XFILLER_3_195 VGND VGND VPWR VPWR sky130_fd_sc_hd__fill_1
XFILLER_80_1327 VPWR VGND VPWR VGND sky130_ef_sc_hd__decap_12
XFILLER_239_223 VGND VGND VPWR VPWR sky130_fd_sc_hd__fill_1
XFILLER_171_1455 VGND VGND VPWR VPWR sky130_fd_sc_hd__fill_1
XTAP_TAPCELL_ROW_245_3489 VGND VPWR sky130_fd_sc_hd__tapvpwrvgnd_1
XFILLER_230_1029 VGND VGND VPWR VPWR sky130_fd_sc_hd__decap_6
XFILLER_132_1439 VPWR VGND VPWR VGND sky130_ef_sc_hd__decap_12
Xhold2 rd_addr\[1\] VGND VGND VPWR VPWR net689 sky130_fd_sc_hd__dlygate4sd3_1
XFILLER_212_1441 VPWR VGND VPWR VGND sky130_ef_sc_hd__decap_12
XFILLER_227_429 VPWR VGND VPWR VGND sky130_ef_sc_hd__decap_12
XFILLER_181_81 VPWR VGND VPWR VGND sky130_ef_sc_hd__decap_12
XFILLER_208_643 VGND VGND VPWR VPWR sky130_fd_sc_hd__fill_1
XFILLER_212_1485 VPWR VGND VPWR VGND sky130_ef_sc_hd__decap_12
XFILLER_78_1245 VGND VGND VPWR VPWR sky130_fd_sc_hd__fill_1
XFILLER_235_473 VPWR VGND VPWR VGND sky130_ef_sc_hd__decap_12
XFILLER_251_933 VPWR VGND VPWR VGND sky130_ef_sc_hd__decap_12
XFILLER_21_1491 VGND VGND VPWR VPWR sky130_fd_sc_hd__decap_6
XFILLER_250_421 VPWR VGND VPWR VGND sky130_ef_sc_hd__decap_12
XFILLER_251_977 VPWR VGND VPWR VGND sky130_ef_sc_hd__decap_12
XFILLER_91_1423 VPWR VGND VPWR VGND sky130_ef_sc_hd__decap_12
XFILLER_210_307 VGND VGND VPWR VPWR sky130_fd_sc_hd__fill_1
XFILLER_52_1407 VGND VGND VPWR VPWR sky130_fd_sc_hd__decap_6
XFILLER_176_701 VPWR VGND VPWR VGND sky130_ef_sc_hd__decap_12
XFILLER_204_893 VPWR VGND VPWR VGND sky130_ef_sc_hd__decap_12
XFILLER_222_189 VGND VGND VPWR VPWR sky130_fd_sc_hd__decap_6
XFILLER_91_1467 VPWR VGND VPWR VGND sky130_ef_sc_hd__decap_12
XFILLER_200_77 VGND VGND VPWR VPWR sky130_fd_sc_hd__decap_6
XFILLER_241_1169 VGND VGND VPWR VPWR sky130_fd_sc_hd__decap_6
XFILLER_198_1035 VGND VGND VPWR VPWR sky130_fd_sc_hd__fill_1
XFILLER_15_1273 VGND VGND VPWR VPWR sky130_fd_sc_hd__fill_1
XFILLER_239_1021 VPWR VGND VPWR VGND sky130_ef_sc_hd__decap_12
Xmax_cap110 net111 VGND VGND VPWR VPWR net110 sky130_fd_sc_hd__clkbuf_1
Xmax_cap121 _204_ VGND VGND VPWR VPWR net121 sky130_fd_sc_hd__clkbuf_1
Xmax_cap132 net133 VGND VGND VPWR VPWR net132 sky130_fd_sc_hd__clkbuf_1
XFILLER_89_1385 VGND VGND VPWR VPWR sky130_fd_sc_hd__fill_1
XFILLER_239_1065 VPWR VGND VPWR VGND sky130_ef_sc_hd__decap_12
Xmax_cap143 net144 VGND VGND VPWR VPWR net143 sky130_fd_sc_hd__clkbuf_1
XFILLER_172_973 VGND VGND VPWR VPWR sky130_fd_sc_hd__decap_6
XFILLER_171_461 VPWR VGND VPWR VGND sky130_ef_sc_hd__decap_12
Xmax_cap165 _143_ VGND VGND VPWR VPWR net165 sky130_fd_sc_hd__clkbuf_1
Xmax_cap176 _106_ VGND VGND VPWR VPWR net176 sky130_fd_sc_hd__clkbuf_1
XTAP_TAPCELL_ROW_71_2_4179 VGND VPWR sky130_fd_sc_hd__tapvpwrvgnd_1
XFILLER_6_1441 VPWR VGND VPWR VGND sky130_ef_sc_hd__decap_12
XPHY_EDGE_ROW_150_2_Right_241 VGND VGND VPWR VPWR sky130_fd_sc_hd__decap_3
XFILLER_246_749 VGND VGND VPWR VPWR sky130_fd_sc_hd__decap_6
XFILLER_245_237 VPWR VGND VPWR VGND sky130_ef_sc_hd__decap_12
XFILLER_6_1485 VPWR VGND VPWR VGND sky130_ef_sc_hd__decap_12
XFILLER_96_1301 VGND VGND VPWR VPWR sky130_fd_sc_hd__fill_1
XFILLER_241_51 VGND VGND VPWR VPWR sky130_fd_sc_hd__decap_4
XTAP_TAPCELL_ROW_36_2_3971 VGND VPWR sky130_fd_sc_hd__tapvpwrvgnd_1
XFILLER_54_27 VGND VGND VPWR VPWR sky130_fd_sc_hd__fill_1
XPHY_EDGE_ROW_88_1_Right_744 VGND VGND VPWR VPWR sky130_fd_sc_hd__decap_3
XFILLER_148_1413 VGND VGND VPWR VPWR sky130_fd_sc_hd__fill_1
XFILLER_214_613 VPWR VGND VPWR VGND sky130_ef_sc_hd__decap_12
XFILLER_254_793 VPWR VGND VPWR VGND sky130_ef_sc_hd__decap_12
XFILLER_253_281 VPWR VGND VPWR VGND sky130_ef_sc_hd__decap_12
XFILLER_57_1329 VGND VGND VPWR VPWR sky130_fd_sc_hd__fill_1
XFILLER_183_1337 VGND VGND VPWR VPWR sky130_fd_sc_hd__decap_6
XFILLER_214_657 VPWR VGND VPWR VGND sky130_ef_sc_hd__decap_12
XFILLER_207_1009 VPWR VGND VPWR VGND sky130_ef_sc_hd__decap_12
XFILLER_213_167 VGND VGND VPWR VPWR sky130_fd_sc_hd__fill_1
XFILLER_179_561 VPWR VGND VPWR VGND sky130_ef_sc_hd__decap_12
XFILLER_201_329 VGND VGND VPWR VPWR sky130_fd_sc_hd__decap_6
XFILLER_70_1507 VGND VGND VPWR VPWR sky130_fd_sc_hd__decap_8
XFILLER_70_15 VPWR VGND VPWR VGND sky130_ef_sc_hd__decap_12
XTAP_TAPCELL_ROW_175_1603 VGND VPWR sky130_fd_sc_hd__tapvpwrvgnd_1
XTAP_TAPCELL_ROW_175_1614 VGND VPWR sky130_fd_sc_hd__tapvpwrvgnd_1
XFILLER_194_531 VGND VGND VPWR VPWR sky130_fd_sc_hd__fill_1
XFILLER_107_1165 VPWR VGND VPWR VGND sky130_ef_sc_hd__decap_12
XFILLER_166_233 VPWR VGND VPWR VGND sky130_ef_sc_hd__decap_12
XFILLER_186_15 VPWR VGND VPWR VGND sky130_ef_sc_hd__decap_12
XFILLER_166_277 VPWR VGND VPWR VGND sky130_ef_sc_hd__decap_12
XFILLER_182_737 VPWR VGND VPWR VGND sky130_ef_sc_hd__decap_12
XFILLER_222_1091 VGND VGND VPWR VPWR sky130_fd_sc_hd__fill_1
XFILLER_177_1119 VGND VGND VPWR VPWR sky130_fd_sc_hd__fill_1
XFILLER_181_225 VPWR VGND VPWR VGND sky130_ef_sc_hd__decap_12
XFILLER_5_449 VGND VGND VPWR VPWR sky130_fd_sc_hd__fill_1
XFILLER_218_1105 VPWR VGND VPWR VGND sky130_ef_sc_hd__decap_12
XFILLER_102_3 VPWR VGND VPWR VGND sky130_ef_sc_hd__decap_12
XFILLER_253_1007 VGND VGND VPWR VPWR sky130_fd_sc_hd__fill_1
XFILLER_79_57 VPWR VGND VPWR VGND sky130_ef_sc_hd__decap_12
XFILLER_68_1469 VGND VGND VPWR VPWR sky130_fd_sc_hd__fill_1
XFILLER_190_781 VPWR VGND VPWR VGND sky130_ef_sc_hd__decap_12
XFILLER_194_1477 VGND VGND VPWR VPWR sky130_fd_sc_hd__decap_6
XFILLER_218_1149 VPWR VGND VPWR VGND sky130_ef_sc_hd__decap_12
XFILLER_0_165 VGND VGND VPWR VPWR sky130_fd_sc_hd__decap_3
XFILLER_118_1283 VPWR VGND VPWR VGND sky130_ef_sc_hd__decap_12
XFILLER_27_1177 VPWR VGND VPWR VGND sky130_ef_sc_hd__decap_12
XFILLER_237_727 VGND VGND VPWR VPWR sky130_fd_sc_hd__fill_1
XFILLER_209_429 VPWR VGND VPWR VGND sky130_ef_sc_hd__decap_12
XTAP_TAPCELL_ROW_5_994 VGND VPWR sky130_fd_sc_hd__tapvpwrvgnd_1
XTAP_TAPCELL_ROW_240_3353 VGND VPWR sky130_fd_sc_hd__tapvpwrvgnd_1
XTAP_TAPCELL_ROW_240_3364 VGND VPWR sky130_fd_sc_hd__tapvpwrvgnd_1
XFILLER_151_51 VGND VGND VPWR VPWR sky130_fd_sc_hd__decap_4
XFILLER_188_1259 VGND VGND VPWR VPWR sky130_fd_sc_hd__fill_1
XTAP_TAPCELL_ROW_240_3375 VGND VPWR sky130_fd_sc_hd__tapvpwrvgnd_1
XPHY_EDGE_ROW_24_2_Right_115 VGND VGND VPWR VPWR sky130_fd_sc_hd__decap_3
X_634_ clknet_3_3__leaf_clk acc_core.adder.cla_blocks\[0\].block.p\[0\] _042_ VGND
+ VGND VPWR VPWR net43 sky130_fd_sc_hd__dfrtp_1
XFILLER_229_1201 VPWR VGND VPWR VGND sky130_ef_sc_hd__decap_12
XFILLER_217_473 VPWR VGND VPWR VGND sky130_ef_sc_hd__decap_12
XFILLER_233_933 VPWR VGND VPWR VGND sky130_ef_sc_hd__decap_12
XFILLER_229_1245 VPWR VGND VPWR VGND sky130_ef_sc_hd__decap_12
XFILLER_232_421 VPWR VGND VPWR VGND sky130_ef_sc_hd__decap_12
X_565_ net663 VGND VGND VPWR VPWR _047_ sky130_fd_sc_hd__inv_2
XFILLER_233_977 VPWR VGND VPWR VGND sky130_ef_sc_hd__decap_12
XFILLER_229_1289 VPWR VGND VPWR VGND sky130_ef_sc_hd__decap_12
XTAP_TAPCELL_ROW_253_3703 VGND VPWR sky130_fd_sc_hd__tapvpwrvgnd_1
XTAP_TAPCELL_ROW_253_3714 VGND VPWR sky130_fd_sc_hd__tapvpwrvgnd_1
X_496_ net145 _254_ VGND VGND VPWR VPWR acc_core.adder.cla_blocks\[5\].block.sum\[3\]
+ sky130_fd_sc_hd__xor2_1
XTAP_TAPCELL_ROW_253_3725 VGND VPWR sky130_fd_sc_hd__tapvpwrvgnd_1
XFILLER_204_189 VGND VGND VPWR VPWR sky130_fd_sc_hd__decap_6
XFILLER_198_881 VPWR VGND VPWR VGND sky130_ef_sc_hd__decap_12
XFILLER_38_1295 VGND VGND VPWR VPWR sky130_fd_sc_hd__decap_6
XFILLER_125_1243 VPWR VGND VPWR VGND sky130_ef_sc_hd__decap_12
XFILLER_201_841 VPWR VGND VPWR VGND sky130_ef_sc_hd__decap_12
XFILLER_197_391 VGND VGND VPWR VPWR sky130_fd_sc_hd__fill_1
XFILLER_185_553 VGND VGND VPWR VPWR sky130_fd_sc_hd__decap_6
XFILLER_125_1287 VPWR VGND VPWR VGND sky130_ef_sc_hd__decap_12
XFILLER_8_243 VGND VGND VPWR VPWR sky130_fd_sc_hd__decap_8
XFILLER_12_1413 VGND VGND VPWR VPWR sky130_fd_sc_hd__fill_1
XFILLER_160_1189 VGND VGND VPWR VPWR sky130_fd_sc_hd__fill_1
XFILLER_185_597 VPWR VGND VPWR VGND sky130_ef_sc_hd__decap_12
XFILLER_199_1399 VGND VGND VPWR VPWR sky130_fd_sc_hd__fill_1
XFILLER_246_29 VPWR VGND VPWR VGND sky130_ef_sc_hd__decap_12
XFILLER_201_1175 VGND VGND VPWR VPWR sky130_fd_sc_hd__fill_1
XFILLER_236_1205 VPWR VGND VPWR VGND sky130_ef_sc_hd__decap_12
XFILLER_5_54 VGND VGND VPWR VPWR sky130_fd_sc_hd__fill_2
XFILLER_84_1271 VPWR VGND VPWR VGND sky130_ef_sc_hd__decap_12
XFILLER_45_1255 VPWR VGND VPWR VGND sky130_ef_sc_hd__decap_12
XFILLER_132_1203 VPWR VGND VPWR VGND sky130_ef_sc_hd__decap_12
XFILLER_136_1383 VPWR VGND VPWR VGND sky130_ef_sc_hd__decap_12
XFILLER_45_1299 VPWR VGND VPWR VGND sky130_ef_sc_hd__decap_12
XFILLER_132_1247 VPWR VGND VPWR VGND sky130_ef_sc_hd__decap_12
XFILLER_228_749 VGND VGND VPWR VPWR sky130_fd_sc_hd__decap_6
XFILLER_227_237 VPWR VGND VPWR VGND sky130_ef_sc_hd__decap_12
XFILLER_255_557 VGND VGND VPWR VPWR sky130_fd_sc_hd__decap_3
XFILLER_247_1301 VPWR VGND VPWR VGND sky130_ef_sc_hd__decap_12
XFILLER_236_793 VPWR VGND VPWR VGND sky130_ef_sc_hd__decap_12
XFILLER_247_1345 VPWR VGND VPWR VGND sky130_ef_sc_hd__decap_12
XFILLER_235_281 VPWR VGND VPWR VGND sky130_ef_sc_hd__decap_12
XTAP_TAPCELL_ROW_223_2894 VGND VPWR sky130_fd_sc_hd__tapvpwrvgnd_1
XFILLER_251_741 VPWR VGND VPWR VGND sky130_ef_sc_hd__decap_12
XFILLER_208_1329 VPWR VGND VPWR VGND sky130_ef_sc_hd__decap_12
XFILLER_250_251 VGND VGND VPWR VPWR sky130_fd_sc_hd__fill_1
XFILLER_1_1393 VGND VGND VPWR VPWR sky130_fd_sc_hd__decap_6
XFILLER_251_785 VPWR VGND VPWR VGND sky130_ef_sc_hd__decap_12
XFILLER_56_1351 VGND VGND VPWR VPWR sky130_fd_sc_hd__decap_6
XFILLER_91_1231 VPWR VGND VPWR VGND sky130_ef_sc_hd__decap_12
XFILLER_195_317 VPWR VGND VPWR VGND sky130_ef_sc_hd__decap_12
XTAP_TAPCELL_ROW_14_2_3838 VGND VPWR sky130_fd_sc_hd__tapvpwrvgnd_1
XFILLER_52_1215 VPWR VGND VPWR VGND sky130_ef_sc_hd__decap_12
XFILLER_56_1395 VPWR VGND VPWR VGND sky130_ef_sc_hd__decap_12
XFILLER_91_1275 VPWR VGND VPWR VGND sky130_ef_sc_hd__decap_12
XFILLER_108_1463 VGND VGND VPWR VPWR sky130_fd_sc_hd__decap_6
XFILLER_143_1343 VPWR VGND VPWR VGND sky130_ef_sc_hd__decap_12
XFILLER_176_531 VGND VGND VPWR VPWR sky130_fd_sc_hd__fill_1
XFILLER_52_1259 VPWR VGND VPWR VGND sky130_ef_sc_hd__decap_12
XFILLER_17_1379 VGND VGND VPWR VPWR sky130_fd_sc_hd__decap_6
XFILLER_104_1327 VPWR VGND VPWR VGND sky130_ef_sc_hd__decap_12
XFILLER_143_1387 VPWR VGND VPWR VGND sky130_ef_sc_hd__decap_12
XFILLER_40_29 VPWR VGND VPWR VGND sky130_ef_sc_hd__decap_12
XFILLER_156_29 VPWR VGND VPWR VGND sky130_ef_sc_hd__decap_12
XFILLER_3_909 VPWR VGND VPWR VGND sky130_ef_sc_hd__decap_12
XFILLER_176_1141 VGND VGND VPWR VPWR sky130_fd_sc_hd__decap_6
XFILLER_219_1425 VPWR VGND VPWR VGND sky130_ef_sc_hd__decap_12
XPHY_EDGE_ROW_120_2_Left_622 VGND VGND VPWR VPWR sky130_fd_sc_hd__decap_3
XFILLER_172_781 VPWR VGND VPWR VGND sky130_ef_sc_hd__decap_12
XFILLER_172_1005 VPWR VGND VPWR VGND sky130_ef_sc_hd__decap_12
XFILLER_219_1469 VPWR VGND VPWR VGND sky130_ef_sc_hd__decap_12
XFILLER_176_1185 VPWR VGND VPWR VGND sky130_ef_sc_hd__decap_12
XFILLER_49_27 VPWR VGND VPWR VGND sky130_ef_sc_hd__decap_12
XTAP_TAPCELL_ROW_133_2_4552 VGND VPWR sky130_fd_sc_hd__tapvpwrvgnd_1
XFILLER_63_1311 VPWR VGND VPWR VGND sky130_ef_sc_hd__decap_12
XFILLER_67_1491 VGND VGND VPWR VPWR sky130_fd_sc_hd__decap_6
XFILLER_172_1049 VPWR VGND VPWR VGND sky130_ef_sc_hd__decap_12
XFILLER_63_1355 VPWR VGND VPWR VGND sky130_ef_sc_hd__decap_12
XFILLER_115_1423 VPWR VGND VPWR VGND sky130_ef_sc_hd__decap_12
XFILLER_150_1303 VPWR VGND VPWR VGND sky130_ef_sc_hd__decap_12
XFILLER_252_1073 VPWR VGND VPWR VGND sky130_ef_sc_hd__decap_12
XFILLER_154_1483 VPWR VGND VPWR VGND sky130_ef_sc_hd__decap_12
XFILLER_246_513 VPWR VGND VPWR VGND sky130_ef_sc_hd__decap_12
XFILLER_24_1339 VPWR VGND VPWR VGND sky130_ef_sc_hd__decap_12
XFILLER_219_727 VGND VGND VPWR VPWR sky130_fd_sc_hd__fill_1
XFILLER_189_1513 VGND VGND VPWR VPWR sky130_fd_sc_hd__fill_2
XFILLER_213_1057 VGND VGND VPWR VPWR sky130_fd_sc_hd__decap_6
XFILLER_63_1399 VPWR VGND VPWR VGND sky130_ef_sc_hd__decap_12
XFILLER_98_1407 VGND VGND VPWR VPWR sky130_fd_sc_hd__decap_6
XFILLER_105_55 VGND VGND VPWR VPWR sky130_fd_sc_hd__fill_1
XFILLER_115_1467 VPWR VGND VPWR VGND sky130_ef_sc_hd__decap_12
XTAP_TAPCELL_ROW_2_920 VGND VPWR sky130_fd_sc_hd__tapvpwrvgnd_1
XFILLER_252_83 VGND VGND VPWR VPWR sky130_fd_sc_hd__fill_1
XFILLER_246_557 VPWR VGND VPWR VGND sky130_ef_sc_hd__decap_12
XPHY_EDGE_ROW_151_2_Right_242 VGND VGND VPWR VPWR sky130_fd_sc_hd__decap_3
XFILLER_230_1371 VGND VGND VPWR VPWR sky130_fd_sc_hd__fill_1
XFILLER_215_933 VPWR VGND VPWR VGND sky130_ef_sc_hd__decap_12
XFILLER_183_1101 VPWR VGND VPWR VGND sky130_ef_sc_hd__decap_12
XFILLER_214_421 VPWR VGND VPWR VGND sky130_ef_sc_hd__decap_12
XFILLER_187_1281 VGND VGND VPWR VPWR sky130_fd_sc_hd__decap_6
XPHY_EDGE_ROW_89_1_Right_745 VGND VGND VPWR VPWR sky130_fd_sc_hd__decap_3
XFILLER_215_977 VPWR VGND VPWR VGND sky130_ef_sc_hd__decap_12
XFILLER_183_1145 VPWR VGND VPWR VGND sky130_ef_sc_hd__decap_12
XFILLER_198_133 VGND VGND VPWR VPWR sky130_fd_sc_hd__decap_6
XFILLER_226_1429 VPWR VGND VPWR VGND sky130_ef_sc_hd__decap_12
X_350_ _136_ _137_ VGND VGND VPWR VPWR _139_ sky130_fd_sc_hd__or2_1
XFILLER_230_925 VPWR VGND VPWR VGND sky130_ef_sc_hd__decap_12
XFILLER_241_273 VGND VGND VPWR VPWR sky130_fd_sc_hd__decap_6
XFILLER_74_1451 VPWR VGND VPWR VGND sky130_ef_sc_hd__decap_12
XFILLER_183_1189 VPWR VGND VPWR VGND sky130_ef_sc_hd__decap_12
XFILLER_198_177 VPWR VGND VPWR VGND sky130_ef_sc_hd__decap_12
XFILLER_81_69 VGND VGND VPWR VPWR sky130_fd_sc_hd__fill_2
XFILLER_70_1315 VPWR VGND VPWR VGND sky130_ef_sc_hd__decap_12
XFILLER_201_137 VPWR VGND VPWR VGND sky130_ef_sc_hd__decap_12
XFILLER_35_1435 VGND VGND VPWR VPWR sky130_fd_sc_hd__decap_6
XFILLER_14_41 VPWR VGND VPWR VGND sky130_ef_sc_hd__decap_12
XFILLER_74_1495 VPWR VGND VPWR VGND sky130_ef_sc_hd__decap_12
XFILLER_161_1443 VPWR VGND VPWR VGND sky130_ef_sc_hd__decap_12
XFILLER_179_391 VGND VGND VPWR VPWR sky130_fd_sc_hd__fill_1
XFILLER_197_69 VPWR VGND VPWR VGND sky130_ef_sc_hd__decap_12
XFILLER_35_1479 VPWR VGND VPWR VGND sky130_ef_sc_hd__decap_12
XFILLER_70_1359 VPWR VGND VPWR VGND sky130_ef_sc_hd__decap_12
XFILLER_122_1427 VPWR VGND VPWR VGND sky130_ef_sc_hd__decap_12
XFILLER_167_553 VGND VGND VPWR VPWR sky130_fd_sc_hd__decap_6
XFILLER_220_1017 VPWR VGND VPWR VGND sky130_ef_sc_hd__decap_12
XFILLER_224_1197 VGND VGND VPWR VPWR sky130_fd_sc_hd__decap_6
XFILLER_182_501 VPWR VGND VPWR VGND sky130_ef_sc_hd__decap_12
XFILLER_195_895 VGND VGND VPWR VPWR sky130_fd_sc_hd__fill_1
XFILLER_210_693 VGND VGND VPWR VPWR sky130_fd_sc_hd__decap_6
XFILLER_167_597 VPWR VGND VPWR VGND sky130_ef_sc_hd__decap_12
XFILLER_182_545 VPWR VGND VPWR VGND sky130_ef_sc_hd__decap_12
XPHY_EDGE_ROW_52_2_Left_554 VGND VGND VPWR VPWR sky130_fd_sc_hd__decap_3
XFILLER_182_589 VPWR VGND VPWR VGND sky130_ef_sc_hd__decap_12
XFILLER_194_1241 VPWR VGND VPWR VGND sky130_ef_sc_hd__decap_12
XFILLER_29_1217 VGND VGND VPWR VPWR sky130_fd_sc_hd__fill_1
XFILLER_190_1105 VPWR VGND VPWR VGND sky130_ef_sc_hd__decap_12
XPHY_EDGE_ROW_229_Right_74 VGND VGND VPWR VPWR sky130_fd_sc_hd__decap_3
XFILLER_194_1285 VPWR VGND VPWR VGND sky130_ef_sc_hd__decap_12
XTAP_TAPCELL_ROW_246_3540 VGND VPWR sky130_fd_sc_hd__tapvpwrvgnd_1
XFILLER_81_1411 VPWR VGND VPWR VGND sky130_ef_sc_hd__decap_12
XFILLER_190_1149 VPWR VGND VPWR VGND sky130_ef_sc_hd__decap_12
XFILLER_231_1113 VGND VGND VPWR VPWR sky130_fd_sc_hd__decap_6
XTAP_TAPCELL_ROW_242_3415 VGND VPWR sky130_fd_sc_hd__tapvpwrvgnd_1
XFILLER_81_1455 VPWR VGND VPWR VGND sky130_ef_sc_hd__decap_12
XTAP_TAPCELL_ROW_242_3426 VGND VPWR sky130_fd_sc_hd__tapvpwrvgnd_1
XFILLER_39_60 VGND VGND VPWR VPWR sky130_fd_sc_hd__decap_8
XFILLER_249_373 VPWR VGND VPWR VGND sky130_ef_sc_hd__decap_12
XFILLER_42_1439 VPWR VGND VPWR VGND sky130_ef_sc_hd__decap_12
XFILLER_7_1057 VGND VGND VPWR VPWR sky130_fd_sc_hd__decap_6
XFILLER_81_1499 VPWR VGND VPWR VGND sky130_ef_sc_hd__decap_12
XFILLER_231_1157 VPWR VGND VPWR VGND sky130_ef_sc_hd__decap_12
XFILLER_209_237 VPWR VGND VPWR VGND sky130_ef_sc_hd__decap_12
XTAP_TAPCELL_ROW_8_1074 VGND VPWR sky130_fd_sc_hd__tapvpwrvgnd_1
XTAP_TAPCELL_ROW_8_1085 VGND VPWR sky130_fd_sc_hd__tapvpwrvgnd_1
XPHY_EDGE_ROW_129_1_Left_384 VGND VGND VPWR VPWR sky130_fd_sc_hd__decap_3
XFILLER_218_793 VPWR VGND VPWR VGND sky130_ef_sc_hd__decap_12
XPHY_EDGE_ROW_25_2_Right_116 VGND VGND VPWR VPWR sky130_fd_sc_hd__decap_3
XFILLER_217_281 VPWR VGND VPWR VGND sky130_ef_sc_hd__decap_12
XFILLER_233_741 VPWR VGND VPWR VGND sky130_ef_sc_hd__decap_12
X_617_ clknet_3_7__leaf_clk dout0\[15\] _025_ VGND VGND VPWR VPWR dout0_q\[15\] sky130_fd_sc_hd__dfrtp_1
XPHY_EDGE_ROW_238_Right_83 VGND VGND VPWR VPWR sky130_fd_sc_hd__decap_3
XFILLER_189_111 VGND VGND VPWR VPWR sky130_fd_sc_hd__fill_1
XTAP_TAPCELL_ROW_255_3809 VGND VPWR sky130_fd_sc_hd__tapvpwrvgnd_1
XFILLER_166_1365 VGND VGND VPWR VPWR sky130_fd_sc_hd__decap_6
XFILLER_233_785 VPWR VGND VPWR VGND sky130_ef_sc_hd__decap_12
X_548_ net668 VGND VGND VPWR VPWR _030_ sky130_fd_sc_hd__inv_2
XFILLER_232_251 VGND VGND VPWR VPWR sky130_fd_sc_hd__fill_1
XFILLER_220_413 VGND VGND VPWR VPWR sky130_fd_sc_hd__decap_6
XPHY_EDGE_ROW_66_1_Left_321 VGND VGND VPWR VPWR sky130_fd_sc_hd__decap_3
XFILLER_177_317 VPWR VGND VPWR VGND sky130_ef_sc_hd__decap_12
X_479_ _141_ _245_ net329 VGND VGND VPWR VPWR _246_ sky130_fd_sc_hd__a21o_1
XFILLER_242_1253 VGND VGND VPWR VPWR sky130_fd_sc_hd__decap_6
XFILLER_220_457 VPWR VGND VPWR VGND sky130_ef_sc_hd__decap_12
XFILLER_192_309 VPWR VGND VPWR VGND sky130_ef_sc_hd__decap_12
XFILLER_201_671 VGND VGND VPWR VPWR sky130_fd_sc_hd__fill_1
XFILLER_242_1297 VPWR VGND VPWR VGND sky130_ef_sc_hd__decap_12
XFILLER_185_361 VPWR VGND VPWR VGND sky130_ef_sc_hd__decap_12
XPHY_EDGE_ROW_247_Right_92 VGND VGND VPWR VPWR sky130_fd_sc_hd__decap_3
XFILLER_236_1035 VGND VGND VPWR VPWR sky130_fd_sc_hd__fill_1
XTAP_TAPCELL_ROW_118_2_4465 VGND VPWR sky130_fd_sc_hd__tapvpwrvgnd_1
XFILLER_173_1325 VPWR VGND VPWR VGND sky130_ef_sc_hd__decap_12
XFILLER_173_1369 VPWR VGND VPWR VGND sky130_ef_sc_hd__decap_12
XFILLER_206_65 VPWR VGND VPWR VGND sky130_ef_sc_hd__decap_12
XFILLER_253_1393 VGND VGND VPWR VPWR sky130_fd_sc_hd__decap_6
XFILLER_136_1191 VPWR VGND VPWR VGND sky130_ef_sc_hd__decap_12
XFILLER_228_513 VPWR VGND VPWR VGND sky130_ef_sc_hd__decap_12
XFILLER_255_321 VPWR VGND VPWR VGND sky130_ef_sc_hd__decap_12
XFILLER_228_557 VPWR VGND VPWR VGND sky130_ef_sc_hd__decap_12
XTAP_TAPCELL_ROW_225_2956 VGND VPWR sky130_fd_sc_hd__tapvpwrvgnd_1
XTAP_TAPCELL_ROW_225_2967 VGND VPWR sky130_fd_sc_hd__tapvpwrvgnd_1
XFILLER_255_365 VPWR VGND VPWR VGND sky130_ef_sc_hd__decap_12
XFILLER_243_505 VPWR VGND VPWR VGND sky130_ef_sc_hd__decap_12
XTAP_TAPCELL_ROW_111_2_4419 VGND VPWR sky130_fd_sc_hd__tapvpwrvgnd_1
XTAP_TAPCELL_ROW_66_2_4152 VGND VPWR sky130_fd_sc_hd__tapvpwrvgnd_1
XFILLER_222_53 VPWR VGND VPWR VGND sky130_ef_sc_hd__decap_12
XFILLER_3_1455 VGND VGND VPWR VPWR sky130_fd_sc_hd__fill_1
XFILLER_58_1413 VGND VGND VPWR VPWR sky130_fd_sc_hd__fill_1
XFILLER_184_1421 VGND VGND VPWR VPWR sky130_fd_sc_hd__decap_6
XFILLER_222_97 VPWR VGND VPWR VGND sky130_ef_sc_hd__decap_12
XFILLER_247_1175 VGND VGND VPWR VPWR sky130_fd_sc_hd__fill_1
XFILLER_184_1465 VPWR VGND VPWR VGND sky130_ef_sc_hd__decap_12
XFILLER_212_925 VPWR VGND VPWR VGND sky130_ef_sc_hd__decap_12
XFILLER_223_273 VGND VGND VPWR VPWR sky130_fd_sc_hd__decap_6
XFILLER_180_1329 VPWR VGND VPWR VGND sky130_ef_sc_hd__decap_12
XFILLER_196_637 VGND VGND VPWR VPWR sky130_fd_sc_hd__decap_6
XTAP_TAPCELL_ROW_162_1_1297 VGND VPWR sky130_fd_sc_hd__tapvpwrvgnd_1
XFILLER_195_125 VPWR VGND VPWR VGND sky130_ef_sc_hd__decap_12
XFILLER_51_39 VGND VGND VPWR VPWR sky130_fd_sc_hd__decap_8
Xwire409 net410 VGND VGND VPWR VPWR net409 sky130_fd_sc_hd__clkbuf_1
XFILLER_108_1271 VPWR VGND VPWR VGND sky130_ef_sc_hd__decap_12
XFILLER_17_1165 VPWR VGND VPWR VGND sky130_ef_sc_hd__decap_12
XFILLER_195_169 VPWR VGND VPWR VGND sky130_ef_sc_hd__decap_12
XFILLER_221_1337 VGND VGND VPWR VPWR sky130_fd_sc_hd__decap_6
XFILLER_167_39 VPWR VGND VPWR VGND sky130_ef_sc_hd__decap_12
XFILLER_177_895 VGND VGND VPWR VPWR sky130_fd_sc_hd__fill_1
XFILLER_178_1203 VGND VGND VPWR VPWR sky130_fd_sc_hd__fill_1
XFILLER_219_1233 VPWR VGND VPWR VGND sky130_ef_sc_hd__decap_12
XFILLER_183_27 VPWR VGND VPWR VGND sky130_ef_sc_hd__decap_12
XFILLER_4_7 VPWR VGND VPWR VGND sky130_ef_sc_hd__decap_12
XFILLER_191_1425 VPWR VGND VPWR VGND sky130_ef_sc_hd__decap_12
XFILLER_215_1119 VGND VGND VPWR VPWR sky130_fd_sc_hd__fill_1
XFILLER_191_1469 VPWR VGND VPWR VGND sky130_ef_sc_hd__decap_12
XFILLER_116_65 VGND VGND VPWR VPWR sky130_fd_sc_hd__decap_6
XFILLER_28_1283 VPWR VGND VPWR VGND sky130_ef_sc_hd__decap_12
XFILLER_115_1231 VPWR VGND VPWR VGND sky130_ef_sc_hd__decap_12
XFILLER_247_833 VGND VGND VPWR VPWR sky130_fd_sc_hd__decap_6
XFILLER_246_321 VPWR VGND VPWR VGND sky130_ef_sc_hd__decap_12
XFILLER_232_1477 VGND VGND VPWR VPWR sky130_fd_sc_hd__decap_6
Xfanout597 net598 VGND VGND VPWR VPWR net597 sky130_fd_sc_hd__clkbuf_2
XFILLER_115_1275 VPWR VGND VPWR VGND sky130_ef_sc_hd__decap_12
XFILLER_98_1215 VPWR VGND VPWR VGND sky130_ef_sc_hd__decap_12
XFILLER_247_877 VPWR VGND VPWR VGND sky130_ef_sc_hd__decap_12
XFILLER_189_1343 VGND VGND VPWR VPWR sky130_fd_sc_hd__fill_1
XFILLER_150_1177 VPWR VGND VPWR VGND sky130_ef_sc_hd__decap_12
XFILLER_246_365 VPWR VGND VPWR VGND sky130_ef_sc_hd__decap_12
XFILLER_98_1259 VPWR VGND VPWR VGND sky130_ef_sc_hd__decap_12
XFILLER_132_53 VPWR VGND VPWR VGND sky130_ef_sc_hd__decap_12
XPHY_EDGE_ROW_152_2_Right_243 VGND VGND VPWR VPWR sky130_fd_sc_hd__decap_3
XFILLER_215_741 VPWR VGND VPWR VGND sky130_ef_sc_hd__decap_12
X_402_ net590 net588 net567 VGND VGND VPWR VPWR _191_ sky130_fd_sc_hd__and3_1
XFILLER_214_251 VGND VGND VPWR VPWR sky130_fd_sc_hd__fill_1
XFILLER_215_785 VPWR VGND VPWR VGND sky130_ef_sc_hd__decap_12
XFILLER_202_413 VGND VGND VPWR VPWR sky130_fd_sc_hd__decap_6
XFILLER_187_615 VGND VGND VPWR VPWR sky130_fd_sc_hd__fill_1
XFILLER_226_1259 VGND VGND VPWR VPWR sky130_fd_sc_hd__fill_1
X_333_ net496 VGND VGND VPWR VPWR _122_ sky130_fd_sc_hd__inv_2
XFILLER_199_497 VGND VGND VPWR VPWR sky130_fd_sc_hd__decap_6
XFILLER_230_755 VGND VGND VPWR VPWR sky130_fd_sc_hd__fill_1
XTAP_TAPCELL_ROW_235_3230 VGND VPWR sky130_fd_sc_hd__tapvpwrvgnd_1
XFILLER_202_457 VPWR VGND VPWR VGND sky130_ef_sc_hd__decap_12
XTAP_TAPCELL_ROW_235_3241 VGND VPWR sky130_fd_sc_hd__tapvpwrvgnd_1
XFILLER_35_1243 VPWR VGND VPWR VGND sky130_ef_sc_hd__decap_12
XTAP_TAPCELL_ROW_124_2_4497 VGND VPWR sky130_fd_sc_hd__tapvpwrvgnd_1
XFILLER_126_1371 VPWR VGND VPWR VGND sky130_ef_sc_hd__decap_12
XFILLER_174_309 VPWR VGND VPWR VGND sky130_ef_sc_hd__decap_12
XFILLER_161_1273 VGND VGND VPWR VPWR sky130_fd_sc_hd__fill_1
XFILLER_167_361 VPWR VGND VPWR VGND sky130_ef_sc_hd__decap_12
XTAP_TAPCELL_ROW_231_3116 VGND VPWR sky130_fd_sc_hd__tapvpwrvgnd_1
XFILLER_35_1287 VPWR VGND VPWR VGND sky130_ef_sc_hd__decap_12
XFILLER_183_821 VPWR VGND VPWR VGND sky130_ef_sc_hd__decap_12
XTAP_TAPCELL_ROW_231_3127 VGND VPWR sky130_fd_sc_hd__tapvpwrvgnd_1
XFILLER_70_1189 VGND VGND VPWR VPWR sky130_fd_sc_hd__fill_1
XFILLER_41_61 VGND VGND VPWR VPWR sky130_fd_sc_hd__fill_1
XFILLER_6_533 VGND VGND VPWR VPWR sky130_fd_sc_hd__fill_2
XFILLER_183_865 VPWR VGND VPWR VGND sky130_ef_sc_hd__decap_12
XFILLER_6_577 VGND VGND VPWR VPWR sky130_fd_sc_hd__fill_1
XTAP_TAPCELL_ROW_72_2_4184 VGND VPWR sky130_fd_sc_hd__tapvpwrvgnd_1
XFILLER_194_1093 VPWR VGND VPWR VGND sky130_ef_sc_hd__decap_12
XTAP_TAPCELL_ROW_229_3056 VGND VPWR sky130_fd_sc_hd__tapvpwrvgnd_1
XFILLER_170_1509 VGND VGND VPWR VPWR sky130_fd_sc_hd__decap_6
XFILLER_237_1399 VGND VGND VPWR VPWR sky130_fd_sc_hd__fill_1
XTAP_TAPCELL_ROW_229_3067 VGND VPWR sky130_fd_sc_hd__tapvpwrvgnd_1
XTAP_TAPCELL_ROW_229_3078 VGND VPWR sky130_fd_sc_hd__tapvpwrvgnd_1
XFILLER_238_811 VGND VGND VPWR VPWR sky130_fd_sc_hd__fill_1
XFILLER_42_1203 VPWR VGND VPWR VGND sky130_ef_sc_hd__decap_12
XFILLER_46_1383 VPWR VGND VPWR VGND sky130_ef_sc_hd__decap_12
XFILLER_133_1331 VPWR VGND VPWR VGND sky130_ef_sc_hd__decap_12
XFILLER_173_93 VPWR VGND VPWR VGND sky130_ef_sc_hd__decap_12
XFILLER_249_181 VPWR VGND VPWR VGND sky130_ef_sc_hd__decap_12
XFILLER_42_1247 VPWR VGND VPWR VGND sky130_ef_sc_hd__decap_12
XFILLER_2_77 VGND VGND VPWR VPWR sky130_fd_sc_hd__decap_6
XFILLER_225_505 VPWR VGND VPWR VGND sky130_ef_sc_hd__decap_12
XFILLER_168_1427 VGND VGND VPWR VPWR sky130_fd_sc_hd__fill_1
XTAP_TAPCELL_ROW_220_2820 VGND VPWR sky130_fd_sc_hd__tapvpwrvgnd_1
XFILLER_252_357 VGND VGND VPWR VPWR sky130_fd_sc_hd__decap_6
XTAP_TAPCELL_ROW_220_2831 VGND VPWR sky130_fd_sc_hd__tapvpwrvgnd_1
XFILLER_209_1413 VPWR VGND VPWR VGND sky130_ef_sc_hd__decap_12
XFILLER_244_1315 VGND VGND VPWR VPWR sky130_fd_sc_hd__fill_1
XPHY_EDGE_ROW_26_2_Right_117 VGND VGND VPWR VPWR sky130_fd_sc_hd__decap_3
XFILLER_166_1173 VPWR VGND VPWR VGND sky130_ef_sc_hd__decap_12
XFILLER_205_273 VGND VGND VPWR VPWR sky130_fd_sc_hd__decap_6
XFILLER_209_1457 VPWR VGND VPWR VGND sky130_ef_sc_hd__decap_12
XFILLER_178_637 VGND VGND VPWR VPWR sky130_fd_sc_hd__decap_6
XFILLER_220_221 VPWR VGND VPWR VGND sky130_ef_sc_hd__decap_12
XFILLER_177_125 VPWR VGND VPWR VGND sky130_ef_sc_hd__decap_12
XTAP_TAPCELL_ROW_44_2_4019 VGND VPWR sky130_fd_sc_hd__tapvpwrvgnd_1
XFILLER_221_777 VGND VGND VPWR VPWR sky130_fd_sc_hd__decap_6
XFILLER_53_1343 VPWR VGND VPWR VGND sky130_ef_sc_hd__decap_12
XFILLER_18_1463 VGND VGND VPWR VPWR sky130_fd_sc_hd__decap_6
XFILLER_105_1411 VPWR VGND VPWR VGND sky130_ef_sc_hd__decap_12
XFILLER_203_1001 VGND VGND VPWR VPWR sky130_fd_sc_hd__decap_6
XFILLER_220_265 VPWR VGND VPWR VGND sky130_ef_sc_hd__decap_12
XFILLER_242_1061 VPWR VGND VPWR VGND sky130_ef_sc_hd__decap_12
XFILLER_144_1471 VPWR VGND VPWR VGND sky130_ef_sc_hd__decap_12
XFILLER_165_309 VPWR VGND VPWR VGND sky130_ef_sc_hd__decap_12
XFILLER_177_169 VPWR VGND VPWR VGND sky130_ef_sc_hd__decap_12
XFILLER_193_629 VPWR VGND VPWR VGND sky130_ef_sc_hd__decap_12
XFILLER_14_1327 VPWR VGND VPWR VGND sky130_ef_sc_hd__decap_12
XTAP_TAPCELL_ROW_193_2086 VGND VPWR sky130_fd_sc_hd__tapvpwrvgnd_1
XTAP_TAPCELL_ROW_218_2760 VGND VPWR sky130_fd_sc_hd__tapvpwrvgnd_1
XFILLER_53_1387 VPWR VGND VPWR VGND sky130_ef_sc_hd__decap_12
XFILLER_105_1455 VPWR VGND VPWR VGND sky130_ef_sc_hd__decap_12
XFILLER_186_681 VPWR VGND VPWR VGND sky130_ef_sc_hd__decap_12
XTAP_TAPCELL_ROW_193_2097 VGND VPWR sky130_fd_sc_hd__tapvpwrvgnd_1
XFILLER_203_1045 VPWR VGND VPWR VGND sky130_ef_sc_hd__decap_12
XTAP_TAPCELL_ROW_218_2771 VGND VPWR sky130_fd_sc_hd__tapvpwrvgnd_1
XTAP_TAPCELL_ROW_218_2782 VGND VPWR sky130_fd_sc_hd__tapvpwrvgnd_1
XFILLER_140_1357 VGND VGND VPWR VPWR sky130_fd_sc_hd__fill_1
XFILLER_192_139 VGND VGND VPWR VPWR sky130_fd_sc_hd__fill_1
XFILLER_9_393 VPWR VGND VPWR VGND sky130_ef_sc_hd__decap_12
XFILLER_88_1439 VPWR VGND VPWR VGND sky130_ef_sc_hd__decap_12
XFILLER_105_1499 VPWR VGND VPWR VGND sky130_ef_sc_hd__decap_12
XFILLER_203_1089 VPWR VGND VPWR VGND sky130_ef_sc_hd__decap_12
XTAP_TAPCELL_ROW_214_2657 VGND VPWR sky130_fd_sc_hd__tapvpwrvgnd_1
XTAP_TAPCELL_ROW_214_2668 VGND VPWR sky130_fd_sc_hd__tapvpwrvgnd_1
XFILLER_173_1133 VPWR VGND VPWR VGND sky130_ef_sc_hd__decap_12
XFILLER_173_1177 VPWR VGND VPWR VGND sky130_ef_sc_hd__decap_12
XFILLER_60_1303 VPWR VGND VPWR VGND sky130_ef_sc_hd__decap_12
XFILLER_25_1423 VPWR VGND VPWR VGND sky130_ef_sc_hd__decap_12
XFILLER_64_1483 VPWR VGND VPWR VGND sky130_ef_sc_hd__decap_12
XFILLER_214_1141 VGND VGND VPWR VPWR sky130_fd_sc_hd__decap_6
XFILLER_229_833 VGND VGND VPWR VPWR sky130_fd_sc_hd__decap_6
XFILLER_228_321 VPWR VGND VPWR VGND sky130_ef_sc_hd__decap_12
XFILLER_210_1005 VPWR VGND VPWR VGND sky130_ef_sc_hd__decap_12
XFILLER_25_1467 VPWR VGND VPWR VGND sky130_ef_sc_hd__decap_12
XFILLER_112_1415 VPWR VGND VPWR VGND sky130_ef_sc_hd__decap_12
XFILLER_214_1185 VPWR VGND VPWR VGND sky130_ef_sc_hd__decap_12
XFILLER_229_877 VPWR VGND VPWR VGND sky130_ef_sc_hd__decap_12
XFILLER_228_365 VPWR VGND VPWR VGND sky130_ef_sc_hd__decap_12
XFILLER_244_825 VPWR VGND VPWR VGND sky130_ef_sc_hd__decap_12
XFILLER_151_1497 VGND VGND VPWR VPWR sky130_fd_sc_hd__fill_1
XFILLER_210_1049 VPWR VGND VPWR VGND sky130_ef_sc_hd__decap_12
XFILLER_243_335 VGND VGND VPWR VPWR sky130_fd_sc_hd__fill_1
XFILLER_244_869 VPWR VGND VPWR VGND sky130_ef_sc_hd__decap_12
XTAP_TAPCELL_ROW_182_1790 VGND VPWR sky130_fd_sc_hd__tapvpwrvgnd_1
XTAP_TAPCELL_ROW_141_2_4603 VGND VPWR sky130_fd_sc_hd__tapvpwrvgnd_1
XFILLER_227_1513 VGND VGND VPWR VPWR sky130_fd_sc_hd__fill_2
XFILLER_145_1213 VGND VGND VPWR VPWR sky130_fd_sc_hd__decap_4
XFILLER_169_615 VGND VGND VPWR VPWR sky130_fd_sc_hd__fill_1
XFILLER_184_1273 VPWR VGND VPWR VGND sky130_ef_sc_hd__decap_12
XFILLER_196_401 VPWR VGND VPWR VGND sky130_ef_sc_hd__decap_12
XFILLER_93_1189 VPWR VGND VPWR VGND sky130_ef_sc_hd__decap_12
XFILLER_178_27 VGND VGND VPWR VPWR sky130_fd_sc_hd__fill_1
XFILLER_212_755 VGND VGND VPWR VPWR sky130_fd_sc_hd__fill_1
XFILLER_196_445 VPWR VGND VPWR VGND sky130_ef_sc_hd__decap_12
XFILLER_200_917 VGND VGND VPWR VPWR sky130_fd_sc_hd__decap_6
XFILLER_71_1443 VPWR VGND VPWR VGND sky130_ef_sc_hd__decap_12
XFILLER_123_1511 VGND VGND VPWR VPWR sky130_fd_sc_hd__decap_4
XFILLER_221_1101 VPWR VGND VPWR VGND sky130_ef_sc_hd__decap_12
XFILLER_225_1281 VGND VGND VPWR VPWR sky130_fd_sc_hd__decap_6
XFILLER_196_489 VPWR VGND VPWR VGND sky130_ef_sc_hd__decap_12
XTAP_TAPCELL_ROW_96_1_1231 VGND VPWR sky130_fd_sc_hd__tapvpwrvgnd_1
XFILLER_32_1427 VPWR VGND VPWR VGND sky130_ef_sc_hd__decap_12
Xwire228 net229 VGND VGND VPWR VPWR net228 sky130_fd_sc_hd__clkbuf_1
Xwire239 net240 VGND VGND VPWR VPWR net239 sky130_fd_sc_hd__clkbuf_1
XTAP_TAPCELL_ROW_110_1_1245 VGND VPWR sky130_fd_sc_hd__tapvpwrvgnd_1
XFILLER_221_1145 VPWR VGND VPWR VGND sky130_ef_sc_hd__decap_12
XFILLER_165_865 VGND VGND VPWR VPWR sky130_fd_sc_hd__decap_3
XFILLER_194_15 VPWR VGND VPWR VGND sky130_ef_sc_hd__decap_12
XFILLER_221_1189 VPWR VGND VPWR VGND sky130_ef_sc_hd__decap_12
XFILLER_180_813 VPWR VGND VPWR VGND sky130_ef_sc_hd__decap_12
XFILLER_191_161 VGND VGND VPWR VPWR sky130_fd_sc_hd__decap_6
XTAP_TAPCELL_ROW_57_2_4097 VGND VPWR sky130_fd_sc_hd__tapvpwrvgnd_1
XFILLER_191_1233 VPWR VGND VPWR VGND sky130_ef_sc_hd__decap_12
XFILLER_219_1063 VGND VGND VPWR VPWR sky130_fd_sc_hd__fill_1
XFILLER_87_57 VPWR VGND VPWR VGND sky130_ef_sc_hd__decap_12
XTAP_TAPCELL_ROW_189_1977 VGND VPWR sky130_fd_sc_hd__tapvpwrvgnd_1
XTAP_TAPCELL_ROW_189_1988 VGND VPWR sky130_fd_sc_hd__tapvpwrvgnd_1
XFILLER_152_1239 VGND VGND VPWR VPWR sky130_fd_sc_hd__decap_6
XTAP_TAPCELL_ROW_189_1999 VGND VPWR sky130_fd_sc_hd__tapvpwrvgnd_1
XFILLER_8_1141 VGND VGND VPWR VPWR sky130_fd_sc_hd__decap_6
XFILLER_232_1241 VPWR VGND VPWR VGND sky130_ef_sc_hd__decap_12
XFILLER_247_641 VPWR VGND VPWR VGND sky130_ef_sc_hd__decap_12
XFILLER_4_1005 VPWR VGND VPWR VGND sky130_ef_sc_hd__decap_12
XFILLER_8_1185 VPWR VGND VPWR VGND sky130_ef_sc_hd__decap_12
XTAP_TAPCELL_ROW_5_1000 VGND VPWR sky130_fd_sc_hd__tapvpwrvgnd_1
XFILLER_232_1285 VPWR VGND VPWR VGND sky130_ef_sc_hd__decap_12
XPHY_EDGE_ROW_14_1_Right_670 VGND VGND VPWR VPWR sky130_fd_sc_hd__decap_3
XFILLER_207_505 VPWR VGND VPWR VGND sky130_ef_sc_hd__decap_12
XFILLER_247_685 VPWR VGND VPWR VGND sky130_ef_sc_hd__decap_12
XFILLER_4_1049 VPWR VGND VPWR VGND sky130_ef_sc_hd__decap_12
XFILLER_246_195 VGND VGND VPWR VPWR sky130_fd_sc_hd__fill_1
XTAP_TAPCELL_ROW_35_2_3967 VGND VPWR sky130_fd_sc_hd__tapvpwrvgnd_1
XPHY_EDGE_ROW_153_2_Right_244 VGND VGND VPWR VPWR sky130_fd_sc_hd__decap_3
XFILLER_234_357 VGND VGND VPWR VPWR sky130_fd_sc_hd__decap_6
XFILLER_199_261 VPWR VGND VPWR VGND sky130_ef_sc_hd__decap_12
XFILLER_167_1493 VPWR VGND VPWR VGND sky130_ef_sc_hd__decap_12
XFILLER_202_221 VPWR VGND VPWR VGND sky130_ef_sc_hd__decap_12
XTAP_TAPCELL_ROW_15_2_3843 VGND VPWR sky130_fd_sc_hd__tapvpwrvgnd_1
XFILLER_203_777 VGND VGND VPWR VPWR sky130_fd_sc_hd__decap_6
XFILLER_188_979 VGND VGND VPWR VPWR sky130_fd_sc_hd__fill_1
XFILLER_163_1379 VGND VGND VPWR VPWR sky130_fd_sc_hd__decap_6
XFILLER_202_265 VPWR VGND VPWR VGND sky130_ef_sc_hd__decap_12
X_316_ net595 dout0_q\[26\] net61 VGND VGND VPWR VPWR _105_ sky130_fd_sc_hd__a21oi_1
XFILLER_243_1381 VPWR VGND VPWR VGND sky130_ef_sc_hd__decap_12
XFILLER_175_629 VPWR VGND VPWR VGND sky130_ef_sc_hd__decap_12
XFILLER_198_1409 VPWR VGND VPWR VGND sky130_ef_sc_hd__decap_12
XFILLER_168_681 VPWR VGND VPWR VGND sky130_ef_sc_hd__decap_12
Xinput14 wr_data[13] VGND VGND VPWR VPWR net14 sky130_fd_sc_hd__clkbuf_1
XFILLER_204_1365 VGND VGND VPWR VPWR sky130_fd_sc_hd__decap_6
Xinput25 wr_data[23] VGND VGND VPWR VPWR net25 sky130_fd_sc_hd__clkbuf_1
XFILLER_174_139 VGND VGND VPWR VPWR sky130_fd_sc_hd__fill_1
Xinput36 wr_data[4] VGND VGND VPWR VPWR net36 sky130_fd_sc_hd__clkbuf_1
XTAP_TAPCELL_ROW_154_2_4681 VGND VPWR sky130_fd_sc_hd__tapvpwrvgnd_1
XFILLER_200_1229 VPWR VGND VPWR VGND sky130_ef_sc_hd__decap_12
Xmax_cap506 _101_ VGND VGND VPWR VPWR net506 sky130_fd_sc_hd__clkbuf_1
XFILLER_183_673 VPWR VGND VPWR VGND sky130_ef_sc_hd__decap_12
Xmax_cap517 net518 VGND VGND VPWR VPWR net517 sky130_fd_sc_hd__clkbuf_1
XFILLER_170_301 VGND VGND VPWR VPWR sky130_fd_sc_hd__decap_6
XFILLER_7_897 VPWR VGND VPWR VGND sky130_ef_sc_hd__decap_12
Xmax_cap528 net62 VGND VGND VPWR VPWR net528 sky130_fd_sc_hd__clkbuf_1
XFILLER_170_345 VPWR VGND VPWR VGND sky130_ef_sc_hd__decap_12
XFILLER_254_29 VPWR VGND VPWR VGND sky130_ef_sc_hd__decap_12
XFILLER_174_1453 VPWR VGND VPWR VGND sky130_ef_sc_hd__decap_12
XFILLER_170_389 VPWR VGND VPWR VGND sky130_ef_sc_hd__decap_12
XPHY_EDGE_ROW_15_2_Left_517 VGND VGND VPWR VPWR sky130_fd_sc_hd__decap_3
XFILLER_170_1317 VPWR VGND VPWR VGND sky130_ef_sc_hd__decap_12
XFILLER_174_1497 VPWR VGND VPWR VGND sky130_ef_sc_hd__decap_12
XTAP_TAPCELL_ROW_146_2_4629 VGND VPWR sky130_fd_sc_hd__tapvpwrvgnd_1
XFILLER_250_1341 VPWR VGND VPWR VGND sky130_ef_sc_hd__decap_12
XFILLER_28_3 VPWR VGND VPWR VGND sky130_ef_sc_hd__decap_12
XFILLER_46_1191 VPWR VGND VPWR VGND sky130_ef_sc_hd__decap_12
XFILLER_211_1325 VPWR VGND VPWR VGND sky130_ef_sc_hd__decap_12
XFILLER_250_1385 VPWR VGND VPWR VGND sky130_ef_sc_hd__decap_12
XTAP_TAPCELL_ROW_207_2461 VGND VPWR sky130_fd_sc_hd__tapvpwrvgnd_1
XFILLER_226_825 VPWR VGND VPWR VGND sky130_ef_sc_hd__decap_12
XTAP_TAPCELL_ROW_207_2472 VGND VPWR sky130_fd_sc_hd__tapvpwrvgnd_1
XFILLER_211_1369 VPWR VGND VPWR VGND sky130_ef_sc_hd__decap_12
XTAP_TAPCELL_ROW_207_2483 VGND VPWR sky130_fd_sc_hd__tapvpwrvgnd_1
XFILLER_252_121 VPWR VGND VPWR VGND sky130_ef_sc_hd__decap_12
XFILLER_203_55 VGND VGND VPWR VPWR sky130_fd_sc_hd__fill_1
XFILLER_225_335 VGND VGND VPWR VPWR sky130_fd_sc_hd__fill_1
XFILLER_226_869 VPWR VGND VPWR VGND sky130_ef_sc_hd__decap_12
XFILLER_0_1425 VGND VGND VPWR VPWR sky130_fd_sc_hd__decap_3
XTAP_TAPCELL_ROW_203_2358 VGND VPWR sky130_fd_sc_hd__tapvpwrvgnd_1
XFILLER_129_1219 VPWR VGND VPWR VGND sky130_ef_sc_hd__decap_12
XTAP_TAPCELL_ROW_199_2251 VGND VPWR sky130_fd_sc_hd__tapvpwrvgnd_1
XTAP_TAPCELL_ROW_203_2369 VGND VPWR sky130_fd_sc_hd__tapvpwrvgnd_1
XFILLER_252_165 VPWR VGND VPWR VGND sky130_ef_sc_hd__decap_12
XTAP_TAPCELL_ROW_199_2262 VGND VPWR sky130_fd_sc_hd__tapvpwrvgnd_1
XFILLER_241_839 VGND VGND VPWR VPWR sky130_fd_sc_hd__fill_1
XFILLER_0_1469 VPWR VGND VPWR VGND sky130_ef_sc_hd__decap_12
XTAP_TAPCELL_ROW_94_2_4316 VGND VPWR sky130_fd_sc_hd__tapvpwrvgnd_1
XFILLER_178_401 VPWR VGND VPWR VGND sky130_ef_sc_hd__decap_12
XFILLER_181_1413 VPWR VGND VPWR VGND sky130_ef_sc_hd__decap_12
XPHY_EDGE_ROW_27_2_Right_118 VGND VGND VPWR VPWR sky130_fd_sc_hd__decap_3
XTAP_TAPCELL_ROW_195_2137 VGND VPWR sky130_fd_sc_hd__tapvpwrvgnd_1
XTAP_TAPCELL_ROW_195_2148 VGND VPWR sky130_fd_sc_hd__tapvpwrvgnd_1
XTAP_TAPCELL_ROW_195_2159 VGND VPWR sky130_fd_sc_hd__tapvpwrvgnd_1
XFILLER_221_541 VPWR VGND VPWR VGND sky130_ef_sc_hd__decap_12
XFILLER_178_445 VPWR VGND VPWR VGND sky130_ef_sc_hd__decap_12
XFILLER_181_1457 VPWR VGND VPWR VGND sky130_ef_sc_hd__decap_12
XFILLER_209_1287 VGND VGND VPWR VPWR sky130_fd_sc_hd__fill_1
XFILLER_194_905 VPWR VGND VPWR VGND sky130_ef_sc_hd__decap_12
XFILLER_221_585 VPWR VGND VPWR VGND sky130_ef_sc_hd__decap_12
XFILLER_222_1421 VGND VGND VPWR VPWR sky130_fd_sc_hd__decap_6
XTAP_TAPCELL_ROW_216_2708 VGND VPWR sky130_fd_sc_hd__tapvpwrvgnd_1
XFILLER_18_1271 VPWR VGND VPWR VGND sky130_ef_sc_hd__decap_12
XFILLER_178_489 VPWR VGND VPWR VGND sky130_ef_sc_hd__decap_12
XTAP_TAPCELL_ROW_216_2719 VGND VPWR sky130_fd_sc_hd__tapvpwrvgnd_1
XFILLER_194_949 VPWR VGND VPWR VGND sky130_ef_sc_hd__decap_12
XFILLER_222_1465 VPWR VGND VPWR VGND sky130_ef_sc_hd__decap_12
XFILLER_88_1203 VPWR VGND VPWR VGND sky130_ef_sc_hd__decap_12
XFILLER_140_1165 VPWR VGND VPWR VGND sky130_ef_sc_hd__decap_12
XFILLER_180_109 VPWR VGND VPWR VGND sky130_ef_sc_hd__decap_12
XFILLER_228_41 VPWR VGND VPWR VGND sky130_ef_sc_hd__decap_12
XFILLER_88_1247 VPWR VGND VPWR VGND sky130_ef_sc_hd__decap_12
XFILLER_173_161 VGND VGND VPWR VPWR sky130_fd_sc_hd__decap_6
XTAP_TAPCELL_ROW_157_1_1292 VGND VPWR sky130_fd_sc_hd__tapvpwrvgnd_1
XFILLER_228_85 VPWR VGND VPWR VGND sky130_ef_sc_hd__decap_12
XFILLER_164_29 VPWR VGND VPWR VGND sky130_ef_sc_hd__decap_12
XTAP_TAPCELL_ROW_171_1491 VGND VPWR sky130_fd_sc_hd__tapvpwrvgnd_1
XFILLER_216_1203 VGND VGND VPWR VPWR sky130_fd_sc_hd__fill_1
XFILLER_255_1285 VGND VGND VPWR VPWR sky130_fd_sc_hd__decap_3
XTAP_TAPCELL_ROW_41_2_3999 VGND VPWR sky130_fd_sc_hd__tapvpwrvgnd_1
XFILLER_57_27 VPWR VGND VPWR VGND sky130_ef_sc_hd__decap_12
XFILLER_25_1231 VPWR VGND VPWR VGND sky130_ef_sc_hd__decap_12
XTAP_TAPCELL_ROW_184_1841 VGND VPWR sky130_fd_sc_hd__tapvpwrvgnd_1
XFILLER_229_641 VPWR VGND VPWR VGND sky130_ef_sc_hd__decap_12
XFILLER_5_1325 VPWR VGND VPWR VGND sky130_ef_sc_hd__decap_12
XTAP_TAPCELL_ROW_184_1852 VGND VPWR sky130_fd_sc_hd__tapvpwrvgnd_1
XFILLER_25_1275 VPWR VGND VPWR VGND sky130_ef_sc_hd__decap_12
XTAP_TAPCELL_ROW_184_1863 VGND VPWR sky130_fd_sc_hd__tapvpwrvgnd_1
XFILLER_249_1001 VGND VGND VPWR VPWR sky130_fd_sc_hd__decap_6
XFILLER_99_1343 VPWR VGND VPWR VGND sky130_ef_sc_hd__decap_12
XFILLER_229_685 VPWR VGND VPWR VGND sky130_ef_sc_hd__decap_12
XFILLER_60_1177 VPWR VGND VPWR VGND sky130_ef_sc_hd__decap_12
XFILLER_5_1369 VPWR VGND VPWR VGND sky130_ef_sc_hd__decap_12
XFILLER_112_1245 VGND VGND VPWR VPWR sky130_fd_sc_hd__fill_1
XTAP_TAPCELL_ROW_180_1738 VGND VPWR sky130_fd_sc_hd__tapvpwrvgnd_1
XFILLER_113_55 VGND VGND VPWR VPWR sky130_fd_sc_hd__fill_1
XFILLER_228_195 VGND VGND VPWR VPWR sky130_fd_sc_hd__fill_1
XFILLER_249_1045 VPWR VGND VPWR VGND sky130_ef_sc_hd__decap_12
XFILLER_73_15 VPWR VGND VPWR VGND sky130_ef_sc_hd__decap_12
XFILLER_99_1387 VPWR VGND VPWR VGND sky130_ef_sc_hd__decap_12
XTAP_TAPCELL_ROW_180_1749 VGND VPWR sky130_fd_sc_hd__tapvpwrvgnd_1
XFILLER_216_357 VGND VGND VPWR VPWR sky130_fd_sc_hd__decap_6
XPHY_EDGE_ROW_61_2_Left_563 VGND VGND VPWR VPWR sky130_fd_sc_hd__decap_3
XFILLER_189_15 VPWR VGND VPWR VGND sky130_ef_sc_hd__decap_12
XFILLER_231_305 VPWR VGND VPWR VGND sky130_ef_sc_hd__decap_12
XFILLER_249_1089 VPWR VGND VPWR VGND sky130_ef_sc_hd__decap_12
XFILLER_244_699 VGND VGND VPWR VPWR sky130_fd_sc_hd__fill_1
XFILLER_188_209 VPWR VGND VPWR VGND sky130_ef_sc_hd__decap_12
Xwire82 _236_ VGND VGND VPWR VPWR net82 sky130_fd_sc_hd__clkbuf_1
XFILLER_227_1343 VGND VGND VPWR VPWR sky130_fd_sc_hd__fill_1
XFILLER_197_721 VGND VGND VPWR VPWR sky130_fd_sc_hd__decap_6
XFILLER_231_349 VPWR VGND VPWR VGND sky130_ef_sc_hd__decap_12
XFILLER_240_861 VGND VGND VPWR VPWR sky130_fd_sc_hd__decap_6
XFILLER_197_765 VPWR VGND VPWR VGND sky130_ef_sc_hd__decap_12
XFILLER_196_253 VPWR VGND VPWR VGND sky130_ef_sc_hd__decap_12
XFILLER_200_725 VPWR VGND VPWR VGND sky130_ef_sc_hd__decap_12
XTAP_TAPCELL_ROW_178_1678 VGND VPWR sky130_fd_sc_hd__tapvpwrvgnd_1
XFILLER_36_1371 VPWR VGND VPWR VGND sky130_ef_sc_hd__decap_12
XFILLER_132_3 VPWR VGND VPWR VGND sky130_ef_sc_hd__decap_12
XTAP_TAPCELL_ROW_178_1689 VGND VPWR sky130_fd_sc_hd__tapvpwrvgnd_1
XFILLER_71_1273 VGND VGND VPWR VPWR sky130_fd_sc_hd__fill_1
XFILLER_200_769 VPWR VGND VPWR VGND sky130_ef_sc_hd__decap_12
XFILLER_201_1505 VGND VGND VPWR VPWR sky130_fd_sc_hd__decap_6
XFILLER_22_41 VPWR VGND VPWR VGND sky130_ef_sc_hd__decap_12
XPHY_EDGE_ROW_13_1_Left_268 VGND VGND VPWR VPWR sky130_fd_sc_hd__decap_3
XFILLER_123_1385 VGND VGND VPWR VPWR sky130_fd_sc_hd__fill_1
XFILLER_138_41 VPWR VGND VPWR VGND sky130_ef_sc_hd__decap_12
XFILLER_165_673 VPWR VGND VPWR VGND sky130_ef_sc_hd__decap_12
XFILLER_158_1415 VPWR VGND VPWR VGND sky130_ef_sc_hd__decap_12
XPHY_EDGE_ROW_138_1_Left_393 VGND VGND VPWR VPWR sky130_fd_sc_hd__decap_3
XFILLER_180_643 VGND VGND VPWR VPWR sky130_fd_sc_hd__fill_1
XTAP_TAPCELL_ROW_119_2_4470 VGND VPWR sky130_fd_sc_hd__tapvpwrvgnd_1
XFILLER_3_344 VGND VGND VPWR VPWR sky130_fd_sc_hd__fill_2
XFILLER_4_878 VPWR VGND VPWR VGND sky130_ef_sc_hd__decap_12
XFILLER_238_1483 VGND VGND VPWR VPWR sky130_fd_sc_hd__fill_1
XFILLER_3_388 VGND VGND VPWR VPWR sky130_fd_sc_hd__fill_1
XFILLER_239_405 VPWR VGND VPWR VGND sky130_ef_sc_hd__decap_12
XTAP_TAPCELL_ROW_132_2_4548 VGND VPWR sky130_fd_sc_hd__tapvpwrvgnd_1
XFILLER_191_1063 VGND VGND VPWR VPWR sky130_fd_sc_hd__fill_1
XPHY_EDGE_ROW_75_1_Left_330 VGND VGND VPWR VPWR sky130_fd_sc_hd__decap_3
XFILLER_239_449 VPWR VGND VPWR VGND sky130_ef_sc_hd__decap_12
XFILLER_255_909 VPWR VGND VPWR VGND sky130_ef_sc_hd__decap_12
XFILLER_43_1331 VPWR VGND VPWR VGND sky130_ef_sc_hd__decap_12
XFILLER_117_1189 VPWR VGND VPWR VGND sky130_ef_sc_hd__decap_12
XFILLER_248_961 VPWR VGND VPWR VGND sky130_ef_sc_hd__decap_12
XFILLER_130_1301 VGND VGND VPWR VPWR sky130_fd_sc_hd__fill_1
XFILLER_254_419 VGND VGND VPWR VPWR sky130_fd_sc_hd__fill_1
XFILLER_232_1093 VPWR VGND VPWR VGND sky130_ef_sc_hd__decap_12
XTAP_TAPCELL_ROW_112_2_4424 VGND VPWR sky130_fd_sc_hd__tapvpwrvgnd_1
XFILLER_169_1511 VGND VGND VPWR VPWR sky130_fd_sc_hd__fill_1
XFILLER_208_825 VPWR VGND VPWR VGND sky130_ef_sc_hd__decap_12
XPHY_EDGE_ROW_15_1_Right_671 VGND VGND VPWR VPWR sky130_fd_sc_hd__decap_3
XPHY_EDGE_ROW_179_Right_24 VGND VGND VPWR VPWR sky130_fd_sc_hd__decap_3
XFILLER_78_1427 VPWR VGND VPWR VGND sky130_ef_sc_hd__decap_12
XFILLER_207_335 VGND VGND VPWR VPWR sky130_fd_sc_hd__fill_1
XFILLER_208_869 VPWR VGND VPWR VGND sky130_ef_sc_hd__decap_12
XFILLER_234_121 VPWR VGND VPWR VGND sky130_ef_sc_hd__decap_12
XFILLER_170_83 VGND VGND VPWR VPWR sky130_fd_sc_hd__fill_1
XFILLER_228_1129 VPWR VGND VPWR VGND sky130_ef_sc_hd__decap_12
XTAP_TAPCELL_ROW_80_2_4235 VGND VPWR sky130_fd_sc_hd__tapvpwrvgnd_1
XFILLER_223_839 VGND VGND VPWR VPWR sky130_fd_sc_hd__fill_1
XFILLER_234_165 VPWR VGND VPWR VGND sky130_ef_sc_hd__decap_12
XFILLER_250_625 VPWR VGND VPWR VGND sky130_ef_sc_hd__decap_12
XTAP_TAPCELL_ROW_79_2_4229 VGND VPWR sky130_fd_sc_hd__tapvpwrvgnd_1
XPHY_EDGE_ROW_154_2_Right_245 VGND VGND VPWR VPWR sky130_fd_sc_hd__decap_3
XFILLER_250_669 VPWR VGND VPWR VGND sky130_ef_sc_hd__decap_12
XFILLER_203_541 VPWR VGND VPWR VGND sky130_ef_sc_hd__decap_12
XFILLER_206_1427 VGND VGND VPWR VPWR sky130_fd_sc_hd__fill_1
XFILLER_176_905 VPWR VGND VPWR VGND sky130_ef_sc_hd__decap_12
XFILLER_163_1165 VPWR VGND VPWR VGND sky130_ef_sc_hd__decap_12
XFILLER_179_81 VPWR VGND VPWR VGND sky130_ef_sc_hd__decap_12
XFILLER_203_585 VPWR VGND VPWR VGND sky130_ef_sc_hd__decap_12
XFILLER_15_1411 VPWR VGND VPWR VGND sky130_ef_sc_hd__decap_12
XFILLER_54_1471 VPWR VGND VPWR VGND sky130_ef_sc_hd__decap_12
XFILLER_176_949 VPWR VGND VPWR VGND sky130_ef_sc_hd__decap_12
XTAP_TAPCELL_ROW_190_2012 VGND VPWR sky130_fd_sc_hd__tapvpwrvgnd_1
XTAP_TAPCELL_ROW_190_2023 VGND VPWR sky130_fd_sc_hd__tapvpwrvgnd_1
XFILLER_198_1217 VPWR VGND VPWR VGND sky130_ef_sc_hd__decap_12
XFILLER_141_1441 VGND VGND VPWR VPWR sky130_fd_sc_hd__fill_1
XFILLER_15_1455 VPWR VGND VPWR VGND sky130_ef_sc_hd__decap_12
XFILLER_8_65 VPWR VGND VPWR VGND sky130_ef_sc_hd__decap_12
XFILLER_204_1173 VPWR VGND VPWR VGND sky130_ef_sc_hd__decap_12
XPHY_EDGE_ROW_188_Right_33 VGND VGND VPWR VPWR sky130_fd_sc_hd__decap_3
XFILLER_50_1357 VGND VGND VPWR VPWR sky130_fd_sc_hd__fill_1
XFILLER_15_1499 VPWR VGND VPWR VGND sky130_ef_sc_hd__decap_12
XFILLER_200_1037 VPWR VGND VPWR VGND sky130_ef_sc_hd__decap_12
XFILLER_239_1225 VGND VGND VPWR VPWR sky130_fd_sc_hd__decap_6
Xwire570 dout0_q\[16\] VGND VGND VPWR VPWR net570 sky130_fd_sc_hd__clkbuf_1
XFILLER_184_993 VPWR VGND VPWR VGND sky130_ef_sc_hd__decap_12
Xwire581 net582 VGND VGND VPWR VPWR net581 sky130_fd_sc_hd__clkbuf_1
XFILLER_102_1469 VGND VGND VPWR VPWR sky130_fd_sc_hd__fill_1
XFILLER_239_1269 VPWR VGND VPWR VGND sky130_ef_sc_hd__decap_12
XFILLER_171_665 VGND VGND VPWR VPWR sky130_fd_sc_hd__decap_6
XFILLER_170_153 VPWR VGND VPWR VGND sky130_ef_sc_hd__decap_12
XFILLER_135_1201 VPWR VGND VPWR VGND sky130_ef_sc_hd__decap_12
XFILLER_174_1261 VPWR VGND VPWR VGND sky130_ef_sc_hd__decap_12
XFILLER_170_197 VPWR VGND VPWR VGND sky130_ef_sc_hd__decap_12
XFILLER_83_1177 VPWR VGND VPWR VGND sky130_ef_sc_hd__decap_12
XTAP_TAPCELL_ROW_209_2523 VGND VPWR sky130_fd_sc_hd__tapvpwrvgnd_1
XFILLER_170_1147 VGND VGND VPWR VPWR sky130_fd_sc_hd__fill_1
XTAP_TAPCELL_ROW_209_2534 VGND VPWR sky130_fd_sc_hd__tapvpwrvgnd_1
XFILLER_135_1267 VGND VGND VPWR VPWR sky130_fd_sc_hd__decap_6
XFILLER_22_1415 VPWR VGND VPWR VGND sky130_ef_sc_hd__decap_12
XPHY_EDGE_ROW_197_Right_42 VGND VGND VPWR VPWR sky130_fd_sc_hd__decap_3
XTAP_TAPCELL_ROW_205_2409 VGND VPWR sky130_fd_sc_hd__tapvpwrvgnd_1
XFILLER_211_1133 VPWR VGND VPWR VGND sky130_ef_sc_hd__decap_12
XFILLER_214_65 VPWR VGND VPWR VGND sky130_ef_sc_hd__decap_12
XFILLER_2_1509 VGND VGND VPWR VPWR sky130_fd_sc_hd__decap_6
XFILLER_61_1497 VGND VGND VPWR VPWR sky130_fd_sc_hd__fill_1
XFILLER_211_1177 VPWR VGND VPWR VGND sky130_ef_sc_hd__decap_12
XFILLER_253_441 VGND VGND VPWR VPWR sky130_fd_sc_hd__decap_6
XFILLER_246_1229 VPWR VGND VPWR VGND sky130_ef_sc_hd__decap_12
XFILLER_0_1233 VPWR VGND VPWR VGND sky130_ef_sc_hd__decap_12
XFILLER_213_305 VPWR VGND VPWR VGND sky130_ef_sc_hd__decap_12
XFILLER_253_485 VPWR VGND VPWR VGND sky130_ef_sc_hd__decap_12
XFILLER_226_699 VGND VGND VPWR VPWR sky130_fd_sc_hd__fill_1
XFILLER_230_53 VPWR VGND VPWR VGND sky130_ef_sc_hd__decap_12
XFILLER_179_721 VGND VGND VPWR VPWR sky130_fd_sc_hd__decap_6
XFILLER_55_1213 VGND VGND VPWR VPWR sky130_fd_sc_hd__decap_4
XFILLER_213_349 VPWR VGND VPWR VGND sky130_ef_sc_hd__decap_12
XFILLER_222_861 VGND VGND VPWR VPWR sky130_fd_sc_hd__decap_6
XFILLER_230_97 VPWR VGND VPWR VGND sky130_ef_sc_hd__decap_12
XFILLER_94_1295 VGND VGND VPWR VPWR sky130_fd_sc_hd__decap_6
XFILLER_179_765 VPWR VGND VPWR VGND sky130_ef_sc_hd__decap_12
XPHY_EDGE_ROW_28_2_Right_119 VGND VGND VPWR VPWR sky130_fd_sc_hd__decap_3
XFILLER_178_253 VPWR VGND VPWR VGND sky130_ef_sc_hd__decap_12
XFILLER_142_1227 VPWR VGND VPWR VGND sky130_ef_sc_hd__decap_12
XFILLER_194_713 VPWR VGND VPWR VGND sky130_ef_sc_hd__decap_12
XFILLER_33_1511 VGND VGND VPWR VPWR sky130_fd_sc_hd__decap_4
XFILLER_181_1287 VGND VGND VPWR VPWR sky130_fd_sc_hd__fill_1
XFILLER_221_393 VPWR VGND VPWR VGND sky130_ef_sc_hd__decap_12
XFILLER_193_223 VGND VGND VPWR VPWR sky130_fd_sc_hd__fill_1
XFILLER_239_51 VGND VGND VPWR VPWR sky130_fd_sc_hd__decap_4
XFILLER_194_757 VPWR VGND VPWR VGND sky130_ef_sc_hd__decap_12
XFILLER_222_1273 VPWR VGND VPWR VGND sky130_ef_sc_hd__decap_12
XTAP_TAPCELL_ROW_173_1553 VGND VPWR sky130_fd_sc_hd__tapvpwrvgnd_1
XTAP_TAPCELL_ROW_173_1564 VGND VPWR sky130_fd_sc_hd__tapvpwrvgnd_1
XFILLER_181_429 VPWR VGND VPWR VGND sky130_ef_sc_hd__decap_12
XFILLER_175_39 VPWR VGND VPWR VGND sky130_ef_sc_hd__decap_12
XFILLER_218_1309 VGND VGND VPWR VPWR sky130_fd_sc_hd__decap_6
XFILLER_1_804 VGND VGND VPWR VPWR sky130_fd_sc_hd__fill_2
XFILLER_68_15 VPWR VGND VPWR VGND sky130_ef_sc_hd__decap_12
XFILLER_1_837 VGND VGND VPWR VPWR sky130_fd_sc_hd__decap_3
XTAP_TAPCELL_ROW_186_1903 VGND VPWR sky130_fd_sc_hd__tapvpwrvgnd_1
XTAP_TAPCELL_ROW_105_1_1240 VGND VPWR sky130_fd_sc_hd__tapvpwrvgnd_1
XFILLER_153_1323 VGND VGND VPWR VPWR sky130_fd_sc_hd__decap_6
XFILLER_255_1093 VPWR VGND VPWR VGND sky130_ef_sc_hd__decap_12
XTAP_TAPCELL_ROW_186_1914 VGND VPWR sky130_fd_sc_hd__tapvpwrvgnd_1
XFILLER_191_27 VPWR VGND VPWR VGND sky130_ef_sc_hd__decap_12
XFILLER_62_1239 VGND VGND VPWR VPWR sky130_fd_sc_hd__decap_6
XFILLER_153_1367 VPWR VGND VPWR VGND sky130_ef_sc_hd__decap_12
XFILLER_237_909 VPWR VGND VPWR VGND sky130_ef_sc_hd__decap_12
XFILLER_236_419 VGND VGND VPWR VPWR sky130_fd_sc_hd__fill_1
XFILLER_5_1133 VPWR VGND VPWR VGND sky130_ef_sc_hd__decap_12
XFILLER_124_65 VGND VGND VPWR VPWR sky130_fd_sc_hd__decap_6
X_650_ clknet_3_6__leaf_clk acc_core.adder.cla_blocks\[4\].block.sum\[0\] _058_ VGND
+ VGND VPWR VPWR net50 sky130_fd_sc_hd__dfrtp_1
XFILLER_245_953 VPWR VGND VPWR VGND sky130_ef_sc_hd__decap_12
XFILLER_5_1177 VPWR VGND VPWR VGND sky130_ef_sc_hd__decap_12
XFILLER_216_121 VPWR VGND VPWR VGND sky130_ef_sc_hd__decap_12
X_581_ net668 VGND VGND VPWR VPWR _063_ sky130_fd_sc_hd__inv_2
XFILLER_216_165 VPWR VGND VPWR VGND sky130_ef_sc_hd__decap_12
XFILLER_205_839 VGND VGND VPWR VPWR sky130_fd_sc_hd__fill_1
XFILLER_229_1449 VGND VGND VPWR VPWR sky130_fd_sc_hd__decap_6
XFILLER_232_625 VPWR VGND VPWR VGND sky130_ef_sc_hd__decap_12
XPHY_EDGE_ROW_201_Right_46 VGND VGND VPWR VPWR sky130_fd_sc_hd__decap_3
XFILLER_140_53 VPWR VGND VPWR VGND sky130_ef_sc_hd__decap_12
XFILLER_189_529 VPWR VGND VPWR VGND sky130_ef_sc_hd__decap_12
XFILLER_231_113 VPWR VGND VPWR VGND sky130_ef_sc_hd__decap_12
XTAP_TAPCELL_ROW_0_870 VGND VPWR sky130_fd_sc_hd__tapvpwrvgnd_1
XFILLER_182_1029 VGND VGND VPWR VPWR sky130_fd_sc_hd__decap_6
XFILLER_232_669 VPWR VGND VPWR VGND sky130_ef_sc_hd__decap_12
XTAP_TAPCELL_ROW_45_2_4024 VGND VPWR sky130_fd_sc_hd__tapvpwrvgnd_1
XFILLER_164_1463 VGND VGND VPWR VPWR sky130_fd_sc_hd__decap_6
XFILLER_197_573 VPWR VGND VPWR VGND sky130_ef_sc_hd__decap_12
XFILLER_73_1379 VGND VGND VPWR VPWR sky130_fd_sc_hd__decap_6
XFILLER_160_1327 VPWR VGND VPWR VGND sky130_ef_sc_hd__decap_12
XFILLER_8_403 VGND VGND VPWR VPWR sky130_fd_sc_hd__decap_4
XFILLER_200_533 VPWR VGND VPWR VGND sky130_ef_sc_hd__decap_12
XFILLER_9_937 VPWR VGND VPWR VGND sky130_ef_sc_hd__decap_12
XFILLER_149_51 VGND VGND VPWR VPWR sky130_fd_sc_hd__decap_4
XTAP_TAPCELL_ROW_251_3653 VGND VPWR sky130_fd_sc_hd__tapvpwrvgnd_1
XTAP_TAPCELL_ROW_251_3664 VGND VPWR sky130_fd_sc_hd__tapvpwrvgnd_1
XFILLER_184_245 VGND VGND VPWR VPWR sky130_fd_sc_hd__decap_6
XFILLER_201_1313 VPWR VGND VPWR VGND sky130_ef_sc_hd__decap_12
XTAP_TAPCELL_ROW_251_3675 VGND VPWR sky130_fd_sc_hd__tapvpwrvgnd_1
XFILLER_240_1373 VPWR VGND VPWR VGND sky130_ef_sc_hd__decap_12
XFILLER_205_1493 VPWR VGND VPWR VGND sky130_ef_sc_hd__decap_12
XTAP_TAPCELL_ROW_64_1_1199 VGND VPWR sky130_fd_sc_hd__tapvpwrvgnd_1
XFILLER_166_993 VPWR VGND VPWR VGND sky130_ef_sc_hd__decap_12
XFILLER_184_289 VPWR VGND VPWR VGND sky130_ef_sc_hd__decap_12
XFILLER_201_1357 VPWR VGND VPWR VGND sky130_ef_sc_hd__decap_12
XPHY_EDGE_ROW_210_Right_55 VGND VGND VPWR VPWR sky130_fd_sc_hd__decap_3
XFILLER_236_1409 VPWR VGND VPWR VGND sky130_ef_sc_hd__decap_12
XFILLER_4_642 VGND VGND VPWR VPWR sky130_fd_sc_hd__fill_2
XFILLER_158_1245 VGND VGND VPWR VPWR sky130_fd_sc_hd__fill_1
XFILLER_101_1491 VGND VGND VPWR VPWR sky130_fd_sc_hd__decap_6
XFILLER_193_1169 VGND VGND VPWR VPWR sky130_fd_sc_hd__decap_6
XFILLER_171_1401 VPWR VGND VPWR VGND sky130_ef_sc_hd__decap_12
XFILLER_80_1339 VPWR VGND VPWR VGND sky130_ef_sc_hd__decap_12
XFILLER_132_1407 VGND VGND VPWR VPWR sky130_fd_sc_hd__decap_6
XFILLER_239_279 VGND VGND VPWR VPWR sky130_fd_sc_hd__fill_1
Xhold3 rd_addr\[5\] VGND VGND VPWR VPWR net690 sky130_fd_sc_hd__dlygate4sd3_1
XFILLER_212_1453 VPWR VGND VPWR VGND sky130_ef_sc_hd__decap_12
XFILLER_181_93 VPWR VGND VPWR VGND sky130_ef_sc_hd__decap_12
XFILLER_247_1505 VGND VGND VPWR VPWR sky130_fd_sc_hd__decap_6
XFILLER_235_441 VGND VGND VPWR VPWR sky130_fd_sc_hd__decap_6
XFILLER_212_1497 VPWR VGND VPWR VGND sky130_ef_sc_hd__decap_12
XPHY_EDGE_ROW_16_1_Right_672 VGND VGND VPWR VPWR sky130_fd_sc_hd__decap_3
XFILLER_165_1205 VPWR VGND VPWR VGND sky130_ef_sc_hd__decap_12
XFILLER_235_485 VPWR VGND VPWR VGND sky130_ef_sc_hd__decap_12
XFILLER_39_1219 VPWR VGND VPWR VGND sky130_ef_sc_hd__decap_12
XFILLER_208_699 VGND VGND VPWR VPWR sky130_fd_sc_hd__fill_1
XFILLER_251_945 VGND VGND VPWR VPWR sky130_fd_sc_hd__decap_6
XFILLER_250_433 VPWR VGND VPWR VGND sky130_ef_sc_hd__decap_12
XFILLER_211_809 VPWR VGND VPWR VGND sky130_ef_sc_hd__decap_12
XFILLER_251_989 VPWR VGND VPWR VGND sky130_ef_sc_hd__decap_12
XPHY_EDGE_ROW_155_2_Right_246 VGND VGND VPWR VPWR sky130_fd_sc_hd__decap_3
XFILLER_204_861 VGND VGND VPWR VPWR sky130_fd_sc_hd__decap_6
XFILLER_250_477 VPWR VGND VPWR VGND sky130_ef_sc_hd__decap_12
XFILLER_91_1435 VGND VGND VPWR VPWR sky130_fd_sc_hd__decap_6
XFILLER_95_3 VPWR VGND VPWR VGND sky130_ef_sc_hd__decap_12
XFILLER_176_713 VPWR VGND VPWR VGND sky130_ef_sc_hd__decap_12
XFILLER_91_1479 VPWR VGND VPWR VGND sky130_ef_sc_hd__decap_12
XFILLER_203_393 VPWR VGND VPWR VGND sky130_ef_sc_hd__decap_12
XFILLER_175_223 VGND VGND VPWR VPWR sky130_fd_sc_hd__fill_1
XFILLER_176_757 VPWR VGND VPWR VGND sky130_ef_sc_hd__decap_12
XFILLER_191_727 VGND VGND VPWR VPWR sky130_fd_sc_hd__fill_1
XFILLER_50_1165 VPWR VGND VPWR VGND sky130_ef_sc_hd__decap_12
XFILLER_89_1331 VPWR VGND VPWR VGND sky130_ef_sc_hd__decap_12
XFILLER_8_981 VPWR VGND VPWR VGND sky130_ef_sc_hd__decap_12
XFILLER_239_1033 VPWR VGND VPWR VGND sky130_ef_sc_hd__decap_12
Xmax_cap122 _201_ VGND VGND VPWR VPWR net122 sky130_fd_sc_hd__clkbuf_1
XFILLER_85_1217 VGND VGND VPWR VPWR sky130_fd_sc_hd__fill_1
XFILLER_254_1509 VGND VGND VPWR VPWR sky130_fd_sc_hd__decap_6
Xmax_cap144 _223_ VGND VGND VPWR VPWR net144 sky130_fd_sc_hd__clkbuf_1
Xmax_cap155 net156 VGND VGND VPWR VPWR net155 sky130_fd_sc_hd__clkbuf_1
XFILLER_239_1077 VPWR VGND VPWR VGND sky130_ef_sc_hd__decap_12
XFILLER_171_473 VPWR VGND VPWR VGND sky130_ef_sc_hd__decap_12
Xmax_cap177 _102_ VGND VGND VPWR VPWR net177 sky130_fd_sc_hd__clkbuf_1
XFILLER_137_1329 VGND VGND VPWR VPWR sky130_fd_sc_hd__fill_1
Xmax_cap188 net189 VGND VGND VPWR VPWR net188 sky130_fd_sc_hd__clkbuf_1
Xmax_cap199 _192_ VGND VGND VPWR VPWR net199 sky130_fd_sc_hd__clkbuf_1
XFILLER_174_1091 VGND VGND VPWR VPWR sky130_fd_sc_hd__fill_1
XFILLER_150_1507 VGND VGND VPWR VPWR sky130_fd_sc_hd__decap_8
XFILLER_219_909 VPWR VGND VPWR VGND sky130_ef_sc_hd__decap_12
XFILLER_38_29 VPWR VGND VPWR VGND sky130_ef_sc_hd__decap_12
XFILLER_218_419 VGND VGND VPWR VPWR sky130_fd_sc_hd__fill_1
XFILLER_245_205 VPWR VGND VPWR VGND sky130_ef_sc_hd__decap_12
XFILLER_6_1453 VPWR VGND VPWR VGND sky130_ef_sc_hd__decap_12
XFILLER_22_1245 VGND VGND VPWR VPWR sky130_fd_sc_hd__fill_1
XFILLER_245_249 VPWR VGND VPWR VGND sky130_ef_sc_hd__decap_12
XFILLER_2_1317 VPWR VGND VPWR VGND sky130_ef_sc_hd__decap_12
XFILLER_227_953 VPWR VGND VPWR VGND sky130_ef_sc_hd__decap_12
XTAP_TAPCELL_ROW_36_2_3972 VGND VPWR sky130_fd_sc_hd__tapvpwrvgnd_1
XFILLER_6_1497 VPWR VGND VPWR VGND sky130_ef_sc_hd__decap_12
XFILLER_242_923 VGND VGND VPWR VPWR sky130_fd_sc_hd__fill_1
XFILLER_96_1357 VGND VGND VPWR VPWR sky130_fd_sc_hd__fill_1
XFILLER_214_625 VPWR VGND VPWR VGND sky130_ef_sc_hd__decap_12
XFILLER_246_1037 VPWR VGND VPWR VGND sky130_ef_sc_hd__decap_12
XFILLER_213_113 VPWR VGND VPWR VGND sky130_ef_sc_hd__decap_12
XFILLER_253_293 VPWR VGND VPWR VGND sky130_ef_sc_hd__decap_12
XFILLER_148_1469 VGND VGND VPWR VPWR sky130_fd_sc_hd__fill_1
XFILLER_214_669 VPWR VGND VPWR VGND sky130_ef_sc_hd__decap_12
XFILLER_179_573 VPWR VGND VPWR VGND sky130_ef_sc_hd__decap_12
XTAP_TAPCELL_ROW_175_1604 VGND VPWR sky130_fd_sc_hd__tapvpwrvgnd_1
XFILLER_70_27 VGND VGND VPWR VPWR sky130_fd_sc_hd__fill_1
XTAP_TAPCELL_ROW_175_1615 VGND VPWR sky130_fd_sc_hd__tapvpwrvgnd_1
XFILLER_107_1177 VPWR VGND VPWR VGND sky130_ef_sc_hd__decap_12
XFILLER_166_245 VGND VGND VPWR VPWR sky130_fd_sc_hd__decap_6
XFILLER_186_27 VGND VGND VPWR VPWR sky130_fd_sc_hd__fill_1
XFILLER_194_587 VGND VGND VPWR VPWR sky130_fd_sc_hd__fill_1
XFILLER_33_1385 VGND VGND VPWR VPWR sky130_fd_sc_hd__fill_1
XFILLER_166_289 VPWR VGND VPWR VGND sky130_ef_sc_hd__decap_12
XFILLER_182_749 VGND VGND VPWR VPWR sky130_fd_sc_hd__decap_6
XFILLER_68_1415 VPWR VGND VPWR VGND sky130_ef_sc_hd__decap_12
XFILLER_181_237 VPWR VGND VPWR VGND sky130_ef_sc_hd__decap_12
XFILLER_218_1117 VPWR VGND VPWR VGND sky130_ef_sc_hd__decap_12
XFILLER_79_69 VGND VGND VPWR VPWR sky130_fd_sc_hd__fill_2
XFILLER_190_1309 VGND VGND VPWR VPWR sky130_fd_sc_hd__decap_6
XFILLER_190_793 VPWR VGND VPWR VGND sky130_ef_sc_hd__decap_12
XTAP_TAPCELL_ROW_147_2_4634 VGND VPWR sky130_fd_sc_hd__tapvpwrvgnd_1
XFILLER_118_1295 VGND VGND VPWR VPWR sky130_fd_sc_hd__decap_6
XFILLER_27_1189 VPWR VGND VPWR VGND sky130_ef_sc_hd__decap_12
XFILLER_95_57 VPWR VGND VPWR VGND sky130_ef_sc_hd__decap_12
XFILLER_40_1301 VGND VGND VPWR VPWR sky130_fd_sc_hd__fill_1
XFILLER_188_1205 VPWR VGND VPWR VGND sky130_ef_sc_hd__decap_12
XTAP_TAPCELL_ROW_5_984 VGND VPWR sky130_fd_sc_hd__tapvpwrvgnd_1
XTAP_TAPCELL_ROW_5_995 VGND VPWR sky130_fd_sc_hd__tapvpwrvgnd_1
XFILLER_79_1511 VGND VGND VPWR VPWR sky130_fd_sc_hd__decap_4
XTAP_TAPCELL_ROW_240_3354 VGND VPWR sky130_fd_sc_hd__tapvpwrvgnd_1
XTAP_TAPCELL_ROW_240_3365 VGND VPWR sky130_fd_sc_hd__tapvpwrvgnd_1
X_633_ clknet_3_5__leaf_clk dout0\[31\] _041_ VGND VGND VPWR VPWR dout0_q\[31\] sky130_fd_sc_hd__dfrtp_1
XFILLER_217_441 VGND VGND VPWR VPWR sky130_fd_sc_hd__decap_6
XTAP_TAPCELL_ROW_240_3376 VGND VPWR sky130_fd_sc_hd__tapvpwrvgnd_1
XFILLER_229_1213 VPWR VGND VPWR VGND sky130_ef_sc_hd__decap_12
XFILLER_245_783 VGND VGND VPWR VPWR sky130_fd_sc_hd__fill_1
XFILLER_217_485 VPWR VGND VPWR VGND sky130_ef_sc_hd__decap_12
XFILLER_233_945 VGND VGND VPWR VPWR sky130_fd_sc_hd__decap_6
X_564_ net663 VGND VGND VPWR VPWR _046_ sky130_fd_sc_hd__inv_2
XFILLER_229_1257 VPWR VGND VPWR VGND sky130_ef_sc_hd__decap_12
XFILLER_232_433 VPWR VGND VPWR VGND sky130_ef_sc_hd__decap_12
XFILLER_189_337 VPWR VGND VPWR VGND sky130_ef_sc_hd__decap_12
XFILLER_233_989 VPWR VGND VPWR VGND sky130_ef_sc_hd__decap_12
XFILLER_207_1511 VGND VGND VPWR VPWR sky130_fd_sc_hd__fill_1
XTAP_TAPCELL_ROW_253_3704 VGND VPWR sky130_fd_sc_hd__tapvpwrvgnd_1
X_495_ net194 net78 net191 VGND VGND VPWR VPWR _254_ sky130_fd_sc_hd__o21ba_1
XFILLER_232_477 VPWR VGND VPWR VGND sky130_ef_sc_hd__decap_12
XTAP_TAPCELL_ROW_253_3715 VGND VPWR sky130_fd_sc_hd__tapvpwrvgnd_1
XTAP_TAPCELL_ROW_253_3726 VGND VPWR sky130_fd_sc_hd__tapvpwrvgnd_1
XFILLER_164_1271 VPWR VGND VPWR VGND sky130_ef_sc_hd__decap_12
XFILLER_9_701 VPWR VGND VPWR VGND sky130_ef_sc_hd__decap_12
XFILLER_73_1165 VPWR VGND VPWR VGND sky130_ef_sc_hd__decap_12
XPHY_EDGE_ROW_24_2_Left_526 VGND VGND VPWR VPWR sky130_fd_sc_hd__decap_3
XFILLER_198_893 VPWR VGND VPWR VGND sky130_ef_sc_hd__decap_12
XFILLER_199_1301 VPWR VGND VPWR VGND sky130_ef_sc_hd__decap_12
XFILLER_125_1255 VPWR VGND VPWR VGND sky130_ef_sc_hd__decap_12
XFILLER_201_853 VPWR VGND VPWR VGND sky130_ef_sc_hd__decap_12
XFILLER_51_1441 VGND VGND VPWR VPWR sky130_fd_sc_hd__fill_1
XFILLER_199_1345 VPWR VGND VPWR VGND sky130_ef_sc_hd__decap_12
XFILLER_200_363 VGND VGND VPWR VPWR sky130_fd_sc_hd__fill_1
XFILLER_201_897 VPWR VGND VPWR VGND sky130_ef_sc_hd__decap_12
XFILLER_125_1299 VPWR VGND VPWR VGND sky130_ef_sc_hd__decap_12
XFILLER_201_1121 VPWR VGND VPWR VGND sky130_ef_sc_hd__decap_12
XPHY_EDGE_ROW_149_2_Left_651 VGND VGND VPWR VPWR sky130_fd_sc_hd__decap_3
XFILLER_173_727 VGND VGND VPWR VPWR sky130_fd_sc_hd__fill_1
XFILLER_8_277 VGND VGND VPWR VPWR sky130_fd_sc_hd__decap_8
XFILLER_12_1469 VGND VGND VPWR VPWR sky130_fd_sc_hd__fill_1
XFILLER_5_951 VGND VGND VPWR VPWR sky130_fd_sc_hd__fill_1
XFILLER_236_1217 VPWR VGND VPWR VGND sky130_ef_sc_hd__decap_12
XTAP_TAPCELL_ROW_12_1_1147 VGND VPWR sky130_fd_sc_hd__tapvpwrvgnd_1
XFILLER_84_1283 VPWR VGND VPWR VGND sky130_ef_sc_hd__decap_12
XFILLER_136_1351 VGND VGND VPWR VPWR sky130_fd_sc_hd__decap_6
XFILLER_171_1231 VGND VGND VPWR VPWR sky130_fd_sc_hd__fill_1
XFILLER_45_1267 VGND VGND VPWR VPWR sky130_fd_sc_hd__decap_6
XFILLER_132_1215 VPWR VGND VPWR VGND sky130_ef_sc_hd__decap_12
XFILLER_136_1395 VPWR VGND VPWR VGND sky130_ef_sc_hd__decap_12
XFILLER_227_205 VPWR VGND VPWR VGND sky130_ef_sc_hd__decap_12
XFILLER_132_1259 VPWR VGND VPWR VGND sky130_ef_sc_hd__decap_12
XFILLER_209_953 VPWR VGND VPWR VGND sky130_ef_sc_hd__decap_12
XFILLER_212_1261 VPWR VGND VPWR VGND sky130_ef_sc_hd__decap_12
XFILLER_227_249 VPWR VGND VPWR VGND sky130_ef_sc_hd__decap_12
XFILLER_243_709 VPWR VGND VPWR VGND sky130_ef_sc_hd__decap_12
XFILLER_247_1313 VPWR VGND VPWR VGND sky130_ef_sc_hd__decap_12
XFILLER_224_923 VGND VGND VPWR VPWR sky130_fd_sc_hd__fill_1
XTAP_TAPCELL_ROW_223_2895 VGND VPWR sky130_fd_sc_hd__tapvpwrvgnd_1
XFILLER_247_1357 VPWR VGND VPWR VGND sky130_ef_sc_hd__decap_12
XFILLER_235_293 VPWR VGND VPWR VGND sky130_ef_sc_hd__decap_12
XPHY_EDGE_ROW_17_1_Right_673 VGND VGND VPWR VPWR sky130_fd_sc_hd__decap_3
XPHY_EDGE_ROW_207_Left_462 VGND VGND VPWR VPWR sky130_fd_sc_hd__decap_3
XFILLER_251_753 VPWR VGND VPWR VGND sky130_ef_sc_hd__decap_12
XFILLER_211_55 VGND VGND VPWR VPWR sky130_fd_sc_hd__fill_1
XFILLER_211_617 VPWR VGND VPWR VGND sky130_ef_sc_hd__decap_12
XFILLER_251_797 VPWR VGND VPWR VGND sky130_ef_sc_hd__decap_12
XFILLER_165_1079 VPWR VGND VPWR VGND sky130_ef_sc_hd__decap_12
XFILLER_91_1243 VPWR VGND VPWR VGND sky130_ef_sc_hd__decap_12
XFILLER_143_1311 VPWR VGND VPWR VGND sky130_ef_sc_hd__decap_12
XFILLER_147_1491 VGND VGND VPWR VPWR sky130_fd_sc_hd__decap_6
XPHY_EDGE_ROW_156_2_Right_247 VGND VGND VPWR VPWR sky130_fd_sc_hd__decap_3
XFILLER_182_1371 VGND VGND VPWR VPWR sky130_fd_sc_hd__fill_1
XFILLER_195_329 VGND VGND VPWR VPWR sky130_fd_sc_hd__decap_6
XTAP_TAPCELL_ROW_14_2_3839 VGND VPWR sky130_fd_sc_hd__tapvpwrvgnd_1
XFILLER_52_1227 VPWR VGND VPWR VGND sky130_ef_sc_hd__decap_12
XFILLER_91_1287 VPWR VGND VPWR VGND sky130_ef_sc_hd__decap_12
XFILLER_143_1355 VPWR VGND VPWR VGND sky130_ef_sc_hd__decap_12
XFILLER_104_1339 VPWR VGND VPWR VGND sky130_ef_sc_hd__decap_12
XFILLER_143_1399 VPWR VGND VPWR VGND sky130_ef_sc_hd__decap_12
XFILLER_176_587 VGND VGND VPWR VPWR sky130_fd_sc_hd__fill_1
XFILLER_178_1429 VPWR VGND VPWR VGND sky130_ef_sc_hd__decap_12
XPHY_EDGE_ROW_216_Left_471 VGND VGND VPWR VPWR sky130_fd_sc_hd__decap_3
XFILLER_254_1317 VPWR VGND VPWR VGND sky130_ef_sc_hd__decap_12
XFILLER_219_1437 VPWR VGND VPWR VGND sky130_ef_sc_hd__decap_12
XFILLER_236_41 VPWR VGND VPWR VGND sky130_ef_sc_hd__decap_12
XFILLER_172_793 VPWR VGND VPWR VGND sky130_ef_sc_hd__decap_12
XPHY_EDGE_ROW_70_2_Left_572 VGND VGND VPWR VPWR sky130_fd_sc_hd__decap_3
XFILLER_171_281 VPWR VGND VPWR VGND sky130_ef_sc_hd__decap_12
XFILLER_172_1017 VPWR VGND VPWR VGND sky130_ef_sc_hd__decap_12
XFILLER_236_85 VPWR VGND VPWR VGND sky130_ef_sc_hd__decap_12
XFILLER_49_39 VPWR VGND VPWR VGND sky130_ef_sc_hd__decap_12
XTAP_TAPCELL_ROW_133_2_4553 VGND VPWR sky130_fd_sc_hd__tapvpwrvgnd_1
XFILLER_176_1197 VGND VGND VPWR VPWR sky130_fd_sc_hd__decap_6
XFILLER_63_1323 VGND VGND VPWR VPWR sky130_fd_sc_hd__decap_6
XFILLER_154_1451 VPWR VGND VPWR VGND sky130_ef_sc_hd__decap_12
XFILLER_172_29 VPWR VGND VPWR VGND sky130_ef_sc_hd__decap_12
XTAP_TAPCELL_ROW_168_1430 VGND VPWR sky130_fd_sc_hd__tapvpwrvgnd_1
XFILLER_252_1085 VGND VGND VPWR VPWR sky130_fd_sc_hd__decap_6
XFILLER_63_1367 VPWR VGND VPWR VGND sky130_ef_sc_hd__decap_12
XFILLER_115_1435 VGND VGND VPWR VPWR sky130_fd_sc_hd__decap_6
XFILLER_150_1315 VPWR VGND VPWR VGND sky130_ef_sc_hd__decap_12
XFILLER_154_1495 VPWR VGND VPWR VGND sky130_ef_sc_hd__decap_12
XFILLER_246_525 VGND VGND VPWR VPWR sky130_fd_sc_hd__decap_6
XFILLER_150_1359 VPWR VGND VPWR VGND sky130_ef_sc_hd__decap_12
XTAP_TAPCELL_ROW_2_910 VGND VPWR sky130_fd_sc_hd__tapvpwrvgnd_1
XFILLER_115_1479 VPWR VGND VPWR VGND sky130_ef_sc_hd__decap_12
XFILLER_6_1261 VPWR VGND VPWR VGND sky130_ef_sc_hd__decap_12
XTAP_TAPCELL_ROW_2_921 VGND VPWR sky130_fd_sc_hd__tapvpwrvgnd_1
XFILLER_246_569 VPWR VGND VPWR VGND sky130_ef_sc_hd__decap_12
XPHY_EDGE_ROW_22_1_Left_277 VGND VGND VPWR VPWR sky130_fd_sc_hd__decap_3
XPHY_EDGE_ROW_225_Left_480 VGND VGND VPWR VPWR sky130_fd_sc_hd__decap_3
XFILLER_2_1147 VGND VGND VPWR VPWR sky130_fd_sc_hd__fill_1
XFILLER_227_783 VGND VGND VPWR VPWR sky130_fd_sc_hd__fill_1
XTAP_TAPCELL_ROW_81_2_4240 VGND VPWR sky130_fd_sc_hd__tapvpwrvgnd_1
XFILLER_215_945 VGND VGND VPWR VPWR sky130_fd_sc_hd__decap_6
XFILLER_96_1165 VPWR VGND VPWR VGND sky130_ef_sc_hd__decap_12
XFILLER_183_1113 VGND VGND VPWR VPWR sky130_fd_sc_hd__decap_6
XFILLER_214_433 VPWR VGND VPWR VGND sky130_ef_sc_hd__decap_12
XFILLER_121_55 VGND VGND VPWR VPWR sky130_fd_sc_hd__fill_1
XFILLER_81_15 VPWR VGND VPWR VGND sky130_ef_sc_hd__decap_12
XFILLER_109_1217 VGND VGND VPWR VPWR sky130_fd_sc_hd__fill_1
XFILLER_215_989 VPWR VGND VPWR VGND sky130_ef_sc_hd__decap_12
XFILLER_183_1157 VPWR VGND VPWR VGND sky130_ef_sc_hd__decap_12
XFILLER_214_477 VPWR VGND VPWR VGND sky130_ef_sc_hd__decap_12
XFILLER_186_307 VGND VGND VPWR VPWR sky130_fd_sc_hd__fill_1
XFILLER_197_15 VPWR VGND VPWR VGND sky130_ef_sc_hd__decap_12
XFILLER_201_105 VGND VGND VPWR VPWR sky130_fd_sc_hd__decap_6
XFILLER_230_937 VPWR VGND VPWR VGND sky130_ef_sc_hd__decap_12
XFILLER_74_1463 VGND VGND VPWR VPWR sky130_fd_sc_hd__decap_6
XFILLER_161_1411 VPWR VGND VPWR VGND sky130_ef_sc_hd__decap_12
XFILLER_198_189 VGND VGND VPWR VPWR sky130_fd_sc_hd__decap_6
XFILLER_70_1327 VPWR VGND VPWR VGND sky130_ef_sc_hd__decap_12
XFILLER_201_149 VPWR VGND VPWR VGND sky130_ef_sc_hd__decap_12
XFILLER_14_53 VPWR VGND VPWR VGND sky130_ef_sc_hd__decap_12
XFILLER_195_841 VPWR VGND VPWR VGND sky130_ef_sc_hd__decap_12
XFILLER_161_1455 VPWR VGND VPWR VGND sky130_ef_sc_hd__decap_12
XFILLER_122_1439 VPWR VGND VPWR VGND sky130_ef_sc_hd__decap_12
XFILLER_220_1029 VGND VGND VPWR VPWR sky130_fd_sc_hd__decap_6
XFILLER_161_1499 VPWR VGND VPWR VGND sky130_ef_sc_hd__decap_12
XFILLER_182_513 VPWR VGND VPWR VGND sky130_ef_sc_hd__decap_12
XFILLER_202_1441 VPWR VGND VPWR VGND sky130_ef_sc_hd__decap_12
XTAP_TAPCELL_ROW_233_3180 VGND VPWR sky130_fd_sc_hd__tapvpwrvgnd_1
XFILLER_212_3 VPWR VGND VPWR VGND sky130_ef_sc_hd__decap_12
XFILLER_182_557 VPWR VGND VPWR VGND sky130_ef_sc_hd__decap_12
XFILLER_202_1485 VPWR VGND VPWR VGND sky130_ef_sc_hd__decap_12
XFILLER_30_41 VPWR VGND VPWR VGND sky130_ef_sc_hd__decap_12
XFILLER_68_1245 VGND VGND VPWR VPWR sky130_fd_sc_hd__fill_1
XFILLER_146_41 VPWR VGND VPWR VGND sky130_ef_sc_hd__decap_12
XFILLER_155_1204 VPWR VGND VPWR VGND sky130_ef_sc_hd__decap_12
XFILLER_194_1253 VGND VGND VPWR VPWR sky130_fd_sc_hd__decap_6
XFILLER_11_1491 VGND VGND VPWR VPWR sky130_fd_sc_hd__decap_6
XFILLER_190_1117 VPWR VGND VPWR VGND sky130_ef_sc_hd__decap_12
XTAP_TAPCELL_ROW_246_3530 VGND VPWR sky130_fd_sc_hd__tapvpwrvgnd_1
XFILLER_194_1297 VPWR VGND VPWR VGND sky130_ef_sc_hd__decap_12
XFILLER_81_1423 VPWR VGND VPWR VGND sky130_ef_sc_hd__decap_12
XTAP_TAPCELL_ROW_242_3416 VGND VPWR sky130_fd_sc_hd__tapvpwrvgnd_1
XFILLER_42_1407 VGND VGND VPWR VPWR sky130_fd_sc_hd__decap_6
XTAP_TAPCELL_ROW_242_3427 VGND VPWR sky130_fd_sc_hd__tapvpwrvgnd_1
XTAP_TAPCELL_ROW_59_1_1194 VGND VPWR sky130_fd_sc_hd__tapvpwrvgnd_1
XFILLER_81_1467 VPWR VGND VPWR VGND sky130_ef_sc_hd__decap_12
XFILLER_237_503 VGND VGND VPWR VPWR sky130_fd_sc_hd__fill_1
XFILLER_209_205 VPWR VGND VPWR VGND sky130_ef_sc_hd__decap_12
XFILLER_249_385 VGND VGND VPWR VPWR sky130_fd_sc_hd__decap_6
XFILLER_231_1169 VGND VGND VPWR VPWR sky130_fd_sc_hd__decap_6
XFILLER_209_249 VPWR VGND VPWR VGND sky130_ef_sc_hd__decap_12
XTAP_TAPCELL_ROW_8_1075 VGND VPWR sky130_fd_sc_hd__tapvpwrvgnd_1
XFILLER_188_1035 VGND VGND VPWR VPWR sky130_fd_sc_hd__fill_1
XFILLER_225_709 VPWR VGND VPWR VGND sky130_ef_sc_hd__decap_12
XTAP_TAPCELL_ROW_8_1086 VGND VPWR sky130_fd_sc_hd__tapvpwrvgnd_1
XFILLER_206_923 VGND VGND VPWR VPWR sky130_fd_sc_hd__fill_1
X_616_ clknet_3_7__leaf_clk dout0\[14\] _024_ VGND VGND VPWR VPWR dout0_q\[14\] sky130_fd_sc_hd__dfrtp_1
XFILLER_229_1021 VPWR VGND VPWR VGND sky130_ef_sc_hd__decap_12
XFILLER_79_1385 VGND VGND VPWR VPWR sky130_fd_sc_hd__fill_1
XFILLER_217_293 VPWR VGND VPWR VGND sky130_ef_sc_hd__decap_12
XFILLER_233_753 VPWR VGND VPWR VGND sky130_ef_sc_hd__decap_12
XFILLER_229_1065 VPWR VGND VPWR VGND sky130_ef_sc_hd__decap_12
X_547_ net668 VGND VGND VPWR VPWR _029_ sky130_fd_sc_hd__inv_2
XFILLER_233_797 VPWR VGND VPWR VGND sky130_ef_sc_hd__decap_12
XFILLER_189_167 VGND VGND VPWR VPWR sky130_fd_sc_hd__fill_1
XFILLER_177_329 VGND VGND VPWR VPWR sky130_fd_sc_hd__decap_6
X_478_ net335 _244_ VGND VGND VPWR VPWR _245_ sky130_fd_sc_hd__or2_1
XFILLER_220_469 VGND VGND VPWR VPWR sky130_fd_sc_hd__decap_6
XPHY_EDGE_ROW_80_2_Right_171 VGND VGND VPWR VPWR sky130_fd_sc_hd__decap_3
XFILLER_185_373 VPWR VGND VPWR VGND sky130_ef_sc_hd__decap_12
XFILLER_187_81 VPWR VGND VPWR VGND sky130_ef_sc_hd__decap_12
XFILLER_9_586 VGND VGND VPWR VPWR sky130_fd_sc_hd__fill_2
XFILLER_199_1175 VGND VGND VPWR VPWR sky130_fd_sc_hd__fill_1
XFILLER_86_1301 VGND VGND VPWR VPWR sky130_fd_sc_hd__fill_1
XFILLER_58_3 VPWR VGND VPWR VGND sky130_ef_sc_hd__decap_12
XFILLER_138_1413 VGND VGND VPWR VPWR sky130_fd_sc_hd__fill_1
XFILLER_47_1329 VGND VGND VPWR VPWR sky130_fd_sc_hd__fill_1
XFILLER_173_1337 VGND VGND VPWR VPWR sky130_fd_sc_hd__decap_6
XTAP_TAPCELL_ROW_212_2596 VGND VPWR sky130_fd_sc_hd__tapvpwrvgnd_1
XFILLER_60_1507 VGND VGND VPWR VPWR sky130_fd_sc_hd__decap_8
XFILLER_206_77 VGND VGND VPWR VPWR sky130_fd_sc_hd__decap_6
XFILLER_228_525 VGND VGND VPWR VPWR sky130_fd_sc_hd__decap_6
XFILLER_255_333 VGND VGND VPWR VPWR sky130_fd_sc_hd__decap_3
XFILLER_3_1401 VPWR VGND VPWR VGND sky130_ef_sc_hd__decap_12
XTAP_TAPCELL_ROW_225_2957 VGND VPWR sky130_fd_sc_hd__tapvpwrvgnd_1
XFILLER_228_569 VPWR VGND VPWR VGND sky130_ef_sc_hd__decap_12
XTAP_TAPCELL_ROW_225_2968 VGND VPWR sky130_fd_sc_hd__tapvpwrvgnd_1
XFILLER_255_377 VPWR VGND VPWR VGND sky130_ef_sc_hd__decap_12
XFILLER_243_517 VPWR VGND VPWR VGND sky130_ef_sc_hd__decap_12
XTAP_TAPCELL_ROW_66_2_4153 VGND VPWR sky130_fd_sc_hd__tapvpwrvgnd_1
XFILLER_97_1441 VGND VGND VPWR VPWR sky130_fd_sc_hd__fill_1
XFILLER_167_1119 VGND VGND VPWR VPWR sky130_fd_sc_hd__fill_1
XFILLER_212_1091 VGND VGND VPWR VPWR sky130_fd_sc_hd__fill_1
XFILLER_209_783 VGND VGND VPWR VPWR sky130_fd_sc_hd__fill_1
XFILLER_222_65 VPWR VGND VPWR VGND sky130_ef_sc_hd__decap_12
XFILLER_247_1121 VPWR VGND VPWR VGND sky130_ef_sc_hd__decap_12
XFILLER_208_1105 VPWR VGND VPWR VGND sky130_ef_sc_hd__decap_12
XFILLER_251_561 VPWR VGND VPWR VGND sky130_ef_sc_hd__decap_12
XFILLER_243_1007 VGND VGND VPWR VPWR sky130_fd_sc_hd__fill_1
XFILLER_58_1469 VGND VGND VPWR VPWR sky130_fd_sc_hd__fill_1
XPHY_EDGE_ROW_18_1_Right_674 VGND VGND VPWR VPWR sky130_fd_sc_hd__decap_3
XFILLER_184_1477 VGND VGND VPWR VPWR sky130_fd_sc_hd__decap_6
XFILLER_212_937 VPWR VGND VPWR VGND sky130_ef_sc_hd__decap_12
XFILLER_168_307 VGND VGND VPWR VPWR sky130_fd_sc_hd__fill_1
XFILLER_208_1149 VPWR VGND VPWR VGND sky130_ef_sc_hd__decap_12
XFILLER_211_447 VGND VGND VPWR VPWR sky130_fd_sc_hd__fill_1
XFILLER_177_841 VPWR VGND VPWR VGND sky130_ef_sc_hd__decap_12
XFILLER_195_137 VPWR VGND VPWR VGND sky130_ef_sc_hd__decap_12
XPHY_EDGE_ROW_157_2_Right_248 VGND VGND VPWR VPWR sky130_fd_sc_hd__decap_3
XFILLER_108_1283 VPWR VGND VPWR VGND sky130_ef_sc_hd__decap_12
XFILLER_220_981 VPWR VGND VPWR VGND sky130_ef_sc_hd__decap_12
XFILLER_17_1177 VPWR VGND VPWR VGND sky130_ef_sc_hd__decap_12
XFILLER_192_811 VGND VGND VPWR VPWR sky130_fd_sc_hd__fill_1
XFILLER_247_51 VGND VGND VPWR VPWR sky130_fd_sc_hd__decap_4
XFILLER_178_1259 VGND VGND VPWR VPWR sky130_fd_sc_hd__fill_1
XFILLER_219_1201 VPWR VGND VPWR VGND sky130_ef_sc_hd__decap_12
XFILLER_219_1245 VPWR VGND VPWR VGND sky130_ef_sc_hd__decap_12
XFILLER_183_39 VPWR VGND VPWR VGND sky130_ef_sc_hd__decap_12
XFILLER_254_1147 VGND VGND VPWR VPWR sky130_fd_sc_hd__fill_1
XFILLER_191_1437 VPWR VGND VPWR VGND sky130_ef_sc_hd__decap_12
XFILLER_219_1289 VPWR VGND VPWR VGND sky130_ef_sc_hd__decap_12
XFILLER_76_15 VPWR VGND VPWR VGND sky130_ef_sc_hd__decap_12
XFILLER_219_503 VGND VGND VPWR VPWR sky130_fd_sc_hd__fill_1
XFILLER_28_1295 VGND VGND VPWR VPWR sky130_fd_sc_hd__decap_6
XFILLER_115_1243 VPWR VGND VPWR VGND sky130_ef_sc_hd__decap_12
XFILLER_246_333 VPWR VGND VPWR VGND sky130_ef_sc_hd__decap_12
XFILLER_98_1227 VPWR VGND VPWR VGND sky130_ef_sc_hd__decap_12
XFILLER_115_1287 VPWR VGND VPWR VGND sky130_ef_sc_hd__decap_12
XFILLER_207_709 VPWR VGND VPWR VGND sky130_ef_sc_hd__decap_12
XFILLER_247_889 VGND VGND VPWR VPWR sky130_fd_sc_hd__decap_6
XFILLER_246_377 VPWR VGND VPWR VGND sky130_ef_sc_hd__decap_12
XFILLER_150_1189 VGND VGND VPWR VPWR sky130_fd_sc_hd__fill_1
XFILLER_6_1091 VGND VGND VPWR VPWR sky130_fd_sc_hd__fill_1
XFILLER_132_65 VGND VGND VPWR VPWR sky130_fd_sc_hd__decap_6
XFILLER_189_1399 VGND VGND VPWR VPWR sky130_fd_sc_hd__fill_1
XFILLER_162_3 VPWR VGND VPWR VGND sky130_ef_sc_hd__decap_12
XFILLER_215_753 VPWR VGND VPWR VGND sky130_ef_sc_hd__decap_12
X_401_ net200 _189_ VGND VGND VPWR VPWR _190_ sky130_fd_sc_hd__nand2_1
XFILLER_226_1205 VPWR VGND VPWR VGND sky130_ef_sc_hd__decap_12
XFILLER_230_701 VPWR VGND VPWR VGND sky130_ef_sc_hd__decap_12
XFILLER_215_797 VPWR VGND VPWR VGND sky130_ef_sc_hd__decap_12
X_332_ net594 dout0_q\[18\] net52 VGND VGND VPWR VPWR _121_ sky130_fd_sc_hd__a21oi_1
XTAP_TAPCELL_ROW_235_3220 VGND VPWR sky130_fd_sc_hd__tapvpwrvgnd_1
XTAP_TAPCELL_ROW_235_3231 VGND VPWR sky130_fd_sc_hd__tapvpwrvgnd_1
XFILLER_74_1271 VPWR VGND VPWR VGND sky130_ef_sc_hd__decap_12
XTAP_TAPCELL_ROW_235_3242 VGND VPWR sky130_fd_sc_hd__tapvpwrvgnd_1
XFILLER_202_469 VGND VGND VPWR VPWR sky130_fd_sc_hd__decap_6
XFILLER_35_1255 VPWR VGND VPWR VGND sky130_ef_sc_hd__decap_12
XFILLER_122_1203 VPWR VGND VPWR VGND sky130_ef_sc_hd__decap_12
XTAP_TAPCELL_ROW_124_2_4498 VGND VPWR sky130_fd_sc_hd__tapvpwrvgnd_1
XFILLER_126_1383 VPWR VGND VPWR VGND sky130_ef_sc_hd__decap_12
XTAP_TAPCELL_ROW_231_3117 VGND VPWR sky130_fd_sc_hd__tapvpwrvgnd_1
XFILLER_195_671 VGND VGND VPWR VPWR sky130_fd_sc_hd__fill_1
XFILLER_167_373 VPWR VGND VPWR VGND sky130_ef_sc_hd__decap_12
XTAP_TAPCELL_ROW_231_3128 VGND VPWR sky130_fd_sc_hd__tapvpwrvgnd_1
XFILLER_35_1299 VPWR VGND VPWR VGND sky130_ef_sc_hd__decap_12
XFILLER_122_1247 VPWR VGND VPWR VGND sky130_ef_sc_hd__decap_12
XFILLER_183_833 VGND VGND VPWR VPWR sky130_fd_sc_hd__decap_6
XFILLER_41_51 VGND VGND VPWR VPWR sky130_fd_sc_hd__fill_1
XFILLER_182_321 VPWR VGND VPWR VGND sky130_ef_sc_hd__decap_12
XFILLER_196_1315 VGND VGND VPWR VPWR sky130_fd_sc_hd__fill_1
XFILLER_157_51 VGND VGND VPWR VPWR sky130_fd_sc_hd__decap_4
XFILLER_183_877 VPWR VGND VPWR VGND sky130_ef_sc_hd__decap_12
XFILLER_237_1301 VPWR VGND VPWR VGND sky130_ef_sc_hd__decap_12
XFILLER_6_567 VGND VGND VPWR VPWR sky130_fd_sc_hd__fill_1
XFILLER_182_365 VPWR VGND VPWR VGND sky130_ef_sc_hd__decap_12
XFILLER_237_1345 VPWR VGND VPWR VGND sky130_ef_sc_hd__decap_12
XFILLER_194_1061 VPWR VGND VPWR VGND sky130_ef_sc_hd__decap_12
XFILLER_2_751 VGND VGND VPWR VPWR sky130_fd_sc_hd__decap_4
XTAP_TAPCELL_ROW_72_2_4185 VGND VPWR sky130_fd_sc_hd__tapvpwrvgnd_1
XPHY_EDGE_ROW_119_2_Right_210 VGND VGND VPWR VPWR sky130_fd_sc_hd__decap_3
XTAP_TAPCELL_ROW_229_3057 VGND VPWR sky130_fd_sc_hd__tapvpwrvgnd_1
XTAP_TAPCELL_ROW_229_3068 VGND VPWR sky130_fd_sc_hd__tapvpwrvgnd_1
XTAP_TAPCELL_ROW_229_3079 VGND VPWR sky130_fd_sc_hd__tapvpwrvgnd_1
XFILLER_46_1351 VGND VGND VPWR VPWR sky130_fd_sc_hd__decap_6
XFILLER_81_1231 VPWR VGND VPWR VGND sky130_ef_sc_hd__decap_12
XFILLER_42_1215 VPWR VGND VPWR VGND sky130_ef_sc_hd__decap_12
XFILLER_46_1395 VPWR VGND VPWR VGND sky130_ef_sc_hd__decap_12
XFILLER_81_1275 VPWR VGND VPWR VGND sky130_ef_sc_hd__decap_12
XFILLER_133_1343 VPWR VGND VPWR VGND sky130_ef_sc_hd__decap_12
XFILLER_249_193 VPWR VGND VPWR VGND sky130_ef_sc_hd__decap_12
XFILLER_238_867 VGND VGND VPWR VPWR sky130_fd_sc_hd__fill_1
XFILLER_42_1259 VPWR VGND VPWR VGND sky130_ef_sc_hd__decap_12
XFILLER_133_1387 VPWR VGND VPWR VGND sky130_ef_sc_hd__decap_12
XFILLER_225_517 VPWR VGND VPWR VGND sky130_ef_sc_hd__decap_12
XFILLER_248_1441 VPWR VGND VPWR VGND sky130_ef_sc_hd__decap_12
XTAP_TAPCELL_ROW_220_2821 VGND VPWR sky130_fd_sc_hd__tapvpwrvgnd_1
XTAP_TAPCELL_ROW_220_2832 VGND VPWR sky130_fd_sc_hd__tapvpwrvgnd_1
XFILLER_166_1141 VGND VGND VPWR VPWR sky130_fd_sc_hd__decap_6
XFILLER_209_1425 VPWR VGND VPWR VGND sky130_ef_sc_hd__decap_12
XFILLER_248_1485 VPWR VGND VPWR VGND sky130_ef_sc_hd__decap_12
XFILLER_233_561 VPWR VGND VPWR VGND sky130_ef_sc_hd__decap_12
XFILLER_166_1185 VPWR VGND VPWR VGND sky130_ef_sc_hd__decap_12
XFILLER_209_1469 VPWR VGND VPWR VGND sky130_ef_sc_hd__decap_12
XFILLER_53_1311 VPWR VGND VPWR VGND sky130_ef_sc_hd__decap_12
XFILLER_220_233 VPWR VGND VPWR VGND sky130_ef_sc_hd__decap_12
XFILLER_92_1371 VPWR VGND VPWR VGND sky130_ef_sc_hd__decap_12
XFILLER_57_1491 VGND VGND VPWR VPWR sky130_fd_sc_hd__decap_6
XFILLER_177_137 VPWR VGND VPWR VGND sky130_ef_sc_hd__decap_12
XFILLER_53_1355 VPWR VGND VPWR VGND sky130_ef_sc_hd__decap_12
XFILLER_105_1423 VPWR VGND VPWR VGND sky130_ef_sc_hd__decap_12
XFILLER_140_1303 VPWR VGND VPWR VGND sky130_ef_sc_hd__decap_12
XFILLER_202_981 VPWR VGND VPWR VGND sky130_ef_sc_hd__decap_12
XFILLER_220_277 VPWR VGND VPWR VGND sky130_ef_sc_hd__decap_12
XFILLER_242_1073 VPWR VGND VPWR VGND sky130_ef_sc_hd__decap_12
XFILLER_144_1483 VPWR VGND VPWR VGND sky130_ef_sc_hd__decap_12
XFILLER_174_811 VGND VGND VPWR VPWR sky130_fd_sc_hd__fill_1
XTAP_TAPCELL_ROW_218_2761 VGND VPWR sky130_fd_sc_hd__tapvpwrvgnd_1
XTAP_TAPCELL_ROW_193_2087 VGND VPWR sky130_fd_sc_hd__tapvpwrvgnd_1
XFILLER_14_1339 VPWR VGND VPWR VGND sky130_ef_sc_hd__decap_12
XFILLER_9_361 VGND VGND VPWR VPWR sky130_fd_sc_hd__decap_3
XFILLER_179_1513 VGND VGND VPWR VPWR sky130_fd_sc_hd__fill_2
XTAP_TAPCELL_ROW_193_2098 VGND VPWR sky130_fd_sc_hd__tapvpwrvgnd_1
XFILLER_203_1057 VGND VGND VPWR VPWR sky130_fd_sc_hd__decap_6
XTAP_TAPCELL_ROW_218_2772 VGND VPWR sky130_fd_sc_hd__tapvpwrvgnd_1
XFILLER_53_1399 VPWR VGND VPWR VGND sky130_ef_sc_hd__decap_12
XFILLER_88_1407 VGND VGND VPWR VPWR sky130_fd_sc_hd__decap_6
XFILLER_105_1467 VPWR VGND VPWR VGND sky130_ef_sc_hd__decap_12
XFILLER_186_693 VGND VGND VPWR VPWR sky130_fd_sc_hd__decap_6
XTAP_TAPCELL_ROW_218_2783 VGND VPWR sky130_fd_sc_hd__tapvpwrvgnd_1
XFILLER_185_181 VPWR VGND VPWR VGND sky130_ef_sc_hd__decap_12
XPHY_EDGE_ROW_81_2_Right_172 VGND VGND VPWR VPWR sky130_fd_sc_hd__decap_3
XFILLER_220_1371 VGND VGND VPWR VPWR sky130_fd_sc_hd__fill_1
XTAP_TAPCELL_ROW_214_2658 VGND VPWR sky130_fd_sc_hd__tapvpwrvgnd_1
XTAP_TAPCELL_ROW_214_2669 VGND VPWR sky130_fd_sc_hd__tapvpwrvgnd_1
XFILLER_255_1401 VPWR VGND VPWR VGND sky130_ef_sc_hd__decap_12
XFILLER_173_1101 VPWR VGND VPWR VGND sky130_ef_sc_hd__decap_12
XFILLER_177_1281 VGND VGND VPWR VPWR sky130_fd_sc_hd__decap_6
XFILLER_216_1429 VPWR VGND VPWR VGND sky130_ef_sc_hd__decap_12
XFILLER_173_1145 VPWR VGND VPWR VGND sky130_ef_sc_hd__decap_12
XFILLER_64_1451 VPWR VGND VPWR VGND sky130_ef_sc_hd__decap_12
XFILLER_173_1189 VPWR VGND VPWR VGND sky130_ef_sc_hd__decap_12
XFILLER_60_1315 VPWR VGND VPWR VGND sky130_ef_sc_hd__decap_12
XFILLER_25_1435 VGND VGND VPWR VPWR sky130_fd_sc_hd__decap_6
XFILLER_64_1495 VPWR VGND VPWR VGND sky130_ef_sc_hd__decap_12
XFILLER_151_1443 VPWR VGND VPWR VGND sky130_ef_sc_hd__decap_12
XFILLER_228_333 VPWR VGND VPWR VGND sky130_ef_sc_hd__decap_12
XFILLER_210_1017 VPWR VGND VPWR VGND sky130_ef_sc_hd__decap_12
XFILLER_60_1359 VPWR VGND VPWR VGND sky130_ef_sc_hd__decap_12
XFILLER_25_1479 VPWR VGND VPWR VGND sky130_ef_sc_hd__decap_12
XFILLER_112_1427 VPWR VGND VPWR VGND sky130_ef_sc_hd__decap_12
XFILLER_255_141 VPWR VGND VPWR VGND sky130_ef_sc_hd__decap_12
XFILLER_46_29 VPWR VGND VPWR VGND sky130_ef_sc_hd__decap_12
XFILLER_214_1197 VGND VGND VPWR VPWR sky130_fd_sc_hd__decap_6
XFILLER_229_889 VGND VGND VPWR VPWR sky130_fd_sc_hd__decap_6
XPHY_EDGE_ROW_101_2_Left_603 VGND VGND VPWR VPWR sky130_fd_sc_hd__decap_3
XFILLER_228_377 VPWR VGND VPWR VGND sky130_ef_sc_hd__decap_12
XFILLER_244_837 VPWR VGND VPWR VGND sky130_ef_sc_hd__decap_12
XFILLER_3_1231 VGND VGND VPWR VPWR sky130_fd_sc_hd__fill_1
XTAP_TAPCELL_ROW_182_1791 VGND VPWR sky130_fd_sc_hd__tapvpwrvgnd_1
XFILLER_184_1241 VPWR VGND VPWR VGND sky130_ef_sc_hd__decap_12
XFILLER_212_701 VPWR VGND VPWR VGND sky130_ef_sc_hd__decap_12
XFILLER_252_881 VPWR VGND VPWR VGND sky130_ef_sc_hd__decap_12
XFILLER_19_1217 VGND VGND VPWR VPWR sky130_fd_sc_hd__fill_1
XFILLER_180_1105 VPWR VGND VPWR VGND sky130_ef_sc_hd__decap_12
XFILLER_184_1285 VPWR VGND VPWR VGND sky130_ef_sc_hd__decap_12
XFILLER_196_413 VGND VGND VPWR VPWR sky130_fd_sc_hd__decap_6
XFILLER_251_391 VGND VGND VPWR VPWR sky130_fd_sc_hd__fill_1
XPHY_EDGE_ROW_19_1_Right_675 VGND VGND VPWR VPWR sky130_fd_sc_hd__decap_3
XFILLER_71_1411 VPWR VGND VPWR VGND sky130_ef_sc_hd__decap_12
XFILLER_180_1149 VPWR VGND VPWR VGND sky130_ef_sc_hd__decap_12
XFILLER_196_457 VPWR VGND VPWR VGND sky130_ef_sc_hd__decap_12
XFILLER_221_1113 VGND VGND VPWR VPWR sky130_fd_sc_hd__decap_6
XFILLER_71_1455 VPWR VGND VPWR VGND sky130_ef_sc_hd__decap_12
XFILLER_177_671 VGND VGND VPWR VPWR sky130_fd_sc_hd__fill_1
XFILLER_32_1439 VPWR VGND VPWR VGND sky130_ef_sc_hd__decap_12
Xwire229 net230 VGND VGND VPWR VPWR net229 sky130_fd_sc_hd__clkbuf_1
XPHY_EDGE_ROW_158_2_Right_249 VGND VGND VPWR VPWR sky130_fd_sc_hd__decap_3
XFILLER_221_1157 VPWR VGND VPWR VGND sky130_ef_sc_hd__decap_12
XFILLER_71_1499 VPWR VGND VPWR VGND sky130_ef_sc_hd__decap_12
XFILLER_194_27 VGND VGND VPWR VPWR sky130_fd_sc_hd__fill_1
XFILLER_180_825 VPWR VGND VPWR VGND sky130_ef_sc_hd__decap_12
XFILLER_180_869 VPWR VGND VPWR VGND sky130_ef_sc_hd__decap_12
XFILLER_191_1201 VPWR VGND VPWR VGND sky130_ef_sc_hd__decap_12
XTAP_TAPCELL_ROW_57_2_4098 VGND VPWR sky130_fd_sc_hd__tapvpwrvgnd_1
XFILLER_195_1381 VPWR VGND VPWR VGND sky130_ef_sc_hd__decap_12
XFILLER_191_1245 VPWR VGND VPWR VGND sky130_ef_sc_hd__decap_12
XFILLER_239_609 VGND VGND VPWR VPWR sky130_fd_sc_hd__decap_6
XTAP_TAPCELL_ROW_189_1978 VGND VPWR sky130_fd_sc_hd__tapvpwrvgnd_1
XFILLER_87_69 VGND VGND VPWR VPWR sky130_fd_sc_hd__fill_2
XTAP_TAPCELL_ROW_189_1989 VGND VPWR sky130_fd_sc_hd__tapvpwrvgnd_1
XFILLER_191_1289 VPWR VGND VPWR VGND sky130_ef_sc_hd__decap_12
XFILLER_232_1253 VGND VGND VPWR VPWR sky130_fd_sc_hd__decap_6
XPHY_EDGE_ROW_33_2_Left_535 VGND VGND VPWR VPWR sky130_fd_sc_hd__decap_3
XFILLER_247_653 VPWR VGND VPWR VGND sky130_ef_sc_hd__decap_12
XFILLER_4_1017 VPWR VGND VPWR VGND sky130_ef_sc_hd__decap_12
XFILLER_246_141 VPWR VGND VPWR VGND sky130_ef_sc_hd__decap_12
XFILLER_8_1197 VGND VGND VPWR VPWR sky130_fd_sc_hd__decap_6
XTAP_TAPCELL_ROW_5_1001 VGND VPWR sky130_fd_sc_hd__tapvpwrvgnd_1
XFILLER_232_1297 VPWR VGND VPWR VGND sky130_ef_sc_hd__decap_12
XFILLER_207_517 VPWR VGND VPWR VGND sky130_ef_sc_hd__decap_12
XFILLER_247_697 VPWR VGND VPWR VGND sky130_ef_sc_hd__decap_12
XPHY_EDGE_ROW_158_2_Left_660 VGND VGND VPWR VPWR sky130_fd_sc_hd__decap_3
XFILLER_215_561 VPWR VGND VPWR VGND sky130_ef_sc_hd__decap_12
XFILLER_188_925 VPWR VGND VPWR VGND sky130_ef_sc_hd__decap_12
XFILLER_226_1035 VGND VGND VPWR VPWR sky130_fd_sc_hd__fill_1
XFILLER_199_273 VGND VGND VPWR VPWR sky130_fd_sc_hd__decap_6
XFILLER_230_531 VGND VGND VPWR VPWR sky130_fd_sc_hd__fill_1
XTAP_TAPCELL_ROW_15_2_3844 VGND VPWR sky130_fd_sc_hd__tapvpwrvgnd_1
XFILLER_202_233 VPWR VGND VPWR VGND sky130_ef_sc_hd__decap_12
X_315_ net595 dout0_q\[26\] net529 VGND VGND VPWR VPWR _104_ sky130_fd_sc_hd__and3_1
XFILLER_202_277 VPWR VGND VPWR VGND sky130_ef_sc_hd__decap_12
XFILLER_243_1393 VGND VGND VPWR VPWR sky130_fd_sc_hd__decap_6
XFILLER_126_1191 VPWR VGND VPWR VGND sky130_ef_sc_hd__decap_12
XFILLER_168_693 VGND VGND VPWR VPWR sky130_fd_sc_hd__decap_6
Xinput15 wr_data[14] VGND VGND VPWR VPWR net15 sky130_fd_sc_hd__clkbuf_1
Xinput26 wr_data[24] VGND VGND VPWR VPWR net26 sky130_fd_sc_hd__clkbuf_1
XFILLER_168_83 VGND VGND VPWR VPWR sky130_fd_sc_hd__fill_1
XFILLER_167_181 VPWR VGND VPWR VGND sky130_ef_sc_hd__decap_12
Xinput37 wr_data[5] VGND VGND VPWR VPWR net37 sky130_fd_sc_hd__clkbuf_1
XFILLER_183_641 VPWR VGND VPWR VGND sky130_ef_sc_hd__decap_12
Xmax_cap507 _100_ VGND VGND VPWR VPWR net507 sky130_fd_sc_hd__clkbuf_1
Xmax_cap529 net61 VGND VGND VPWR VPWR net529 sky130_fd_sc_hd__clkbuf_1
XFILLER_183_685 VPWR VGND VPWR VGND sky130_ef_sc_hd__decap_12
XPHY_EDGE_ROW_47_1_Left_302 VGND VGND VPWR VPWR sky130_fd_sc_hd__decap_3
XFILLER_48_1413 VGND VGND VPWR VPWR sky130_fd_sc_hd__fill_1
XFILLER_182_195 VGND VGND VPWR VPWR sky130_fd_sc_hd__fill_1
XFILLER_174_1421 VGND VGND VPWR VPWR sky130_fd_sc_hd__decap_6
XFILLER_170_357 VGND VGND VPWR VPWR sky130_fd_sc_hd__decap_6
XFILLER_237_1175 VGND VGND VPWR VPWR sky130_fd_sc_hd__fill_1
XFILLER_174_1465 VPWR VGND VPWR VGND sky130_ef_sc_hd__decap_12
XFILLER_170_1329 VPWR VGND VPWR VGND sky130_ef_sc_hd__decap_12
XFILLER_250_1353 VPWR VGND VPWR VGND sky130_ef_sc_hd__decap_12
XFILLER_211_1337 VGND VGND VPWR VPWR sky130_fd_sc_hd__decap_6
XFILLER_250_1397 VPWR VGND VPWR VGND sky130_ef_sc_hd__decap_12
XFILLER_168_1203 VGND VGND VPWR VPWR sky130_fd_sc_hd__fill_1
XTAP_TAPCELL_ROW_207_2462 VGND VPWR sky130_fd_sc_hd__tapvpwrvgnd_1
XTAP_TAPCELL_ROW_207_2473 VGND VPWR sky130_fd_sc_hd__tapvpwrvgnd_1
XFILLER_226_837 VPWR VGND VPWR VGND sky130_ef_sc_hd__decap_12
XTAP_TAPCELL_ROW_207_2484 VGND VPWR sky130_fd_sc_hd__tapvpwrvgnd_1
XFILLER_252_133 VGND VGND VPWR VPWR sky130_fd_sc_hd__decap_6
XTAP_TAPCELL_ROW_203_2359 VGND VPWR sky130_fd_sc_hd__tapvpwrvgnd_1
XTAP_TAPCELL_ROW_199_2252 VGND VPWR sky130_fd_sc_hd__tapvpwrvgnd_1
XTAP_TAPCELL_ROW_199_2263 VGND VPWR sky130_fd_sc_hd__tapvpwrvgnd_1
XFILLER_252_177 VPWR VGND VPWR VGND sky130_ef_sc_hd__decap_12
XFILLER_234_881 VPWR VGND VPWR VGND sky130_ef_sc_hd__decap_12
XFILLER_209_1233 VPWR VGND VPWR VGND sky130_ef_sc_hd__decap_12
XTAP_TAPCELL_ROW_94_2_4317 VGND VPWR sky130_fd_sc_hd__tapvpwrvgnd_1
XFILLER_178_413 VGND VGND VPWR VPWR sky130_fd_sc_hd__decap_6
XFILLER_181_1425 VPWR VGND VPWR VGND sky130_ef_sc_hd__decap_12
XTAP_TAPCELL_ROW_195_2138 VGND VPWR sky130_fd_sc_hd__tapvpwrvgnd_1
XFILLER_233_391 VGND VGND VPWR VPWR sky130_fd_sc_hd__fill_1
XTAP_TAPCELL_ROW_195_2149 VGND VPWR sky130_fd_sc_hd__tapvpwrvgnd_1
XFILLER_221_553 VGND VGND VPWR VPWR sky130_fd_sc_hd__decap_6
XFILLER_205_1119 VGND VGND VPWR VPWR sky130_fd_sc_hd__fill_1
XFILLER_178_457 VPWR VGND VPWR VGND sky130_ef_sc_hd__decap_12
XFILLER_181_1469 VPWR VGND VPWR VGND sky130_ef_sc_hd__decap_12
XFILLER_194_917 VGND VGND VPWR VPWR sky130_fd_sc_hd__decap_6
XTAP_TAPCELL_ROW_216_2709 VGND VPWR sky130_fd_sc_hd__tapvpwrvgnd_1
XFILLER_193_405 VPWR VGND VPWR VGND sky130_ef_sc_hd__decap_12
XFILLER_221_597 VPWR VGND VPWR VGND sky130_ef_sc_hd__decap_12
XFILLER_18_1283 VPWR VGND VPWR VGND sky130_ef_sc_hd__decap_12
XFILLER_105_1231 VPWR VGND VPWR VGND sky130_ef_sc_hd__decap_12
XFILLER_193_449 VPWR VGND VPWR VGND sky130_ef_sc_hd__decap_12
XFILLER_222_1477 VGND VGND VPWR VPWR sky130_fd_sc_hd__decap_6
XFILLER_88_1215 VPWR VGND VPWR VGND sky130_ef_sc_hd__decap_12
XFILLER_105_1275 VPWR VGND VPWR VGND sky130_ef_sc_hd__decap_12
XFILLER_179_1343 VGND VGND VPWR VPWR sky130_fd_sc_hd__fill_1
XFILLER_140_1177 VPWR VGND VPWR VGND sky130_ef_sc_hd__decap_12
XFILLER_228_53 VPWR VGND VPWR VGND sky130_ef_sc_hd__decap_12
XPHY_EDGE_ROW_82_2_Right_173 VGND VGND VPWR VPWR sky130_fd_sc_hd__decap_3
XFILLER_88_1259 VPWR VGND VPWR VGND sky130_ef_sc_hd__decap_12
XPHY_EDGE_ROW_31_1_Left_286 VGND VGND VPWR VPWR sky130_fd_sc_hd__decap_3
XFILLER_228_97 VPWR VGND VPWR VGND sky130_ef_sc_hd__decap_12
XTAP_TAPCELL_ROW_171_1492 VGND VPWR sky130_fd_sc_hd__tapvpwrvgnd_1
XFILLER_244_41 VPWR VGND VPWR VGND sky130_ef_sc_hd__decap_12
XFILLER_216_1259 VGND VGND VPWR VPWR sky130_fd_sc_hd__fill_1
XFILLER_244_85 VPWR VGND VPWR VGND sky130_ef_sc_hd__decap_12
XFILLER_57_39 VPWR VGND VPWR VGND sky130_ef_sc_hd__decap_12
XFILLER_25_1243 VPWR VGND VPWR VGND sky130_ef_sc_hd__decap_12
XFILLER_99_1311 VPWR VGND VPWR VGND sky130_ef_sc_hd__decap_12
XFILLER_116_1371 VPWR VGND VPWR VGND sky130_ef_sc_hd__decap_12
XFILLER_180_29 VPWR VGND VPWR VGND sky130_ef_sc_hd__decap_12
XTAP_TAPCELL_ROW_184_1842 VGND VPWR sky130_fd_sc_hd__tapvpwrvgnd_1
XFILLER_229_653 VPWR VGND VPWR VGND sky130_ef_sc_hd__decap_12
XFILLER_5_1337 VGND VGND VPWR VPWR sky130_fd_sc_hd__decap_6
XTAP_TAPCELL_ROW_184_1853 VGND VPWR sky130_fd_sc_hd__tapvpwrvgnd_1
XFILLER_151_1273 VGND VGND VPWR VPWR sky130_fd_sc_hd__fill_1
XPHY_EDGE_ROW_166_Left_421 VGND VGND VPWR VPWR sky130_fd_sc_hd__decap_3
XTAP_TAPCELL_ROW_184_1864 VGND VPWR sky130_fd_sc_hd__tapvpwrvgnd_1
XFILLER_228_141 VPWR VGND VPWR VGND sky130_ef_sc_hd__decap_12
XFILLER_244_601 VPWR VGND VPWR VGND sky130_ef_sc_hd__decap_12
XFILLER_25_1287 VPWR VGND VPWR VGND sky130_ef_sc_hd__decap_12
XFILLER_99_1355 VPWR VGND VPWR VGND sky130_ef_sc_hd__decap_12
XFILLER_229_697 VPWR VGND VPWR VGND sky130_ef_sc_hd__decap_12
XFILLER_60_1189 VGND VGND VPWR VPWR sky130_fd_sc_hd__fill_1
XFILLER_243_111 VGND VGND VPWR VPWR sky130_fd_sc_hd__fill_1
XTAP_TAPCELL_ROW_180_1739 VGND VPWR sky130_fd_sc_hd__tapvpwrvgnd_1
XFILLER_244_645 VPWR VGND VPWR VGND sky130_ef_sc_hd__decap_12
XFILLER_95_1219 VPWR VGND VPWR VGND sky130_ef_sc_hd__decap_12
XFILLER_249_1057 VGND VGND VPWR VPWR sky130_fd_sc_hd__decap_6
XFILLER_73_27 VPWR VGND VPWR VGND sky130_ef_sc_hd__decap_12
XFILLER_99_1399 VPWR VGND VPWR VGND sky130_ef_sc_hd__decap_12
XFILLER_189_27 VPWR VGND VPWR VGND sky130_ef_sc_hd__decap_12
XFILLER_231_317 VPWR VGND VPWR VGND sky130_ef_sc_hd__decap_12
Xwire83 _235_ VGND VGND VPWR VPWR net83 sky130_fd_sc_hd__clkbuf_1
XFILLER_212_531 VGND VGND VPWR VPWR sky130_fd_sc_hd__fill_1
XFILLER_196_221 VPWR VGND VPWR VGND sky130_ef_sc_hd__decap_12
XFILLER_184_1093 VPWR VGND VPWR VGND sky130_ef_sc_hd__decap_12
XFILLER_227_1399 VGND VGND VPWR VPWR sky130_fd_sc_hd__fill_1
XFILLER_197_777 VGND VGND VPWR VPWR sky130_fd_sc_hd__decap_6
XFILLER_196_265 VPWR VGND VPWR VGND sky130_ef_sc_hd__decap_12
XFILLER_200_737 VPWR VGND VPWR VGND sky130_ef_sc_hd__decap_12
XFILLER_32_1203 VPWR VGND VPWR VGND sky130_ef_sc_hd__decap_12
XTAP_TAPCELL_ROW_178_1679 VGND VPWR sky130_fd_sc_hd__tapvpwrvgnd_1
XFILLER_36_1383 VPWR VGND VPWR VGND sky130_ef_sc_hd__decap_12
XFILLER_123_1331 VPWR VGND VPWR VGND sky130_ef_sc_hd__decap_12
XPHY_EDGE_ROW_175_Left_430 VGND VGND VPWR VPWR sky130_fd_sc_hd__decap_3
XFILLER_32_1247 VPWR VGND VPWR VGND sky130_ef_sc_hd__decap_12
XFILLER_22_53 VPWR VGND VPWR VGND sky130_ef_sc_hd__decap_12
XFILLER_125_3 VPWR VGND VPWR VGND sky130_ef_sc_hd__decap_12
XFILLER_165_641 VGND VGND VPWR VPWR sky130_fd_sc_hd__decap_3
XFILLER_138_53 VPWR VGND VPWR VGND sky130_ef_sc_hd__decap_12
XFILLER_165_685 VPWR VGND VPWR VGND sky130_ef_sc_hd__decap_12
XFILLER_3_301 VPWR VGND VPWR VGND sky130_ef_sc_hd__decap_12
XFILLER_158_1427 VPWR VGND VPWR VGND sky130_ef_sc_hd__decap_12
XTAP_TAPCELL_ROW_119_2_4471 VGND VPWR sky130_fd_sc_hd__tapvpwrvgnd_1
XFILLER_234_1315 VGND VGND VPWR VPWR sky130_fd_sc_hd__fill_1
XFILLER_180_699 VGND VGND VPWR VPWR sky130_fd_sc_hd__fill_1
XFILLER_154_41 VPWR VGND VPWR VGND sky130_ef_sc_hd__decap_12
XTAP_TAPCELL_ROW_132_2_4549 VGND VPWR sky130_fd_sc_hd__tapvpwrvgnd_1
XFILLER_239_417 VPWR VGND VPWR VGND sky130_ef_sc_hd__decap_12
XFILLER_43_1343 VPWR VGND VPWR VGND sky130_ef_sc_hd__decap_12
XFILLER_232_1061 VPWR VGND VPWR VGND sky130_ef_sc_hd__decap_12
XFILLER_134_1471 VPWR VGND VPWR VGND sky130_ef_sc_hd__decap_12
XFILLER_248_973 VGND VGND VPWR VPWR sky130_fd_sc_hd__decap_6
XFILLER_247_461 VPWR VGND VPWR VGND sky130_ef_sc_hd__decap_12
XFILLER_43_1387 VPWR VGND VPWR VGND sky130_ef_sc_hd__decap_12
XTAP_TAPCELL_ROW_112_2_4425 VGND VPWR sky130_fd_sc_hd__tapvpwrvgnd_1
XFILLER_208_837 VPWR VGND VPWR VGND sky130_ef_sc_hd__decap_12
XFILLER_130_1357 VGND VGND VPWR VPWR sky130_fd_sc_hd__fill_1
XFILLER_78_1439 VPWR VGND VPWR VGND sky130_ef_sc_hd__decap_12
XFILLER_234_133 VGND VGND VPWR VPWR sky130_fd_sc_hd__decap_6
XTAP_TAPCELL_ROW_80_2_4236 VGND VPWR sky130_fd_sc_hd__tapvpwrvgnd_1
XFILLER_216_881 VPWR VGND VPWR VGND sky130_ef_sc_hd__decap_12
XFILLER_234_177 VPWR VGND VPWR VGND sky130_ef_sc_hd__decap_12
XFILLER_250_637 VGND VGND VPWR VPWR sky130_fd_sc_hd__decap_6
XFILLER_245_1455 VGND VGND VPWR VPWR sky130_fd_sc_hd__fill_1
XFILLER_215_391 VGND VGND VPWR VPWR sky130_fd_sc_hd__fill_1
Xclkbuf_3_4__f_clk clknet_0_clk VGND VGND VPWR VPWR clknet_3_4__leaf_clk sky130_fd_sc_hd__clkbuf_16
XFILLER_188_755 VGND VGND VPWR VPWR sky130_fd_sc_hd__fill_1
XFILLER_203_553 VGND VGND VPWR VPWR sky130_fd_sc_hd__decap_6
XFILLER_176_917 VGND VGND VPWR VPWR sky130_fd_sc_hd__decap_6
XTAP_TAPCELL_ROW_60_2_4112 VGND VPWR sky130_fd_sc_hd__tapvpwrvgnd_1
XFILLER_163_1177 VPWR VGND VPWR VGND sky130_ef_sc_hd__decap_12
XFILLER_175_405 VPWR VGND VPWR VGND sky130_ef_sc_hd__decap_12
XFILLER_231_895 VGND VGND VPWR VPWR sky130_fd_sc_hd__fill_1
XTAP_TAPCELL_ROW_59_2_4106 VGND VPWR sky130_fd_sc_hd__tapvpwrvgnd_1
XFILLER_179_93 VPWR VGND VPWR VGND sky130_ef_sc_hd__decap_12
XTAP_TAPCELL_ROW_190_2002 VGND VPWR sky130_fd_sc_hd__tapvpwrvgnd_1
XFILLER_203_597 VPWR VGND VPWR VGND sky130_ef_sc_hd__decap_12
XFILLER_50_1303 VPWR VGND VPWR VGND sky130_ef_sc_hd__decap_12
XFILLER_15_1423 VPWR VGND VPWR VGND sky130_ef_sc_hd__decap_12
XTAP_TAPCELL_ROW_190_2013 VGND VPWR sky130_fd_sc_hd__tapvpwrvgnd_1
XFILLER_204_1141 VGND VGND VPWR VPWR sky130_fd_sc_hd__decap_6
XFILLER_54_1483 VPWR VGND VPWR VGND sky130_ef_sc_hd__decap_12
XTAP_TAPCELL_ROW_190_2024 VGND VPWR sky130_fd_sc_hd__tapvpwrvgnd_1
XFILLER_175_449 VPWR VGND VPWR VGND sky130_ef_sc_hd__decap_12
XFILLER_198_1229 VPWR VGND VPWR VGND sky130_ef_sc_hd__decap_12
XFILLER_191_909 VPWR VGND VPWR VGND sky130_ef_sc_hd__decap_12
XFILLER_15_1467 VPWR VGND VPWR VGND sky130_ef_sc_hd__decap_12
XFILLER_8_77 VGND VGND VPWR VPWR sky130_fd_sc_hd__decap_6
XFILLER_102_1415 VPWR VGND VPWR VGND sky130_ef_sc_hd__decap_12
XFILLER_200_1005 VPWR VGND VPWR VGND sky130_ef_sc_hd__decap_12
XFILLER_184_961 VPWR VGND VPWR VGND sky130_ef_sc_hd__decap_12
XFILLER_204_1185 VPWR VGND VPWR VGND sky130_ef_sc_hd__decap_12
Xwire560 net68 VGND VGND VPWR VPWR net560 sky130_fd_sc_hd__buf_1
XFILLER_190_419 VGND VGND VPWR VPWR sky130_fd_sc_hd__fill_1
Xwire571 dout0_q\[14\] VGND VGND VPWR VPWR net571 sky130_fd_sc_hd__clkbuf_1
XFILLER_7_662 VGND VGND VPWR VPWR sky130_fd_sc_hd__decap_4
XFILLER_141_1497 VGND VGND VPWR VPWR sky130_fd_sc_hd__fill_1
XFILLER_7_673 VGND VGND VPWR VPWR sky130_fd_sc_hd__decap_6
Xwire582 dout0_q\[6\] VGND VGND VPWR VPWR net582 sky130_fd_sc_hd__clkbuf_1
XFILLER_200_1049 VPWR VGND VPWR VGND sky130_ef_sc_hd__decap_12
Xmax_cap326 net327 VGND VGND VPWR VPWR net326 sky130_fd_sc_hd__clkbuf_1
XFILLER_195_81 VPWR VGND VPWR VGND sky130_ef_sc_hd__decap_12
XFILLER_170_121 VPWR VGND VPWR VGND sky130_ef_sc_hd__decap_12
XFILLER_217_1513 VGND VGND VPWR VPWR sky130_fd_sc_hd__fill_2
XFILLER_40_3 VPWR VGND VPWR VGND sky130_ef_sc_hd__decap_12
XFILLER_170_165 VPWR VGND VPWR VGND sky130_ef_sc_hd__decap_12
XFILLER_135_1213 VGND VGND VPWR VPWR sky130_fd_sc_hd__decap_4
XFILLER_174_1273 VPWR VGND VPWR VGND sky130_ef_sc_hd__decap_12
XFILLER_83_1189 VPWR VGND VPWR VGND sky130_ef_sc_hd__decap_12
XTAP_TAPCELL_ROW_209_2524 VGND VPWR sky130_fd_sc_hd__tapvpwrvgnd_1
XTAP_TAPCELL_ROW_209_2535 VGND VPWR sky130_fd_sc_hd__tapvpwrvgnd_1
XFILLER_239_951 VGND VGND VPWR VPWR sky130_fd_sc_hd__fill_1
XFILLER_61_1443 VPWR VGND VPWR VGND sky130_ef_sc_hd__decap_12
XFILLER_113_1511 VGND VGND VPWR VPWR sky130_fd_sc_hd__decap_4
XFILLER_211_1101 VPWR VGND VPWR VGND sky130_ef_sc_hd__decap_12
XFILLER_250_1161 VPWR VGND VPWR VGND sky130_ef_sc_hd__decap_12
XFILLER_215_1281 VGND VGND VPWR VPWR sky130_fd_sc_hd__decap_6
XFILLER_22_1427 VPWR VGND VPWR VGND sky130_ef_sc_hd__decap_12
XFILLER_226_601 VPWR VGND VPWR VGND sky130_ef_sc_hd__decap_12
XFILLER_211_1145 VPWR VGND VPWR VGND sky130_ef_sc_hd__decap_12
XFILLER_214_77 VGND VGND VPWR VPWR sky130_fd_sc_hd__decap_6
XFILLER_225_111 VGND VGND VPWR VPWR sky130_fd_sc_hd__fill_1
XFILLER_226_645 VPWR VGND VPWR VGND sky130_ef_sc_hd__decap_12
XFILLER_0_1201 VGND VGND VPWR VPWR sky130_fd_sc_hd__decap_3
XFILLER_211_1189 VPWR VGND VPWR VGND sky130_ef_sc_hd__decap_12
XFILLER_241_615 VGND VGND VPWR VPWR sky130_fd_sc_hd__fill_1
XFILLER_0_1245 VPWR VGND VPWR VGND sky130_ef_sc_hd__decap_12
XFILLER_213_317 VPWR VGND VPWR VGND sky130_ef_sc_hd__decap_12
XFILLER_253_497 VGND VGND VPWR VPWR sky130_fd_sc_hd__decap_6
XFILLER_230_65 VPWR VGND VPWR VGND sky130_ef_sc_hd__decap_12
XFILLER_0_1289 VPWR VGND VPWR VGND sky130_ef_sc_hd__decap_12
XFILLER_178_221 VPWR VGND VPWR VGND sky130_ef_sc_hd__decap_12
XFILLER_181_1233 VPWR VGND VPWR VGND sky130_ef_sc_hd__decap_12
XFILLER_209_1063 VGND VGND VPWR VPWR sky130_fd_sc_hd__fill_1
XFILLER_179_777 VGND VGND VPWR VPWR sky130_fd_sc_hd__decap_6
XFILLER_221_361 VPWR VGND VPWR VGND sky130_ef_sc_hd__decap_12
XFILLER_178_265 VPWR VGND VPWR VGND sky130_ef_sc_hd__decap_12
XFILLER_142_1239 VGND VGND VPWR VPWR sky130_fd_sc_hd__decap_6
XFILLER_194_725 VPWR VGND VPWR VGND sky130_ef_sc_hd__decap_12
XFILLER_222_1241 VPWR VGND VPWR VGND sky130_ef_sc_hd__decap_12
XFILLER_194_769 VPWR VGND VPWR VGND sky130_ef_sc_hd__decap_12
XTAP_TAPCELL_ROW_173_1543 VGND VPWR sky130_fd_sc_hd__tapvpwrvgnd_1
XFILLER_222_1285 VPWR VGND VPWR VGND sky130_ef_sc_hd__decap_12
XTAP_TAPCELL_ROW_173_1554 VGND VPWR sky130_fd_sc_hd__tapvpwrvgnd_1
XFILLER_193_279 VGND VGND VPWR VPWR sky130_fd_sc_hd__fill_1
XTAP_TAPCELL_ROW_173_1565 VGND VPWR sky130_fd_sc_hd__tapvpwrvgnd_1
XTAP_TAPCELL_ROW_30_1_1165 VGND VPWR sky130_fd_sc_hd__tapvpwrvgnd_1
XPHY_EDGE_ROW_83_2_Right_174 VGND VGND VPWR VPWR sky130_fd_sc_hd__decap_3
XTAP_TAPCELL_ROW_73_2_4190 VGND VPWR sky130_fd_sc_hd__tapvpwrvgnd_1
XFILLER_255_1061 VGND VGND VPWR VPWR sky130_fd_sc_hd__decap_3
XFILLER_68_27 VGND VGND VPWR VPWR sky130_fd_sc_hd__fill_1
XTAP_TAPCELL_ROW_186_1904 VGND VPWR sky130_fd_sc_hd__tapvpwrvgnd_1
XTAP_TAPCELL_ROW_186_1915 VGND VPWR sky130_fd_sc_hd__tapvpwrvgnd_1
XFILLER_192_1373 VPWR VGND VPWR VGND sky130_ef_sc_hd__decap_12
XFILLER_191_39 VPWR VGND VPWR VGND sky130_ef_sc_hd__decap_12
XFILLER_5_1101 VPWR VGND VPWR VGND sky130_ef_sc_hd__decap_12
XFILLER_153_1379 VGND VGND VPWR VPWR sky130_fd_sc_hd__decap_6
XFILLER_233_1381 VPWR VGND VPWR VGND sky130_ef_sc_hd__decap_12
XFILLER_188_1409 VPWR VGND VPWR VGND sky130_ef_sc_hd__decap_12
XFILLER_84_15 VPWR VGND VPWR VGND sky130_ef_sc_hd__decap_12
XFILLER_229_461 VPWR VGND VPWR VGND sky130_ef_sc_hd__decap_12
XFILLER_245_921 VPWR VGND VPWR VGND sky130_ef_sc_hd__decap_12
XFILLER_5_1145 VPWR VGND VPWR VGND sky130_ef_sc_hd__decap_12
XFILLER_1_1009 VPWR VGND VPWR VGND sky130_ef_sc_hd__decap_12
XFILLER_245_965 VPWR VGND VPWR VGND sky130_ef_sc_hd__decap_12
XFILLER_5_1189 VPWR VGND VPWR VGND sky130_ef_sc_hd__decap_12
X_580_ net668 VGND VGND VPWR VPWR _062_ sky130_fd_sc_hd__inv_2
XFILLER_216_133 VGND VGND VPWR VPWR sky130_fd_sc_hd__decap_6
XFILLER_244_475 VGND VGND VPWR VPWR sky130_fd_sc_hd__fill_1
XFILLER_216_177 VPWR VGND VPWR VGND sky130_ef_sc_hd__decap_12
XTAP_TAPCELL_ROW_0_860 VGND VPWR sky130_fd_sc_hd__tapvpwrvgnd_1
XFILLER_232_637 VGND VGND VPWR VPWR sky130_fd_sc_hd__decap_6
XTAP_TAPCELL_ROW_0_871 VGND VPWR sky130_fd_sc_hd__tapvpwrvgnd_1
XFILLER_140_65 VGND VGND VPWR VPWR sky130_fd_sc_hd__decap_6
XFILLER_231_125 VPWR VGND VPWR VGND sky130_ef_sc_hd__decap_12
XFILLER_242_3 VPWR VGND VPWR VGND sky130_ef_sc_hd__decap_12
XFILLER_197_541 VPWR VGND VPWR VGND sky130_ef_sc_hd__decap_12
XTAP_TAPCELL_ROW_45_2_4025 VGND VPWR sky130_fd_sc_hd__tapvpwrvgnd_1
XFILLER_231_169 VPWR VGND VPWR VGND sky130_ef_sc_hd__decap_12
XFILLER_200_501 VPWR VGND VPWR VGND sky130_ef_sc_hd__decap_12
XFILLER_213_895 VGND VGND VPWR VPWR sky130_fd_sc_hd__fill_1
XFILLER_240_681 VPWR VGND VPWR VGND sky130_ef_sc_hd__decap_12
XFILLER_197_585 VPWR VGND VPWR VGND sky130_ef_sc_hd__decap_12
XFILLER_199_1505 VGND VGND VPWR VPWR sky130_fd_sc_hd__decap_6
XTAP_TAPCELL_ROW_255_3790 VGND VPWR sky130_fd_sc_hd__tapvpwrvgnd_1
XFILLER_160_1339 VPWR VGND VPWR VGND sky130_ef_sc_hd__decap_12
XFILLER_8_415 VGND VGND VPWR VPWR sky130_fd_sc_hd__decap_4
XFILLER_200_545 VPWR VGND VPWR VGND sky130_ef_sc_hd__decap_12
XFILLER_240_1341 VPWR VGND VPWR VGND sky130_ef_sc_hd__decap_12
XFILLER_9_949 VGND VGND VPWR VPWR sky130_fd_sc_hd__decap_3
XTAP_TAPCELL_ROW_251_3654 VGND VPWR sky130_fd_sc_hd__tapvpwrvgnd_1
XFILLER_36_1191 VPWR VGND VPWR VGND sky130_ef_sc_hd__decap_12
XFILLER_173_909 VPWR VGND VPWR VGND sky130_ef_sc_hd__decap_12
XTAP_TAPCELL_ROW_251_3665 VGND VPWR sky130_fd_sc_hd__tapvpwrvgnd_1
XFILLER_166_961 VPWR VGND VPWR VGND sky130_ef_sc_hd__decap_12
XFILLER_200_589 VPWR VGND VPWR VGND sky130_ef_sc_hd__decap_12
XFILLER_201_1325 VPWR VGND VPWR VGND sky130_ef_sc_hd__decap_12
XFILLER_240_1385 VPWR VGND VPWR VGND sky130_ef_sc_hd__decap_12
XFILLER_172_419 VGND VGND VPWR VPWR sky130_fd_sc_hd__fill_1
XFILLER_201_1369 VPWR VGND VPWR VGND sky130_ef_sc_hd__decap_12
XFILLER_181_953 VPWR VGND VPWR VGND sky130_ef_sc_hd__decap_12
XFILLER_119_1219 VPWR VGND VPWR VGND sky130_ef_sc_hd__decap_12
XFILLER_171_1413 VPWR VGND VPWR VGND sky130_ef_sc_hd__decap_12
XFILLER_239_225 VPWR VGND VPWR VGND sky130_ef_sc_hd__decap_12
XFILLER_171_1457 VPWR VGND VPWR VGND sky130_ef_sc_hd__decap_12
XFILLER_212_1421 VGND VGND VPWR VPWR sky130_fd_sc_hd__decap_6
XFILLER_251_1481 VPWR VGND VPWR VGND sky130_ef_sc_hd__decap_12
Xhold4 rd_addr\[4\] VGND VGND VPWR VPWR net691 sky130_fd_sc_hd__dlygate4sd3_1
XFILLER_255_729 VPWR VGND VPWR VGND sky130_ef_sc_hd__decap_12
XFILLER_208_601 VPWR VGND VPWR VGND sky130_ef_sc_hd__decap_12
XFILLER_248_781 VPWR VGND VPWR VGND sky130_ef_sc_hd__decap_12
XFILLER_212_1465 VPWR VGND VPWR VGND sky130_ef_sc_hd__decap_12
XFILLER_78_1203 VPWR VGND VPWR VGND sky130_ef_sc_hd__decap_12
XFILLER_207_111 VGND VGND VPWR VPWR sky130_fd_sc_hd__fill_1
XFILLER_208_645 VPWR VGND VPWR VGND sky130_ef_sc_hd__decap_12
XFILLER_130_1165 VPWR VGND VPWR VGND sky130_ef_sc_hd__decap_12
XFILLER_78_1247 VPWR VGND VPWR VGND sky130_ef_sc_hd__decap_12
XFILLER_223_615 VGND VGND VPWR VPWR sky130_fd_sc_hd__fill_1
XFILLER_250_401 VPWR VGND VPWR VGND sky130_ef_sc_hd__decap_12
XFILLER_165_1217 VPWR VGND VPWR VGND sky130_ef_sc_hd__decap_12
XFILLER_235_497 VGND VGND VPWR VPWR sky130_fd_sc_hd__decap_6
XFILLER_250_445 VPWR VGND VPWR VGND sky130_ef_sc_hd__decap_12
XFILLER_206_1203 VGND VGND VPWR VPWR sky130_fd_sc_hd__fill_1
XFILLER_210_309 VPWR VGND VPWR VGND sky130_ef_sc_hd__decap_12
XFILLER_250_489 VPWR VGND VPWR VGND sky130_ef_sc_hd__decap_12
XFILLER_203_361 VPWR VGND VPWR VGND sky130_ef_sc_hd__decap_12
XFILLER_176_725 VPWR VGND VPWR VGND sky130_ef_sc_hd__decap_12
XFILLER_88_3 VPWR VGND VPWR VGND sky130_ef_sc_hd__decap_12
XFILLER_15_1231 VPWR VGND VPWR VGND sky130_ef_sc_hd__decap_12
XFILLER_176_769 VPWR VGND VPWR VGND sky130_ef_sc_hd__decap_12
XFILLER_198_1037 VPWR VGND VPWR VGND sky130_ef_sc_hd__decap_12
XFILLER_15_1275 VPWR VGND VPWR VGND sky130_ef_sc_hd__decap_12
XFILLER_175_279 VGND VGND VPWR VPWR sky130_fd_sc_hd__fill_1
XFILLER_239_1001 VGND VGND VPWR VPWR sky130_fd_sc_hd__decap_6
XFILLER_89_1343 VPWR VGND VPWR VGND sky130_ef_sc_hd__decap_12
XFILLER_50_1177 VPWR VGND VPWR VGND sky130_ef_sc_hd__decap_12
XFILLER_102_1245 VGND VGND VPWR VPWR sky130_fd_sc_hd__fill_1
XFILLER_8_993 VPWR VGND VPWR VGND sky130_ef_sc_hd__decap_12
Xmax_cap101 net102 VGND VGND VPWR VPWR net101 sky130_fd_sc_hd__clkbuf_1
Xmax_cap112 _129_ VGND VGND VPWR VPWR net112 sky130_fd_sc_hd__clkbuf_1
XPHY_EDGE_ROW_110_2_Left_612 VGND VGND VPWR VPWR sky130_fd_sc_hd__decap_3
XFILLER_209_55 VGND VGND VPWR VPWR sky130_fd_sc_hd__fill_1
Xmax_cap123 _198_ VGND VGND VPWR VPWR net123 sky130_fd_sc_hd__clkbuf_1
Xwire390 net391 VGND VGND VPWR VPWR net390 sky130_fd_sc_hd__clkbuf_1
XFILLER_239_1045 VPWR VGND VPWR VGND sky130_ef_sc_hd__decap_12
XFILLER_89_1387 VPWR VGND VPWR VGND sky130_ef_sc_hd__decap_12
Xmax_cap134 _146_ VGND VGND VPWR VPWR net134 sky130_fd_sc_hd__clkbuf_1
XFILLER_171_441 VGND VGND VPWR VPWR sky130_fd_sc_hd__decap_6
XFILLER_239_1089 VPWR VGND VPWR VGND sky130_ef_sc_hd__decap_12
XFILLER_171_485 VPWR VGND VPWR VGND sky130_ef_sc_hd__decap_12
Xmax_cap189 _226_ VGND VGND VPWR VPWR net189 sky130_fd_sc_hd__clkbuf_1
XFILLER_217_1343 VGND VGND VPWR VPWR sky130_fd_sc_hd__fill_1
XFILLER_6_1421 VGND VGND VPWR VPWR sky130_fd_sc_hd__decap_6
XFILLER_26_1371 VPWR VGND VPWR VGND sky130_ef_sc_hd__decap_12
XFILLER_245_217 VGND VGND VPWR VPWR sky130_fd_sc_hd__decap_6
XFILLER_61_1273 VGND VGND VPWR VPWR sky130_fd_sc_hd__fill_1
XFILLER_227_921 VPWR VGND VPWR VGND sky130_ef_sc_hd__decap_12
XFILLER_6_1465 VPWR VGND VPWR VGND sky130_ef_sc_hd__decap_12
XFILLER_96_1303 VPWR VGND VPWR VGND sky130_ef_sc_hd__decap_12
XTAP_TAPCELL_ROW_166_1380 VGND VPWR sky130_fd_sc_hd__tapvpwrvgnd_1
XFILLER_2_1329 VPWR VGND VPWR VGND sky130_ef_sc_hd__decap_12
XTAP_TAPCELL_ROW_36_2_3973 VGND VPWR sky130_fd_sc_hd__tapvpwrvgnd_1
XFILLER_113_1385 VGND VGND VPWR VPWR sky130_fd_sc_hd__fill_1
XFILLER_227_965 VPWR VGND VPWR VGND sky130_ef_sc_hd__decap_12
XFILLER_246_1005 VPWR VGND VPWR VGND sky130_ef_sc_hd__decap_12
XFILLER_148_1415 VPWR VGND VPWR VGND sky130_ef_sc_hd__decap_12
XFILLER_253_261 VPWR VGND VPWR VGND sky130_ef_sc_hd__decap_12
XFILLER_54_29 VPWR VGND VPWR VGND sky130_ef_sc_hd__decap_12
XFILLER_226_475 VGND VGND VPWR VPWR sky130_fd_sc_hd__fill_1
XFILLER_199_839 VGND VGND VPWR VPWR sky130_fd_sc_hd__fill_1
XFILLER_214_637 VGND VGND VPWR VPWR sky130_fd_sc_hd__decap_6
XFILLER_213_125 VPWR VGND VPWR VGND sky130_ef_sc_hd__decap_12
XFILLER_246_1049 VPWR VGND VPWR VGND sky130_ef_sc_hd__decap_12
XFILLER_242_979 VGND VGND VPWR VPWR sky130_fd_sc_hd__fill_1
XFILLER_179_541 VPWR VGND VPWR VGND sky130_ef_sc_hd__decap_12
XTAP_TAPCELL_ROW_179_1730 VGND VPWR sky130_fd_sc_hd__tapvpwrvgnd_1
XFILLER_213_169 VPWR VGND VPWR VGND sky130_ef_sc_hd__decap_12
XFILLER_228_1483 VGND VGND VPWR VPWR sky130_fd_sc_hd__fill_1
XFILLER_222_681 VPWR VGND VPWR VGND sky130_ef_sc_hd__decap_12
XTAP_TAPCELL_ROW_175_1605 VGND VPWR sky130_fd_sc_hd__tapvpwrvgnd_1
XFILLER_181_1063 VGND VGND VPWR VPWR sky130_fd_sc_hd__fill_1
XTAP_TAPCELL_ROW_175_1616 VGND VPWR sky130_fd_sc_hd__tapvpwrvgnd_1
XFILLER_179_585 VPWR VGND VPWR VGND sky130_ef_sc_hd__decap_12
XFILLER_194_533 VPWR VGND VPWR VGND sky130_ef_sc_hd__decap_12
XFILLER_33_1331 VPWR VGND VPWR VGND sky130_ef_sc_hd__decap_12
XFILLER_107_1189 VPWR VGND VPWR VGND sky130_ef_sc_hd__decap_12
XFILLER_6_908 VPWR VGND VPWR VGND sky130_ef_sc_hd__decap_12
XFILLER_120_1301 VGND VGND VPWR VPWR sky130_fd_sc_hd__fill_1
XPHY_EDGE_ROW_42_2_Left_544 VGND VGND VPWR VPWR sky130_fd_sc_hd__decap_3
XFILLER_181_205 VPWR VGND VPWR VGND sky130_ef_sc_hd__decap_12
XFILLER_159_1511 VGND VGND VPWR VPWR sky130_fd_sc_hd__decap_4
XFILLER_222_1093 VPWR VGND VPWR VGND sky130_ef_sc_hd__decap_12
XFILLER_119_55 VGND VGND VPWR VPWR sky130_fd_sc_hd__fill_1
XFILLER_79_15 VPWR VGND VPWR VGND sky130_ef_sc_hd__decap_12
XFILLER_68_1427 VPWR VGND VPWR VGND sky130_ef_sc_hd__decap_12
XFILLER_181_249 VPWR VGND VPWR VGND sky130_ef_sc_hd__decap_12
XFILLER_253_1009 VPWR VGND VPWR VGND sky130_ef_sc_hd__decap_12
XPHY_EDGE_ROW_2_Left_258 VGND VGND VPWR VPWR sky130_fd_sc_hd__decap_3
XFILLER_218_1129 VPWR VGND VPWR VGND sky130_ef_sc_hd__decap_12
XPHY_EDGE_ROW_84_2_Right_175 VGND VGND VPWR VPWR sky130_fd_sc_hd__decap_3
XTAP_TAPCELL_ROW_147_2_4635 VGND VPWR sky130_fd_sc_hd__tapvpwrvgnd_1
XFILLER_153_1165 VPWR VGND VPWR VGND sky130_ef_sc_hd__decap_12
XFILLER_192_3 VPWR VGND VPWR VGND sky130_ef_sc_hd__decap_12
XFILLER_237_729 VPWR VGND VPWR VGND sky130_ef_sc_hd__decap_12
XTAP_TAPCELL_ROW_244_3480 VGND VPWR sky130_fd_sc_hd__tapvpwrvgnd_1
XFILLER_44_1471 VPWR VGND VPWR VGND sky130_ef_sc_hd__decap_12
XFILLER_95_69 VGND VGND VPWR VPWR sky130_fd_sc_hd__fill_2
XFILLER_28_41 VGND VGND VPWR VPWR sky130_fd_sc_hd__decap_4
XFILLER_131_1441 VGND VGND VPWR VPWR sky130_fd_sc_hd__fill_1
XFILLER_188_1217 VPWR VGND VPWR VGND sky130_ef_sc_hd__decap_12
XTAP_TAPCELL_ROW_5_985 VGND VPWR sky130_fd_sc_hd__tapvpwrvgnd_1
XPHY_EDGE_ROW_119_1_Left_374 VGND VGND VPWR VPWR sky130_fd_sc_hd__decap_3
XTAP_TAPCELL_ROW_5_996 VGND VPWR sky130_fd_sc_hd__tapvpwrvgnd_1
XTAP_TAPCELL_ROW_240_3355 VGND VPWR sky130_fd_sc_hd__tapvpwrvgnd_1
X_632_ clknet_3_5__leaf_clk dout0\[30\] _040_ VGND VGND VPWR VPWR dout0_q\[30\] sky130_fd_sc_hd__dfrtp_1
XTAP_TAPCELL_ROW_240_3366 VGND VPWR sky130_fd_sc_hd__tapvpwrvgnd_1
XFILLER_40_1357 VGND VGND VPWR VPWR sky130_fd_sc_hd__fill_1
XTAP_TAPCELL_ROW_240_3377 VGND VPWR sky130_fd_sc_hd__tapvpwrvgnd_1
XFILLER_205_615 VGND VGND VPWR VPWR sky130_fd_sc_hd__fill_1
XFILLER_229_1225 VGND VGND VPWR VPWR sky130_fd_sc_hd__decap_6
XFILLER_232_401 VPWR VGND VPWR VGND sky130_ef_sc_hd__decap_12
X_563_ net663 VGND VGND VPWR VPWR _045_ sky130_fd_sc_hd__inv_2
XFILLER_189_305 VPWR VGND VPWR VGND sky130_ef_sc_hd__decap_12
XFILLER_217_497 VGND VGND VPWR VPWR sky130_fd_sc_hd__decap_6
XTAP_TAPCELL_ROW_95_2_4322 VGND VPWR sky130_fd_sc_hd__tapvpwrvgnd_1
XPHY_EDGE_ROW_56_1_Left_311 VGND VGND VPWR VPWR sky130_fd_sc_hd__decap_3
XFILLER_229_1269 VPWR VGND VPWR VGND sky130_ef_sc_hd__decap_12
XFILLER_232_445 VPWR VGND VPWR VGND sky130_ef_sc_hd__decap_12
X_494_ net144 net85 net190 VGND VGND VPWR VPWR _253_ sky130_fd_sc_hd__o21ba_1
XFILLER_189_349 VPWR VGND VPWR VGND sky130_ef_sc_hd__decap_12
XTAP_TAPCELL_ROW_253_3705 VGND VPWR sky130_fd_sc_hd__tapvpwrvgnd_1
XTAP_TAPCELL_ROW_253_3716 VGND VPWR sky130_fd_sc_hd__tapvpwrvgnd_1
XFILLER_125_1201 VPWR VGND VPWR VGND sky130_ef_sc_hd__decap_12
XFILLER_198_861 VGND VGND VPWR VPWR sky130_fd_sc_hd__decap_6
XFILLER_232_489 VPWR VGND VPWR VGND sky130_ef_sc_hd__decap_12
XTAP_TAPCELL_ROW_253_3727 VGND VPWR sky130_fd_sc_hd__tapvpwrvgnd_1
XFILLER_201_821 VPWR VGND VPWR VGND sky130_ef_sc_hd__decap_12
XFILLER_9_713 VPWR VGND VPWR VGND sky130_ef_sc_hd__decap_12
XFILLER_164_1283 VPWR VGND VPWR VGND sky130_ef_sc_hd__decap_12
XFILLER_73_1177 VPWR VGND VPWR VGND sky130_ef_sc_hd__decap_12
XFILLER_197_393 VPWR VGND VPWR VGND sky130_ef_sc_hd__decap_12
XFILLER_199_1313 VPWR VGND VPWR VGND sky130_ef_sc_hd__decap_12
XFILLER_201_865 VPWR VGND VPWR VGND sky130_ef_sc_hd__decap_12
XFILLER_125_1267 VGND VGND VPWR VPWR sky130_fd_sc_hd__decap_6
XFILLER_9_757 VPWR VGND VPWR VGND sky130_ef_sc_hd__decap_12
XFILLER_12_1415 VPWR VGND VPWR VGND sky130_ef_sc_hd__decap_12
XFILLER_199_1357 VPWR VGND VPWR VGND sky130_ef_sc_hd__decap_12
XFILLER_201_1133 VPWR VGND VPWR VGND sky130_ef_sc_hd__decap_12
XFILLER_51_1497 VGND VGND VPWR VPWR sky130_fd_sc_hd__fill_1
XFILLER_201_1177 VPWR VGND VPWR VGND sky130_ef_sc_hd__decap_12
XFILLER_176_83 VGND VGND VPWR VPWR sky130_fd_sc_hd__fill_1
XFILLER_236_1229 VPWR VGND VPWR VGND sky130_ef_sc_hd__decap_12
XFILLER_181_783 VGND VGND VPWR VPWR sky130_fd_sc_hd__fill_1
XFILLER_84_1295 VGND VGND VPWR VPWR sky130_fd_sc_hd__decap_6
XFILLER_132_1227 VPWR VGND VPWR VGND sky130_ef_sc_hd__decap_12
XFILLER_23_1511 VGND VGND VPWR VPWR sky130_fd_sc_hd__decap_4
XFILLER_171_1287 VGND VGND VPWR VPWR sky130_fd_sc_hd__fill_1
XFILLER_209_921 VPWR VGND VPWR VGND sky130_ef_sc_hd__decap_12
XFILLER_227_217 VGND VGND VPWR VPWR sky130_fd_sc_hd__decap_6
XFILLER_212_1273 VPWR VGND VPWR VGND sky130_ef_sc_hd__decap_12
XFILLER_209_965 VPWR VGND VPWR VGND sky130_ef_sc_hd__decap_12
XFILLER_242_209 VPWR VGND VPWR VGND sky130_ef_sc_hd__decap_12
XFILLER_208_475 VGND VGND VPWR VPWR sky130_fd_sc_hd__fill_1
XFILLER_247_1325 VPWR VGND VPWR VGND sky130_ef_sc_hd__decap_12
XFILLER_235_261 VPWR VGND VPWR VGND sky130_ef_sc_hd__decap_12
XFILLER_251_721 VGND VGND VPWR VPWR sky130_fd_sc_hd__decap_6
XTAP_TAPCELL_ROW_223_2896 VGND VPWR sky130_fd_sc_hd__tapvpwrvgnd_1
XFILLER_208_1309 VGND VGND VPWR VPWR sky130_fd_sc_hd__decap_6
XFILLER_247_1369 VPWR VGND VPWR VGND sky130_ef_sc_hd__decap_12
XFILLER_224_979 VGND VGND VPWR VPWR sky130_fd_sc_hd__fill_1
XFILLER_251_765 VPWR VGND VPWR VGND sky130_ef_sc_hd__decap_12
XPHY_EDGE_ROW_40_1_Left_295 VGND VGND VPWR VPWR sky130_fd_sc_hd__decap_3
XFILLER_250_253 VPWR VGND VPWR VGND sky130_ef_sc_hd__decap_12
XFILLER_211_629 VPWR VGND VPWR VGND sky130_ef_sc_hd__decap_12
XFILLER_204_681 VPWR VGND VPWR VGND sky130_ef_sc_hd__decap_12
XFILLER_91_1255 VPWR VGND VPWR VGND sky130_ef_sc_hd__decap_12
XFILLER_143_1323 VGND VGND VPWR VPWR sky130_fd_sc_hd__decap_6
XFILLER_210_139 VGND VGND VPWR VPWR sky130_fd_sc_hd__fill_1
XFILLER_52_1239 VGND VGND VPWR VPWR sky130_fd_sc_hd__decap_6
XFILLER_176_533 VPWR VGND VPWR VGND sky130_ef_sc_hd__decap_12
XFILLER_91_1299 VPWR VGND VPWR VGND sky130_ef_sc_hd__decap_12
XFILLER_143_1367 VPWR VGND VPWR VGND sky130_ef_sc_hd__decap_12
XFILLER_191_503 VGND VGND VPWR VPWR sky130_fd_sc_hd__fill_1
XFILLER_254_1329 VPWR VGND VPWR VGND sky130_ef_sc_hd__decap_12
XFILLER_219_1449 VGND VGND VPWR VPWR sky130_fd_sc_hd__decap_6
XFILLER_236_53 VPWR VGND VPWR VGND sky130_ef_sc_hd__decap_12
XTAP_TAPCELL_ROW_133_2_4554 VGND VPWR sky130_fd_sc_hd__tapvpwrvgnd_1
XFILLER_171_293 VPWR VGND VPWR VGND sky130_ef_sc_hd__decap_12
XFILLER_172_1029 VGND VGND VPWR VPWR sky130_fd_sc_hd__decap_6
XFILLER_236_97 VPWR VGND VPWR VGND sky130_ef_sc_hd__decap_12
XTAP_TAPCELL_ROW_168_1420 VGND VPWR sky130_fd_sc_hd__tapvpwrvgnd_1
XFILLER_154_1463 VGND VGND VPWR VPWR sky130_fd_sc_hd__decap_6
XTAP_TAPCELL_ROW_168_1431 VGND VPWR sky130_fd_sc_hd__tapvpwrvgnd_1
XFILLER_63_1379 VGND VGND VPWR VPWR sky130_fd_sc_hd__decap_6
XFILLER_150_1327 VPWR VGND VPWR VGND sky130_ef_sc_hd__decap_12
XFILLER_252_41 VPWR VGND VPWR VGND sky130_ef_sc_hd__decap_12
XFILLER_219_729 VPWR VGND VPWR VGND sky130_ef_sc_hd__decap_12
XTAP_TAPCELL_ROW_25_1_1160 VGND VPWR sky130_fd_sc_hd__tapvpwrvgnd_1
XFILLER_105_57 VPWR VGND VPWR VGND sky130_ef_sc_hd__decap_12
XTAP_TAPCELL_ROW_2_911 VGND VPWR sky130_fd_sc_hd__tapvpwrvgnd_1
XTAP_TAPCELL_ROW_113_2_4430 VGND VPWR sky130_fd_sc_hd__tapvpwrvgnd_1
XFILLER_252_85 VPWR VGND VPWR VGND sky130_ef_sc_hd__decap_12
XTAP_TAPCELL_ROW_2_922 VGND VPWR sky130_fd_sc_hd__tapvpwrvgnd_1
XFILLER_6_1273 VPWR VGND VPWR VGND sky130_ef_sc_hd__decap_12
XFILLER_230_1373 VPWR VGND VPWR VGND sky130_ef_sc_hd__decap_12
XTAP_TAPCELL_ROW_81_2_4241 VGND VPWR sky130_fd_sc_hd__tapvpwrvgnd_1
XFILLER_214_401 VPWR VGND VPWR VGND sky130_ef_sc_hd__decap_12
XFILLER_254_581 VGND VGND VPWR VPWR sky130_fd_sc_hd__decap_6
XFILLER_96_1177 VPWR VGND VPWR VGND sky130_ef_sc_hd__decap_12
XFILLER_148_1245 VGND VGND VPWR VPWR sky130_fd_sc_hd__fill_1
XFILLER_226_1409 VPWR VGND VPWR VGND sky130_ef_sc_hd__decap_12
XFILLER_214_445 VPWR VGND VPWR VGND sky130_ef_sc_hd__decap_12
XFILLER_230_905 VPWR VGND VPWR VGND sky130_ef_sc_hd__decap_12
XFILLER_81_27 VPWR VGND VPWR VGND sky130_ef_sc_hd__decap_12
XFILLER_187_809 VPWR VGND VPWR VGND sky130_ef_sc_hd__decap_12
XFILLER_183_1169 VGND VGND VPWR VPWR sky130_fd_sc_hd__decap_6
XFILLER_214_489 VPWR VGND VPWR VGND sky130_ef_sc_hd__decap_12
XFILLER_230_949 VPWR VGND VPWR VGND sky130_ef_sc_hd__decap_12
XFILLER_197_27 VPWR VGND VPWR VGND sky130_ef_sc_hd__decap_12
XFILLER_161_1423 VPWR VGND VPWR VGND sky130_ef_sc_hd__decap_12
XFILLER_70_1339 VPWR VGND VPWR VGND sky130_ef_sc_hd__decap_12
XFILLER_122_1407 VGND VGND VPWR VPWR sky130_fd_sc_hd__decap_6
XFILLER_179_393 VPWR VGND VPWR VGND sky130_ef_sc_hd__decap_12
XFILLER_14_65 VGND VGND VPWR VPWR sky130_fd_sc_hd__decap_6
XFILLER_161_1467 VPWR VGND VPWR VGND sky130_ef_sc_hd__decap_12
XFILLER_195_853 VPWR VGND VPWR VGND sky130_ef_sc_hd__decap_12
XFILLER_194_363 VGND VGND VPWR VPWR sky130_fd_sc_hd__fill_1
XTAP_TAPCELL_ROW_233_3170 VGND VPWR sky130_fd_sc_hd__tapvpwrvgnd_1
XFILLER_195_897 VPWR VGND VPWR VGND sky130_ef_sc_hd__decap_12
XTAP_TAPCELL_ROW_233_3181 VGND VPWR sky130_fd_sc_hd__tapvpwrvgnd_1
XFILLER_182_525 VGND VGND VPWR VPWR sky130_fd_sc_hd__decap_6
XFILLER_202_1453 VPWR VGND VPWR VGND sky130_ef_sc_hd__decap_12
XFILLER_237_1505 VGND VGND VPWR VPWR sky130_fd_sc_hd__decap_6
XFILLER_182_569 VPWR VGND VPWR VGND sky130_ef_sc_hd__decap_12
XFILLER_202_1497 VPWR VGND VPWR VGND sky130_ef_sc_hd__decap_12
XFILLER_30_53 VGND VGND VPWR VPWR sky130_fd_sc_hd__decap_4
XFILLER_205_3 VPWR VGND VPWR VGND sky130_ef_sc_hd__decap_12
XFILLER_29_1219 VPWR VGND VPWR VGND sky130_ef_sc_hd__decap_12
XFILLER_2_922 VGND VGND VPWR VPWR sky130_fd_sc_hd__fill_2
XFILLER_146_53 VPWR VGND VPWR VGND sky130_ef_sc_hd__decap_12
XFILLER_155_1216 VGND VGND VPWR VPWR sky130_fd_sc_hd__fill_2
XFILLER_159_1385 VGND VGND VPWR VPWR sky130_fd_sc_hd__fill_1
XTAP_TAPCELL_ROW_246_3520 VGND VPWR sky130_fd_sc_hd__tapvpwrvgnd_1
XTAP_TAPCELL_ROW_246_3531 VGND VPWR sky130_fd_sc_hd__tapvpwrvgnd_1
XFILLER_190_1129 VPWR VGND VPWR VGND sky130_ef_sc_hd__decap_12
XPHY_EDGE_ROW_85_2_Right_176 VGND VGND VPWR VPWR sky130_fd_sc_hd__decap_3
XFILLER_81_1435 VGND VGND VPWR VPWR sky130_fd_sc_hd__decap_6
XTAP_TAPCELL_ROW_242_3406 VGND VPWR sky130_fd_sc_hd__tapvpwrvgnd_1
XTAP_TAPCELL_ROW_242_3417 VGND VPWR sky130_fd_sc_hd__tapvpwrvgnd_1
XFILLER_39_51 VGND VGND VPWR VPWR sky130_fd_sc_hd__fill_1
XTAP_TAPCELL_ROW_72_1_1207 VGND VPWR sky130_fd_sc_hd__tapvpwrvgnd_1
XTAP_TAPCELL_ROW_242_3428 VGND VPWR sky130_fd_sc_hd__tapvpwrvgnd_1
XFILLER_81_1479 VPWR VGND VPWR VGND sky130_ef_sc_hd__decap_12
XFILLER_162_41 VPWR VGND VPWR VGND sky130_ef_sc_hd__decap_12
XFILLER_209_217 VGND VGND VPWR VPWR sky130_fd_sc_hd__decap_6
XFILLER_237_559 VGND VGND VPWR VPWR sky130_fd_sc_hd__fill_1
XTAP_TAPCELL_ROW_8_1065 VGND VPWR sky130_fd_sc_hd__tapvpwrvgnd_1
XTAP_TAPCELL_ROW_8_1076 VGND VPWR sky130_fd_sc_hd__tapvpwrvgnd_1
XTAP_TAPCELL_ROW_8_1087 VGND VPWR sky130_fd_sc_hd__tapvpwrvgnd_1
XFILLER_79_1331 VPWR VGND VPWR VGND sky130_ef_sc_hd__decap_12
XFILLER_224_209 VPWR VGND VPWR VGND sky130_ef_sc_hd__decap_12
XFILLER_40_1165 VPWR VGND VPWR VGND sky130_ef_sc_hd__decap_12
X_615_ clknet_3_6__leaf_clk dout0\[13\] _023_ VGND VGND VPWR VPWR dout0_q\[13\] sky130_fd_sc_hd__dfrtp_1
XFILLER_217_261 VPWR VGND VPWR VGND sky130_ef_sc_hd__decap_12
XFILLER_233_721 VGND VGND VPWR VPWR sky130_fd_sc_hd__decap_6
XFILLER_229_1033 VPWR VGND VPWR VGND sky130_ef_sc_hd__decap_12
XFILLER_75_1217 VGND VGND VPWR VPWR sky130_fd_sc_hd__fill_1
XFILLER_189_113 VPWR VGND VPWR VGND sky130_ef_sc_hd__decap_12
XFILLER_244_1509 VGND VGND VPWR VPWR sky130_fd_sc_hd__decap_6
XFILLER_233_765 VPWR VGND VPWR VGND sky130_ef_sc_hd__decap_12
X_546_ net668 VGND VGND VPWR VPWR _028_ sky130_fd_sc_hd__inv_2
XFILLER_206_979 VGND VGND VPWR VPWR sky130_fd_sc_hd__fill_1
XFILLER_229_1077 VPWR VGND VPWR VGND sky130_ef_sc_hd__decap_12
XFILLER_232_253 VPWR VGND VPWR VGND sky130_ef_sc_hd__decap_12
XFILLER_127_1329 VGND VGND VPWR VPWR sky130_fd_sc_hd__fill_1
X_477_ net328 net107 net167 VGND VGND VPWR VPWR _244_ sky130_fd_sc_hd__a21oi_1
XFILLER_140_1507 VGND VGND VPWR VPWR sky130_fd_sc_hd__decap_8
XFILLER_199_1121 VPWR VGND VPWR VGND sky130_ef_sc_hd__decap_12
XFILLER_201_673 VPWR VGND VPWR VGND sky130_ef_sc_hd__decap_12
XFILLER_173_503 VGND VGND VPWR VPWR sky130_fd_sc_hd__fill_1
XFILLER_185_385 VGND VGND VPWR VPWR sky130_fd_sc_hd__decap_6
XFILLER_187_93 VPWR VGND VPWR VGND sky130_ef_sc_hd__decap_12
XFILLER_195_1007 VGND VGND VPWR VPWR sky130_fd_sc_hd__fill_1
XFILLER_12_1245 VGND VGND VPWR VPWR sky130_fd_sc_hd__fill_1
XFILLER_5_771 VGND VGND VPWR VPWR sky130_fd_sc_hd__fill_1
XFILLER_86_1357 VGND VGND VPWR VPWR sky130_fd_sc_hd__fill_1
XFILLER_236_1037 VPWR VGND VPWR VGND sky130_ef_sc_hd__decap_12
XTAP_TAPCELL_ROW_212_2597 VGND VPWR sky130_fd_sc_hd__tapvpwrvgnd_1
XFILLER_138_1469 VGND VGND VPWR VPWR sky130_fd_sc_hd__fill_1
XTAP_TAPCELL_ROW_225_2947 VGND VPWR sky130_fd_sc_hd__tapvpwrvgnd_1
XFILLER_3_1413 VPWR VGND VPWR VGND sky130_ef_sc_hd__decap_12
XTAP_TAPCELL_ROW_225_2958 VGND VPWR sky130_fd_sc_hd__tapvpwrvgnd_1
XTAP_TAPCELL_ROW_225_2969 VGND VPWR sky130_fd_sc_hd__tapvpwrvgnd_1
XFILLER_255_389 VGND VGND VPWR VPWR sky130_fd_sc_hd__decap_3
XFILLER_243_529 VPWR VGND VPWR VGND sky130_ef_sc_hd__decap_12
XFILLER_23_1385 VGND VGND VPWR VPWR sky130_fd_sc_hd__fill_1
XFILLER_3_1457 VPWR VGND VPWR VGND sky130_ef_sc_hd__decap_12
XFILLER_236_581 VGND VGND VPWR VPWR sky130_fd_sc_hd__decap_6
XFILLER_58_1415 VPWR VGND VPWR VGND sky130_ef_sc_hd__decap_12
XFILLER_222_77 VGND VGND VPWR VPWR sky130_fd_sc_hd__decap_6
XFILLER_247_1133 VPWR VGND VPWR VGND sky130_ef_sc_hd__decap_12
XFILLER_97_1497 VGND VGND VPWR VPWR sky130_fd_sc_hd__fill_1
XFILLER_212_905 VPWR VGND VPWR VGND sky130_ef_sc_hd__decap_12
XFILLER_208_1117 VPWR VGND VPWR VGND sky130_ef_sc_hd__decap_12
XFILLER_247_1177 VPWR VGND VPWR VGND sky130_ef_sc_hd__decap_12
XFILLER_169_809 VPWR VGND VPWR VGND sky130_ef_sc_hd__decap_12
XFILLER_251_573 VPWR VGND VPWR VGND sky130_ef_sc_hd__decap_12
XFILLER_180_1309 VGND VGND VPWR VPWR sky130_fd_sc_hd__decap_6
XTAP_TAPCELL_ROW_46_2_4030 VGND VPWR sky130_fd_sc_hd__tapvpwrvgnd_1
XFILLER_212_949 VPWR VGND VPWR VGND sky130_ef_sc_hd__decap_12
XFILLER_195_105 VGND VGND VPWR VPWR sky130_fd_sc_hd__decap_6
XFILLER_177_853 VPWR VGND VPWR VGND sky130_ef_sc_hd__decap_12
XFILLER_195_149 VPWR VGND VPWR VGND sky130_ef_sc_hd__decap_12
XFILLER_108_1295 VGND VGND VPWR VPWR sky130_fd_sc_hd__decap_6
XFILLER_176_363 VGND VGND VPWR VPWR sky130_fd_sc_hd__fill_1
XFILLER_220_993 VPWR VGND VPWR VGND sky130_ef_sc_hd__decap_12
XFILLER_30_1301 VGND VGND VPWR VPWR sky130_fd_sc_hd__fill_1
XFILLER_17_1189 VPWR VGND VPWR VGND sky130_ef_sc_hd__decap_12
XFILLER_177_897 VPWR VGND VPWR VGND sky130_ef_sc_hd__decap_12
XFILLER_178_1205 VPWR VGND VPWR VGND sky130_ef_sc_hd__decap_12
XFILLER_69_1511 VGND VGND VPWR VPWR sky130_fd_sc_hd__decap_4
XFILLER_192_867 VGND VGND VPWR VPWR sky130_fd_sc_hd__fill_1
XFILLER_219_1213 VPWR VGND VPWR VGND sky130_ef_sc_hd__decap_12
XTAP_TAPCELL_ROW_24_2_3900 VGND VPWR sky130_fd_sc_hd__tapvpwrvgnd_1
XFILLER_219_1257 VPWR VGND VPWR VGND sky130_ef_sc_hd__decap_12
XFILLER_191_1449 VGND VGND VPWR VPWR sky130_fd_sc_hd__decap_6
XFILLER_76_27 VGND VGND VPWR VPWR sky130_fd_sc_hd__fill_1
XFILLER_154_1271 VPWR VGND VPWR VGND sky130_ef_sc_hd__decap_12
XFILLER_63_1165 VPWR VGND VPWR VGND sky130_ef_sc_hd__decap_12
XFILLER_246_301 VGND VGND VPWR VPWR sky130_fd_sc_hd__decap_6
XFILLER_189_1301 VPWR VGND VPWR VGND sky130_ef_sc_hd__decap_12
XFILLER_115_1255 VPWR VGND VPWR VGND sky130_ef_sc_hd__decap_12
XFILLER_246_345 VPWR VGND VPWR VGND sky130_ef_sc_hd__decap_12
XFILLER_219_559 VGND VGND VPWR VPWR sky130_fd_sc_hd__fill_1
XFILLER_41_1441 VGND VGND VPWR VPWR sky130_fd_sc_hd__fill_1
XFILLER_189_1345 VPWR VGND VPWR VGND sky130_ef_sc_hd__decap_12
XFILLER_98_1239 VGND VGND VPWR VPWR sky130_fd_sc_hd__decap_6
XFILLER_115_1299 VPWR VGND VPWR VGND sky130_ef_sc_hd__decap_12
XFILLER_206_209 VPWR VGND VPWR VGND sky130_ef_sc_hd__decap_12
XFILLER_246_389 VPWR VGND VPWR VGND sky130_ef_sc_hd__decap_12
XTAP_TAPCELL_ROW_133_1_1268 VGND VPWR sky130_fd_sc_hd__tapvpwrvgnd_1
XFILLER_92_15 VPWR VGND VPWR VGND sky130_ef_sc_hd__decap_12
XFILLER_215_721 VGND VGND VPWR VPWR sky130_fd_sc_hd__decap_6
X_400_ net590 net586 net563 VGND VGND VPWR VPWR _189_ sky130_fd_sc_hd__a21o_1
XFILLER_215_765 VPWR VGND VPWR VGND sky130_ef_sc_hd__decap_12
XFILLER_214_253 VPWR VGND VPWR VGND sky130_ef_sc_hd__decap_12
XFILLER_226_1217 VPWR VGND VPWR VGND sky130_ef_sc_hd__decap_12
XFILLER_230_713 VPWR VGND VPWR VGND sky130_ef_sc_hd__decap_12
XFILLER_155_3 VPWR VGND VPWR VGND sky130_ef_sc_hd__decap_12
X_331_ net498 _119_ VGND VGND VPWR VPWR _120_ sky130_fd_sc_hd__or2_1
XFILLER_187_617 VPWR VGND VPWR VGND sky130_ef_sc_hd__decap_12
XFILLER_35_1201 VPWR VGND VPWR VGND sky130_ef_sc_hd__decap_12
XTAP_TAPCELL_ROW_235_3221 VGND VPWR sky130_fd_sc_hd__tapvpwrvgnd_1
XFILLER_230_757 VPWR VGND VPWR VGND sky130_ef_sc_hd__decap_12
XTAP_TAPCELL_ROW_235_3232 VGND VPWR sky130_fd_sc_hd__tapvpwrvgnd_1
XTAP_TAPCELL_ROW_235_3243 VGND VPWR sky130_fd_sc_hd__tapvpwrvgnd_1
XFILLER_74_1283 VPWR VGND VPWR VGND sky130_ef_sc_hd__decap_12
XFILLER_161_1231 VPWR VGND VPWR VGND sky130_ef_sc_hd__decap_12
XFILLER_126_1351 VGND VGND VPWR VPWR sky130_fd_sc_hd__decap_6
XTAP_TAPCELL_ROW_124_2_4499 VGND VPWR sky130_fd_sc_hd__tapvpwrvgnd_1
XFILLER_35_1267 VGND VGND VPWR VPWR sky130_fd_sc_hd__decap_6
XFILLER_122_1215 VPWR VGND VPWR VGND sky130_ef_sc_hd__decap_12
XFILLER_126_1395 VPWR VGND VPWR VGND sky130_ef_sc_hd__decap_12
XFILLER_161_1275 VPWR VGND VPWR VGND sky130_ef_sc_hd__decap_12
XTAP_TAPCELL_ROW_231_3118 VGND VPWR sky130_fd_sc_hd__tapvpwrvgnd_1
XTAP_TAPCELL_ROW_231_3129 VGND VPWR sky130_fd_sc_hd__tapvpwrvgnd_1
XFILLER_167_385 VGND VGND VPWR VPWR sky130_fd_sc_hd__decap_6
XFILLER_122_1259 VPWR VGND VPWR VGND sky130_ef_sc_hd__decap_12
XFILLER_182_333 VPWR VGND VPWR VGND sky130_ef_sc_hd__decap_12
XFILLER_202_1261 VPWR VGND VPWR VGND sky130_ef_sc_hd__decap_12
XFILLER_183_889 VGND VGND VPWR VPWR sky130_fd_sc_hd__decap_6
XFILLER_237_1313 VPWR VGND VPWR VGND sky130_ef_sc_hd__decap_12
XFILLER_182_377 VPWR VGND VPWR VGND sky130_ef_sc_hd__decap_12
XFILLER_237_1357 VPWR VGND VPWR VGND sky130_ef_sc_hd__decap_12
XFILLER_194_1073 VPWR VGND VPWR VGND sky130_ef_sc_hd__decap_12
XTAP_TAPCELL_ROW_72_2_4186 VGND VPWR sky130_fd_sc_hd__tapvpwrvgnd_1
XTAP_TAPCELL_ROW_229_3058 VGND VPWR sky130_fd_sc_hd__tapvpwrvgnd_1
XTAP_TAPCELL_ROW_229_3069 VGND VPWR sky130_fd_sc_hd__tapvpwrvgnd_1
XFILLER_173_51 VGND VGND VPWR VPWR sky130_fd_sc_hd__decap_4
XFILLER_2_785 VGND VGND VPWR VPWR sky130_fd_sc_hd__fill_2
XFILLER_81_1243 VPWR VGND VPWR VGND sky130_ef_sc_hd__decap_12
XFILLER_133_1311 VPWR VGND VPWR VGND sky130_ef_sc_hd__decap_12
XFILLER_238_813 VPWR VGND VPWR VGND sky130_ef_sc_hd__decap_12
XPHY_EDGE_ROW_86_2_Right_177 VGND VGND VPWR VPWR sky130_fd_sc_hd__decap_3
XFILLER_172_1371 VGND VGND VPWR VPWR sky130_fd_sc_hd__fill_1
XFILLER_137_1491 VGND VGND VPWR VPWR sky130_fd_sc_hd__decap_6
XFILLER_249_161 VGND VGND VPWR VPWR sky130_fd_sc_hd__decap_6
XFILLER_42_1227 VPWR VGND VPWR VGND sky130_ef_sc_hd__decap_12
XFILLER_81_1287 VPWR VGND VPWR VGND sky130_ef_sc_hd__decap_12
XFILLER_133_1355 VPWR VGND VPWR VGND sky130_ef_sc_hd__decap_12
XFILLER_133_1399 VPWR VGND VPWR VGND sky130_ef_sc_hd__decap_12
XFILLER_225_529 VPWR VGND VPWR VGND sky130_ef_sc_hd__decap_12
XFILLER_168_1429 VPWR VGND VPWR VGND sky130_ef_sc_hd__decap_12
XFILLER_218_581 VGND VGND VPWR VPWR sky130_fd_sc_hd__decap_6
XTAP_TAPCELL_ROW_220_2822 VGND VPWR sky130_fd_sc_hd__tapvpwrvgnd_1
XFILLER_248_1453 VPWR VGND VPWR VGND sky130_ef_sc_hd__decap_12
XTAP_TAPCELL_ROW_220_2833 VGND VPWR sky130_fd_sc_hd__tapvpwrvgnd_1
XFILLER_244_1317 VPWR VGND VPWR VGND sky130_ef_sc_hd__decap_12
XFILLER_209_1437 VPWR VGND VPWR VGND sky130_ef_sc_hd__decap_12
XFILLER_248_1497 VPWR VGND VPWR VGND sky130_ef_sc_hd__decap_12
XFILLER_233_573 VPWR VGND VPWR VGND sky130_ef_sc_hd__decap_12
X_529_ net665 VGND VGND VPWR VPWR _011_ sky130_fd_sc_hd__inv_2
XFILLER_177_105 VGND VGND VPWR VPWR sky130_fd_sc_hd__decap_6
XFILLER_166_1197 VGND VGND VPWR VPWR sky130_fd_sc_hd__decap_6
XTAP_TAPCELL_ROW_197_2191 VGND VPWR sky130_fd_sc_hd__tapvpwrvgnd_1
XPHY_EDGE_ROW_244_Left_499 VGND VGND VPWR VPWR sky130_fd_sc_hd__decap_3
XFILLER_53_1323 VGND VGND VPWR VPWR sky130_fd_sc_hd__decap_6
XFILLER_220_245 VGND VGND VPWR VPWR sky130_fd_sc_hd__decap_6
XTAP_TAPCELL_ROW_30_2_3932 VGND VPWR sky130_fd_sc_hd__tapvpwrvgnd_1
XFILLER_92_1383 VPWR VGND VPWR VGND sky130_ef_sc_hd__decap_12
XFILLER_144_1451 VPWR VGND VPWR VGND sky130_ef_sc_hd__decap_12
XTAP_TAPCELL_ROW_29_2_3926 VGND VPWR sky130_fd_sc_hd__tapvpwrvgnd_1
XFILLER_177_149 VPWR VGND VPWR VGND sky130_ef_sc_hd__decap_12
XFILLER_193_609 VGND VGND VPWR VPWR sky130_fd_sc_hd__decap_6
XFILLER_53_1367 VPWR VGND VPWR VGND sky130_ef_sc_hd__decap_12
XFILLER_105_1435 VGND VGND VPWR VPWR sky130_fd_sc_hd__decap_6
XFILLER_140_1315 VPWR VGND VPWR VGND sky130_ef_sc_hd__decap_12
XFILLER_202_993 VPWR VGND VPWR VGND sky130_ef_sc_hd__decap_12
XFILLER_220_289 VPWR VGND VPWR VGND sky130_ef_sc_hd__decap_12
XFILLER_242_1085 VGND VGND VPWR VPWR sky130_fd_sc_hd__decap_6
XFILLER_144_1495 VPWR VGND VPWR VGND sky130_ef_sc_hd__decap_12
XTAP_TAPCELL_ROW_193_2088 VGND VPWR sky130_fd_sc_hd__tapvpwrvgnd_1
XTAP_TAPCELL_ROW_218_2762 VGND VPWR sky130_fd_sc_hd__tapvpwrvgnd_1
XTAP_TAPCELL_ROW_193_2099 VGND VPWR sky130_fd_sc_hd__tapvpwrvgnd_1
XTAP_TAPCELL_ROW_218_2773 VGND VPWR sky130_fd_sc_hd__tapvpwrvgnd_1
XFILLER_70_3 VPWR VGND VPWR VGND sky130_ef_sc_hd__decap_12
XTAP_TAPCELL_ROW_218_2784 VGND VPWR sky130_fd_sc_hd__tapvpwrvgnd_1
XFILLER_105_1479 VPWR VGND VPWR VGND sky130_ef_sc_hd__decap_12
XFILLER_140_1359 VPWR VGND VPWR VGND sky130_ef_sc_hd__decap_12
XFILLER_185_193 VPWR VGND VPWR VGND sky130_ef_sc_hd__decap_12
XFILLER_174_867 VGND VGND VPWR VPWR sky130_fd_sc_hd__fill_1
XTAP_TAPCELL_ROW_214_2659 VGND VPWR sky130_fd_sc_hd__tapvpwrvgnd_1
XFILLER_255_1413 VPWR VGND VPWR VGND sky130_ef_sc_hd__decap_12
XFILLER_86_1165 VPWR VGND VPWR VGND sky130_ef_sc_hd__decap_12
XFILLER_173_1113 VGND VGND VPWR VPWR sky130_fd_sc_hd__decap_6
XFILLER_217_55 VGND VGND VPWR VPWR sky130_fd_sc_hd__fill_1
XFILLER_255_1457 VPWR VGND VPWR VGND sky130_ef_sc_hd__decap_12
XTAP_TAPCELL_ROW_148_2_4640 VGND VPWR sky130_fd_sc_hd__tapvpwrvgnd_1
XFILLER_173_1157 VPWR VGND VPWR VGND sky130_ef_sc_hd__decap_12
XFILLER_64_1463 VGND VGND VPWR VPWR sky130_fd_sc_hd__decap_6
XFILLER_151_1411 VPWR VGND VPWR VGND sky130_ef_sc_hd__decap_12
XFILLER_228_301 VGND VGND VPWR VPWR sky130_fd_sc_hd__decap_6
XFILLER_60_1327 VPWR VGND VPWR VGND sky130_ef_sc_hd__decap_12
XFILLER_151_1455 VPWR VGND VPWR VGND sky130_ef_sc_hd__decap_12
XTAP_TAPCELL_ROW_161_2_4718 VGND VPWR sky130_fd_sc_hd__tapvpwrvgnd_1
XFILLER_228_345 VPWR VGND VPWR VGND sky130_ef_sc_hd__decap_12
XFILLER_244_805 VGND VGND VPWR VPWR sky130_fd_sc_hd__decap_6
XFILLER_210_1029 VGND VGND VPWR VPWR sky130_fd_sc_hd__decap_6
XFILLER_112_1439 VPWR VGND VPWR VGND sky130_ef_sc_hd__decap_12
XFILLER_255_153 VPWR VGND VPWR VGND sky130_ef_sc_hd__decap_12
XFILLER_151_1499 VPWR VGND VPWR VGND sky130_ef_sc_hd__decap_12
XFILLER_228_389 VPWR VGND VPWR VGND sky130_ef_sc_hd__decap_12
XFILLER_244_849 VPWR VGND VPWR VGND sky130_ef_sc_hd__decap_12
XPHY_EDGE_ROW_51_2_Left_553 VGND VGND VPWR VPWR sky130_fd_sc_hd__decap_3
XFILLER_255_197 VPWR VGND VPWR VGND sky130_ef_sc_hd__decap_12
XFILLER_243_337 VPWR VGND VPWR VGND sky130_ef_sc_hd__decap_12
XTAP_TAPCELL_ROW_182_1792 VGND VPWR sky130_fd_sc_hd__tapvpwrvgnd_1
XFILLER_3_1287 VGND VGND VPWR VPWR sky130_fd_sc_hd__fill_1
XFILLER_58_1245 VGND VGND VPWR VPWR sky130_fd_sc_hd__fill_1
XFILLER_184_1253 VGND VGND VPWR VPWR sky130_fd_sc_hd__decap_6
XFILLER_212_713 VPWR VGND VPWR VGND sky130_ef_sc_hd__decap_12
XFILLER_252_893 VPWR VGND VPWR VGND sky130_ef_sc_hd__decap_12
XFILLER_62_18 VGND VGND VPWR VPWR sky130_fd_sc_hd__decap_8
XFILLER_62_29 VPWR VGND VPWR VGND sky130_ef_sc_hd__decap_12
XFILLER_169_617 VPWR VGND VPWR VGND sky130_ef_sc_hd__decap_12
XFILLER_180_1117 VPWR VGND VPWR VGND sky130_ef_sc_hd__decap_12
XFILLER_211_223 VGND VGND VPWR VPWR sky130_fd_sc_hd__fill_1
XFILLER_184_1297 VPWR VGND VPWR VGND sky130_ef_sc_hd__decap_12
XFILLER_212_757 VPWR VGND VPWR VGND sky130_ef_sc_hd__decap_12
XFILLER_178_29 VPWR VGND VPWR VGND sky130_ef_sc_hd__decap_12
XFILLER_71_1423 VPWR VGND VPWR VGND sky130_ef_sc_hd__decap_12
XFILLER_196_469 VGND VGND VPWR VPWR sky130_fd_sc_hd__decap_6
XFILLER_32_1407 VGND VGND VPWR VPWR sky130_fd_sc_hd__decap_6
Xwire219 net220 VGND VGND VPWR VPWR net219 sky130_fd_sc_hd__clkbuf_1
XFILLER_71_1467 VPWR VGND VPWR VGND sky130_ef_sc_hd__decap_12
XFILLER_221_1169 VGND VGND VPWR VPWR sky130_fd_sc_hd__decap_6
XFILLER_178_1035 VGND VGND VPWR VPWR sky130_fd_sc_hd__fill_1
XPHY_EDGE_ROW_128_1_Left_383 VGND VGND VPWR VPWR sky130_fd_sc_hd__decap_3
XFILLER_11_55 VGND VGND VPWR VPWR sky130_fd_sc_hd__fill_1
XFILLER_180_837 VPWR VGND VPWR VGND sky130_ef_sc_hd__decap_12
XFILLER_219_1021 VPWR VGND VPWR VGND sky130_ef_sc_hd__decap_12
XFILLER_127_55 VGND VGND VPWR VPWR sky130_fd_sc_hd__fill_1
XFILLER_69_1385 VGND VGND VPWR VPWR sky130_fd_sc_hd__fill_1
XTAP_TAPCELL_ROW_57_2_4099 VGND VPWR sky130_fd_sc_hd__tapvpwrvgnd_1
XFILLER_191_1213 VPWR VGND VPWR VGND sky130_ef_sc_hd__decap_12
XFILLER_87_15 VPWR VGND VPWR VGND sky130_ef_sc_hd__decap_12
XFILLER_195_1393 VGND VGND VPWR VPWR sky130_fd_sc_hd__decap_6
XFILLER_219_1065 VPWR VGND VPWR VGND sky130_ef_sc_hd__decap_12
XPHY_EDGE_ROW_65_1_Left_320 VGND VGND VPWR VPWR sky130_fd_sc_hd__decap_3
XFILLER_191_1257 VPWR VGND VPWR VGND sky130_ef_sc_hd__decap_12
XTAP_TAPCELL_ROW_189_1979 VGND VPWR sky130_fd_sc_hd__tapvpwrvgnd_1
XFILLER_238_109 VPWR VGND VPWR VGND sky130_ef_sc_hd__decap_12
XFILLER_4_1029 VGND VGND VPWR VPWR sky130_fd_sc_hd__decap_6
XFILLER_247_665 VGND VGND VPWR VPWR sky130_fd_sc_hd__decap_6
XTAP_TAPCELL_ROW_5_1002 VGND VPWR sky130_fd_sc_hd__tapvpwrvgnd_1
XFILLER_246_153 VPWR VGND VPWR VGND sky130_ef_sc_hd__decap_12
XFILLER_207_529 VPWR VGND VPWR VGND sky130_ef_sc_hd__decap_12
XFILLER_189_1175 VGND VGND VPWR VPWR sky130_fd_sc_hd__fill_1
XFILLER_246_197 VPWR VGND VPWR VGND sky130_ef_sc_hd__decap_12
XFILLER_36_41 VGND VGND VPWR VPWR sky130_fd_sc_hd__fill_1
XFILLER_76_1301 VGND VGND VPWR VPWR sky130_fd_sc_hd__fill_1
XTAP_TAPCELL_ROW_67_1_1202 VGND VPWR sky130_fd_sc_hd__tapvpwrvgnd_1
XFILLER_128_1413 VGND VGND VPWR VPWR sky130_fd_sc_hd__fill_1
XFILLER_215_573 VPWR VGND VPWR VGND sky130_ef_sc_hd__decap_12
XFILLER_37_1329 VGND VGND VPWR VPWR sky130_fd_sc_hd__fill_1
XFILLER_188_937 VPWR VGND VPWR VGND sky130_ef_sc_hd__decap_12
XTAP_TAPCELL_ROW_15_2_3845 VGND VPWR sky130_fd_sc_hd__tapvpwrvgnd_1
X_314_ net177 VGND VGND VPWR VPWR _103_ sky130_fd_sc_hd__inv_2
XFILLER_187_447 VGND VGND VPWR VPWR sky130_fd_sc_hd__fill_1
XFILLER_202_245 VGND VGND VPWR VPWR sky130_fd_sc_hd__decap_6
XFILLER_175_609 VGND VGND VPWR VPWR sky130_fd_sc_hd__decap_6
XFILLER_230_587 VGND VGND VPWR VPWR sky130_fd_sc_hd__fill_1
XFILLER_50_1507 VGND VGND VPWR VPWR sky130_fd_sc_hd__decap_8
XFILLER_202_289 VPWR VGND VPWR VGND sky130_ef_sc_hd__decap_12
XFILLER_196_981 VPWR VGND VPWR VGND sky130_ef_sc_hd__decap_12
Xinput16 wr_data[15] VGND VGND VPWR VPWR net16 sky130_fd_sc_hd__clkbuf_1
XFILLER_7_833 VGND VGND VPWR VPWR sky130_fd_sc_hd__decap_6
Xinput27 wr_data[25] VGND VGND VPWR VPWR net27 sky130_fd_sc_hd__clkbuf_1
XFILLER_7_844 VPWR VGND VPWR VGND sky130_ef_sc_hd__decap_12
Xinput38 wr_data[6] VGND VGND VPWR VPWR net38 sky130_fd_sc_hd__clkbuf_1
XFILLER_167_193 VPWR VGND VPWR VGND sky130_ef_sc_hd__decap_12
XFILLER_6_332 VGND VGND VPWR VPWR sky130_fd_sc_hd__decap_4
XFILLER_183_653 VPWR VGND VPWR VGND sky130_ef_sc_hd__decap_12
XFILLER_182_141 VPWR VGND VPWR VGND sky130_ef_sc_hd__decap_12
Xmax_cap508 _096_ VGND VGND VPWR VPWR net508 sky130_fd_sc_hd__clkbuf_1
Xmax_cap519 net520 VGND VGND VPWR VPWR net519 sky130_fd_sc_hd__clkbuf_1
XFILLER_6_365 VGND VGND VPWR VPWR sky130_fd_sc_hd__fill_2
XFILLER_202_1091 VGND VGND VPWR VPWR sky130_fd_sc_hd__fill_1
XFILLER_87_1441 VGND VGND VPWR VPWR sky130_fd_sc_hd__fill_1
XFILLER_183_697 VPWR VGND VPWR VGND sky130_ef_sc_hd__decap_12
XFILLER_237_1121 VPWR VGND VPWR VGND sky130_ef_sc_hd__decap_12
XFILLER_184_83 VGND VGND VPWR VPWR sky130_fd_sc_hd__fill_1
XFILLER_233_1007 VGND VGND VPWR VPWR sky130_fd_sc_hd__fill_1
XFILLER_48_1469 VGND VGND VPWR VPWR sky130_fd_sc_hd__fill_1
XFILLER_174_1477 VGND VGND VPWR VPWR sky130_fd_sc_hd__decap_6
XFILLER_250_1365 VGND VGND VPWR VPWR sky130_fd_sc_hd__decap_6
XFILLER_238_643 VGND VGND VPWR VPWR sky130_fd_sc_hd__fill_1
XPHY_EDGE_ROW_87_2_Right_178 VGND VGND VPWR VPWR sky130_fd_sc_hd__decap_3
XFILLER_226_805 VGND VGND VPWR VPWR sky130_fd_sc_hd__decap_6
XTAP_TAPCELL_ROW_207_2463 VGND VPWR sky130_fd_sc_hd__tapvpwrvgnd_1
XTAP_TAPCELL_ROW_207_2474 VGND VPWR sky130_fd_sc_hd__tapvpwrvgnd_1
XTAP_TAPCELL_ROW_207_2485 VGND VPWR sky130_fd_sc_hd__tapvpwrvgnd_1
XFILLER_226_849 VPWR VGND VPWR VGND sky130_ef_sc_hd__decap_12
XFILLER_203_57 VPWR VGND VPWR VGND sky130_ef_sc_hd__decap_12
XFILLER_225_337 VPWR VGND VPWR VGND sky130_ef_sc_hd__decap_12
XFILLER_168_1259 VGND VGND VPWR VPWR sky130_fd_sc_hd__fill_1
XTAP_TAPCELL_ROW_199_2253 VGND VPWR sky130_fd_sc_hd__tapvpwrvgnd_1
XFILLER_209_1201 VPWR VGND VPWR VGND sky130_ef_sc_hd__decap_12
XFILLER_248_1261 VPWR VGND VPWR VGND sky130_ef_sc_hd__decap_12
XFILLER_240_307 VGND VGND VPWR VPWR sky130_fd_sc_hd__fill_1
XTAP_TAPCELL_ROW_199_2264 VGND VPWR sky130_fd_sc_hd__tapvpwrvgnd_1
XPHY_EDGE_ROW_252_Left_507 VGND VGND VPWR VPWR sky130_fd_sc_hd__decap_3
XFILLER_252_189 VGND VGND VPWR VPWR sky130_fd_sc_hd__decap_6
XFILLER_234_893 VPWR VGND VPWR VGND sky130_ef_sc_hd__decap_12
XTAP_TAPCELL_ROW_94_2_4318 VGND VPWR sky130_fd_sc_hd__tapvpwrvgnd_1
XFILLER_209_1245 VPWR VGND VPWR VGND sky130_ef_sc_hd__decap_12
XTAP_TAPCELL_ROW_195_2139 VGND VPWR sky130_fd_sc_hd__tapvpwrvgnd_1
XFILLER_244_1147 VGND VGND VPWR VPWR sky130_fd_sc_hd__fill_1
XFILLER_181_1437 VPWR VGND VPWR VGND sky130_ef_sc_hd__decap_12
XFILLER_209_1289 VPWR VGND VPWR VGND sky130_ef_sc_hd__decap_12
XFILLER_178_469 VGND VGND VPWR VPWR sky130_fd_sc_hd__decap_6
XFILLER_92_1191 VPWR VGND VPWR VGND sky130_ef_sc_hd__decap_12
XFILLER_193_417 VPWR VGND VPWR VGND sky130_ef_sc_hd__decap_12
XFILLER_18_1295 VGND VGND VPWR VPWR sky130_fd_sc_hd__decap_6
XFILLER_105_1243 VPWR VGND VPWR VGND sky130_ef_sc_hd__decap_12
XFILLER_9_181 VGND VGND VPWR VPWR sky130_fd_sc_hd__decap_6
XFILLER_88_1227 VPWR VGND VPWR VGND sky130_ef_sc_hd__decap_12
XFILLER_105_1287 VPWR VGND VPWR VGND sky130_ef_sc_hd__decap_12
XFILLER_140_1189 VGND VGND VPWR VPWR sky130_fd_sc_hd__fill_1
XFILLER_228_65 VPWR VGND VPWR VGND sky130_ef_sc_hd__decap_12
XFILLER_179_1399 VGND VGND VPWR VPWR sky130_fd_sc_hd__fill_1
XTAP_TAPCELL_ROW_171_1493 VGND VPWR sky130_fd_sc_hd__tapvpwrvgnd_1
XFILLER_216_1205 VPWR VGND VPWR VGND sky130_ef_sc_hd__decap_12
XFILLER_170_881 VPWR VGND VPWR VGND sky130_ef_sc_hd__decap_12
XFILLER_244_53 VPWR VGND VPWR VGND sky130_ef_sc_hd__decap_12
XFILLER_9_1441 VPWR VGND VPWR VGND sky130_ef_sc_hd__decap_12
XFILLER_64_1271 VPWR VGND VPWR VGND sky130_ef_sc_hd__decap_12
XFILLER_244_97 VPWR VGND VPWR VGND sky130_ef_sc_hd__decap_12
XFILLER_25_1255 VPWR VGND VPWR VGND sky130_ef_sc_hd__decap_12
XFILLER_9_1485 VPWR VGND VPWR VGND sky130_ef_sc_hd__decap_12
XFILLER_112_1203 VPWR VGND VPWR VGND sky130_ef_sc_hd__decap_12
XTAP_TAPCELL_ROW_184_1843 VGND VPWR sky130_fd_sc_hd__tapvpwrvgnd_1
XFILLER_99_1323 VGND VGND VPWR VPWR sky130_fd_sc_hd__decap_6
XFILLER_116_1383 VPWR VGND VPWR VGND sky130_ef_sc_hd__decap_12
XTAP_TAPCELL_ROW_184_1854 VGND VPWR sky130_fd_sc_hd__tapvpwrvgnd_1
XFILLER_229_665 VGND VGND VPWR VPWR sky130_fd_sc_hd__decap_6
XTAP_TAPCELL_ROW_184_1865 VGND VPWR sky130_fd_sc_hd__tapvpwrvgnd_1
XFILLER_228_153 VPWR VGND VPWR VGND sky130_ef_sc_hd__decap_12
XFILLER_244_613 VPWR VGND VPWR VGND sky130_ef_sc_hd__decap_12
XFILLER_25_1299 VPWR VGND VPWR VGND sky130_ef_sc_hd__decap_12
XFILLER_112_1247 VPWR VGND VPWR VGND sky130_ef_sc_hd__decap_12
XFILLER_99_1367 VPWR VGND VPWR VGND sky130_ef_sc_hd__decap_12
XFILLER_186_1315 VGND VGND VPWR VPWR sky130_fd_sc_hd__fill_1
XFILLER_113_57 VPWR VGND VPWR VGND sky130_ef_sc_hd__decap_12
XFILLER_228_197 VPWR VGND VPWR VGND sky130_ef_sc_hd__decap_12
XFILLER_244_657 VPWR VGND VPWR VGND sky130_ef_sc_hd__decap_12
XFILLER_73_39 VPWR VGND VPWR VGND sky130_ef_sc_hd__decap_12
XFILLER_227_1301 VPWR VGND VPWR VGND sky130_ef_sc_hd__decap_12
XFILLER_243_167 VGND VGND VPWR VPWR sky130_fd_sc_hd__fill_1
XFILLER_189_39 VPWR VGND VPWR VGND sky130_ef_sc_hd__decap_12
XFILLER_231_329 VGND VGND VPWR VPWR sky130_fd_sc_hd__decap_6
XFILLER_227_1345 VPWR VGND VPWR VGND sky130_ef_sc_hd__decap_12
Xwire95 _229_ VGND VGND VPWR VPWR net95 sky130_fd_sc_hd__clkbuf_1
XFILLER_184_1061 VPWR VGND VPWR VGND sky130_ef_sc_hd__decap_12
XPHY_EDGE_ROW_49_2_Right_140 VGND VGND VPWR VPWR sky130_fd_sc_hd__decap_3
XFILLER_169_447 VGND VGND VPWR VPWR sky130_fd_sc_hd__fill_1
XFILLER_196_233 VPWR VGND VPWR VGND sky130_ef_sc_hd__decap_12
XFILLER_36_1351 VGND VGND VPWR VPWR sky130_fd_sc_hd__decap_6
XFILLER_71_1231 VPWR VGND VPWR VGND sky130_ef_sc_hd__decap_12
XFILLER_212_587 VGND VGND VPWR VPWR sky130_fd_sc_hd__fill_1
XTAP_TAPCELL_ROW_128_1_1263 VGND VPWR sky130_fd_sc_hd__tapvpwrvgnd_1
XFILLER_178_981 VPWR VGND VPWR VGND sky130_ef_sc_hd__decap_12
XFILLER_196_277 VPWR VGND VPWR VGND sky130_ef_sc_hd__decap_12
XFILLER_200_749 VGND VGND VPWR VPWR sky130_fd_sc_hd__decap_6
XFILLER_32_1215 VPWR VGND VPWR VGND sky130_ef_sc_hd__decap_12
XFILLER_71_1275 VPWR VGND VPWR VGND sky130_ef_sc_hd__decap_12
XFILLER_36_1395 VPWR VGND VPWR VGND sky130_ef_sc_hd__decap_12
XFILLER_123_1343 VPWR VGND VPWR VGND sky130_ef_sc_hd__decap_12
XFILLER_193_951 VGND VGND VPWR VPWR sky130_fd_sc_hd__fill_1
XFILLER_32_1259 VPWR VGND VPWR VGND sky130_ef_sc_hd__decap_12
XFILLER_123_1387 VPWR VGND VPWR VGND sky130_ef_sc_hd__decap_12
XFILLER_180_601 VPWR VGND VPWR VGND sky130_ef_sc_hd__decap_12
XFILLER_197_1455 VGND VGND VPWR VPWR sky130_fd_sc_hd__fill_1
XFILLER_118_3 VPWR VGND VPWR VGND sky130_ef_sc_hd__decap_12
XFILLER_138_65 VGND VGND VPWR VPWR sky130_fd_sc_hd__decap_6
XFILLER_165_697 VGND VGND VPWR VPWR sky130_fd_sc_hd__decap_3
XFILLER_3_313 VPWR VGND VPWR VGND sky130_ef_sc_hd__decap_12
XFILLER_158_1439 VPWR VGND VPWR VGND sky130_ef_sc_hd__decap_12
XFILLER_180_645 VPWR VGND VPWR VGND sky130_ef_sc_hd__decap_12
XFILLER_238_1441 VPWR VGND VPWR VGND sky130_ef_sc_hd__decap_12
XFILLER_191_1021 VPWR VGND VPWR VGND sky130_ef_sc_hd__decap_12
XFILLER_238_1485 VPWR VGND VPWR VGND sky130_ef_sc_hd__decap_12
XFILLER_154_53 VPWR VGND VPWR VGND sky130_ef_sc_hd__decap_12
XFILLER_191_1065 VPWR VGND VPWR VGND sky130_ef_sc_hd__decap_12
XFILLER_239_429 VPWR VGND VPWR VGND sky130_ef_sc_hd__decap_12
XFILLER_43_1311 VPWR VGND VPWR VGND sky130_ef_sc_hd__decap_12
XFILLER_47_1491 VGND VGND VPWR VPWR sky130_fd_sc_hd__decap_6
XFILLER_82_1371 VPWR VGND VPWR VGND sky130_ef_sc_hd__decap_12
XFILLER_43_1355 VPWR VGND VPWR VGND sky130_ef_sc_hd__decap_12
XFILLER_130_1303 VPWR VGND VPWR VGND sky130_ef_sc_hd__decap_12
XFILLER_208_805 VGND VGND VPWR VPWR sky130_fd_sc_hd__decap_6
XFILLER_232_1073 VPWR VGND VPWR VGND sky130_ef_sc_hd__decap_12
XFILLER_134_1483 VPWR VGND VPWR VGND sky130_ef_sc_hd__decap_12
XFILLER_47_51 VGND VGND VPWR VPWR sky130_fd_sc_hd__decap_4
XFILLER_247_473 VPWR VGND VPWR VGND sky130_ef_sc_hd__decap_12
XTAP_TAPCELL_ROW_112_2_4426 VGND VPWR sky130_fd_sc_hd__tapvpwrvgnd_1
XFILLER_169_1513 VGND VGND VPWR VPWR sky130_fd_sc_hd__fill_2
XFILLER_43_1399 VPWR VGND VPWR VGND sky130_ef_sc_hd__decap_12
XFILLER_78_1407 VGND VGND VPWR VPWR sky130_fd_sc_hd__decap_6
XFILLER_170_41 VPWR VGND VPWR VGND sky130_ef_sc_hd__decap_12
XFILLER_208_849 VPWR VGND VPWR VGND sky130_ef_sc_hd__decap_12
XFILLER_207_337 VPWR VGND VPWR VGND sky130_ef_sc_hd__decap_12
XFILLER_210_1371 VGND VGND VPWR VPWR sky130_fd_sc_hd__fill_1
XFILLER_170_85 VPWR VGND VPWR VGND sky130_ef_sc_hd__decap_12
XFILLER_245_1401 VPWR VGND VPWR VGND sky130_ef_sc_hd__decap_12
XTAP_TAPCELL_ROW_80_2_4237 VGND VPWR sky130_fd_sc_hd__tapvpwrvgnd_1
XFILLER_222_307 VGND VGND VPWR VPWR sky130_fd_sc_hd__fill_1
XFILLER_188_701 VPWR VGND VPWR VGND sky130_ef_sc_hd__decap_12
XFILLER_234_189 VGND VGND VPWR VPWR sky130_fd_sc_hd__decap_6
XFILLER_216_893 VPWR VGND VPWR VGND sky130_ef_sc_hd__decap_12
XFILLER_167_1281 VGND VGND VPWR VPWR sky130_fd_sc_hd__decap_6
XFILLER_231_841 VPWR VGND VPWR VGND sky130_ef_sc_hd__decap_12
XFILLER_206_1429 VPWR VGND VPWR VGND sky130_ef_sc_hd__decap_12
XTAP_TAPCELL_ROW_60_2_4113 VGND VPWR sky130_fd_sc_hd__tapvpwrvgnd_1
XFILLER_54_1451 VPWR VGND VPWR VGND sky130_ef_sc_hd__decap_12
XTAP_TAPCELL_ROW_59_2_4107 VGND VPWR sky130_fd_sc_hd__tapvpwrvgnd_1
XFILLER_163_1189 VPWR VGND VPWR VGND sky130_ef_sc_hd__decap_12
XFILLER_175_417 VPWR VGND VPWR VGND sky130_ef_sc_hd__decap_12
XTAP_TAPCELL_ROW_190_2003 VGND VPWR sky130_fd_sc_hd__tapvpwrvgnd_1
XTAP_TAPCELL_ROW_190_2014 VGND VPWR sky130_fd_sc_hd__tapvpwrvgnd_1
XFILLER_50_1315 VPWR VGND VPWR VGND sky130_ef_sc_hd__decap_12
XFILLER_15_1435 VGND VGND VPWR VPWR sky130_fd_sc_hd__decap_6
XTAP_TAPCELL_ROW_190_2025 VGND VPWR sky130_fd_sc_hd__tapvpwrvgnd_1
XFILLER_54_1495 VPWR VGND VPWR VGND sky130_ef_sc_hd__decap_12
XFILLER_141_1443 VPWR VGND VPWR VGND sky130_ef_sc_hd__decap_12
XFILLER_200_1017 VPWR VGND VPWR VGND sky130_ef_sc_hd__decap_12
XFILLER_50_1359 VPWR VGND VPWR VGND sky130_ef_sc_hd__decap_12
XFILLER_15_1479 VPWR VGND VPWR VGND sky130_ef_sc_hd__decap_12
XFILLER_102_1427 VPWR VGND VPWR VGND sky130_ef_sc_hd__decap_12
XFILLER_184_973 VGND VGND VPWR VPWR sky130_fd_sc_hd__decap_6
XFILLER_204_1197 VGND VGND VPWR VPWR sky130_fd_sc_hd__decap_6
Xwire572 dout0_q\[13\] VGND VGND VPWR VPWR net572 sky130_fd_sc_hd__clkbuf_1
XFILLER_183_461 VPWR VGND VPWR VGND sky130_ef_sc_hd__decap_12
Xwire583 dout0_q\[5\] VGND VGND VPWR VPWR net583 sky130_fd_sc_hd__clkbuf_1
Xmax_cap327 net328 VGND VGND VPWR VPWR net327 sky130_fd_sc_hd__clkbuf_1
XFILLER_195_93 VPWR VGND VPWR VGND sky130_ef_sc_hd__decap_12
XFILLER_6_184 VGND VGND VPWR VPWR sky130_fd_sc_hd__decap_8
XFILLER_170_133 VGND VGND VPWR VPWR sky130_fd_sc_hd__decap_6
XFILLER_174_1241 VPWR VGND VPWR VGND sky130_ef_sc_hd__decap_12
XFILLER_252_1427 VGND VGND VPWR VPWR sky130_fd_sc_hd__fill_1
XFILLER_170_177 VPWR VGND VPWR VGND sky130_ef_sc_hd__decap_12
XFILLER_170_1105 VPWR VGND VPWR VGND sky130_ef_sc_hd__decap_12
XFILLER_33_3 VPWR VGND VPWR VGND sky130_ef_sc_hd__decap_12
XFILLER_174_1285 VPWR VGND VPWR VGND sky130_ef_sc_hd__decap_12
XFILLER_61_1411 VPWR VGND VPWR VGND sky130_ef_sc_hd__decap_12
XTAP_TAPCELL_ROW_209_2525 VGND VPWR sky130_fd_sc_hd__tapvpwrvgnd_1
XFILLER_170_1149 VPWR VGND VPWR VGND sky130_ef_sc_hd__decap_12
XTAP_TAPCELL_ROW_209_2536 VGND VPWR sky130_fd_sc_hd__tapvpwrvgnd_1
XFILLER_61_1455 VPWR VGND VPWR VGND sky130_ef_sc_hd__decap_12
XFILLER_211_1113 VGND VGND VPWR VPWR sky130_fd_sc_hd__decap_6
XFILLER_250_1173 VPWR VGND VPWR VGND sky130_ef_sc_hd__decap_12
XPHY_EDGE_ROW_88_2_Right_179 VGND VGND VPWR VPWR sky130_fd_sc_hd__decap_3
XFILLER_226_613 VPWR VGND VPWR VGND sky130_ef_sc_hd__decap_12
XFILLER_22_1439 VPWR VGND VPWR VGND sky130_ef_sc_hd__decap_12
XFILLER_61_1499 VPWR VGND VPWR VGND sky130_ef_sc_hd__decap_12
XFILLER_96_1507 VGND VGND VPWR VPWR sky130_fd_sc_hd__decap_8
XFILLER_211_1157 VPWR VGND VPWR VGND sky130_ef_sc_hd__decap_12
XFILLER_226_657 VPWR VGND VPWR VGND sky130_ef_sc_hd__decap_12
XFILLER_4_1371 VGND VGND VPWR VPWR sky130_fd_sc_hd__fill_1
XFILLER_225_167 VGND VGND VPWR VPWR sky130_fd_sc_hd__fill_1
XFILLER_0_1257 VGND VGND VPWR VPWR sky130_fd_sc_hd__decap_3
XFILLER_213_329 VGND VGND VPWR VPWR sky130_fd_sc_hd__decap_6
XFILLER_181_1201 VPWR VGND VPWR VGND sky130_ef_sc_hd__decap_12
XFILLER_248_1091 VGND VGND VPWR VPWR sky130_fd_sc_hd__fill_1
XFILLER_185_1381 VPWR VGND VPWR VGND sky130_ef_sc_hd__decap_12
XFILLER_230_77 VGND VGND VPWR VPWR sky130_fd_sc_hd__decap_6
XFILLER_178_233 VPWR VGND VPWR VGND sky130_ef_sc_hd__decap_12
XFILLER_181_1245 VPWR VGND VPWR VGND sky130_ef_sc_hd__decap_12
XFILLER_221_373 VPWR VGND VPWR VGND sky130_ef_sc_hd__decap_12
XFILLER_178_277 VPWR VGND VPWR VGND sky130_ef_sc_hd__decap_12
XFILLER_181_1289 VPWR VGND VPWR VGND sky130_ef_sc_hd__decap_12
XFILLER_194_737 VPWR VGND VPWR VGND sky130_ef_sc_hd__decap_12
XFILLER_193_225 VPWR VGND VPWR VGND sky130_ef_sc_hd__decap_12
XFILLER_222_1253 VGND VGND VPWR VPWR sky130_fd_sc_hd__decap_6
XFILLER_175_951 VGND VGND VPWR VPWR sky130_fd_sc_hd__fill_1
XTAP_TAPCELL_ROW_173_1544 VGND VPWR sky130_fd_sc_hd__tapvpwrvgnd_1
XTAP_TAPCELL_ROW_173_1555 VGND VPWR sky130_fd_sc_hd__tapvpwrvgnd_1
XFILLER_222_1297 VPWR VGND VPWR VGND sky130_ef_sc_hd__decap_12
XTAP_TAPCELL_ROW_173_1566 VGND VPWR sky130_fd_sc_hd__tapvpwrvgnd_1
XFILLER_255_41 VPWR VGND VPWR VGND sky130_ef_sc_hd__decap_12
XTAP_TAPCELL_ROW_73_2_4191 VGND VPWR sky130_fd_sc_hd__tapvpwrvgnd_1
XFILLER_192_1341 VPWR VGND VPWR VGND sky130_ef_sc_hd__decap_12
XFILLER_255_85 VPWR VGND VPWR VGND sky130_ef_sc_hd__decap_12
XTAP_TAPCELL_ROW_186_1905 VGND VPWR sky130_fd_sc_hd__tapvpwrvgnd_1
XFILLER_216_1035 VGND VGND VPWR VPWR sky130_fd_sc_hd__fill_1
XFILLER_249_727 VGND VGND VPWR VPWR sky130_fd_sc_hd__fill_1
XTAP_TAPCELL_ROW_186_1916 VGND VPWR sky130_fd_sc_hd__tapvpwrvgnd_1
XFILLER_192_1385 VPWR VGND VPWR VGND sky130_ef_sc_hd__decap_12
XFILLER_5_1113 VGND VGND VPWR VPWR sky130_fd_sc_hd__decap_6
XFILLER_233_1393 VGND VGND VPWR VPWR sky130_fd_sc_hd__decap_6
XFILLER_84_27 VGND VGND VPWR VPWR sky130_fd_sc_hd__fill_1
XFILLER_116_1191 VPWR VGND VPWR VGND sky130_ef_sc_hd__decap_12
XFILLER_229_473 VPWR VGND VPWR VGND sky130_ef_sc_hd__decap_12
XFILLER_245_933 VPWR VGND VPWR VGND sky130_ef_sc_hd__decap_12
XFILLER_5_1157 VPWR VGND VPWR VGND sky130_ef_sc_hd__decap_12
XFILLER_244_421 VPWR VGND VPWR VGND sky130_ef_sc_hd__decap_12
XFILLER_245_977 VPWR VGND VPWR VGND sky130_ef_sc_hd__decap_12
XFILLER_204_307 VGND VGND VPWR VPWR sky130_fd_sc_hd__fill_1
XTAP_TAPCELL_ROW_0_850 VGND VPWR sky130_fd_sc_hd__tapvpwrvgnd_1
XTAP_TAPCELL_ROW_0_861 VGND VPWR sky130_fd_sc_hd__tapvpwrvgnd_1
XFILLER_216_189 VGND VGND VPWR VPWR sky130_fd_sc_hd__decap_6
XFILLER_38_1413 VGND VGND VPWR VPWR sky130_fd_sc_hd__fill_1
XTAP_TAPCELL_ROW_0_872 VGND VPWR sky130_fd_sc_hd__tapvpwrvgnd_1
XFILLER_213_841 VPWR VGND VPWR VGND sky130_ef_sc_hd__decap_12
XFILLER_231_137 VPWR VGND VPWR VGND sky130_ef_sc_hd__decap_12
XPHY_EDGE_ROW_14_2_Left_516 VGND VGND VPWR VPWR sky130_fd_sc_hd__decap_3
XTAP_TAPCELL_ROW_45_2_4026 VGND VPWR sky130_fd_sc_hd__tapvpwrvgnd_1
XFILLER_197_553 VGND VGND VPWR VPWR sky130_fd_sc_hd__decap_6
XFILLER_227_1175 VGND VGND VPWR VPWR sky130_fd_sc_hd__fill_1
XFILLER_200_513 VPWR VGND VPWR VGND sky130_ef_sc_hd__decap_12
XTAP_TAPCELL_ROW_255_3780 VGND VPWR sky130_fd_sc_hd__tapvpwrvgnd_1
XFILLER_235_3 VPWR VGND VPWR VGND sky130_ef_sc_hd__decap_12
XFILLER_240_693 VGND VGND VPWR VPWR sky130_fd_sc_hd__decap_6
XFILLER_33_53 VGND VGND VPWR VPWR sky130_fd_sc_hd__decap_3
XTAP_TAPCELL_ROW_255_3791 VGND VPWR sky130_fd_sc_hd__tapvpwrvgnd_1
XFILLER_197_597 VPWR VGND VPWR VGND sky130_ef_sc_hd__decap_12
XPHY_EDGE_ROW_139_2_Left_641 VGND VGND VPWR VPWR sky130_fd_sc_hd__decap_3
XFILLER_200_557 VPWR VGND VPWR VGND sky130_ef_sc_hd__decap_12
XTAP_TAPCELL_ROW_251_3655 VGND VPWR sky130_fd_sc_hd__tapvpwrvgnd_1
XFILLER_240_1353 VPWR VGND VPWR VGND sky130_ef_sc_hd__decap_12
XTAP_TAPCELL_ROW_251_3666 VGND VPWR sky130_fd_sc_hd__tapvpwrvgnd_1
XFILLER_201_1337 VGND VGND VPWR VPWR sky130_fd_sc_hd__decap_6
XFILLER_166_973 VGND VGND VPWR VPWR sky130_fd_sc_hd__decap_6
XFILLER_240_1397 VPWR VGND VPWR VGND sky130_ef_sc_hd__decap_12
XFILLER_165_461 VPWR VGND VPWR VGND sky130_ef_sc_hd__decap_12
XFILLER_158_1203 VPWR VGND VPWR VGND sky130_ef_sc_hd__decap_12
XFILLER_181_921 VPWR VGND VPWR VGND sky130_ef_sc_hd__decap_12
XFILLER_4_611 VGND VGND VPWR VPWR sky130_fd_sc_hd__fill_2
XFILLER_158_1247 VPWR VGND VPWR VGND sky130_ef_sc_hd__decap_12
XFILLER_181_965 VPWR VGND VPWR VGND sky130_ef_sc_hd__decap_12
XFILLER_165_41 VPWR VGND VPWR VGND sky130_ef_sc_hd__decap_12
XFILLER_180_475 VGND VGND VPWR VPWR sky130_fd_sc_hd__fill_1
XFILLER_165_85 VPWR VGND VPWR VGND sky130_ef_sc_hd__decap_12
XFILLER_4_699 VGND VGND VPWR VPWR sky130_fd_sc_hd__fill_1
XTAP_TAPCELL_ROW_249_3595 VGND VPWR sky130_fd_sc_hd__tapvpwrvgnd_1
XFILLER_171_1425 VPWR VGND VPWR VGND sky130_ef_sc_hd__decap_12
XFILLER_239_237 VPWR VGND VPWR VGND sky130_ef_sc_hd__decap_12
XFILLER_0_861 VGND VGND VPWR VPWR sky130_fd_sc_hd__decap_6
XFILLER_171_1469 VPWR VGND VPWR VGND sky130_ef_sc_hd__decap_12
XFILLER_181_51 VGND VGND VPWR VPWR sky130_fd_sc_hd__decap_4
XFILLER_0_894 VGND VGND VPWR VPWR sky130_fd_sc_hd__fill_2
XFILLER_251_1493 VPWR VGND VPWR VGND sky130_ef_sc_hd__decap_12
XFILLER_208_613 VPWR VGND VPWR VGND sky130_ef_sc_hd__decap_12
XFILLER_248_793 VPWR VGND VPWR VGND sky130_ef_sc_hd__decap_12
XTAP_TAPCELL_ROW_204_2400 VGND VPWR sky130_fd_sc_hd__tapvpwrvgnd_1
XFILLER_212_1477 VGND VGND VPWR VPWR sky130_fd_sc_hd__decap_6
XFILLER_247_281 VPWR VGND VPWR VGND sky130_ef_sc_hd__decap_12
XFILLER_78_1215 VPWR VGND VPWR VGND sky130_ef_sc_hd__decap_12
XFILLER_1_1511 VGND VGND VPWR VPWR sky130_fd_sc_hd__fill_1
XFILLER_208_657 VPWR VGND VPWR VGND sky130_ef_sc_hd__decap_12
XFILLER_130_1177 VPWR VGND VPWR VGND sky130_ef_sc_hd__decap_12
XFILLER_169_1343 VGND VGND VPWR VPWR sky130_fd_sc_hd__fill_1
XFILLER_78_1259 VPWR VGND VPWR VGND sky130_ef_sc_hd__decap_12
XFILLER_207_167 VGND VGND VPWR VPWR sky130_fd_sc_hd__fill_1
XFILLER_250_413 VGND VGND VPWR VPWR sky130_fd_sc_hd__decap_6
XFILLER_165_1229 VGND VGND VPWR VPWR sky130_fd_sc_hd__decap_3
XFILLER_245_1231 VGND VGND VPWR VPWR sky130_fd_sc_hd__fill_1
XFILLER_250_457 VPWR VGND VPWR VGND sky130_ef_sc_hd__decap_12
XFILLER_188_531 VGND VGND VPWR VPWR sky130_fd_sc_hd__fill_1
XFILLER_231_671 VGND VGND VPWR VPWR sky130_fd_sc_hd__fill_1
XFILLER_203_373 VPWR VGND VPWR VGND sky130_ef_sc_hd__decap_12
XFILLER_206_1259 VGND VGND VPWR VPWR sky130_fd_sc_hd__fill_1
XFILLER_176_737 VPWR VGND VPWR VGND sky130_ef_sc_hd__decap_12
XFILLER_175_225 VPWR VGND VPWR VGND sky130_ef_sc_hd__decap_12
XFILLER_198_1005 VPWR VGND VPWR VGND sky130_ef_sc_hd__decap_12
XFILLER_15_1243 VPWR VGND VPWR VGND sky130_ef_sc_hd__decap_12
XFILLER_89_1311 VPWR VGND VPWR VGND sky130_ef_sc_hd__decap_12
XFILLER_106_1371 VPWR VGND VPWR VGND sky130_ef_sc_hd__decap_12
XFILLER_8_961 VPWR VGND VPWR VGND sky130_ef_sc_hd__decap_12
XFILLER_198_1049 VPWR VGND VPWR VGND sky130_ef_sc_hd__decap_12
XFILLER_141_1273 VGND VGND VPWR VPWR sky130_fd_sc_hd__fill_1
XFILLER_191_729 VPWR VGND VPWR VGND sky130_ef_sc_hd__decap_12
XFILLER_15_1287 VPWR VGND VPWR VGND sky130_ef_sc_hd__decap_12
XFILLER_89_1355 VPWR VGND VPWR VGND sky130_ef_sc_hd__decap_12
XFILLER_184_781 VPWR VGND VPWR VGND sky130_ef_sc_hd__decap_12
XFILLER_50_1189 VGND VGND VPWR VPWR sky130_fd_sc_hd__fill_1
Xwire380 net381 VGND VGND VPWR VPWR net380 sky130_fd_sc_hd__clkbuf_1
Xmax_cap113 net114 VGND VGND VPWR VPWR net113 sky130_fd_sc_hd__clkbuf_1
Xmax_cap124 net125 VGND VGND VPWR VPWR net124 sky130_fd_sc_hd__clkbuf_1
Xwire391 net392 VGND VGND VPWR VPWR net391 sky130_fd_sc_hd__clkbuf_1
Xmax_cap135 _145_ VGND VGND VPWR VPWR net135 sky130_fd_sc_hd__clkbuf_1
XFILLER_85_1219 VPWR VGND VPWR VGND sky130_ef_sc_hd__decap_12
XFILLER_239_1057 VGND VGND VPWR VPWR sky130_fd_sc_hd__decap_6
XPHY_EDGE_ROW_60_2_Left_562 VGND VGND VPWR VPWR sky130_fd_sc_hd__decap_3
Xmax_cap146 _195_ VGND VGND VPWR VPWR net146 sky130_fd_sc_hd__clkbuf_1
XFILLER_89_1399 VPWR VGND VPWR VGND sky130_ef_sc_hd__decap_12
Xmax_cap157 net158 VGND VGND VPWR VPWR net157 sky130_fd_sc_hd__clkbuf_1
XPHY_EDGE_ROW_194_Left_449 VGND VGND VPWR VPWR sky130_fd_sc_hd__decap_3
Xmax_cap168 _135_ VGND VGND VPWR VPWR net168 sky130_fd_sc_hd__clkbuf_1
Xmax_cap179 _099_ VGND VGND VPWR VPWR net179 sky130_fd_sc_hd__clkbuf_1
XFILLER_171_497 VGND VGND VPWR VPWR sky130_fd_sc_hd__decap_6
XTAP_TAPCELL_ROW_90_1_1225 VGND VPWR sky130_fd_sc_hd__tapvpwrvgnd_1
XFILLER_225_55 VGND VGND VPWR VPWR sky130_fd_sc_hd__fill_1
XFILLER_174_1093 VPWR VGND VPWR VGND sky130_ef_sc_hd__decap_12
XFILLER_217_1399 VGND VGND VPWR VPWR sky130_fd_sc_hd__fill_1
XFILLER_22_1203 VPWR VGND VPWR VGND sky130_ef_sc_hd__decap_12
XFILLER_26_1383 VPWR VGND VPWR VGND sky130_ef_sc_hd__decap_12
XFILLER_113_1331 VPWR VGND VPWR VGND sky130_ef_sc_hd__decap_12
XPHY_EDGE_ROW_12_1_Left_267 VGND VGND VPWR VPWR sky130_fd_sc_hd__decap_3
XTAP_TAPCELL_ROW_166_1370 VGND VPWR sky130_fd_sc_hd__tapvpwrvgnd_1
XFILLER_227_933 VPWR VGND VPWR VGND sky130_ef_sc_hd__decap_12
XTAP_TAPCELL_ROW_51_2_4058 VGND VPWR sky130_fd_sc_hd__tapvpwrvgnd_1
XFILLER_22_1247 VPWR VGND VPWR VGND sky130_ef_sc_hd__decap_12
XFILLER_6_1477 VGND VGND VPWR VPWR sky130_fd_sc_hd__decap_6
XFILLER_226_421 VPWR VGND VPWR VGND sky130_ef_sc_hd__decap_12
XFILLER_96_1315 VPWR VGND VPWR VGND sky130_ef_sc_hd__decap_12
XFILLER_227_977 VPWR VGND VPWR VGND sky130_ef_sc_hd__decap_12
XFILLER_242_925 VPWR VGND VPWR VGND sky130_ef_sc_hd__decap_12
XFILLER_246_1017 VPWR VGND VPWR VGND sky130_ef_sc_hd__decap_12
XFILLER_0_1021 VPWR VGND VPWR VGND sky130_ef_sc_hd__decap_12
XFILLER_96_1359 VPWR VGND VPWR VGND sky130_ef_sc_hd__decap_12
XPHY_EDGE_ROW_137_1_Left_392 VGND VGND VPWR VPWR sky130_fd_sc_hd__decap_3
XFILLER_148_1427 VPWR VGND VPWR VGND sky130_ef_sc_hd__decap_12
XFILLER_253_273 VGND VGND VPWR VPWR sky130_fd_sc_hd__decap_6
XFILLER_213_137 VPWR VGND VPWR VGND sky130_ef_sc_hd__decap_12
XFILLER_0_1065 VPWR VGND VPWR VGND sky130_ef_sc_hd__decap_12
XTAP_TAPCELL_ROW_179_1720 VGND VPWR sky130_fd_sc_hd__tapvpwrvgnd_1
XTAP_TAPCELL_ROW_16_2_3850 VGND VPWR sky130_fd_sc_hd__tapvpwrvgnd_1
XTAP_TAPCELL_ROW_179_1731 VGND VPWR sky130_fd_sc_hd__tapvpwrvgnd_1
XFILLER_224_1315 VGND VGND VPWR VPWR sky130_fd_sc_hd__fill_1
XFILLER_179_553 VGND VGND VPWR VPWR sky130_fd_sc_hd__decap_6
XFILLER_210_811 VGND VGND VPWR VPWR sky130_fd_sc_hd__fill_1
XFILLER_194_501 VPWR VGND VPWR VGND sky130_ef_sc_hd__decap_12
XTAP_TAPCELL_ROW_175_1606 VGND VPWR sky130_fd_sc_hd__tapvpwrvgnd_1
XFILLER_222_693 VGND VGND VPWR VPWR sky130_fd_sc_hd__decap_6
XFILLER_70_29 VPWR VGND VPWR VGND sky130_ef_sc_hd__decap_12
XTAP_TAPCELL_ROW_175_1617 VGND VPWR sky130_fd_sc_hd__tapvpwrvgnd_1
XFILLER_179_597 VPWR VGND VPWR VGND sky130_ef_sc_hd__decap_12
XFILLER_221_181 VPWR VGND VPWR VGND sky130_ef_sc_hd__decap_12
XFILLER_194_545 VPWR VGND VPWR VGND sky130_ef_sc_hd__decap_12
XFILLER_186_29 VPWR VGND VPWR VGND sky130_ef_sc_hd__decap_12
XFILLER_33_1343 VPWR VGND VPWR VGND sky130_ef_sc_hd__decap_12
XFILLER_124_1471 VPWR VGND VPWR VGND sky130_ef_sc_hd__decap_12
XFILLER_222_1061 VPWR VGND VPWR VGND sky130_ef_sc_hd__decap_12
XFILLER_194_589 VPWR VGND VPWR VGND sky130_ef_sc_hd__decap_12
XFILLER_33_1387 VPWR VGND VPWR VGND sky130_ef_sc_hd__decap_12
XFILLER_181_217 VGND VGND VPWR VPWR sky130_fd_sc_hd__decap_6
XFILLER_120_1357 VGND VGND VPWR VPWR sky130_fd_sc_hd__fill_1
XFILLER_79_27 VPWR VGND VPWR VGND sky130_ef_sc_hd__decap_12
XFILLER_68_1439 VPWR VGND VPWR VGND sky130_ef_sc_hd__decap_12
XFILLER_0_113 VPWR VGND VPWR VGND sky130_ef_sc_hd__decap_12
XFILLER_235_1455 VGND VGND VPWR VPWR sky130_fd_sc_hd__fill_1
XFILLER_135_55 VGND VGND VPWR VPWR sky130_fd_sc_hd__fill_1
XFILLER_95_15 VPWR VGND VPWR VGND sky130_ef_sc_hd__decap_12
XTAP_TAPCELL_ROW_147_2_4636 VGND VPWR sky130_fd_sc_hd__tapvpwrvgnd_1
XFILLER_153_1177 VPWR VGND VPWR VGND sky130_ef_sc_hd__decap_12
XTAP_TAPCELL_ROW_244_3470 VGND VPWR sky130_fd_sc_hd__tapvpwrvgnd_1
XFILLER_40_1303 VPWR VGND VPWR VGND sky130_ef_sc_hd__decap_12
XTAP_TAPCELL_ROW_244_3481 VGND VPWR sky130_fd_sc_hd__tapvpwrvgnd_1
XFILLER_44_1483 VPWR VGND VPWR VGND sky130_ef_sc_hd__decap_12
XTAP_TAPCELL_ROW_5_986 VGND VPWR sky130_fd_sc_hd__tapvpwrvgnd_1
XFILLER_185_3 VPWR VGND VPWR VGND sky130_ef_sc_hd__decap_12
XFILLER_188_1229 VPWR VGND VPWR VGND sky130_ef_sc_hd__decap_12
XTAP_TAPCELL_ROW_240_3356 VGND VPWR sky130_fd_sc_hd__tapvpwrvgnd_1
X_631_ clknet_3_5__leaf_clk dout0\[29\] _039_ VGND VGND VPWR VPWR dout0_q\[29\] sky130_fd_sc_hd__dfrtp_1
XTAP_TAPCELL_ROW_5_997 VGND VPWR sky130_fd_sc_hd__tapvpwrvgnd_1
XFILLER_229_281 VPWR VGND VPWR VGND sky130_ef_sc_hd__decap_12
XFILLER_245_741 VPWR VGND VPWR VGND sky130_ef_sc_hd__decap_12
XTAP_TAPCELL_ROW_240_3367 VGND VPWR sky130_fd_sc_hd__tapvpwrvgnd_1
XTAP_TAPCELL_ROW_240_3378 VGND VPWR sky130_fd_sc_hd__tapvpwrvgnd_1
XFILLER_131_1497 VGND VGND VPWR VPWR sky130_fd_sc_hd__fill_1
XFILLER_244_251 VGND VGND VPWR VPWR sky130_fd_sc_hd__fill_1
X_562_ net663 VGND VGND VPWR VPWR _044_ sky130_fd_sc_hd__inv_2
XFILLER_245_785 VPWR VGND VPWR VGND sky130_ef_sc_hd__decap_12
XFILLER_232_413 VGND VGND VPWR VPWR sky130_fd_sc_hd__decap_6
XFILLER_189_317 VPWR VGND VPWR VGND sky130_ef_sc_hd__decap_12
XTAP_TAPCELL_ROW_95_2_4323 VGND VPWR sky130_fd_sc_hd__tapvpwrvgnd_1
XFILLER_44_41 VGND VGND VPWR VPWR sky130_fd_sc_hd__decap_8
X_493_ net97 net141 net188 VGND VGND VPWR VPWR _252_ sky130_fd_sc_hd__a21oi_1
XFILLER_232_457 VPWR VGND VPWR VGND sky130_ef_sc_hd__decap_12
XFILLER_207_1513 VGND VGND VPWR VPWR sky130_fd_sc_hd__fill_2
XTAP_TAPCELL_ROW_253_3706 VGND VPWR sky130_fd_sc_hd__tapvpwrvgnd_1
XTAP_TAPCELL_ROW_253_3717 VGND VPWR sky130_fd_sc_hd__tapvpwrvgnd_1
XTAP_TAPCELL_ROW_253_3728 VGND VPWR sky130_fd_sc_hd__tapvpwrvgnd_1
XFILLER_125_1213 VGND VGND VPWR VPWR sky130_fd_sc_hd__decap_4
XFILLER_213_671 VGND VGND VPWR VPWR sky130_fd_sc_hd__fill_1
XFILLER_197_361 VPWR VGND VPWR VGND sky130_ef_sc_hd__decap_12
XFILLER_201_833 VGND VGND VPWR VPWR sky130_fd_sc_hd__decap_6
XFILLER_9_725 VGND VGND VPWR VPWR sky130_fd_sc_hd__decap_3
XFILLER_164_1295 VGND VGND VPWR VPWR sky130_fd_sc_hd__decap_6
XFILLER_200_321 VPWR VGND VPWR VGND sky130_ef_sc_hd__decap_12
XFILLER_73_1189 VPWR VGND VPWR VGND sky130_ef_sc_hd__decap_12
XFILLER_199_1325 VPWR VGND VPWR VGND sky130_ef_sc_hd__decap_12
XFILLER_201_877 VPWR VGND VPWR VGND sky130_ef_sc_hd__decap_12
XFILLER_8_235 VGND VGND VPWR VPWR sky130_fd_sc_hd__decap_4
XFILLER_201_1101 VPWR VGND VPWR VGND sky130_ef_sc_hd__decap_12
XFILLER_240_1161 VPWR VGND VPWR VGND sky130_ef_sc_hd__decap_12
XFILLER_51_1443 VPWR VGND VPWR VGND sky130_ef_sc_hd__decap_12
XFILLER_9_769 VPWR VGND VPWR VGND sky130_ef_sc_hd__decap_12
XFILLER_103_1511 VGND VGND VPWR VPWR sky130_fd_sc_hd__decap_4
XFILLER_200_365 VPWR VGND VPWR VGND sky130_ef_sc_hd__decap_12
XFILLER_205_1281 VGND VGND VPWR VPWR sky130_fd_sc_hd__decap_6
XFILLER_8_257 VPWR VGND VPWR VGND sky130_ef_sc_hd__decap_12
XFILLER_173_729 VPWR VGND VPWR VGND sky130_ef_sc_hd__decap_12
XFILLER_12_1427 VPWR VGND VPWR VGND sky130_ef_sc_hd__decap_12
XFILLER_199_1369 VPWR VGND VPWR VGND sky130_ef_sc_hd__decap_12
XFILLER_166_781 VPWR VGND VPWR VGND sky130_ef_sc_hd__decap_12
XFILLER_201_1145 VPWR VGND VPWR VGND sky130_ef_sc_hd__decap_12
XFILLER_5_953 VPWR VGND VPWR VGND sky130_ef_sc_hd__decap_12
XFILLER_201_1189 VPWR VGND VPWR VGND sky130_ef_sc_hd__decap_12
XFILLER_5_57 VPWR VGND VPWR VGND sky130_ef_sc_hd__decap_12
XFILLER_253_1511 VGND VGND VPWR VPWR sky130_fd_sc_hd__fill_1
XFILLER_171_1233 VPWR VGND VPWR VGND sky130_ef_sc_hd__decap_12
XFILLER_192_83 VGND VGND VPWR VPWR sky130_fd_sc_hd__fill_1
XFILLER_255_505 VPWR VGND VPWR VGND sky130_ef_sc_hd__decap_12
XFILLER_132_1239 VGND VGND VPWR VPWR sky130_fd_sc_hd__decap_6
XFILLER_212_1241 VPWR VGND VPWR VGND sky130_ef_sc_hd__decap_12
XFILLER_209_933 VPWR VGND VPWR VGND sky130_ef_sc_hd__decap_12
XTAP_TAPCELL_ROW_151_1_1286 VGND VPWR sky130_fd_sc_hd__tapvpwrvgnd_1
XFILLER_208_421 VPWR VGND VPWR VGND sky130_ef_sc_hd__decap_12
XFILLER_212_1285 VPWR VGND VPWR VGND sky130_ef_sc_hd__decap_12
XFILLER_209_977 VPWR VGND VPWR VGND sky130_ef_sc_hd__decap_12
XFILLER_224_925 VPWR VGND VPWR VGND sky130_ef_sc_hd__decap_12
XFILLER_247_1337 VGND VGND VPWR VPWR sky130_fd_sc_hd__decap_6
XFILLER_235_273 VGND VGND VPWR VPWR sky130_fd_sc_hd__decap_6
XPHY_EDGE_ROW_70_1_Right_726 VGND VGND VPWR VPWR sky130_fd_sc_hd__decap_3
XTAP_TAPCELL_ROW_223_2897 VGND VPWR sky130_fd_sc_hd__tapvpwrvgnd_1
XFILLER_250_221 VPWR VGND VPWR VGND sky130_ef_sc_hd__decap_12
XFILLER_165_1037 VPWR VGND VPWR VGND sky130_ef_sc_hd__decap_12
XFILLER_211_57 VPWR VGND VPWR VGND sky130_ef_sc_hd__decap_12
XFILLER_91_1201 VPWR VGND VPWR VGND sky130_ef_sc_hd__decap_12
XFILLER_251_777 VGND VGND VPWR VPWR sky130_fd_sc_hd__decap_6
XFILLER_250_265 VPWR VGND VPWR VGND sky130_ef_sc_hd__decap_12
XFILLER_176_501 VPWR VGND VPWR VGND sky130_ef_sc_hd__decap_12
XFILLER_182_1373 VPWR VGND VPWR VGND sky130_ef_sc_hd__decap_12
XFILLER_91_1267 VGND VGND VPWR VPWR sky130_fd_sc_hd__decap_6
XFILLER_189_895 VGND VGND VPWR VPWR sky130_fd_sc_hd__fill_1
XFILLER_204_693 VGND VGND VPWR VPWR sky130_fd_sc_hd__decap_6
XFILLER_203_181 VPWR VGND VPWR VGND sky130_ef_sc_hd__decap_12
XFILLER_176_545 VPWR VGND VPWR VGND sky130_ef_sc_hd__decap_12
XFILLER_143_1379 VGND VGND VPWR VPWR sky130_fd_sc_hd__decap_6
XFILLER_223_1381 VPWR VGND VPWR VGND sky130_ef_sc_hd__decap_12
XFILLER_178_1409 VPWR VGND VPWR VGND sky130_ef_sc_hd__decap_12
XFILLER_176_589 VPWR VGND VPWR VGND sky130_ef_sc_hd__decap_12
XFILLER_191_559 VGND VGND VPWR VPWR sky130_fd_sc_hd__fill_1
XFILLER_171_261 VPWR VGND VPWR VGND sky130_ef_sc_hd__decap_12
XFILLER_236_65 VPWR VGND VPWR VGND sky130_ef_sc_hd__decap_12
XTAP_TAPCELL_ROW_133_2_4555 VGND VPWR sky130_fd_sc_hd__tapvpwrvgnd_1
XTAP_TAPCELL_ROW_168_1410 VGND VPWR sky130_fd_sc_hd__tapvpwrvgnd_1
XTAP_TAPCELL_ROW_168_1421 VGND VPWR sky130_fd_sc_hd__tapvpwrvgnd_1
XTAP_TAPCELL_ROW_168_1432 VGND VPWR sky130_fd_sc_hd__tapvpwrvgnd_1
XFILLER_189_1505 VGND VGND VPWR VPWR sky130_fd_sc_hd__decap_6
XFILLER_150_1339 VPWR VGND VPWR VGND sky130_ef_sc_hd__decap_12
XFILLER_252_53 VPWR VGND VPWR VGND sky130_ef_sc_hd__decap_12
XFILLER_6_1241 VPWR VGND VPWR VGND sky130_ef_sc_hd__decap_12
XFILLER_230_1341 VPWR VGND VPWR VGND sky130_ef_sc_hd__decap_12
XTAP_TAPCELL_ROW_2_912 VGND VPWR sky130_fd_sc_hd__tapvpwrvgnd_1
XFILLER_105_69 VGND VGND VPWR VPWR sky130_fd_sc_hd__fill_2
XTAP_TAPCELL_ROW_113_2_4431 VGND VPWR sky130_fd_sc_hd__tapvpwrvgnd_1
XFILLER_26_1191 VPWR VGND VPWR VGND sky130_ef_sc_hd__decap_12
XTAP_TAPCELL_ROW_2_923 VGND VPWR sky130_fd_sc_hd__tapvpwrvgnd_1
XFILLER_2_1105 VPWR VGND VPWR VGND sky130_ef_sc_hd__decap_12
XFILLER_227_741 VPWR VGND VPWR VGND sky130_ef_sc_hd__decap_12
XFILLER_252_97 VPWR VGND VPWR VGND sky130_ef_sc_hd__decap_12
XFILLER_6_1285 VPWR VGND VPWR VGND sky130_ef_sc_hd__decap_12
XFILLER_230_1385 VPWR VGND VPWR VGND sky130_ef_sc_hd__decap_12
XFILLER_226_251 VGND VGND VPWR VPWR sky130_fd_sc_hd__fill_1
XFILLER_2_1149 VPWR VGND VPWR VGND sky130_ef_sc_hd__decap_12
XFILLER_227_785 VPWR VGND VPWR VGND sky130_ef_sc_hd__decap_12
XTAP_TAPCELL_ROW_81_2_4242 VGND VPWR sky130_fd_sc_hd__tapvpwrvgnd_1
XFILLER_199_615 VGND VGND VPWR VPWR sky130_fd_sc_hd__fill_1
XFILLER_214_413 VGND VGND VPWR VPWR sky130_fd_sc_hd__decap_6
XFILLER_242_755 VGND VGND VPWR VPWR sky130_fd_sc_hd__fill_1
XFILLER_96_1189 VGND VGND VPWR VPWR sky130_fd_sc_hd__fill_1
XFILLER_121_57 VPWR VGND VPWR VGND sky130_ef_sc_hd__decap_12
XFILLER_214_457 VPWR VGND VPWR VGND sky130_ef_sc_hd__decap_12
XFILLER_109_1219 VPWR VGND VPWR VGND sky130_ef_sc_hd__decap_12
XFILLER_230_917 VGND VGND VPWR VPWR sky130_fd_sc_hd__decap_6
XFILLER_81_39 VPWR VGND VPWR VGND sky130_ef_sc_hd__decap_12
XFILLER_186_309 VPWR VGND VPWR VGND sky130_ef_sc_hd__decap_12
XFILLER_179_361 VPWR VGND VPWR VGND sky130_ef_sc_hd__decap_12
XFILLER_197_39 VPWR VGND VPWR VGND sky130_ef_sc_hd__decap_12
XFILLER_161_1435 VGND VGND VPWR VPWR sky130_fd_sc_hd__decap_6
XFILLER_195_821 VPWR VGND VPWR VGND sky130_ef_sc_hd__decap_12
XFILLER_195_865 VPWR VGND VPWR VGND sky130_ef_sc_hd__decap_12
XFILLER_161_1479 VPWR VGND VPWR VGND sky130_ef_sc_hd__decap_12
XFILLER_202_1421 VGND VGND VPWR VPWR sky130_fd_sc_hd__decap_6
XFILLER_241_1481 VPWR VGND VPWR VGND sky130_ef_sc_hd__decap_12
XFILLER_196_1509 VGND VGND VPWR VPWR sky130_fd_sc_hd__decap_6
XTAP_TAPCELL_ROW_233_3171 VGND VPWR sky130_fd_sc_hd__tapvpwrvgnd_1
XTAP_TAPCELL_ROW_233_3182 VGND VPWR sky130_fd_sc_hd__tapvpwrvgnd_1
XFILLER_6_728 VGND VGND VPWR VPWR sky130_fd_sc_hd__decap_4
XFILLER_202_1465 VPWR VGND VPWR VGND sky130_ef_sc_hd__decap_12
XFILLER_68_1203 VPWR VGND VPWR VGND sky130_ef_sc_hd__decap_12
XFILLER_159_1331 VPWR VGND VPWR VGND sky130_ef_sc_hd__decap_12
XFILLER_120_1165 VPWR VGND VPWR VGND sky130_ef_sc_hd__decap_12
XFILLER_68_1247 VPWR VGND VPWR VGND sky130_ef_sc_hd__decap_12
XFILLER_100_3 VPWR VGND VPWR VGND sky130_ef_sc_hd__decap_12
XFILLER_190_581 VGND VGND VPWR VPWR sky130_fd_sc_hd__decap_6
XFILLER_146_65 VGND VGND VPWR VPWR sky130_fd_sc_hd__decap_6
XTAP_TAPCELL_ROW_246_3521 VGND VPWR sky130_fd_sc_hd__tapvpwrvgnd_1
XTAP_TAPCELL_ROW_246_3532 VGND VPWR sky130_fd_sc_hd__tapvpwrvgnd_1
XTAP_TAPCELL_ROW_242_3407 VGND VPWR sky130_fd_sc_hd__tapvpwrvgnd_1
XTAP_TAPCELL_ROW_242_3418 VGND VPWR sky130_fd_sc_hd__tapvpwrvgnd_1
XTAP_TAPCELL_ROW_242_3429 VGND VPWR sky130_fd_sc_hd__tapvpwrvgnd_1
XFILLER_237_505 VPWR VGND VPWR VGND sky130_ef_sc_hd__decap_12
XFILLER_162_53 VPWR VGND VPWR VGND sky130_ef_sc_hd__decap_12
XTAP_TAPCELL_ROW_8_1066 VGND VPWR sky130_fd_sc_hd__tapvpwrvgnd_1
XTAP_TAPCELL_ROW_8_1077 VGND VPWR sky130_fd_sc_hd__tapvpwrvgnd_1
XFILLER_188_1037 VPWR VGND VPWR VGND sky130_ef_sc_hd__decap_12
XTAP_TAPCELL_ROW_8_1088 VGND VPWR sky130_fd_sc_hd__tapvpwrvgnd_1
XFILLER_229_1001 VGND VGND VPWR VPWR sky130_fd_sc_hd__decap_6
XFILLER_40_1177 VPWR VGND VPWR VGND sky130_ef_sc_hd__decap_12
X_614_ clknet_3_6__leaf_clk dout0\[12\] _022_ VGND VGND VPWR VPWR dout0_q\[12\] sky130_fd_sc_hd__dfrtp_1
XFILLER_79_1343 VPWR VGND VPWR VGND sky130_ef_sc_hd__decap_12
XFILLER_206_925 VPWR VGND VPWR VGND sky130_ef_sc_hd__decap_12
XFILLER_217_273 VGND VGND VPWR VPWR sky130_fd_sc_hd__decap_6
XFILLER_229_1045 VPWR VGND VPWR VGND sky130_ef_sc_hd__decap_12
XFILLER_79_1387 VPWR VGND VPWR VGND sky130_ef_sc_hd__decap_12
XFILLER_232_221 VPWR VGND VPWR VGND sky130_ef_sc_hd__decap_12
X_545_ net668 VGND VGND VPWR VPWR _027_ sky130_fd_sc_hd__inv_2
XFILLER_189_125 VPWR VGND VPWR VGND sky130_ef_sc_hd__decap_12
XFILLER_233_777 VGND VGND VPWR VPWR sky130_fd_sc_hd__decap_6
XFILLER_229_1089 VPWR VGND VPWR VGND sky130_ef_sc_hd__decap_12
XFILLER_232_265 VPWR VGND VPWR VGND sky130_ef_sc_hd__decap_12
XFILLER_189_169 VPWR VGND VPWR VGND sky130_ef_sc_hd__decap_12
X_476_ net155 net115 VGND VGND VPWR VPWR acc_core.adder.cla_blocks\[2\].block.sum\[0\]
+ sky130_fd_sc_hd__xor2_1
XFILLER_207_1343 VGND VGND VPWR VPWR sky130_fd_sc_hd__fill_1
XFILLER_198_681 VPWR VGND VPWR VGND sky130_ef_sc_hd__decap_12
XFILLER_201_641 VPWR VGND VPWR VGND sky130_ef_sc_hd__decap_12
XPHY_EDGE_ROW_207_Right_52 VGND VGND VPWR VPWR sky130_fd_sc_hd__decap_3
XFILLER_199_1133 VPWR VGND VPWR VGND sky130_ef_sc_hd__decap_12
XFILLER_201_685 VPWR VGND VPWR VGND sky130_ef_sc_hd__decap_12
XFILLER_16_1371 VPWR VGND VPWR VGND sky130_ef_sc_hd__decap_12
XFILLER_51_1273 VGND VGND VPWR VPWR sky130_fd_sc_hd__fill_1
XFILLER_199_1177 VPWR VGND VPWR VGND sky130_ef_sc_hd__decap_12
XFILLER_200_195 VGND VGND VPWR VPWR sky130_fd_sc_hd__fill_1
XFILLER_86_1303 VPWR VGND VPWR VGND sky130_ef_sc_hd__decap_12
XFILLER_173_559 VGND VGND VPWR VPWR sky130_fd_sc_hd__fill_1
XFILLER_103_1385 VGND VGND VPWR VPWR sky130_fd_sc_hd__fill_1
XFILLER_236_1005 VPWR VGND VPWR VGND sky130_ef_sc_hd__decap_12
XFILLER_138_1415 VPWR VGND VPWR VGND sky130_ef_sc_hd__decap_12
XFILLER_236_1049 VPWR VGND VPWR VGND sky130_ef_sc_hd__decap_12
XTAP_TAPCELL_ROW_212_2598 VGND VPWR sky130_fd_sc_hd__tapvpwrvgnd_1
XPHY_EDGE_ROW_216_Right_61 VGND VGND VPWR VPWR sky130_fd_sc_hd__decap_3
XFILLER_218_1483 VGND VGND VPWR VPWR sky130_fd_sc_hd__fill_1
XTAP_TAPCELL_ROW_86_2_4268 VGND VPWR sky130_fd_sc_hd__tapvpwrvgnd_1
XFILLER_171_1063 VGND VGND VPWR VPWR sky130_fd_sc_hd__fill_1
XFILLER_23_1331 VPWR VGND VPWR VGND sky130_ef_sc_hd__decap_12
XTAP_TAPCELL_ROW_225_2948 VGND VPWR sky130_fd_sc_hd__tapvpwrvgnd_1
XFILLER_209_741 VPWR VGND VPWR VGND sky130_ef_sc_hd__decap_12
XTAP_TAPCELL_ROW_225_2959 VGND VPWR sky130_fd_sc_hd__tapvpwrvgnd_1
XFILLER_3_1425 VPWR VGND VPWR VGND sky130_ef_sc_hd__decap_12
XFILLER_110_1301 VGND VGND VPWR VPWR sky130_fd_sc_hd__fill_1
XFILLER_247_1101 VPWR VGND VPWR VGND sky130_ef_sc_hd__decap_12
XFILLER_208_251 VGND VGND VPWR VPWR sky130_fd_sc_hd__fill_1
XFILLER_212_1093 VPWR VGND VPWR VGND sky130_ef_sc_hd__decap_12
XFILLER_97_1443 VPWR VGND VPWR VGND sky130_ef_sc_hd__decap_12
XFILLER_149_1511 VGND VGND VPWR VPWR sky130_fd_sc_hd__decap_4
XFILLER_209_785 VPWR VGND VPWR VGND sky130_ef_sc_hd__decap_12
XFILLER_3_1469 VPWR VGND VPWR VGND sky130_ef_sc_hd__decap_12
XTAP_TAPCELL_ROW_85_1_1220 VGND VPWR sky130_fd_sc_hd__tapvpwrvgnd_1
XFILLER_58_1427 VPWR VGND VPWR VGND sky130_ef_sc_hd__decap_12
XFILLER_247_1145 VPWR VGND VPWR VGND sky130_ef_sc_hd__decap_12
XFILLER_251_541 VPWR VGND VPWR VGND sky130_ef_sc_hd__decap_12
XFILLER_93_1329 VGND VGND VPWR VPWR sky130_fd_sc_hd__fill_1
XFILLER_224_755 VGND VGND VPWR VPWR sky130_fd_sc_hd__fill_1
XPHY_EDGE_ROW_71_1_Right_727 VGND VGND VPWR VPWR sky130_fd_sc_hd__decap_3
XFILLER_212_917 VGND VGND VPWR VPWR sky130_fd_sc_hd__decap_6
XFILLER_243_1009 VPWR VGND VPWR VGND sky130_ef_sc_hd__decap_12
XFILLER_208_1129 VPWR VGND VPWR VGND sky130_ef_sc_hd__decap_12
XFILLER_247_1189 VPWR VGND VPWR VGND sky130_ef_sc_hd__decap_12
XFILLER_211_405 VPWR VGND VPWR VGND sky130_ef_sc_hd__decap_12
XFILLER_251_585 VPWR VGND VPWR VGND sky130_ef_sc_hd__decap_12
XTAP_TAPCELL_ROW_46_2_4031 VGND VPWR sky130_fd_sc_hd__tapvpwrvgnd_1
XFILLER_168_309 VPWR VGND VPWR VGND sky130_ef_sc_hd__decap_12
XPHY_EDGE_ROW_225_Right_70 VGND VGND VPWR VPWR sky130_fd_sc_hd__decap_3
XFILLER_177_821 VPWR VGND VPWR VGND sky130_ef_sc_hd__decap_12
XFILLER_211_449 VPWR VGND VPWR VGND sky130_ef_sc_hd__decap_12
XFILLER_220_961 VPWR VGND VPWR VGND sky130_ef_sc_hd__decap_12
XFILLER_177_865 VPWR VGND VPWR VGND sky130_ef_sc_hd__decap_12
XFILLER_143_1165 VPWR VGND VPWR VGND sky130_ef_sc_hd__decap_12
XFILLER_192_813 VPWR VGND VPWR VGND sky130_ef_sc_hd__decap_12
XFILLER_34_1471 VPWR VGND VPWR VGND sky130_ef_sc_hd__decap_12
XFILLER_178_1217 VPWR VGND VPWR VGND sky130_ef_sc_hd__decap_12
XFILLER_121_1441 VGND VGND VPWR VPWR sky130_fd_sc_hd__fill_1
XFILLER_30_1357 VGND VGND VPWR VPWR sky130_fd_sc_hd__fill_1
XFILLER_254_1105 VPWR VGND VPWR VGND sky130_ef_sc_hd__decap_12
XTAP_TAPCELL_ROW_24_2_3901 VGND VPWR sky130_fd_sc_hd__tapvpwrvgnd_1
XFILLER_219_1225 VGND VGND VPWR VPWR sky130_fd_sc_hd__decap_6
XFILLER_172_581 VGND VGND VPWR VPWR sky130_fd_sc_hd__decap_6
XFILLER_254_1149 VPWR VGND VPWR VGND sky130_ef_sc_hd__decap_12
XFILLER_219_1269 VPWR VGND VPWR VGND sky130_ef_sc_hd__decap_12
XFILLER_115_1201 VPWR VGND VPWR VGND sky130_ef_sc_hd__decap_12
XPHY_EDGE_ROW_23_2_Left_525 VGND VGND VPWR VPWR sky130_fd_sc_hd__decap_3
XFILLER_154_1283 VPWR VGND VPWR VGND sky130_ef_sc_hd__decap_12
XFILLER_219_505 VPWR VGND VPWR VGND sky130_ef_sc_hd__decap_12
XFILLER_63_1177 VPWR VGND VPWR VGND sky130_ef_sc_hd__decap_12
XFILLER_189_1313 VPWR VGND VPWR VGND sky130_ef_sc_hd__decap_12
XFILLER_115_1267 VGND VGND VPWR VPWR sky130_fd_sc_hd__decap_6
XPHY_EDGE_ROW_148_2_Left_650 VGND VGND VPWR VPWR sky130_fd_sc_hd__decap_3
XFILLER_246_357 VGND VGND VPWR VPWR sky130_fd_sc_hd__decap_6
XFILLER_189_1357 VPWR VGND VPWR VGND sky130_ef_sc_hd__decap_12
XFILLER_6_1093 VPWR VGND VPWR VGND sky130_ef_sc_hd__decap_12
XFILLER_41_1497 VGND VGND VPWR VPWR sky130_fd_sc_hd__fill_1
XFILLER_92_27 VGND VGND VPWR VPWR sky130_fd_sc_hd__fill_1
XFILLER_214_221 VPWR VGND VPWR VGND sky130_ef_sc_hd__decap_12
XFILLER_215_777 VGND VGND VPWR VPWR sky130_fd_sc_hd__decap_6
XFILLER_214_265 VPWR VGND VPWR VGND sky130_ef_sc_hd__decap_12
XFILLER_226_1229 VPWR VGND VPWR VGND sky130_ef_sc_hd__decap_12
X_330_ net594 dout0_q\[19\] net536 VGND VGND VPWR VPWR _119_ sky130_fd_sc_hd__a21oi_1
XFILLER_230_725 VPWR VGND VPWR VGND sky130_ef_sc_hd__decap_12
XFILLER_25_65 VGND VGND VPWR VPWR sky130_fd_sc_hd__fill_2
XFILLER_187_629 VPWR VGND VPWR VGND sky130_ef_sc_hd__decap_12
XTAP_TAPCELL_ROW_235_3222 VGND VPWR sky130_fd_sc_hd__tapvpwrvgnd_1
XFILLER_35_1213 VGND VGND VPWR VPWR sky130_fd_sc_hd__decap_4
XFILLER_148_3 VPWR VGND VPWR VGND sky130_ef_sc_hd__decap_12
XTAP_TAPCELL_ROW_235_3233 VGND VPWR sky130_fd_sc_hd__tapvpwrvgnd_1
XFILLER_230_769 VPWR VGND VPWR VGND sky130_ef_sc_hd__decap_12
XFILLER_186_139 VGND VGND VPWR VPWR sky130_fd_sc_hd__fill_1
XFILLER_74_1295 VGND VGND VPWR VPWR sky130_fd_sc_hd__decap_6
XFILLER_161_1243 VPWR VGND VPWR VGND sky130_ef_sc_hd__decap_12
XFILLER_122_1227 VPWR VGND VPWR VGND sky130_ef_sc_hd__decap_12
XFILLER_195_673 VPWR VGND VPWR VGND sky130_ef_sc_hd__decap_12
XTAP_TAPCELL_ROW_231_3119 VGND VPWR sky130_fd_sc_hd__tapvpwrvgnd_1
XFILLER_13_1511 VGND VGND VPWR VPWR sky130_fd_sc_hd__decap_4
XFILLER_161_1287 VPWR VGND VPWR VGND sky130_ef_sc_hd__decap_12
XFILLER_182_301 VGND VGND VPWR VPWR sky130_fd_sc_hd__decap_6
XFILLER_196_1317 VPWR VGND VPWR VGND sky130_ef_sc_hd__decap_12
XFILLER_182_345 VPWR VGND VPWR VGND sky130_ef_sc_hd__decap_12
XFILLER_202_1273 VPWR VGND VPWR VGND sky130_ef_sc_hd__decap_12
XTAP_TAPCELL_ROW_104_2_4376 VGND VPWR sky130_fd_sc_hd__tapvpwrvgnd_1
XFILLER_182_389 VPWR VGND VPWR VGND sky130_ef_sc_hd__decap_12
XFILLER_237_1325 VPWR VGND VPWR VGND sky130_ef_sc_hd__decap_12
XFILLER_237_1369 VPWR VGND VPWR VGND sky130_ef_sc_hd__decap_12
XFILLER_194_1085 VGND VGND VPWR VPWR sky130_fd_sc_hd__decap_6
XTAP_TAPCELL_ROW_72_2_4187 VGND VPWR sky130_fd_sc_hd__tapvpwrvgnd_1
XTAP_TAPCELL_ROW_229_3059 VGND VPWR sky130_fd_sc_hd__tapvpwrvgnd_1
XFILLER_81_1255 VPWR VGND VPWR VGND sky130_ef_sc_hd__decap_12
XFILLER_133_1323 VGND VGND VPWR VPWR sky130_fd_sc_hd__decap_6
XFILLER_238_825 VPWR VGND VPWR VGND sky130_ef_sc_hd__decap_12
XFILLER_42_1239 VGND VGND VPWR VPWR sky130_fd_sc_hd__decap_6
XFILLER_237_335 VGND VGND VPWR VPWR sky130_fd_sc_hd__fill_1
XFILLER_81_1299 VPWR VGND VPWR VGND sky130_ef_sc_hd__decap_12
XFILLER_133_1367 VPWR VGND VPWR VGND sky130_ef_sc_hd__decap_12
XFILLER_238_869 VPWR VGND VPWR VGND sky130_ef_sc_hd__decap_12
XFILLER_253_839 VGND VGND VPWR VPWR sky130_fd_sc_hd__fill_1
XFILLER_248_1421 VGND VGND VPWR VPWR sky130_fd_sc_hd__decap_6
XTAP_TAPCELL_ROW_220_2812 VGND VPWR sky130_fd_sc_hd__tapvpwrvgnd_1
XTAP_TAPCELL_ROW_220_2823 VGND VPWR sky130_fd_sc_hd__tapvpwrvgnd_1
XTAP_TAPCELL_ROW_220_2834 VGND VPWR sky130_fd_sc_hd__tapvpwrvgnd_1
XFILLER_206_755 VGND VGND VPWR VPWR sky130_fd_sc_hd__fill_1
XFILLER_248_1465 VPWR VGND VPWR VGND sky130_ef_sc_hd__decap_12
XFILLER_233_541 VPWR VGND VPWR VGND sky130_ef_sc_hd__decap_12
XFILLER_244_1329 VPWR VGND VPWR VGND sky130_ef_sc_hd__decap_12
XFILLER_209_1449 VGND VGND VPWR VPWR sky130_fd_sc_hd__decap_6
XFILLER_233_585 VPWR VGND VPWR VGND sky130_ef_sc_hd__decap_12
X_528_ net665 VGND VGND VPWR VPWR _010_ sky130_fd_sc_hd__inv_2
XFILLER_92_1351 VGND VGND VPWR VPWR sky130_fd_sc_hd__decap_6
XTAP_TAPCELL_ROW_146_1_1281 VGND VPWR sky130_fd_sc_hd__tapvpwrvgnd_1
XTAP_TAPCELL_ROW_201_2299 VGND VPWR sky130_fd_sc_hd__tapvpwrvgnd_1
XTAP_TAPCELL_ROW_197_2192 VGND VPWR sky130_fd_sc_hd__tapvpwrvgnd_1
X_459_ net607 net7 net42 VGND VGND VPWR VPWR addr0\[5\] sky130_fd_sc_hd__mux2_1
XTAP_TAPCELL_ROW_30_2_3933 VGND VPWR sky130_fd_sc_hd__tapvpwrvgnd_1
XFILLER_202_961 VPWR VGND VPWR VGND sky130_ef_sc_hd__decap_12
XTAP_TAPCELL_ROW_29_2_3927 VGND VPWR sky130_fd_sc_hd__tapvpwrvgnd_1
XFILLER_92_1395 VPWR VGND VPWR VGND sky130_ef_sc_hd__decap_12
XFILLER_144_1463 VGND VGND VPWR VPWR sky130_fd_sc_hd__decap_6
XFILLER_174_813 VPWR VGND VPWR VGND sky130_ef_sc_hd__decap_12
XFILLER_192_109 VPWR VGND VPWR VGND sky130_ef_sc_hd__decap_12
XFILLER_53_1379 VGND VGND VPWR VPWR sky130_fd_sc_hd__decap_6
XFILLER_140_1327 VPWR VGND VPWR VGND sky130_ef_sc_hd__decap_12
XTAP_TAPCELL_ROW_193_2089 VGND VPWR sky130_fd_sc_hd__tapvpwrvgnd_1
XTAP_TAPCELL_ROW_218_2763 VGND VPWR sky130_fd_sc_hd__tapvpwrvgnd_1
XFILLER_185_161 VGND VGND VPWR VPWR sky130_fd_sc_hd__decap_6
XTAP_TAPCELL_ROW_218_2774 VGND VPWR sky130_fd_sc_hd__tapvpwrvgnd_1
XFILLER_63_3 VPWR VGND VPWR VGND sky130_ef_sc_hd__decap_12
XFILLER_220_1373 VPWR VGND VPWR VGND sky130_ef_sc_hd__decap_12
XPHY_EDGE_ROW_21_1_Left_276 VGND VGND VPWR VPWR sky130_fd_sc_hd__decap_3
XFILLER_255_1425 VGND VGND VPWR VPWR sky130_fd_sc_hd__decap_3
XFILLER_216_1409 VPWR VGND VPWR VGND sky130_ef_sc_hd__decap_12
XFILLER_86_1177 VPWR VGND VPWR VGND sky130_ef_sc_hd__decap_12
XFILLER_138_1245 VGND VGND VPWR VPWR sky130_fd_sc_hd__fill_1
XFILLER_255_1469 VPWR VGND VPWR VGND sky130_ef_sc_hd__decap_12
XTAP_TAPCELL_ROW_148_2_4641 VGND VPWR sky130_fd_sc_hd__tapvpwrvgnd_1
XFILLER_173_1169 VGND VGND VPWR VPWR sky130_fd_sc_hd__decap_6
XFILLER_151_1423 VPWR VGND VPWR VGND sky130_ef_sc_hd__decap_12
XFILLER_190_1483 VGND VGND VPWR VPWR sky130_fd_sc_hd__fill_1
XFILLER_60_1339 VPWR VGND VPWR VGND sky130_ef_sc_hd__decap_12
XTAP_TAPCELL_ROW_161_2_4719 VGND VPWR sky130_fd_sc_hd__tapvpwrvgnd_1
XFILLER_112_1407 VGND VGND VPWR VPWR sky130_fd_sc_hd__decap_6
XFILLER_233_55 VGND VGND VPWR VPWR sky130_fd_sc_hd__fill_1
XFILLER_151_1467 VPWR VGND VPWR VGND sky130_ef_sc_hd__decap_12
XFILLER_228_357 VGND VGND VPWR VPWR sky130_fd_sc_hd__decap_6
XFILLER_243_305 VPWR VGND VPWR VGND sky130_ef_sc_hd__decap_12
XFILLER_255_165 VGND VGND VPWR VPWR sky130_fd_sc_hd__decap_3
XFILLER_3_1233 VPWR VGND VPWR VGND sky130_ef_sc_hd__decap_12
XFILLER_243_349 VPWR VGND VPWR VGND sky130_ef_sc_hd__decap_12
XFILLER_102_15 VPWR VGND VPWR VGND sky130_ef_sc_hd__decap_12
XTAP_TAPCELL_ROW_182_1793 VGND VPWR sky130_fd_sc_hd__tapvpwrvgnd_1
XFILLER_97_1273 VGND VGND VPWR VPWR sky130_fd_sc_hd__fill_1
XFILLER_227_1505 VGND VGND VPWR VPWR sky130_fd_sc_hd__decap_6
XFILLER_252_861 VGND VGND VPWR VPWR sky130_fd_sc_hd__decap_6
XFILLER_19_1219 VPWR VGND VPWR VGND sky130_ef_sc_hd__decap_12
XFILLER_149_1385 VGND VGND VPWR VPWR sky130_fd_sc_hd__fill_1
XFILLER_212_725 VPWR VGND VPWR VGND sky130_ef_sc_hd__decap_12
XFILLER_169_629 VPWR VGND VPWR VGND sky130_ef_sc_hd__decap_12
XPHY_EDGE_ROW_72_1_Right_728 VGND VGND VPWR VPWR sky130_fd_sc_hd__decap_3
XFILLER_251_393 VPWR VGND VPWR VGND sky130_ef_sc_hd__decap_12
XFILLER_180_1129 VPWR VGND VPWR VGND sky130_ef_sc_hd__decap_12
XFILLER_168_139 VGND VGND VPWR VPWR sky130_fd_sc_hd__fill_1
XFILLER_212_769 VPWR VGND VPWR VGND sky130_ef_sc_hd__decap_12
XFILLER_71_1435 VGND VGND VPWR VPWR sky130_fd_sc_hd__decap_6
XFILLER_211_279 VGND VGND VPWR VPWR sky130_fd_sc_hd__fill_1
XFILLER_71_1479 VPWR VGND VPWR VGND sky130_ef_sc_hd__decap_12
XFILLER_165_813 VPWR VGND VPWR VGND sky130_ef_sc_hd__decap_12
XFILLER_177_673 VPWR VGND VPWR VGND sky130_ef_sc_hd__decap_12
XFILLER_192_643 VGND VGND VPWR VPWR sky130_fd_sc_hd__fill_1
XFILLER_180_805 VGND VGND VPWR VPWR sky130_fd_sc_hd__decap_6
XFILLER_194_29 VPWR VGND VPWR VGND sky130_ef_sc_hd__decap_12
XFILLER_69_1331 VPWR VGND VPWR VGND sky130_ef_sc_hd__decap_12
XFILLER_30_1165 VPWR VGND VPWR VGND sky130_ef_sc_hd__decap_12
XFILLER_156_1301 VGND VGND VPWR VPWR sky130_fd_sc_hd__fill_1
XFILLER_180_849 VPWR VGND VPWR VGND sky130_ef_sc_hd__decap_12
XFILLER_219_1033 VPWR VGND VPWR VGND sky130_ef_sc_hd__decap_12
XFILLER_65_1217 VGND VGND VPWR VPWR sky130_fd_sc_hd__fill_1
XFILLER_234_1509 VGND VGND VPWR VPWR sky130_fd_sc_hd__decap_6
XFILLER_191_1225 VGND VGND VPWR VPWR sky130_fd_sc_hd__decap_6
XFILLER_2_7 VPWR VGND VPWR VGND sky130_ef_sc_hd__decap_12
XFILLER_87_27 VPWR VGND VPWR VGND sky130_ef_sc_hd__decap_12
XFILLER_219_1077 VPWR VGND VPWR VGND sky130_ef_sc_hd__decap_12
XFILLER_117_1329 VGND VGND VPWR VPWR sky130_fd_sc_hd__fill_1
XFILLER_191_1269 VPWR VGND VPWR VGND sky130_ef_sc_hd__decap_12
XFILLER_130_1507 VGND VGND VPWR VPWR sky130_fd_sc_hd__decap_8
XFILLER_246_121 VPWR VGND VPWR VGND sky130_ef_sc_hd__decap_12
XFILLER_143_55 VGND VGND VPWR VPWR sky130_fd_sc_hd__fill_1
XFILLER_219_335 VGND VGND VPWR VPWR sky130_fd_sc_hd__fill_1
XFILLER_189_1121 VPWR VGND VPWR VGND sky130_ef_sc_hd__decap_12
XTAP_TAPCELL_ROW_5_1003 VGND VPWR sky130_fd_sc_hd__tapvpwrvgnd_1
XFILLER_246_165 VPWR VGND VPWR VGND sky130_ef_sc_hd__decap_12
XFILLER_235_839 VGND VGND VPWR VPWR sky130_fd_sc_hd__fill_1
XFILLER_185_1007 VGND VGND VPWR VPWR sky130_fd_sc_hd__fill_1
XFILLER_215_541 VPWR VGND VPWR VGND sky130_ef_sc_hd__decap_12
XFILLER_188_905 VPWR VGND VPWR VGND sky130_ef_sc_hd__decap_12
XFILLER_76_1357 VGND VGND VPWR VPWR sky130_fd_sc_hd__fill_1
XFILLER_215_585 VPWR VGND VPWR VGND sky130_ef_sc_hd__decap_12
XFILLER_226_1037 VPWR VGND VPWR VGND sky130_ef_sc_hd__decap_12
XFILLER_188_949 VPWR VGND VPWR VGND sky130_ef_sc_hd__decap_12
XFILLER_230_533 VPWR VGND VPWR VGND sky130_ef_sc_hd__decap_12
XTAP_TAPCELL_ROW_15_2_3846 VGND VPWR sky130_fd_sc_hd__tapvpwrvgnd_1
XFILLER_128_1469 VGND VGND VPWR VPWR sky130_fd_sc_hd__fill_1
X_313_ _100_ net506 VGND VGND VPWR VPWR _102_ sky130_fd_sc_hd__nor2_1
XFILLER_52_41 VGND VGND VPWR VPWR sky130_fd_sc_hd__decap_3
XFILLER_168_41 VPWR VGND VPWR VGND sky130_ef_sc_hd__decap_12
XFILLER_174_109 VPWR VGND VPWR VGND sky130_ef_sc_hd__decap_12
XFILLER_196_993 VPWR VGND VPWR VGND sky130_ef_sc_hd__decap_12
XFILLER_167_161 VGND VGND VPWR VPWR sky130_fd_sc_hd__decap_6
Xinput17 wr_data[16] VGND VGND VPWR VPWR net17 sky130_fd_sc_hd__clkbuf_1
Xinput28 wr_data[26] VGND VGND VPWR VPWR net28 sky130_fd_sc_hd__clkbuf_1
XFILLER_168_85 VPWR VGND VPWR VGND sky130_ef_sc_hd__decap_12
Xinput39 wr_data[7] VGND VGND VPWR VPWR net39 sky130_fd_sc_hd__clkbuf_1
XFILLER_7_856 VPWR VGND VPWR VGND sky130_ef_sc_hd__decap_12
Xmax_cap509 net510 VGND VGND VPWR VPWR net509 sky130_fd_sc_hd__clkbuf_1
XFILLER_183_665 VGND VGND VPWR VPWR sky130_fd_sc_hd__decap_6
XFILLER_182_153 VPWR VGND VPWR VGND sky130_ef_sc_hd__decap_12
XFILLER_196_1147 VGND VGND VPWR VPWR sky130_fd_sc_hd__fill_1
XFILLER_13_1385 VGND VGND VPWR VPWR sky130_fd_sc_hd__fill_1
XFILLER_48_1415 VPWR VGND VPWR VGND sky130_ef_sc_hd__decap_12
XFILLER_182_197 VPWR VGND VPWR VGND sky130_ef_sc_hd__decap_12
XFILLER_237_1133 VPWR VGND VPWR VGND sky130_ef_sc_hd__decap_12
XFILLER_87_1497 VGND VGND VPWR VPWR sky130_fd_sc_hd__fill_1
XTAP_TAPCELL_ROW_134_2_4560 VGND VPWR sky130_fd_sc_hd__tapvpwrvgnd_1
XFILLER_237_1177 VPWR VGND VPWR VGND sky130_ef_sc_hd__decap_12
XFILLER_170_1309 VGND VGND VPWR VPWR sky130_fd_sc_hd__decap_6
XFILLER_20_1301 VGND VGND VPWR VPWR sky130_fd_sc_hd__fill_1
XFILLER_168_1205 VPWR VGND VPWR VGND sky130_ef_sc_hd__decap_12
XTAP_TAPCELL_ROW_207_2464 VGND VPWR sky130_fd_sc_hd__tapvpwrvgnd_1
XFILLER_225_305 VPWR VGND VPWR VGND sky130_ef_sc_hd__decap_12
XFILLER_238_699 VGND VGND VPWR VPWR sky130_fd_sc_hd__fill_1
XTAP_TAPCELL_ROW_207_2475 VGND VPWR sky130_fd_sc_hd__tapvpwrvgnd_1
XTAP_TAPCELL_ROW_207_2486 VGND VPWR sky130_fd_sc_hd__tapvpwrvgnd_1
XFILLER_59_1511 VGND VGND VPWR VPWR sky130_fd_sc_hd__decap_4
XTAP_TAPCELL_ROW_126_2_4508 VGND VPWR sky130_fd_sc_hd__tapvpwrvgnd_1
XFILLER_203_69 VPWR VGND VPWR VGND sky130_ef_sc_hd__decap_12
XFILLER_225_349 VPWR VGND VPWR VGND sky130_ef_sc_hd__decap_12
XFILLER_241_809 VPWR VGND VPWR VGND sky130_ef_sc_hd__decap_12
XFILLER_94_1413 VGND VGND VPWR VPWR sky130_fd_sc_hd__fill_1
XFILLER_234_861 VGND VGND VPWR VPWR sky130_fd_sc_hd__decap_6
XTAP_TAPCELL_ROW_199_2254 VGND VPWR sky130_fd_sc_hd__tapvpwrvgnd_1
XFILLER_209_1213 VPWR VGND VPWR VGND sky130_ef_sc_hd__decap_12
XTAP_TAPCELL_ROW_199_2265 VGND VPWR sky130_fd_sc_hd__tapvpwrvgnd_1
XFILLER_248_1273 VPWR VGND VPWR VGND sky130_ef_sc_hd__decap_12
XTAP_TAPCELL_ROW_94_2_4319 VGND VPWR sky130_fd_sc_hd__tapvpwrvgnd_1
XFILLER_209_1257 VPWR VGND VPWR VGND sky130_ef_sc_hd__decap_12
XFILLER_233_393 VPWR VGND VPWR VGND sky130_ef_sc_hd__decap_12
XFILLER_181_1449 VGND VGND VPWR VPWR sky130_fd_sc_hd__decap_6
XFILLER_144_1271 VPWR VGND VPWR VGND sky130_ef_sc_hd__decap_12
XFILLER_165_109 VGND VGND VPWR VPWR sky130_fd_sc_hd__decap_3
XFILLER_53_1165 VPWR VGND VPWR VGND sky130_ef_sc_hd__decap_12
XFILLER_193_429 VPWR VGND VPWR VGND sky130_ef_sc_hd__decap_12
XFILLER_179_1301 VPWR VGND VPWR VGND sky130_ef_sc_hd__decap_12
XFILLER_105_1255 VPWR VGND VPWR VGND sky130_ef_sc_hd__decap_12
XFILLER_174_643 VGND VGND VPWR VPWR sky130_fd_sc_hd__fill_1
XFILLER_31_1441 VGND VGND VPWR VPWR sky130_fd_sc_hd__fill_1
XFILLER_105_1299 VPWR VGND VPWR VGND sky130_ef_sc_hd__decap_12
XFILLER_179_1345 VPWR VGND VPWR VGND sky130_ef_sc_hd__decap_12
XFILLER_88_1239 VGND VGND VPWR VPWR sky130_fd_sc_hd__decap_6
XFILLER_228_77 VGND VGND VPWR VPWR sky130_fd_sc_hd__decap_6
XFILLER_255_1233 VPWR VGND VPWR VGND sky130_ef_sc_hd__decap_12
XTAP_TAPCELL_ROW_171_1494 VGND VPWR sky130_fd_sc_hd__tapvpwrvgnd_1
XFILLER_216_1217 VPWR VGND VPWR VGND sky130_ef_sc_hd__decap_12
XFILLER_249_909 VPWR VGND VPWR VGND sky130_ef_sc_hd__decap_12
XFILLER_251_1119 VGND VGND VPWR VPWR sky130_fd_sc_hd__fill_1
XFILLER_170_893 VPWR VGND VPWR VGND sky130_ef_sc_hd__decap_12
XFILLER_248_419 VGND VGND VPWR VPWR sky130_fd_sc_hd__fill_1
XFILLER_25_1201 VPWR VGND VPWR VGND sky130_ef_sc_hd__decap_12
XFILLER_244_65 VPWR VGND VPWR VGND sky130_ef_sc_hd__decap_12
XFILLER_9_1453 VGND VGND VPWR VPWR sky130_fd_sc_hd__decap_3
XFILLER_64_1283 VPWR VGND VPWR VGND sky130_ef_sc_hd__decap_12
XFILLER_116_1351 VGND VGND VPWR VPWR sky130_fd_sc_hd__decap_6
XFILLER_151_1231 VPWR VGND VPWR VGND sky130_ef_sc_hd__decap_12
XTAP_TAPCELL_ROW_184_1844 VGND VPWR sky130_fd_sc_hd__tapvpwrvgnd_1
XFILLER_228_121 VPWR VGND VPWR VGND sky130_ef_sc_hd__decap_12
XFILLER_25_1267 VGND VGND VPWR VPWR sky130_fd_sc_hd__decap_6
XFILLER_9_1497 VPWR VGND VPWR VGND sky130_ef_sc_hd__decap_12
XFILLER_112_1215 VPWR VGND VPWR VGND sky130_ef_sc_hd__decap_12
XTAP_TAPCELL_ROW_184_1855 VGND VPWR sky130_fd_sc_hd__tapvpwrvgnd_1
XFILLER_151_1275 VPWR VGND VPWR VGND sky130_ef_sc_hd__decap_12
XFILLER_116_1395 VPWR VGND VPWR VGND sky130_ef_sc_hd__decap_12
XTAP_TAPCELL_ROW_184_1866 VGND VPWR sky130_fd_sc_hd__tapvpwrvgnd_1
XTAP_TAPCELL_ROW_21_2_3878 VGND VPWR sky130_fd_sc_hd__tapvpwrvgnd_1
XFILLER_217_839 VGND VGND VPWR VPWR sky130_fd_sc_hd__fill_1
XFILLER_228_165 VPWR VGND VPWR VGND sky130_ef_sc_hd__decap_12
XFILLER_244_625 VPWR VGND VPWR VGND sky130_ef_sc_hd__decap_12
XFILLER_112_1259 VPWR VGND VPWR VGND sky130_ef_sc_hd__decap_12
XFILLER_243_113 VPWR VGND VPWR VGND sky130_ef_sc_hd__decap_12
XFILLER_99_1379 VGND VGND VPWR VPWR sky130_fd_sc_hd__decap_6
XFILLER_113_69 VGND VGND VPWR VPWR sky130_fd_sc_hd__fill_2
XFILLER_244_669 VPWR VGND VPWR VGND sky130_ef_sc_hd__decap_12
XFILLER_3_1063 VGND VGND VPWR VPWR sky130_fd_sc_hd__fill_1
XFILLER_227_1313 VPWR VGND VPWR VGND sky130_ef_sc_hd__decap_12
XTAP_TAPCELL_ROW_53_1_1188 VGND VPWR sky130_fd_sc_hd__tapvpwrvgnd_1
Xwire85 _252_ VGND VGND VPWR VPWR net85 sky130_fd_sc_hd__clkbuf_1
XFILLER_184_1073 VPWR VGND VPWR VGND sky130_ef_sc_hd__decap_12
XFILLER_227_1357 VPWR VGND VPWR VGND sky130_ef_sc_hd__decap_12
XFILLER_212_533 VPWR VGND VPWR VGND sky130_ef_sc_hd__decap_12
XPHY_EDGE_ROW_73_1_Right_729 VGND VGND VPWR VPWR sky130_fd_sc_hd__decap_3
XFILLER_196_245 VGND VGND VPWR VPWR sky130_fd_sc_hd__decap_6
XFILLER_71_1243 VPWR VGND VPWR VGND sky130_ef_sc_hd__decap_12
XFILLER_123_1311 VPWR VGND VPWR VGND sky130_ef_sc_hd__decap_12
XFILLER_127_1491 VGND VGND VPWR VPWR sky130_fd_sc_hd__decap_6
XFILLER_162_1371 VPWR VGND VPWR VGND sky130_ef_sc_hd__decap_12
XTAP_TAPCELL_ROW_140_2_4592 VGND VPWR sky130_fd_sc_hd__tapvpwrvgnd_1
XFILLER_178_993 VPWR VGND VPWR VGND sky130_ef_sc_hd__decap_12
XFILLER_196_289 VPWR VGND VPWR VGND sky130_ef_sc_hd__decap_12
XFILLER_32_1227 VPWR VGND VPWR VGND sky130_ef_sc_hd__decap_12
XTAP_TAPCELL_ROW_139_2_4586 VGND VPWR sky130_fd_sc_hd__tapvpwrvgnd_1
XFILLER_71_1287 VPWR VGND VPWR VGND sky130_ef_sc_hd__decap_12
XFILLER_123_1355 VPWR VGND VPWR VGND sky130_ef_sc_hd__decap_12
XFILLER_197_1401 VPWR VGND VPWR VGND sky130_ef_sc_hd__decap_12
XFILLER_123_1399 VPWR VGND VPWR VGND sky130_ef_sc_hd__decap_12
XFILLER_158_1407 VGND VGND VPWR VPWR sky130_fd_sc_hd__decap_6
XFILLER_98_15 VPWR VGND VPWR VGND sky130_ef_sc_hd__decap_12
XFILLER_180_613 VPWR VGND VPWR VGND sky130_ef_sc_hd__decap_12
XFILLER_3_325 VGND VGND VPWR VPWR sky130_fd_sc_hd__decap_4
XFILLER_238_1453 VPWR VGND VPWR VGND sky130_ef_sc_hd__decap_12
XFILLER_180_657 VPWR VGND VPWR VGND sky130_ef_sc_hd__decap_12
XFILLER_234_1317 VPWR VGND VPWR VGND sky130_ef_sc_hd__decap_12
XFILLER_191_1033 VPWR VGND VPWR VGND sky130_ef_sc_hd__decap_12
XFILLER_238_1497 VPWR VGND VPWR VGND sky130_ef_sc_hd__decap_12
XFILLER_154_65 VGND VGND VPWR VPWR sky130_fd_sc_hd__decap_6
XFILLER_191_1077 VPWR VGND VPWR VGND sky130_ef_sc_hd__decap_12
XFILLER_43_1323 VGND VGND VPWR VPWR sky130_fd_sc_hd__decap_6
XFILLER_82_1383 VPWR VGND VPWR VGND sky130_ef_sc_hd__decap_12
XFILLER_134_1451 VPWR VGND VPWR VGND sky130_ef_sc_hd__decap_12
XFILLER_247_441 VGND VGND VPWR VPWR sky130_fd_sc_hd__decap_6
XFILLER_43_1367 VPWR VGND VPWR VGND sky130_ef_sc_hd__decap_12
XFILLER_130_1315 VPWR VGND VPWR VGND sky130_ef_sc_hd__decap_12
XFILLER_232_1085 VGND VGND VPWR VPWR sky130_fd_sc_hd__decap_6
XFILLER_134_1495 VPWR VGND VPWR VGND sky130_ef_sc_hd__decap_12
XTAP_TAPCELL_ROW_112_2_4427 VGND VPWR sky130_fd_sc_hd__tapvpwrvgnd_1
XFILLER_207_305 VPWR VGND VPWR VGND sky130_ef_sc_hd__decap_12
XFILLER_247_485 VPWR VGND VPWR VGND sky130_ef_sc_hd__decap_12
XFILLER_130_1359 VPWR VGND VPWR VGND sky130_ef_sc_hd__decap_12
XFILLER_170_53 VPWR VGND VPWR VGND sky130_ef_sc_hd__decap_12
XFILLER_207_349 VPWR VGND VPWR VGND sky130_ef_sc_hd__decap_12
XFILLER_223_809 VPWR VGND VPWR VGND sky130_ef_sc_hd__decap_12
XFILLER_170_97 VPWR VGND VPWR VGND sky130_ef_sc_hd__decap_12
XFILLER_216_861 VGND VGND VPWR VPWR sky130_fd_sc_hd__decap_6
XFILLER_245_1413 VPWR VGND VPWR VGND sky130_ef_sc_hd__decap_12
XTAP_TAPCELL_ROW_202_2350 VGND VPWR sky130_fd_sc_hd__tapvpwrvgnd_1
XFILLER_188_713 VPWR VGND VPWR VGND sky130_ef_sc_hd__decap_12
XFILLER_63_51 VGND VGND VPWR VPWR sky130_fd_sc_hd__decap_4
XFILLER_76_1165 VPWR VGND VPWR VGND sky130_ef_sc_hd__decap_12
XFILLER_245_1457 VPWR VGND VPWR VGND sky130_ef_sc_hd__decap_12
XFILLER_215_393 VPWR VGND VPWR VGND sky130_ef_sc_hd__decap_12
XFILLER_231_853 VPWR VGND VPWR VGND sky130_ef_sc_hd__decap_12
XFILLER_187_223 VGND VGND VPWR VPWR sky130_fd_sc_hd__fill_1
XFILLER_179_51 VGND VGND VPWR VPWR sky130_fd_sc_hd__decap_4
XFILLER_188_757 VPWR VGND VPWR VGND sky130_ef_sc_hd__decap_12
XFILLER_230_363 VGND VGND VPWR VPWR sky130_fd_sc_hd__fill_1
XTAP_TAPCELL_ROW_60_2_4114 VGND VPWR sky130_fd_sc_hd__tapvpwrvgnd_1
XFILLER_231_897 VPWR VGND VPWR VGND sky130_ef_sc_hd__decap_12
XTAP_TAPCELL_ROW_59_2_4108 VGND VPWR sky130_fd_sc_hd__tapvpwrvgnd_1
XFILLER_54_1463 VGND VGND VPWR VPWR sky130_fd_sc_hd__decap_6
XFILLER_141_1411 VPWR VGND VPWR VGND sky130_ef_sc_hd__decap_12
XTAP_TAPCELL_ROW_190_2004 VGND VPWR sky130_fd_sc_hd__tapvpwrvgnd_1
XFILLER_175_429 VPWR VGND VPWR VGND sky130_ef_sc_hd__decap_12
XTAP_TAPCELL_ROW_190_2015 VGND VPWR sky130_fd_sc_hd__tapvpwrvgnd_1
XTAP_TAPCELL_ROW_190_2026 VGND VPWR sky130_fd_sc_hd__tapvpwrvgnd_1
XTAP_TAPCELL_ROW_215_2700 VGND VPWR sky130_fd_sc_hd__tapvpwrvgnd_1
XFILLER_50_1327 VPWR VGND VPWR VGND sky130_ef_sc_hd__decap_12
XFILLER_7_620 VGND VGND VPWR VPWR sky130_fd_sc_hd__fill_2
XFILLER_141_1455 VPWR VGND VPWR VGND sky130_ef_sc_hd__decap_12
XPHY_EDGE_ROW_100_2_Left_602 VGND VGND VPWR VPWR sky130_fd_sc_hd__decap_3
Xwire551 net72 VGND VGND VPWR VPWR net551 sky130_fd_sc_hd__buf_1
XFILLER_200_1029 VGND VGND VPWR VPWR sky130_fd_sc_hd__decap_6
Xwire562 net564 VGND VGND VPWR VPWR net562 sky130_fd_sc_hd__clkbuf_1
XFILLER_102_1439 VPWR VGND VPWR VGND sky130_ef_sc_hd__decap_12
Xwire573 dout0_q\[12\] VGND VGND VPWR VPWR net573 sky130_fd_sc_hd__clkbuf_1
XFILLER_141_1499 VPWR VGND VPWR VGND sky130_ef_sc_hd__decap_12
XFILLER_6_141 VPWR VGND VPWR VGND sky130_ef_sc_hd__decap_12
XFILLER_183_473 VPWR VGND VPWR VGND sky130_ef_sc_hd__decap_12
Xwire584 dout0_q\[4\] VGND VGND VPWR VPWR net584 sky130_fd_sc_hd__clkbuf_1
Xmax_cap328 _148_ VGND VGND VPWR VPWR net328 sky130_fd_sc_hd__clkbuf_1
XFILLER_48_1245 VGND VGND VPWR VPWR sky130_fd_sc_hd__fill_1
XFILLER_174_1253 VGND VGND VPWR VPWR sky130_fd_sc_hd__decap_6
XFILLER_170_189 VGND VGND VPWR VPWR sky130_fd_sc_hd__decap_6
XFILLER_170_1117 VPWR VGND VPWR VGND sky130_ef_sc_hd__decap_12
XFILLER_174_1297 VPWR VGND VPWR VGND sky130_ef_sc_hd__decap_12
XTAP_TAPCELL_ROW_209_2515 VGND VPWR sky130_fd_sc_hd__tapvpwrvgnd_1
XTAP_TAPCELL_ROW_209_2526 VGND VPWR sky130_fd_sc_hd__tapvpwrvgnd_1
XFILLER_61_1423 VPWR VGND VPWR VGND sky130_ef_sc_hd__decap_12
XTAP_TAPCELL_ROW_209_2537 VGND VPWR sky130_fd_sc_hd__tapvpwrvgnd_1
XFILLER_250_1141 VGND VGND VPWR VPWR sky130_fd_sc_hd__decap_6
XFILLER_26_3 VPWR VGND VPWR VGND sky130_ef_sc_hd__decap_12
XFILLER_239_953 VPWR VGND VPWR VGND sky130_ef_sc_hd__decap_12
XFILLER_22_1407 VGND VGND VPWR VPWR sky130_fd_sc_hd__decap_6
XFILLER_61_1467 VPWR VGND VPWR VGND sky130_ef_sc_hd__decap_12
XFILLER_250_1185 VPWR VGND VPWR VGND sky130_ef_sc_hd__decap_12
XFILLER_254_923 VGND VGND VPWR VPWR sky130_fd_sc_hd__fill_1
XFILLER_226_625 VPWR VGND VPWR VGND sky130_ef_sc_hd__decap_12
XFILLER_211_1169 VGND VGND VPWR VPWR sky130_fd_sc_hd__decap_6
XFILLER_225_113 VPWR VGND VPWR VGND sky130_ef_sc_hd__decap_12
XFILLER_168_1035 VGND VGND VPWR VPWR sky130_fd_sc_hd__fill_1
XFILLER_226_669 VPWR VGND VPWR VGND sky130_ef_sc_hd__decap_12
XFILLER_241_617 VPWR VGND VPWR VGND sky130_ef_sc_hd__decap_12
XPHY_EDGE_ROW_166_Right_11 VGND VGND VPWR VPWR sky130_fd_sc_hd__decap_3
XFILLER_209_1021 VPWR VGND VPWR VGND sky130_ef_sc_hd__decap_12
XFILLER_59_1385 VGND VGND VPWR VPWR sky130_fd_sc_hd__fill_1
XFILLER_181_1213 VPWR VGND VPWR VGND sky130_ef_sc_hd__decap_12
XFILLER_185_1393 VGND VGND VPWR VPWR sky130_fd_sc_hd__decap_6
XFILLER_209_1065 VPWR VGND VPWR VGND sky130_ef_sc_hd__decap_12
XFILLER_178_245 VGND VGND VPWR VPWR sky130_fd_sc_hd__decap_6
XFILLER_181_1257 VPWR VGND VPWR VGND sky130_ef_sc_hd__decap_12
XFILLER_221_385 VGND VGND VPWR VPWR sky130_fd_sc_hd__decap_6
XFILLER_178_289 VPWR VGND VPWR VGND sky130_ef_sc_hd__decap_12
XPHY_EDGE_ROW_32_2_Left_534 VGND VGND VPWR VPWR sky130_fd_sc_hd__decap_3
XFILLER_194_749 VGND VGND VPWR VPWR sky130_fd_sc_hd__decap_6
XTAP_TAPCELL_ROW_177_1670 VGND VPWR sky130_fd_sc_hd__tapvpwrvgnd_1
XFILLER_193_237 VPWR VGND VPWR VGND sky130_ef_sc_hd__decap_12
XTAP_TAPCELL_ROW_173_1545 VGND VPWR sky130_fd_sc_hd__tapvpwrvgnd_1
XTAP_TAPCELL_ROW_173_1556 VGND VPWR sky130_fd_sc_hd__tapvpwrvgnd_1
XTAP_TAPCELL_ROW_173_1567 VGND VPWR sky130_fd_sc_hd__tapvpwrvgnd_1
XPHY_EDGE_ROW_175_Right_20 VGND VGND VPWR VPWR sky130_fd_sc_hd__decap_3
XFILLER_179_1175 VGND VGND VPWR VPWR sky130_fd_sc_hd__fill_1
XFILLER_66_1301 VGND VGND VPWR VPWR sky130_fd_sc_hd__fill_1
XFILLER_255_53 VGND VGND VPWR VPWR sky130_fd_sc_hd__decap_3
XTAP_TAPCELL_ROW_73_2_4192 VGND VPWR sky130_fd_sc_hd__tapvpwrvgnd_1
XFILLER_1_829 VGND VGND VPWR VPWR sky130_fd_sc_hd__decap_4
XFILLER_118_1413 VGND VGND VPWR VPWR sky130_fd_sc_hd__fill_1
XFILLER_68_29 VPWR VGND VPWR VGND sky130_ef_sc_hd__decap_12
XFILLER_192_1353 VPWR VGND VPWR VGND sky130_ef_sc_hd__decap_12
XFILLER_255_97 VPWR VGND VPWR VGND sky130_ef_sc_hd__decap_12
XTAP_TAPCELL_ROW_186_1906 VGND VPWR sky130_fd_sc_hd__tapvpwrvgnd_1
XFILLER_27_1329 VGND VGND VPWR VPWR sky130_fd_sc_hd__fill_1
XTAP_TAPCELL_ROW_186_1917 VGND VPWR sky130_fd_sc_hd__tapvpwrvgnd_1
XFILLER_192_1397 VPWR VGND VPWR VGND sky130_ef_sc_hd__decap_12
XFILLER_9_1261 VPWR VGND VPWR VGND sky130_ef_sc_hd__decap_12
XPHY_EDGE_ROW_109_1_Left_364 VGND VGND VPWR VPWR sky130_fd_sc_hd__decap_3
XFILLER_229_441 VGND VGND VPWR VPWR sky130_fd_sc_hd__decap_6
XFILLER_40_1507 VGND VGND VPWR VPWR sky130_fd_sc_hd__decap_8
XFILLER_229_485 VPWR VGND VPWR VGND sky130_ef_sc_hd__decap_12
XFILLER_245_945 VGND VGND VPWR VPWR sky130_fd_sc_hd__decap_6
XFILLER_5_1169 VGND VGND VPWR VPWR sky130_fd_sc_hd__decap_6
XFILLER_244_433 VPWR VGND VPWR VGND sky130_ef_sc_hd__decap_12
XFILLER_99_1165 VPWR VGND VPWR VGND sky130_ef_sc_hd__decap_12
XFILLER_205_809 VPWR VGND VPWR VGND sky130_ef_sc_hd__decap_12
XFILLER_245_989 VPWR VGND VPWR VGND sky130_ef_sc_hd__decap_12
XPHY_EDGE_ROW_46_1_Left_301 VGND VGND VPWR VPWR sky130_fd_sc_hd__decap_3
XFILLER_17_55 VGND VGND VPWR VPWR sky130_fd_sc_hd__fill_1
XFILLER_244_477 VPWR VGND VPWR VGND sky130_ef_sc_hd__decap_12
XTAP_TAPCELL_ROW_0_840 VGND VPWR sky130_fd_sc_hd__tapvpwrvgnd_1
XTAP_TAPCELL_ROW_0_851 VGND VPWR sky130_fd_sc_hd__tapvpwrvgnd_1
XFILLER_77_1441 VGND VGND VPWR VPWR sky130_fd_sc_hd__fill_1
XTAP_TAPCELL_ROW_0_862 VGND VPWR sky130_fd_sc_hd__tapvpwrvgnd_1
XFILLER_231_105 VGND VGND VPWR VPWR sky130_fd_sc_hd__decap_6
XTAP_TAPCELL_ROW_0_873 VGND VPWR sky130_fd_sc_hd__tapvpwrvgnd_1
XFILLER_227_1121 VPWR VGND VPWR VGND sky130_ef_sc_hd__decap_12
XFILLER_169_223 VGND VGND VPWR VPWR sky130_fd_sc_hd__fill_1
XFILLER_213_853 VPWR VGND VPWR VGND sky130_ef_sc_hd__decap_12
XFILLER_231_149 VPWR VGND VPWR VGND sky130_ef_sc_hd__decap_12
XFILLER_38_1469 VGND VGND VPWR VPWR sky130_fd_sc_hd__fill_1
XFILLER_223_1007 VGND VGND VPWR VPWR sky130_fd_sc_hd__fill_1
XTAP_TAPCELL_ROW_45_2_4027 VGND VPWR sky130_fd_sc_hd__tapvpwrvgnd_1
XFILLER_212_363 VGND VGND VPWR VPWR sky130_fd_sc_hd__fill_1
XTAP_TAPCELL_ROW_255_3770 VGND VPWR sky130_fd_sc_hd__tapvpwrvgnd_1
XFILLER_33_43 VGND VGND VPWR VPWR sky130_fd_sc_hd__fill_1
XFILLER_213_897 VPWR VGND VPWR VGND sky130_ef_sc_hd__decap_12
XTAP_TAPCELL_ROW_255_3781 VGND VPWR sky130_fd_sc_hd__tapvpwrvgnd_1
XFILLER_185_727 VGND VGND VPWR VPWR sky130_fd_sc_hd__fill_1
XFILLER_200_525 VGND VGND VPWR VPWR sky130_fd_sc_hd__decap_6
XTAP_TAPCELL_ROW_255_3792 VGND VPWR sky130_fd_sc_hd__tapvpwrvgnd_1
XFILLER_33_65 VGND VGND VPWR VPWR sky130_fd_sc_hd__fill_1
XFILLER_130_3 VPWR VGND VPWR VGND sky130_ef_sc_hd__decap_12
XFILLER_228_3 VPWR VGND VPWR VGND sky130_ef_sc_hd__decap_12
XTAP_TAPCELL_ROW_251_3656 VGND VPWR sky130_fd_sc_hd__tapvpwrvgnd_1
XFILLER_200_569 VPWR VGND VPWR VGND sky130_ef_sc_hd__decap_12
XTAP_TAPCELL_ROW_251_3667 VGND VPWR sky130_fd_sc_hd__tapvpwrvgnd_1
XFILLER_240_1365 VGND VGND VPWR VPWR sky130_fd_sc_hd__decap_6
XPHY_EDGE_ROW_89_2_Left_591 VGND VGND VPWR VPWR sky130_fd_sc_hd__decap_3
XFILLER_197_1231 VGND VGND VPWR VPWR sky130_fd_sc_hd__fill_1
XFILLER_165_473 VGND VGND VPWR VPWR sky130_fd_sc_hd__decap_3
XFILLER_158_1215 VPWR VGND VPWR VGND sky130_ef_sc_hd__decap_12
XFILLER_181_933 VPWR VGND VPWR VGND sky130_ef_sc_hd__decap_12
XFILLER_180_421 VPWR VGND VPWR VGND sky130_ef_sc_hd__decap_12
XFILLER_3_111 VGND VGND VPWR VPWR sky130_fd_sc_hd__fill_1
XFILLER_158_1259 VPWR VGND VPWR VGND sky130_ef_sc_hd__decap_12
XFILLER_181_977 VPWR VGND VPWR VGND sky130_ef_sc_hd__decap_12
XFILLER_165_53 VGND VGND VPWR VPWR sky130_fd_sc_hd__decap_3
XFILLER_238_1261 VPWR VGND VPWR VGND sky130_ef_sc_hd__decap_12
XTAP_TAPCELL_ROW_249_3596 VGND VPWR sky130_fd_sc_hd__tapvpwrvgnd_1
XFILLER_165_97 VPWR VGND VPWR VGND sky130_ef_sc_hd__decap_12
XFILLER_239_205 VPWR VGND VPWR VGND sky130_ef_sc_hd__decap_12
XFILLER_234_1147 VGND VGND VPWR VPWR sky130_fd_sc_hd__fill_1
XFILLER_171_1437 VPWR VGND VPWR VGND sky130_ef_sc_hd__decap_12
XFILLER_239_249 VPWR VGND VPWR VGND sky130_ef_sc_hd__decap_12
XTAP_TAPCELL_ROW_162_2_4724 VGND VPWR sky130_fd_sc_hd__tapvpwrvgnd_1
XFILLER_82_1191 VPWR VGND VPWR VGND sky130_ef_sc_hd__decap_12
XFILLER_236_923 VGND VGND VPWR VPWR sky130_fd_sc_hd__fill_1
XTAP_TAPCELL_ROW_204_2401 VGND VPWR sky130_fd_sc_hd__tapvpwrvgnd_1
XFILLER_208_625 VPWR VGND VPWR VGND sky130_ef_sc_hd__decap_12
XFILLER_207_113 VPWR VGND VPWR VGND sky130_ef_sc_hd__decap_12
XFILLER_247_293 VPWR VGND VPWR VGND sky130_ef_sc_hd__decap_12
XFILLER_78_1227 VPWR VGND VPWR VGND sky130_ef_sc_hd__decap_12
XFILLER_208_669 VPWR VGND VPWR VGND sky130_ef_sc_hd__decap_12
XFILLER_130_1189 VGND VGND VPWR VPWR sky130_fd_sc_hd__fill_1
XFILLER_223_617 VPWR VGND VPWR VGND sky130_ef_sc_hd__decap_12
XPHY_EDGE_ROW_30_1_Left_285 VGND VGND VPWR VPWR sky130_fd_sc_hd__decap_3
XFILLER_169_1399 VGND VGND VPWR VPWR sky130_fd_sc_hd__fill_1
XFILLER_200_15 VPWR VGND VPWR VGND sky130_ef_sc_hd__decap_12
XFILLER_250_469 VGND VGND VPWR VPWR sky130_fd_sc_hd__decap_6
XFILLER_206_1205 VPWR VGND VPWR VGND sky130_ef_sc_hd__decap_12
XFILLER_245_1287 VGND VGND VPWR VPWR sky130_fd_sc_hd__fill_1
XFILLER_203_385 VGND VGND VPWR VPWR sky130_fd_sc_hd__decap_6
XFILLER_188_587 VGND VGND VPWR VPWR sky130_fd_sc_hd__fill_1
XFILLER_54_1271 VPWR VGND VPWR VGND sky130_ef_sc_hd__decap_12
XFILLER_176_749 VGND VGND VPWR VPWR sky130_fd_sc_hd__decap_6
XFILLER_175_237 VPWR VGND VPWR VGND sky130_ef_sc_hd__decap_12
XFILLER_198_1017 VPWR VGND VPWR VGND sky130_ef_sc_hd__decap_12
XFILLER_15_1255 VPWR VGND VPWR VGND sky130_ef_sc_hd__decap_12
XFILLER_102_1203 VPWR VGND VPWR VGND sky130_ef_sc_hd__decap_12
XFILLER_89_1323 VGND VGND VPWR VPWR sky130_fd_sc_hd__decap_6
XFILLER_106_1383 VPWR VGND VPWR VGND sky130_ef_sc_hd__decap_12
XFILLER_8_973 VGND VGND VPWR VPWR sky130_fd_sc_hd__decap_6
XFILLER_15_1299 VPWR VGND VPWR VGND sky130_ef_sc_hd__decap_12
Xwire370 net371 VGND VGND VPWR VPWR net370 sky130_fd_sc_hd__clkbuf_1
XFILLER_102_1247 VPWR VGND VPWR VGND sky130_ef_sc_hd__decap_12
Xwire381 net382 VGND VGND VPWR VPWR net381 sky130_fd_sc_hd__clkbuf_1
XFILLER_89_1367 VPWR VGND VPWR VGND sky130_ef_sc_hd__decap_12
XFILLER_176_1315 VGND VGND VPWR VPWR sky130_fd_sc_hd__fill_1
XFILLER_184_793 VPWR VGND VPWR VGND sky130_ef_sc_hd__decap_12
XFILLER_209_57 VPWR VGND VPWR VGND sky130_ef_sc_hd__decap_12
Xwire392 net393 VGND VGND VPWR VPWR net392 sky130_fd_sc_hd__clkbuf_1
XFILLER_183_281 VPWR VGND VPWR VGND sky130_ef_sc_hd__decap_12
Xmax_cap136 _125_ VGND VGND VPWR VPWR net136 sky130_fd_sc_hd__clkbuf_1
Xmax_cap158 _162_ VGND VGND VPWR VPWR net158 sky130_fd_sc_hd__clkbuf_1
XFILLER_217_1301 VPWR VGND VPWR VGND sky130_ef_sc_hd__decap_12
Xmax_cap169 net170 VGND VGND VPWR VPWR net169 sky130_fd_sc_hd__clkbuf_1
XFILLER_252_1203 VGND VGND VPWR VPWR sky130_fd_sc_hd__fill_1
XFILLER_174_1061 VPWR VGND VPWR VGND sky130_ef_sc_hd__decap_12
XFILLER_217_1345 VPWR VGND VPWR VGND sky130_ef_sc_hd__decap_12
XFILLER_61_1231 VPWR VGND VPWR VGND sky130_ef_sc_hd__decap_12
XFILLER_26_1351 VGND VGND VPWR VPWR sky130_fd_sc_hd__decap_6
XFILLER_22_1215 VPWR VGND VPWR VGND sky130_ef_sc_hd__decap_12
XFILLER_239_783 VGND VGND VPWR VPWR sky130_fd_sc_hd__fill_1
XFILLER_61_1275 VPWR VGND VPWR VGND sky130_ef_sc_hd__decap_12
XFILLER_26_1395 VPWR VGND VPWR VGND sky130_ef_sc_hd__decap_12
XFILLER_113_1343 VPWR VGND VPWR VGND sky130_ef_sc_hd__decap_12
XTAP_TAPCELL_ROW_166_1360 VGND VPWR sky130_fd_sc_hd__tapvpwrvgnd_1
XTAP_TAPCELL_ROW_51_2_4059 VGND VPWR sky130_fd_sc_hd__tapvpwrvgnd_1
XFILLER_2_1309 VGND VGND VPWR VPWR sky130_fd_sc_hd__decap_6
XTAP_TAPCELL_ROW_166_1371 VGND VPWR sky130_fd_sc_hd__tapvpwrvgnd_1
XFILLER_227_945 VGND VGND VPWR VPWR sky130_fd_sc_hd__decap_6
XFILLER_22_1259 VPWR VGND VPWR VGND sky130_ef_sc_hd__decap_12
XFILLER_226_433 VPWR VGND VPWR VGND sky130_ef_sc_hd__decap_12
XFILLER_241_55 VGND VGND VPWR VPWR sky130_fd_sc_hd__fill_1
XFILLER_96_1327 VPWR VGND VPWR VGND sky130_ef_sc_hd__decap_12
XFILLER_113_1387 VPWR VGND VPWR VGND sky130_ef_sc_hd__decap_12
XFILLER_187_1455 VGND VGND VPWR VPWR sky130_fd_sc_hd__fill_1
XFILLER_227_989 VPWR VGND VPWR VGND sky130_ef_sc_hd__decap_12
XFILLER_226_477 VPWR VGND VPWR VGND sky130_ef_sc_hd__decap_12
XFILLER_246_1029 VGND VGND VPWR VPWR sky130_fd_sc_hd__decap_6
XFILLER_242_937 VPWR VGND VPWR VGND sky130_ef_sc_hd__decap_12
XFILLER_213_105 VGND VGND VPWR VPWR sky130_fd_sc_hd__decap_6
XFILLER_0_1033 VGND VGND VPWR VPWR sky130_fd_sc_hd__decap_3
XFILLER_148_1439 VPWR VGND VPWR VGND sky130_ef_sc_hd__decap_12
XFILLER_198_307 VGND VGND VPWR VPWR sky130_fd_sc_hd__fill_1
XFILLER_228_1441 VPWR VGND VPWR VGND sky130_ef_sc_hd__decap_12
XFILLER_241_447 VGND VGND VPWR VPWR sky130_fd_sc_hd__fill_1
XTAP_TAPCELL_ROW_179_1710 VGND VPWR sky130_fd_sc_hd__tapvpwrvgnd_1
XFILLER_0_1077 VPWR VGND VPWR VGND sky130_ef_sc_hd__decap_12
XFILLER_110_15 VPWR VGND VPWR VGND sky130_ef_sc_hd__decap_12
XFILLER_213_149 VPWR VGND VPWR VGND sky130_ef_sc_hd__decap_12
XTAP_TAPCELL_ROW_179_1721 VGND VPWR sky130_fd_sc_hd__tapvpwrvgnd_1
XTAP_TAPCELL_ROW_16_2_3851 VGND VPWR sky130_fd_sc_hd__tapvpwrvgnd_1
XFILLER_181_1021 VPWR VGND VPWR VGND sky130_ef_sc_hd__decap_12
XFILLER_228_1485 VPWR VGND VPWR VGND sky130_ef_sc_hd__decap_12
XFILLER_250_981 VPWR VGND VPWR VGND sky130_ef_sc_hd__decap_12
XFILLER_181_1065 VPWR VGND VPWR VGND sky130_ef_sc_hd__decap_12
XFILLER_167_727 VGND VGND VPWR VPWR sky130_fd_sc_hd__fill_1
XTAP_TAPCELL_ROW_175_1607 VGND VPWR sky130_fd_sc_hd__tapvpwrvgnd_1
XFILLER_194_513 VPWR VGND VPWR VGND sky130_ef_sc_hd__decap_12
XPHY_EDGE_ROW_3_Right_3 VGND VGND VPWR VPWR sky130_fd_sc_hd__decap_3
XTAP_TAPCELL_ROW_175_1618 VGND VPWR sky130_fd_sc_hd__tapvpwrvgnd_1
XFILLER_33_1311 VPWR VGND VPWR VGND sky130_ef_sc_hd__decap_12
XFILLER_37_1491 VGND VGND VPWR VPWR sky130_fd_sc_hd__decap_6
XFILLER_72_1371 VPWR VGND VPWR VGND sky130_ef_sc_hd__decap_12
XFILLER_210_867 VGND VGND VPWR VPWR sky130_fd_sc_hd__fill_1
XFILLER_221_193 VPWR VGND VPWR VGND sky130_ef_sc_hd__decap_12
XFILLER_194_557 VPWR VGND VPWR VGND sky130_ef_sc_hd__decap_12
XFILLER_33_1355 VPWR VGND VPWR VGND sky130_ef_sc_hd__decap_12
XFILLER_120_1303 VPWR VGND VPWR VGND sky130_ef_sc_hd__decap_12
XFILLER_222_1073 VPWR VGND VPWR VGND sky130_ef_sc_hd__decap_12
XFILLER_124_1483 VPWR VGND VPWR VGND sky130_ef_sc_hd__decap_12
XTAP_TAPCELL_ROW_48_1_1183 VGND VPWR sky130_fd_sc_hd__tapvpwrvgnd_1
XFILLER_33_1399 VPWR VGND VPWR VGND sky130_ef_sc_hd__decap_12
XFILLER_68_1407 VGND VGND VPWR VPWR sky130_fd_sc_hd__decap_6
XFILLER_119_57 VPWR VGND VPWR VGND sky130_ef_sc_hd__decap_12
XFILLER_79_39 VPWR VGND VPWR VGND sky130_ef_sc_hd__decap_12
XFILLER_200_1371 VGND VGND VPWR VPWR sky130_fd_sc_hd__fill_1
XFILLER_235_1401 VPWR VGND VPWR VGND sky130_ef_sc_hd__decap_12
XFILLER_249_503 VGND VGND VPWR VPWR sky130_fd_sc_hd__fill_1
XFILLER_192_1161 VPWR VGND VPWR VGND sky130_ef_sc_hd__decap_12
XFILLER_0_125 VPWR VGND VPWR VGND sky130_ef_sc_hd__decap_12
XTAP_TAPCELL_ROW_147_2_4637 VGND VPWR sky130_fd_sc_hd__tapvpwrvgnd_1
XFILLER_95_27 VPWR VGND VPWR VGND sky130_ef_sc_hd__decap_12
XFILLER_237_709 VPWR VGND VPWR VGND sky130_ef_sc_hd__decap_12
XFILLER_0_169 VPWR VGND VPWR VGND sky130_ef_sc_hd__decap_12
XTAP_TAPCELL_ROW_244_3460 VGND VPWR sky130_fd_sc_hd__tapvpwrvgnd_1
XFILLER_44_1451 VPWR VGND VPWR VGND sky130_ef_sc_hd__decap_12
XTAP_TAPCELL_ROW_244_3471 VGND VPWR sky130_fd_sc_hd__tapvpwrvgnd_1
XFILLER_153_1189 VPWR VGND VPWR VGND sky130_ef_sc_hd__decap_12
XTAP_TAPCELL_ROW_244_3482 VGND VPWR sky130_fd_sc_hd__tapvpwrvgnd_1
XFILLER_40_1315 VPWR VGND VPWR VGND sky130_ef_sc_hd__decap_12
XFILLER_218_923 VGND VGND VPWR VPWR sky130_fd_sc_hd__fill_1
XFILLER_44_1495 VPWR VGND VPWR VGND sky130_ef_sc_hd__decap_12
X_630_ clknet_3_5__leaf_clk dout0\[28\] _038_ VGND VGND VPWR VPWR dout0_q\[28\] sky130_fd_sc_hd__dfrtp_1
XTAP_TAPCELL_ROW_5_987 VGND VPWR sky130_fd_sc_hd__tapvpwrvgnd_1
XFILLER_131_1443 VPWR VGND VPWR VGND sky130_ef_sc_hd__decap_12
XTAP_TAPCELL_ROW_5_998 VGND VPWR sky130_fd_sc_hd__tapvpwrvgnd_1
XTAP_TAPCELL_ROW_240_3357 VGND VPWR sky130_fd_sc_hd__tapvpwrvgnd_1
XTAP_TAPCELL_ROW_240_3368 VGND VPWR sky130_fd_sc_hd__tapvpwrvgnd_1
XFILLER_40_1359 VPWR VGND VPWR VGND sky130_ef_sc_hd__decap_12
XFILLER_229_293 VPWR VGND VPWR VGND sky130_ef_sc_hd__decap_12
XFILLER_245_753 VPWR VGND VPWR VGND sky130_ef_sc_hd__decap_12
XFILLER_151_55 VGND VGND VPWR VPWR sky130_fd_sc_hd__fill_1
XFILLER_178_3 VPWR VGND VPWR VGND sky130_ef_sc_hd__decap_12
X_561_ net663 VGND VGND VPWR VPWR _043_ sky130_fd_sc_hd__inv_2
XFILLER_205_617 VPWR VGND VPWR VGND sky130_ef_sc_hd__decap_12
XFILLER_245_797 VPWR VGND VPWR VGND sky130_ef_sc_hd__decap_12
XTAP_TAPCELL_ROW_95_2_4324 VGND VPWR sky130_fd_sc_hd__tapvpwrvgnd_1
XFILLER_189_329 VGND VGND VPWR VPWR sky130_fd_sc_hd__decap_6
X_492_ net169 net103 VGND VGND VPWR VPWR acc_core.adder.cla_blocks\[4\].block.sum\[0\]
+ sky130_fd_sc_hd__xnor2_1
XFILLER_232_469 VGND VGND VPWR VPWR sky130_fd_sc_hd__decap_6
XTAP_TAPCELL_ROW_253_3707 VGND VPWR sky130_fd_sc_hd__tapvpwrvgnd_1
XTAP_TAPCELL_ROW_253_3718 VGND VPWR sky130_fd_sc_hd__tapvpwrvgnd_1
XTAP_TAPCELL_ROW_253_3729 VGND VPWR sky130_fd_sc_hd__tapvpwrvgnd_1
XFILLER_242_1427 VGND VGND VPWR VPWR sky130_fd_sc_hd__fill_1
XFILLER_197_373 VPWR VGND VPWR VGND sky130_ef_sc_hd__decap_12
XFILLER_51_1411 VPWR VGND VPWR VGND sky130_ef_sc_hd__decap_12
XFILLER_200_333 VPWR VGND VPWR VGND sky130_ef_sc_hd__decap_12
XFILLER_90_1471 VPWR VGND VPWR VGND sky130_ef_sc_hd__decap_12
XFILLER_199_1337 VGND VGND VPWR VPWR sky130_fd_sc_hd__decap_6
XFILLER_201_889 VGND VGND VPWR VPWR sky130_fd_sc_hd__decap_6
XFILLER_60_41 VPWR VGND VPWR VGND sky130_ef_sc_hd__decap_12
XFILLER_51_1455 VPWR VGND VPWR VGND sky130_ef_sc_hd__decap_12
XFILLER_201_1113 VGND VGND VPWR VPWR sky130_fd_sc_hd__decap_6
XFILLER_240_1173 VPWR VGND VPWR VGND sky130_ef_sc_hd__decap_12
XFILLER_200_377 VPWR VGND VPWR VGND sky130_ef_sc_hd__decap_12
XFILLER_12_1439 VPWR VGND VPWR VGND sky130_ef_sc_hd__decap_12
XFILLER_176_41 VPWR VGND VPWR VGND sky130_ef_sc_hd__decap_12
XFILLER_51_1499 VPWR VGND VPWR VGND sky130_ef_sc_hd__decap_12
XFILLER_5_921 VPWR VGND VPWR VGND sky130_ef_sc_hd__decap_12
XFILLER_166_793 VPWR VGND VPWR VGND sky130_ef_sc_hd__decap_12
XFILLER_201_1157 VPWR VGND VPWR VGND sky130_ef_sc_hd__decap_12
XFILLER_86_1507 VGND VGND VPWR VPWR sky130_fd_sc_hd__decap_8
XFILLER_165_281 VPWR VGND VPWR VGND sky130_ef_sc_hd__decap_12
XFILLER_176_85 VPWR VGND VPWR VGND sky130_ef_sc_hd__decap_12
XFILLER_181_741 VPWR VGND VPWR VGND sky130_ef_sc_hd__decap_12
XFILLER_5_965 VPWR VGND VPWR VGND sky130_ef_sc_hd__decap_12
XFILLER_180_251 VGND VGND VPWR VPWR sky130_fd_sc_hd__fill_1
XFILLER_181_785 VPWR VGND VPWR VGND sky130_ef_sc_hd__decap_12
XFILLER_5_69 VPWR VGND VPWR VGND sky130_ef_sc_hd__decap_12
XFILLER_45_1204 VPWR VGND VPWR VGND sky130_ef_sc_hd__decap_12
XFILLER_171_1201 VPWR VGND VPWR VGND sky130_ef_sc_hd__decap_12
XFILLER_238_1091 VGND VGND VPWR VPWR sky130_fd_sc_hd__fill_1
XFILLER_175_1381 VPWR VGND VPWR VGND sky130_ef_sc_hd__decap_12
XFILLER_171_1245 VPWR VGND VPWR VGND sky130_ef_sc_hd__decap_12
XFILLER_255_517 VPWR VGND VPWR VGND sky130_ef_sc_hd__decap_12
XFILLER_171_1289 VPWR VGND VPWR VGND sky130_ef_sc_hd__decap_12
XFILLER_10_6 VPWR VGND VPWR VGND sky130_ef_sc_hd__decap_12
XFILLER_212_1253 VGND VGND VPWR VPWR sky130_fd_sc_hd__decap_6
XFILLER_209_945 VGND VGND VPWR VPWR sky130_fd_sc_hd__decap_6
XFILLER_208_433 VPWR VGND VPWR VGND sky130_ef_sc_hd__decap_12
XFILLER_212_1297 VPWR VGND VPWR VGND sky130_ef_sc_hd__decap_12
XFILLER_209_989 VPWR VGND VPWR VGND sky130_ef_sc_hd__decap_12
XFILLER_208_477 VPWR VGND VPWR VGND sky130_ef_sc_hd__decap_12
XFILLER_165_1005 VGND VGND VPWR VPWR sky130_fd_sc_hd__decap_3
XFILLER_224_937 VPWR VGND VPWR VGND sky130_ef_sc_hd__decap_12
XTAP_TAPCELL_ROW_223_2898 VGND VPWR sky130_fd_sc_hd__tapvpwrvgnd_1
XFILLER_250_233 VPWR VGND VPWR VGND sky130_ef_sc_hd__decap_12
XFILLER_223_447 VGND VGND VPWR VPWR sky130_fd_sc_hd__fill_1
XFILLER_165_1049 VPWR VGND VPWR VGND sky130_ef_sc_hd__decap_12
XFILLER_211_69 VPWR VGND VPWR VGND sky130_ef_sc_hd__decap_12
XFILLER_91_1213 VGND VGND VPWR VPWR sky130_fd_sc_hd__decap_4
XFILLER_189_841 VPWR VGND VPWR VGND sky130_ef_sc_hd__decap_12
XFILLER_211_609 VGND VGND VPWR VPWR sky130_fd_sc_hd__decap_6
XFILLER_182_1341 VPWR VGND VPWR VGND sky130_ef_sc_hd__decap_12
XFILLER_250_277 VPWR VGND VPWR VGND sky130_ef_sc_hd__decap_12
XFILLER_232_981 VPWR VGND VPWR VGND sky130_ef_sc_hd__decap_12
XFILLER_93_3 VPWR VGND VPWR VGND sky130_ef_sc_hd__decap_12
XFILLER_206_1035 VGND VGND VPWR VPWR sky130_fd_sc_hd__fill_1
XFILLER_176_513 VPWR VGND VPWR VGND sky130_ef_sc_hd__decap_12
XFILLER_182_1385 VPWR VGND VPWR VGND sky130_ef_sc_hd__decap_12
XFILLER_203_193 VPWR VGND VPWR VGND sky130_ef_sc_hd__decap_12
XFILLER_176_557 VPWR VGND VPWR VGND sky130_ef_sc_hd__decap_12
XFILLER_191_505 VPWR VGND VPWR VGND sky130_ef_sc_hd__decap_12
XFILLER_223_1393 VGND VGND VPWR VPWR sky130_fd_sc_hd__decap_6
XFILLER_106_1191 VPWR VGND VPWR VGND sky130_ef_sc_hd__decap_12
XFILLER_254_1309 VGND VGND VPWR VPWR sky130_fd_sc_hd__decap_6
XFILLER_171_273 VGND VGND VPWR VPWR sky130_fd_sc_hd__decap_6
XFILLER_236_77 VGND VGND VPWR VPWR sky130_fd_sc_hd__decap_6
XFILLER_28_1413 VGND VGND VPWR VPWR sky130_fd_sc_hd__fill_1
XFILLER_193_1481 VPWR VGND VPWR VGND sky130_ef_sc_hd__decap_12
XTAP_TAPCELL_ROW_168_1411 VGND VPWR sky130_fd_sc_hd__tapvpwrvgnd_1
XTAP_TAPCELL_ROW_168_1422 VGND VPWR sky130_fd_sc_hd__tapvpwrvgnd_1
XTAP_TAPCELL_ROW_168_1433 VGND VPWR sky130_fd_sc_hd__tapvpwrvgnd_1
XFILLER_217_1175 VGND VGND VPWR VPWR sky130_fd_sc_hd__fill_1
XFILLER_105_15 VPWR VGND VPWR VGND sky130_ef_sc_hd__decap_12
XFILLER_219_709 VPWR VGND VPWR VGND sky130_ef_sc_hd__decap_12
XFILLER_252_65 VPWR VGND VPWR VGND sky130_ef_sc_hd__decap_12
XTAP_TAPCELL_ROW_113_2_4432 VGND VPWR sky130_fd_sc_hd__tapvpwrvgnd_1
XFILLER_65_19 VPWR VGND VPWR VGND sky130_ef_sc_hd__decap_12
XFILLER_6_1253 VGND VGND VPWR VPWR sky130_fd_sc_hd__decap_6
XTAP_TAPCELL_ROW_2_913 VGND VPWR sky130_fd_sc_hd__tapvpwrvgnd_1
XFILLER_230_1353 VPWR VGND VPWR VGND sky130_ef_sc_hd__decap_12
XTAP_TAPCELL_ROW_2_924 VGND VPWR sky130_fd_sc_hd__tapvpwrvgnd_1
XFILLER_2_1117 VPWR VGND VPWR VGND sky130_ef_sc_hd__decap_12
XFILLER_227_753 VPWR VGND VPWR VGND sky130_ef_sc_hd__decap_12
XFILLER_6_1297 VPWR VGND VPWR VGND sky130_ef_sc_hd__decap_12
XFILLER_230_1397 VPWR VGND VPWR VGND sky130_ef_sc_hd__decap_12
XFILLER_242_701 VPWR VGND VPWR VGND sky130_ef_sc_hd__decap_12
XFILLER_148_1203 VPWR VGND VPWR VGND sky130_ef_sc_hd__decap_12
XTAP_TAPCELL_ROW_81_2_4243 VGND VPWR sky130_fd_sc_hd__tapvpwrvgnd_1
XFILLER_227_797 VPWR VGND VPWR VGND sky130_ef_sc_hd__decap_12
XFILLER_148_1247 VPWR VGND VPWR VGND sky130_ef_sc_hd__decap_12
XFILLER_121_69 VGND VGND VPWR VPWR sky130_fd_sc_hd__fill_2
XFILLER_214_469 VGND VGND VPWR VPWR sky130_fd_sc_hd__decap_6
XFILLER_179_373 VPWR VGND VPWR VGND sky130_ef_sc_hd__decap_12
XFILLER_195_833 VGND VGND VPWR VPWR sky130_fd_sc_hd__decap_6
XFILLER_194_321 VPWR VGND VPWR VGND sky130_ef_sc_hd__decap_12
XFILLER_195_877 VPWR VGND VPWR VGND sky130_ef_sc_hd__decap_12
XFILLER_194_365 VPWR VGND VPWR VGND sky130_ef_sc_hd__decap_12
XFILLER_241_1493 VPWR VGND VPWR VGND sky130_ef_sc_hd__decap_12
XTAP_TAPCELL_ROW_233_3172 VGND VPWR sky130_fd_sc_hd__tapvpwrvgnd_1
XTAP_TAPCELL_ROW_233_3183 VGND VPWR sky130_fd_sc_hd__tapvpwrvgnd_1
XFILLER_5_228 VGND VGND VPWR VPWR sky130_fd_sc_hd__fill_1
XFILLER_202_1477 VGND VGND VPWR VPWR sky130_fd_sc_hd__decap_6
XFILLER_68_1215 VPWR VGND VPWR VGND sky130_ef_sc_hd__decap_12
XFILLER_159_1343 VPWR VGND VPWR VGND sky130_ef_sc_hd__decap_12
XFILLER_120_1177 VPWR VGND VPWR VGND sky130_ef_sc_hd__decap_12
XFILLER_2_902 VPWR VGND VPWR VGND sky130_ef_sc_hd__decap_12
XFILLER_68_1259 VPWR VGND VPWR VGND sky130_ef_sc_hd__decap_12
XFILLER_159_1387 VPWR VGND VPWR VGND sky130_ef_sc_hd__decap_12
XTAP_TAPCELL_ROW_246_3522 VGND VPWR sky130_fd_sc_hd__tapvpwrvgnd_1
XTAP_TAPCELL_ROW_246_3533 VGND VPWR sky130_fd_sc_hd__tapvpwrvgnd_1
XFILLER_235_1231 VGND VGND VPWR VPWR sky130_fd_sc_hd__fill_1
XFILLER_2_979 VGND VGND VPWR VPWR sky130_fd_sc_hd__fill_1
XTAP_TAPCELL_ROW_242_3408 VGND VPWR sky130_fd_sc_hd__tapvpwrvgnd_1
XTAP_TAPCELL_ROW_242_3419 VGND VPWR sky130_fd_sc_hd__tapvpwrvgnd_1
XFILLER_237_517 VPWR VGND VPWR VGND sky130_ef_sc_hd__decap_12
XFILLER_162_65 VGND VGND VPWR VPWR sky130_fd_sc_hd__decap_6
XFILLER_188_1005 VPWR VGND VPWR VGND sky130_ef_sc_hd__decap_12
XTAP_TAPCELL_ROW_8_1067 VGND VPWR sky130_fd_sc_hd__tapvpwrvgnd_1
XTAP_TAPCELL_ROW_8_1078 VGND VPWR sky130_fd_sc_hd__tapvpwrvgnd_1
XFILLER_79_1311 VPWR VGND VPWR VGND sky130_ef_sc_hd__decap_12
XTAP_TAPCELL_ROW_8_1089 VGND VPWR sky130_fd_sc_hd__tapvpwrvgnd_1
XFILLER_188_1049 VPWR VGND VPWR VGND sky130_ef_sc_hd__decap_12
X_613_ clknet_3_6__leaf_clk dout0\[11\] _021_ VGND VGND VPWR VPWR dout0_q\[11\] sky130_fd_sc_hd__dfrtp_1
XFILLER_131_1273 VGND VGND VPWR VPWR sky130_fd_sc_hd__fill_1
XFILLER_245_561 VPWR VGND VPWR VGND sky130_ef_sc_hd__decap_12
XFILLER_40_1189 VGND VGND VPWR VPWR sky130_fd_sc_hd__fill_1
XFILLER_79_1355 VPWR VGND VPWR VGND sky130_ef_sc_hd__decap_12
XFILLER_206_937 VPWR VGND VPWR VGND sky130_ef_sc_hd__decap_12
XFILLER_55_63 VGND VGND VPWR VPWR sky130_fd_sc_hd__decap_8
X_544_ net667 VGND VGND VPWR VPWR _026_ sky130_fd_sc_hd__inv_2
XFILLER_75_1219 VPWR VGND VPWR VGND sky130_ef_sc_hd__decap_12
XFILLER_79_1399 VPWR VGND VPWR VGND sky130_ef_sc_hd__decap_12
XFILLER_205_447 VGND VGND VPWR VPWR sky130_fd_sc_hd__fill_1
XFILLER_229_1057 VGND VGND VPWR VPWR sky130_fd_sc_hd__decap_6
XFILLER_232_233 VPWR VGND VPWR VGND sky130_ef_sc_hd__decap_12
XFILLER_189_137 VPWR VGND VPWR VGND sky130_ef_sc_hd__decap_12
XFILLER_246_1371 VGND VGND VPWR VPWR sky130_fd_sc_hd__fill_1
X_475_ net157 net110 VGND VGND VPWR VPWR acc_core.adder.cla_blocks\[2\].block.sum\[1\]
+ sky130_fd_sc_hd__xnor2_1
XFILLER_232_277 VPWR VGND VPWR VGND sky130_ef_sc_hd__decap_12
XFILLER_214_981 VPWR VGND VPWR VGND sky130_ef_sc_hd__decap_12
XFILLER_186_811 VGND VGND VPWR VPWR sky130_fd_sc_hd__fill_1
XFILLER_71_51 VGND VGND VPWR VPWR sky130_fd_sc_hd__decap_4
XFILLER_198_693 VGND VGND VPWR VPWR sky130_fd_sc_hd__decap_6
XFILLER_199_1101 VPWR VGND VPWR VGND sky130_ef_sc_hd__decap_12
XFILLER_197_181 VPWR VGND VPWR VGND sky130_ef_sc_hd__decap_12
XFILLER_201_653 VPWR VGND VPWR VGND sky130_ef_sc_hd__decap_12
XFILLER_200_141 VPWR VGND VPWR VGND sky130_ef_sc_hd__decap_12
XFILLER_207_1399 VGND VGND VPWR VPWR sky130_fd_sc_hd__fill_1
XFILLER_187_51 VGND VGND VPWR VPWR sky130_fd_sc_hd__decap_4
XFILLER_173_505 VPWR VGND VPWR VGND sky130_ef_sc_hd__decap_12
XFILLER_199_1145 VPWR VGND VPWR VGND sky130_ef_sc_hd__decap_12
XFILLER_12_1203 VPWR VGND VPWR VGND sky130_ef_sc_hd__decap_12
XFILLER_201_697 VPWR VGND VPWR VGND sky130_ef_sc_hd__decap_12
XFILLER_16_1383 VPWR VGND VPWR VGND sky130_ef_sc_hd__decap_12
XFILLER_103_1331 VPWR VGND VPWR VGND sky130_ef_sc_hd__decap_12
XFILLER_195_1009 VPWR VGND VPWR VGND sky130_ef_sc_hd__decap_12
XFILLER_65_7 VPWR VGND VPWR VGND sky130_ef_sc_hd__decap_12
XFILLER_199_1189 VPWR VGND VPWR VGND sky130_ef_sc_hd__decap_12
XFILLER_12_1247 VPWR VGND VPWR VGND sky130_ef_sc_hd__decap_12
XFILLER_86_1315 VPWR VGND VPWR VGND sky130_ef_sc_hd__decap_12
XFILLER_236_1017 VPWR VGND VPWR VGND sky130_ef_sc_hd__decap_12
XFILLER_86_1359 VPWR VGND VPWR VGND sky130_ef_sc_hd__decap_12
XFILLER_138_1427 VPWR VGND VPWR VGND sky130_ef_sc_hd__decap_12
XTAP_TAPCELL_ROW_212_2599 VGND VPWR sky130_fd_sc_hd__tapvpwrvgnd_1
XPHY_EDGE_ROW_164_1_Right_820 VGND VGND VPWR VPWR sky130_fd_sc_hd__decap_3
XFILLER_214_1315 VGND VGND VPWR VPWR sky130_fd_sc_hd__fill_1
XTAP_TAPCELL_ROW_86_2_4269 VGND VPWR sky130_fd_sc_hd__tapvpwrvgnd_1
XTAP_TAPCELL_ROW_225_2949 VGND VPWR sky130_fd_sc_hd__tapvpwrvgnd_1
XPHY_EDGE_ROW_41_2_Left_543 VGND VGND VPWR VPWR sky130_fd_sc_hd__decap_3
XFILLER_23_1343 VPWR VGND VPWR VGND sky130_ef_sc_hd__decap_12
XFILLER_114_1471 VPWR VGND VPWR VGND sky130_ef_sc_hd__decap_12
XFILLER_212_1061 VPWR VGND VPWR VGND sky130_ef_sc_hd__decap_12
XFILLER_97_1411 VPWR VGND VPWR VGND sky130_ef_sc_hd__decap_12
XFILLER_209_753 VPWR VGND VPWR VGND sky130_ef_sc_hd__decap_12
XFILLER_3_1437 VPWR VGND VPWR VGND sky130_ef_sc_hd__decap_12
XFILLER_224_701 VPWR VGND VPWR VGND sky130_ef_sc_hd__decap_12
XFILLER_23_1387 VPWR VGND VPWR VGND sky130_ef_sc_hd__decap_12
XFILLER_247_1113 VGND VGND VPWR VPWR sky130_fd_sc_hd__decap_6
XFILLER_97_1455 VPWR VGND VPWR VGND sky130_ef_sc_hd__decap_12
XFILLER_110_1357 VGND VGND VPWR VPWR sky130_fd_sc_hd__fill_1
XFILLER_209_797 VPWR VGND VPWR VGND sky130_ef_sc_hd__decap_12
XFILLER_58_1439 VPWR VGND VPWR VGND sky130_ef_sc_hd__decap_12
XFILLER_247_1157 VPWR VGND VPWR VGND sky130_ef_sc_hd__decap_12
XFILLER_97_1499 VPWR VGND VPWR VGND sky130_ef_sc_hd__decap_12
XFILLER_251_553 VGND VGND VPWR VPWR sky130_fd_sc_hd__decap_6
XTAP_TAPCELL_ROW_46_2_4032 VGND VPWR sky130_fd_sc_hd__tapvpwrvgnd_1
XFILLER_211_417 VPWR VGND VPWR VGND sky130_ef_sc_hd__decap_12
XFILLER_251_597 VPWR VGND VPWR VGND sky130_ef_sc_hd__decap_12
XFILLER_189_671 VGND VGND VPWR VPWR sky130_fd_sc_hd__fill_1
XFILLER_225_1455 VGND VGND VPWR VPWR sky130_fd_sc_hd__fill_1
XFILLER_177_833 VGND VGND VPWR VPWR sky130_fd_sc_hd__decap_6
XFILLER_176_321 VPWR VGND VPWR VGND sky130_ef_sc_hd__decap_12
XFILLER_220_973 VGND VGND VPWR VPWR sky130_fd_sc_hd__decap_6
XFILLER_177_877 VPWR VGND VPWR VGND sky130_ef_sc_hd__decap_12
XFILLER_143_1177 VPWR VGND VPWR VGND sky130_ef_sc_hd__decap_12
XFILLER_176_365 VPWR VGND VPWR VGND sky130_ef_sc_hd__decap_12
XFILLER_30_1303 VPWR VGND VPWR VGND sky130_ef_sc_hd__decap_12
XPHY_EDGE_ROW_118_1_Left_373 VGND VGND VPWR VPWR sky130_fd_sc_hd__decap_3
XFILLER_192_825 VPWR VGND VPWR VGND sky130_ef_sc_hd__decap_12
XFILLER_34_1483 VPWR VGND VPWR VGND sky130_ef_sc_hd__decap_12
XFILLER_178_1229 VPWR VGND VPWR VGND sky130_ef_sc_hd__decap_12
XFILLER_191_335 VGND VGND VPWR VPWR sky130_fd_sc_hd__fill_1
XFILLER_192_869 VPWR VGND VPWR VGND sky130_ef_sc_hd__decap_12
XFILLER_121_1497 VGND VGND VPWR VPWR sky130_fd_sc_hd__fill_1
XFILLER_2_209 VPWR VGND VPWR VGND sky130_ef_sc_hd__decap_12
XFILLER_254_1117 VPWR VGND VPWR VGND sky130_ef_sc_hd__decap_12
XPHY_EDGE_ROW_55_1_Left_310 VGND VGND VPWR VPWR sky130_fd_sc_hd__decap_3
XFILLER_8_1315 VGND VGND VPWR VPWR sky130_fd_sc_hd__fill_1
XFILLER_115_1213 VGND VGND VPWR VPWR sky130_fd_sc_hd__decap_4
XFILLER_76_29 VPWR VGND VPWR VGND sky130_ef_sc_hd__decap_12
XFILLER_219_517 VPWR VGND VPWR VGND sky130_ef_sc_hd__decap_12
XFILLER_154_1295 VGND VGND VPWR VPWR sky130_fd_sc_hd__decap_6
XFILLER_63_1189 VPWR VGND VPWR VGND sky130_ef_sc_hd__decap_12
XFILLER_189_1325 VPWR VGND VPWR VGND sky130_ef_sc_hd__decap_12
XFILLER_41_1443 VPWR VGND VPWR VGND sky130_ef_sc_hd__decap_12
XFILLER_6_1061 VPWR VGND VPWR VGND sky130_ef_sc_hd__decap_12
XFILLER_230_1161 VPWR VGND VPWR VGND sky130_ef_sc_hd__decap_12
XFILLER_189_1369 VPWR VGND VPWR VGND sky130_ef_sc_hd__decap_12
XFILLER_227_561 VPWR VGND VPWR VGND sky130_ef_sc_hd__decap_12
XFILLER_255_881 VPWR VGND VPWR VGND sky130_ef_sc_hd__decap_12
XFILLER_242_531 VGND VGND VPWR VPWR sky130_fd_sc_hd__fill_1
XFILLER_214_233 VPWR VGND VPWR VGND sky130_ef_sc_hd__decap_12
XFILLER_243_1511 VGND VGND VPWR VPWR sky130_fd_sc_hd__fill_1
XFILLER_214_277 VPWR VGND VPWR VGND sky130_ef_sc_hd__decap_12
XFILLER_230_737 VPWR VGND VPWR VGND sky130_ef_sc_hd__decap_12
XFILLER_168_811 VGND VGND VPWR VPWR sky130_fd_sc_hd__fill_1
XTAP_TAPCELL_ROW_235_3223 VGND VPWR sky130_fd_sc_hd__tapvpwrvgnd_1
XTAP_TAPCELL_ROW_235_3234 VGND VPWR sky130_fd_sc_hd__tapvpwrvgnd_1
XFILLER_211_951 VGND VGND VPWR VPWR sky130_fd_sc_hd__fill_1
XFILLER_179_181 VPWR VGND VPWR VGND sky130_ef_sc_hd__decap_12
XFILLER_195_641 VPWR VGND VPWR VGND sky130_ef_sc_hd__decap_12
XFILLER_161_1255 VPWR VGND VPWR VGND sky130_ef_sc_hd__decap_12
XTAP_TAPCELL_ROW_231_3109 VGND VPWR sky130_fd_sc_hd__tapvpwrvgnd_1
XFILLER_122_1239 VGND VGND VPWR VPWR sky130_fd_sc_hd__decap_6
XFILLER_195_685 VPWR VGND VPWR VGND sky130_ef_sc_hd__decap_12
XFILLER_161_1299 VPWR VGND VPWR VGND sky130_ef_sc_hd__decap_12
XFILLER_202_1241 VPWR VGND VPWR VGND sky130_ef_sc_hd__decap_12
XFILLER_194_195 VGND VGND VPWR VPWR sky130_fd_sc_hd__fill_1
XFILLER_196_1329 VPWR VGND VPWR VGND sky130_ef_sc_hd__decap_12
XFILLER_210_3 VPWR VGND VPWR VGND sky130_ef_sc_hd__decap_12
XFILLER_182_357 VGND VGND VPWR VPWR sky130_fd_sc_hd__decap_6
XFILLER_202_1285 VPWR VGND VPWR VGND sky130_ef_sc_hd__decap_12
XTAP_TAPCELL_ROW_104_2_4377 VGND VPWR sky130_fd_sc_hd__tapvpwrvgnd_1
XFILLER_237_1337 VGND VGND VPWR VPWR sky130_fd_sc_hd__decap_6
XFILLER_2_710 VGND VGND VPWR VPWR sky130_fd_sc_hd__decap_6
XFILLER_81_1201 VPWR VGND VPWR VGND sky130_ef_sc_hd__decap_12
XFILLER_1_231 VGND VGND VPWR VPWR sky130_fd_sc_hd__fill_1
XTAP_TAPCELL_ROW_72_2_4188 VGND VPWR sky130_fd_sc_hd__tapvpwrvgnd_1
XTAP_TAPCELL_ROW_104_1_1239 VGND VPWR sky130_fd_sc_hd__tapvpwrvgnd_1
XPHY_EDGE_ROW_8_Left_264 VGND VGND VPWR VPWR sky130_fd_sc_hd__decap_3
XFILLER_172_1373 VPWR VGND VPWR VGND sky130_ef_sc_hd__decap_12
XFILLER_81_1267 VGND VGND VPWR VPWR sky130_fd_sc_hd__decap_6
XFILLER_238_837 VPWR VGND VPWR VGND sky130_ef_sc_hd__decap_12
XTAP_TAPCELL_ROW_52_2_4064 VGND VPWR sky130_fd_sc_hd__tapvpwrvgnd_1
XFILLER_133_1379 VGND VGND VPWR VPWR sky130_fd_sc_hd__decap_6
XFILLER_168_1409 VPWR VGND VPWR VGND sky130_ef_sc_hd__decap_12
XFILLER_213_1381 VPWR VGND VPWR VGND sky130_ef_sc_hd__decap_12
XFILLER_206_701 VPWR VGND VPWR VGND sky130_ef_sc_hd__decap_12
XFILLER_246_881 VPWR VGND VPWR VGND sky130_ef_sc_hd__decap_12
XTAP_TAPCELL_ROW_220_2813 VGND VPWR sky130_fd_sc_hd__tapvpwrvgnd_1
XTAP_TAPCELL_ROW_220_2824 VGND VPWR sky130_fd_sc_hd__tapvpwrvgnd_1
XFILLER_245_391 VGND VGND VPWR VPWR sky130_fd_sc_hd__fill_1
XTAP_TAPCELL_ROW_220_2835 VGND VPWR sky130_fd_sc_hd__tapvpwrvgnd_1
XFILLER_248_1477 VGND VGND VPWR VPWR sky130_fd_sc_hd__decap_6
XFILLER_233_553 VGND VGND VPWR VPWR sky130_fd_sc_hd__decap_6
X_527_ net663 VGND VGND VPWR VPWR _009_ sky130_fd_sc_hd__inv_2
XFILLER_233_597 VPWR VGND VPWR VGND sky130_ef_sc_hd__decap_12
XTAP_TAPCELL_ROW_197_2193 VGND VPWR sky130_fd_sc_hd__tapvpwrvgnd_1
X_458_ net609 net6 net624 VGND VGND VPWR VPWR addr0\[4\] sky130_fd_sc_hd__mux2_1
XTAP_TAPCELL_ROW_30_2_3934 VGND VPWR sky130_fd_sc_hd__tapvpwrvgnd_1
XFILLER_198_83 VGND VGND VPWR VPWR sky130_fd_sc_hd__fill_1
XTAP_TAPCELL_ROW_29_2_3928 VGND VPWR sky130_fd_sc_hd__tapvpwrvgnd_1
XFILLER_202_973 VGND VGND VPWR VPWR sky130_fd_sc_hd__decap_6
XFILLER_9_331 VGND VGND VPWR VPWR sky130_fd_sc_hd__decap_4
XFILLER_201_461 VPWR VGND VPWR VGND sky130_ef_sc_hd__decap_12
X_389_ _169_ net212 _177_ net216 VGND VGND VPWR VPWR _178_ sky130_fd_sc_hd__a211oi_1
XTAP_TAPCELL_ROW_218_2764 VGND VPWR sky130_fd_sc_hd__tapvpwrvgnd_1
XFILLER_140_1339 VPWR VGND VPWR VGND sky130_ef_sc_hd__decap_12
XFILLER_174_825 VPWR VGND VPWR VGND sky130_ef_sc_hd__decap_12
XFILLER_179_1505 VGND VGND VPWR VPWR sky130_fd_sc_hd__decap_6
XTAP_TAPCELL_ROW_218_2775 VGND VPWR sky130_fd_sc_hd__tapvpwrvgnd_1
XFILLER_220_1341 VPWR VGND VPWR VGND sky130_ef_sc_hd__decap_12
XFILLER_16_1191 VPWR VGND VPWR VGND sky130_ef_sc_hd__decap_12
XFILLER_173_335 VGND VGND VPWR VPWR sky130_fd_sc_hd__fill_1
XFILLER_174_869 VPWR VGND VPWR VGND sky130_ef_sc_hd__decap_12
XFILLER_220_1385 VPWR VGND VPWR VGND sky130_ef_sc_hd__decap_12
XFILLER_56_3 VPWR VGND VPWR VGND sky130_ef_sc_hd__decap_12
XFILLER_217_57 VPWR VGND VPWR VGND sky130_ef_sc_hd__decap_12
XFILLER_86_1189 VGND VGND VPWR VPWR sky130_fd_sc_hd__fill_1
XTAP_TAPCELL_ROW_148_2_4642 VGND VPWR sky130_fd_sc_hd__tapvpwrvgnd_1
XFILLER_151_1435 VGND VGND VPWR VPWR sky130_fd_sc_hd__decap_6
XFILLER_3_1201 VPWR VGND VPWR VGND sky130_ef_sc_hd__decap_12
XFILLER_151_1479 VPWR VGND VPWR VGND sky130_ef_sc_hd__decap_12
XFILLER_7_1381 VPWR VGND VPWR VGND sky130_ef_sc_hd__decap_12
XFILLER_186_1509 VGND VGND VPWR VPWR sky130_fd_sc_hd__decap_6
XFILLER_231_1481 VPWR VGND VPWR VGND sky130_ef_sc_hd__decap_12
XFILLER_243_317 VPWR VGND VPWR VGND sky130_ef_sc_hd__decap_12
XFILLER_209_561 VPWR VGND VPWR VGND sky130_ef_sc_hd__decap_12
XFILLER_3_1245 VPWR VGND VPWR VGND sky130_ef_sc_hd__decap_12
XFILLER_58_1203 VPWR VGND VPWR VGND sky130_ef_sc_hd__decap_12
XFILLER_149_1331 VPWR VGND VPWR VGND sky130_ef_sc_hd__decap_12
XTAP_TAPCELL_ROW_182_1794 VGND VPWR sky130_fd_sc_hd__tapvpwrvgnd_1
XFILLER_3_1289 VPWR VGND VPWR VGND sky130_ef_sc_hd__decap_12
XFILLER_102_27 VGND VGND VPWR VPWR sky130_fd_sc_hd__fill_1
XFILLER_110_1165 VPWR VGND VPWR VGND sky130_ef_sc_hd__decap_12
XFILLER_224_531 VGND VGND VPWR VPWR sky130_fd_sc_hd__fill_1
XFILLER_58_1247 VPWR VGND VPWR VGND sky130_ef_sc_hd__decap_12
XFILLER_251_361 VPWR VGND VPWR VGND sky130_ef_sc_hd__decap_12
XFILLER_145_1217 VGND VGND VPWR VPWR sky130_fd_sc_hd__fill_1
XFILLER_212_737 VPWR VGND VPWR VGND sky130_ef_sc_hd__decap_12
XFILLER_211_225 VPWR VGND VPWR VGND sky130_ef_sc_hd__decap_12
XFILLER_177_641 VPWR VGND VPWR VGND sky130_ef_sc_hd__decap_12
XFILLER_220_781 VPWR VGND VPWR VGND sky130_ef_sc_hd__decap_12
XFILLER_165_825 VPWR VGND VPWR VGND sky130_ef_sc_hd__decap_12
XFILLER_177_685 VPWR VGND VPWR VGND sky130_ef_sc_hd__decap_12
XFILLER_165_869 VPWR VGND VPWR VGND sky130_ef_sc_hd__decap_12
XFILLER_176_195 VGND VGND VPWR VPWR sky130_fd_sc_hd__fill_1
XFILLER_178_1037 VPWR VGND VPWR VGND sky130_ef_sc_hd__decap_12
XFILLER_69_1343 VPWR VGND VPWR VGND sky130_ef_sc_hd__decap_12
XFILLER_219_1001 VGND VGND VPWR VPWR sky130_fd_sc_hd__decap_6
XFILLER_30_1177 VPWR VGND VPWR VGND sky130_ef_sc_hd__decap_12
XFILLER_11_57 VPWR VGND VPWR VGND sky130_ef_sc_hd__decap_12
XFILLER_192_699 VGND VGND VPWR VPWR sky130_fd_sc_hd__fill_1
XFILLER_127_57 VPWR VGND VPWR VGND sky130_ef_sc_hd__decap_12
XFILLER_69_1387 VPWR VGND VPWR VGND sky130_ef_sc_hd__decap_12
XFILLER_219_1045 VPWR VGND VPWR VGND sky130_ef_sc_hd__decap_12
XFILLER_156_1357 VGND VGND VPWR VPWR sky130_fd_sc_hd__fill_1
XFILLER_87_39 VPWR VGND VPWR VGND sky130_ef_sc_hd__decap_12
XFILLER_219_1089 VPWR VGND VPWR VGND sky130_ef_sc_hd__decap_12
XTAP_TAPCELL_ROW_9_1140 VGND VPWR sky130_fd_sc_hd__tapvpwrvgnd_1
XFILLER_246_133 VGND VGND VPWR VPWR sky130_fd_sc_hd__decap_6
XTAP_TAPCELL_ROW_5_1004 VGND VPWR sky130_fd_sc_hd__tapvpwrvgnd_1
XFILLER_189_1133 VPWR VGND VPWR VGND sky130_ef_sc_hd__decap_12
XFILLER_246_177 VPWR VGND VPWR VGND sky130_ef_sc_hd__decap_12
XFILLER_41_1273 VGND VGND VPWR VPWR sky130_fd_sc_hd__fill_1
XFILLER_228_881 VPWR VGND VPWR VGND sky130_ef_sc_hd__decap_12
XFILLER_189_1177 VPWR VGND VPWR VGND sky130_ef_sc_hd__decap_12
XFILLER_76_1303 VPWR VGND VPWR VGND sky130_ef_sc_hd__decap_12
XFILLER_227_391 VGND VGND VPWR VPWR sky130_fd_sc_hd__fill_1
XFILLER_160_3 VPWR VGND VPWR VGND sky130_ef_sc_hd__decap_12
XFILLER_215_553 VGND VGND VPWR VPWR sky130_fd_sc_hd__decap_6
XFILLER_226_1005 VPWR VGND VPWR VGND sky130_ef_sc_hd__decap_12
XFILLER_128_1415 VPWR VGND VPWR VGND sky130_ef_sc_hd__decap_12
XFILLER_188_917 VGND VGND VPWR VPWR sky130_fd_sc_hd__decap_6
XFILLER_230_501 VPWR VGND VPWR VGND sky130_ef_sc_hd__decap_12
XFILLER_243_895 VGND VGND VPWR VPWR sky130_fd_sc_hd__fill_1
XFILLER_187_405 VPWR VGND VPWR VGND sky130_ef_sc_hd__decap_12
XFILLER_215_597 VPWR VGND VPWR VGND sky130_ef_sc_hd__decap_12
XFILLER_226_1049 VPWR VGND VPWR VGND sky130_ef_sc_hd__decap_12
X_312_ net596 dout0_q\[27\] net528 VGND VGND VPWR VPWR _101_ sky130_fd_sc_hd__a21oi_1
XTAP_TAPCELL_ROW_15_2_3847 VGND VPWR sky130_fd_sc_hd__tapvpwrvgnd_1
XFILLER_230_545 VPWR VGND VPWR VGND sky130_ef_sc_hd__decap_12
XFILLER_39_1180 VPWR VGND VPWR VGND sky130_ef_sc_hd__decap_12
XFILLER_187_449 VPWR VGND VPWR VGND sky130_ef_sc_hd__decap_12
XFILLER_208_1483 VGND VGND VPWR VPWR sky130_fd_sc_hd__fill_1
XFILLER_196_961 VPWR VGND VPWR VGND sky130_ef_sc_hd__decap_12
XFILLER_230_589 VPWR VGND VPWR VGND sky130_ef_sc_hd__decap_12
XFILLER_168_53 VPWR VGND VPWR VGND sky130_ef_sc_hd__decap_12
Xinput18 wr_data[17] VGND VGND VPWR VPWR net18 sky130_fd_sc_hd__clkbuf_1
XFILLER_13_1331 VPWR VGND VPWR VGND sky130_ef_sc_hd__decap_12
Xinput29 wr_data[27] VGND VGND VPWR VPWR net29 sky130_fd_sc_hd__clkbuf_1
XPHY_EDGE_ROW_244_Right_89 VGND VGND VPWR VPWR sky130_fd_sc_hd__decap_3
XFILLER_168_97 VPWR VGND VPWR VGND sky130_ef_sc_hd__decap_12
XFILLER_182_121 VPWR VGND VPWR VGND sky130_ef_sc_hd__decap_12
XFILLER_7_868 VPWR VGND VPWR VGND sky130_ef_sc_hd__decap_12
XFILLER_100_1301 VGND VGND VPWR VPWR sky130_fd_sc_hd__fill_1
XFILLER_182_165 VPWR VGND VPWR VGND sky130_ef_sc_hd__decap_12
XFILLER_202_1093 VPWR VGND VPWR VGND sky130_ef_sc_hd__decap_12
XFILLER_237_1101 VPWR VGND VPWR VGND sky130_ef_sc_hd__decap_12
XFILLER_87_1443 VPWR VGND VPWR VGND sky130_ef_sc_hd__decap_12
XFILLER_139_1511 VGND VGND VPWR VPWR sky130_fd_sc_hd__decap_4
XFILLER_171_839 VGND VGND VPWR VPWR sky130_fd_sc_hd__fill_1
XFILLER_184_41 VPWR VGND VPWR VGND sky130_ef_sc_hd__decap_12
XFILLER_237_1145 VPWR VGND VPWR VGND sky130_ef_sc_hd__decap_12
XFILLER_48_1427 VPWR VGND VPWR VGND sky130_ef_sc_hd__decap_12
Xsram0_680 VGND VGND VPWR VPWR sram0_680/HI net680 sky130_fd_sc_hd__conb_1
XFILLER_83_1329 VGND VGND VPWR VPWR sky130_fd_sc_hd__fill_1
XTAP_TAPCELL_ROW_134_2_4561 VGND VPWR sky130_fd_sc_hd__tapvpwrvgnd_1
XFILLER_184_85 VPWR VGND VPWR VGND sky130_ef_sc_hd__decap_12
XFILLER_233_1009 VPWR VGND VPWR VGND sky130_ef_sc_hd__decap_12
XFILLER_237_1189 VPWR VGND VPWR VGND sky130_ef_sc_hd__decap_12
XFILLER_238_601 VPWR VGND VPWR VGND sky130_ef_sc_hd__decap_12
XFILLER_237_111 VGND VGND VPWR VPWR sky130_fd_sc_hd__fill_1
XFILLER_238_645 VPWR VGND VPWR VGND sky130_ef_sc_hd__decap_12
XFILLER_133_1165 VPWR VGND VPWR VGND sky130_ef_sc_hd__decap_12
XPHY_EDGE_ROW_253_Right_98 VGND VGND VPWR VPWR sky130_fd_sc_hd__decap_3
XFILLER_203_15 VPWR VGND VPWR VGND sky130_ef_sc_hd__decap_12
XFILLER_253_615 VGND VGND VPWR VPWR sky130_fd_sc_hd__fill_1
XFILLER_24_1471 VPWR VGND VPWR VGND sky130_ef_sc_hd__decap_12
XTAP_TAPCELL_ROW_207_2465 VGND VPWR sky130_fd_sc_hd__tapvpwrvgnd_1
XFILLER_168_1217 VPWR VGND VPWR VGND sky130_ef_sc_hd__decap_12
XTAP_TAPCELL_ROW_207_2476 VGND VPWR sky130_fd_sc_hd__tapvpwrvgnd_1
XFILLER_225_317 VPWR VGND VPWR VGND sky130_ef_sc_hd__decap_12
XFILLER_111_1441 VGND VGND VPWR VPWR sky130_fd_sc_hd__fill_1
XTAP_TAPCELL_ROW_207_2487 VGND VPWR sky130_fd_sc_hd__tapvpwrvgnd_1
XTAP_TAPCELL_ROW_126_2_4509 VGND VPWR sky130_fd_sc_hd__tapvpwrvgnd_1
XFILLER_20_1357 VGND VGND VPWR VPWR sky130_fd_sc_hd__fill_1
XFILLER_206_531 VGND VGND VPWR VPWR sky130_fd_sc_hd__fill_1
XFILLER_248_1241 VPWR VGND VPWR VGND sky130_ef_sc_hd__decap_12
XFILLER_0_1429 VPWR VGND VPWR VGND sky130_ef_sc_hd__decap_12
XTAP_TAPCELL_ROW_199_2255 VGND VPWR sky130_fd_sc_hd__tapvpwrvgnd_1
XFILLER_240_309 VPWR VGND VPWR VGND sky130_ef_sc_hd__decap_12
XFILLER_244_1105 VPWR VGND VPWR VGND sky130_ef_sc_hd__decap_12
XTAP_TAPCELL_ROW_199_2266 VGND VPWR sky130_fd_sc_hd__tapvpwrvgnd_1
XFILLER_209_1225 VGND VGND VPWR VPWR sky130_fd_sc_hd__decap_6
XFILLER_233_361 VPWR VGND VPWR VGND sky130_ef_sc_hd__decap_12
XFILLER_248_1285 VPWR VGND VPWR VGND sky130_ef_sc_hd__decap_12
XFILLER_94_1469 VGND VGND VPWR VPWR sky130_fd_sc_hd__fill_1
XFILLER_244_1149 VPWR VGND VPWR VGND sky130_ef_sc_hd__decap_12
XFILLER_209_1269 VPWR VGND VPWR VGND sky130_ef_sc_hd__decap_12
XFILLER_105_1201 VPWR VGND VPWR VGND sky130_ef_sc_hd__decap_12
XFILLER_202_781 VPWR VGND VPWR VGND sky130_ef_sc_hd__decap_12
XFILLER_144_1283 VPWR VGND VPWR VGND sky130_ef_sc_hd__decap_12
XFILLER_53_1177 VPWR VGND VPWR VGND sky130_ef_sc_hd__decap_12
XFILLER_105_1267 VGND VGND VPWR VPWR sky130_fd_sc_hd__decap_6
XFILLER_179_1313 VPWR VGND VPWR VGND sky130_ef_sc_hd__decap_12
XFILLER_179_1357 VPWR VGND VPWR VGND sky130_ef_sc_hd__decap_12
XFILLER_255_1201 VGND VGND VPWR VPWR sky130_fd_sc_hd__decap_3
XFILLER_174_699 VGND VGND VPWR VPWR sky130_fd_sc_hd__fill_1
XFILLER_31_1497 VGND VGND VPWR VPWR sky130_fd_sc_hd__fill_1
XFILLER_255_1245 VPWR VGND VPWR VGND sky130_ef_sc_hd__decap_12
XTAP_TAPCELL_ROW_171_1495 VGND VPWR sky130_fd_sc_hd__tapvpwrvgnd_1
XFILLER_170_861 VGND VGND VPWR VPWR sky130_fd_sc_hd__decap_6
XFILLER_216_1229 VPWR VGND VPWR VGND sky130_ef_sc_hd__decap_12
XFILLER_255_1289 VPWR VGND VPWR VGND sky130_ef_sc_hd__decap_12
XFILLER_244_77 VGND VGND VPWR VPWR sky130_fd_sc_hd__decap_6
XFILLER_25_1213 VGND VGND VPWR VPWR sky130_fd_sc_hd__decap_4
XTAP_TAPCELL_ROW_188_1970 VGND VPWR sky130_fd_sc_hd__tapvpwrvgnd_1
XFILLER_64_1295 VGND VGND VPWR VPWR sky130_fd_sc_hd__decap_6
XFILLER_151_1243 VPWR VGND VPWR VGND sky130_ef_sc_hd__decap_12
XTAP_TAPCELL_ROW_184_1845 VGND VPWR sky130_fd_sc_hd__tapvpwrvgnd_1
XTAP_TAPCELL_ROW_184_1856 VGND VPWR sky130_fd_sc_hd__tapvpwrvgnd_1
XFILLER_228_133 VGND VGND VPWR VPWR sky130_fd_sc_hd__decap_6
XFILLER_112_1227 VPWR VGND VPWR VGND sky130_ef_sc_hd__decap_12
XTAP_TAPCELL_ROW_21_2_3879 VGND VPWR sky130_fd_sc_hd__tapvpwrvgnd_1
XFILLER_113_15 VPWR VGND VPWR VGND sky130_ef_sc_hd__decap_12
XFILLER_151_1287 VPWR VGND VPWR VGND sky130_ef_sc_hd__decap_12
XFILLER_228_177 VPWR VGND VPWR VGND sky130_ef_sc_hd__decap_12
XFILLER_244_637 VGND VGND VPWR VPWR sky130_fd_sc_hd__decap_6
XFILLER_186_1317 VPWR VGND VPWR VGND sky130_ef_sc_hd__decap_12
XFILLER_243_125 VPWR VGND VPWR VGND sky130_ef_sc_hd__decap_12
XFILLER_209_391 VGND VGND VPWR VPWR sky130_fd_sc_hd__fill_1
XFILLER_243_169 VPWR VGND VPWR VGND sky130_ef_sc_hd__decap_12
XFILLER_227_1325 VPWR VGND VPWR VGND sky130_ef_sc_hd__decap_12
Xwire75 _267_ VGND VGND VPWR VPWR net75 sky130_fd_sc_hd__clkbuf_1
XFILLER_212_501 VPWR VGND VPWR VGND sky130_ef_sc_hd__decap_12
XFILLER_252_681 VPWR VGND VPWR VGND sky130_ef_sc_hd__decap_12
Xwire86 _249_ VGND VGND VPWR VPWR net86 sky130_fd_sc_hd__clkbuf_1
XFILLER_169_405 VPWR VGND VPWR VGND sky130_ef_sc_hd__decap_12
XFILLER_225_895 VGND VGND VPWR VPWR sky130_fd_sc_hd__fill_1
Xwire97 _212_ VGND VGND VPWR VPWR net97 sky130_fd_sc_hd__clkbuf_1
XFILLER_184_1085 VGND VGND VPWR VPWR sky130_fd_sc_hd__decap_6
XFILLER_212_545 VPWR VGND VPWR VGND sky130_ef_sc_hd__decap_12
XFILLER_227_1369 VPWR VGND VPWR VGND sky130_ef_sc_hd__decap_12
XFILLER_169_449 VPWR VGND VPWR VGND sky130_ef_sc_hd__decap_12
XPHY_EDGE_ROW_129_2_Left_631 VGND VGND VPWR VPWR sky130_fd_sc_hd__decap_3
XFILLER_185_909 VPWR VGND VPWR VGND sky130_ef_sc_hd__decap_12
XFILLER_178_961 VPWR VGND VPWR VGND sky130_ef_sc_hd__decap_12
XFILLER_212_589 VPWR VGND VPWR VGND sky130_ef_sc_hd__decap_12
XFILLER_71_1255 VPWR VGND VPWR VGND sky130_ef_sc_hd__decap_12
XFILLER_123_1323 VGND VGND VPWR VPWR sky130_fd_sc_hd__decap_6
XFILLER_184_419 VGND VGND VPWR VPWR sky130_fd_sc_hd__fill_1
XTAP_TAPCELL_ROW_140_2_4593 VGND VPWR sky130_fd_sc_hd__tapvpwrvgnd_1
XFILLER_162_1383 VPWR VGND VPWR VGND sky130_ef_sc_hd__decap_12
XTAP_TAPCELL_ROW_139_2_4587 VGND VPWR sky130_fd_sc_hd__tapvpwrvgnd_1
XFILLER_32_1239 VGND VGND VPWR VPWR sky130_fd_sc_hd__decap_6
XFILLER_197_1413 VPWR VGND VPWR VGND sky130_ef_sc_hd__decap_12
XFILLER_71_1299 VPWR VGND VPWR VGND sky130_ef_sc_hd__decap_12
XFILLER_123_1367 VPWR VGND VPWR VGND sky130_ef_sc_hd__decap_12
XFILLER_193_953 VPWR VGND VPWR VGND sky130_ef_sc_hd__decap_12
XFILLER_197_1457 VPWR VGND VPWR VGND sky130_ef_sc_hd__decap_12
XFILLER_238_1421 VGND VGND VPWR VPWR sky130_fd_sc_hd__decap_6
XFILLER_98_27 VGND VGND VPWR VPWR sky130_fd_sc_hd__fill_1
XFILLER_180_625 VPWR VGND VPWR VGND sky130_ef_sc_hd__decap_12
XFILLER_191_1001 VGND VGND VPWR VPWR sky130_fd_sc_hd__decap_6
XFILLER_238_1465 VPWR VGND VPWR VGND sky130_ef_sc_hd__decap_12
XFILLER_180_669 VPWR VGND VPWR VGND sky130_ef_sc_hd__decap_12
XFILLER_234_1329 VPWR VGND VPWR VGND sky130_ef_sc_hd__decap_12
XFILLER_156_1165 VPWR VGND VPWR VGND sky130_ef_sc_hd__decap_12
XFILLER_191_1045 VPWR VGND VPWR VGND sky130_ef_sc_hd__decap_12
XTAP_TAPCELL_ROW_87_2_4274 VGND VPWR sky130_fd_sc_hd__tapvpwrvgnd_1
XFILLER_82_1351 VGND VGND VPWR VPWR sky130_fd_sc_hd__decap_6
XFILLER_191_1089 VPWR VGND VPWR VGND sky130_ef_sc_hd__decap_12
XFILLER_219_111 VGND VGND VPWR VPWR sky130_fd_sc_hd__fill_1
XFILLER_82_1395 VPWR VGND VPWR VGND sky130_ef_sc_hd__decap_12
XFILLER_134_1463 VGND VGND VPWR VPWR sky130_fd_sc_hd__decap_6
XFILLER_43_1379 VGND VGND VPWR VPWR sky130_fd_sc_hd__decap_6
XFILLER_130_1327 VPWR VGND VPWR VGND sky130_ef_sc_hd__decap_12
XFILLER_235_615 VGND VGND VPWR VPWR sky130_fd_sc_hd__fill_1
XTAP_TAPCELL_ROW_112_2_4428 VGND VPWR sky130_fd_sc_hd__tapvpwrvgnd_1
XFILLER_207_317 VPWR VGND VPWR VGND sky130_ef_sc_hd__decap_12
XFILLER_247_497 VGND VGND VPWR VPWR sky130_fd_sc_hd__decap_6
XFILLER_170_65 VPWR VGND VPWR VGND sky130_ef_sc_hd__decap_12
XFILLER_210_1373 VPWR VGND VPWR VGND sky130_ef_sc_hd__decap_12
XFILLER_222_309 VPWR VGND VPWR VGND sky130_ef_sc_hd__decap_12
XTAP_TAPCELL_ROW_202_2340 VGND VPWR sky130_fd_sc_hd__tapvpwrvgnd_1
XFILLER_245_1425 VPWR VGND VPWR VGND sky130_ef_sc_hd__decap_12
XTAP_TAPCELL_ROW_202_2351 VGND VPWR sky130_fd_sc_hd__tapvpwrvgnd_1
XFILLER_215_361 VPWR VGND VPWR VGND sky130_ef_sc_hd__decap_12
XFILLER_231_821 VPWR VGND VPWR VGND sky130_ef_sc_hd__decap_12
XFILLER_188_725 VPWR VGND VPWR VGND sky130_ef_sc_hd__decap_12
XFILLER_76_1177 VPWR VGND VPWR VGND sky130_ef_sc_hd__decap_12
XFILLER_128_1245 VGND VGND VPWR VPWR sky130_fd_sc_hd__fill_1
XFILLER_206_1409 VPWR VGND VPWR VGND sky130_ef_sc_hd__decap_12
XFILLER_245_1469 VPWR VGND VPWR VGND sky130_ef_sc_hd__decap_12
XTAP_TAPCELL_ROW_194_2130 VGND VPWR sky130_fd_sc_hd__tapvpwrvgnd_1
XFILLER_231_865 VPWR VGND VPWR VGND sky130_ef_sc_hd__decap_12
XFILLER_188_769 VPWR VGND VPWR VGND sky130_ef_sc_hd__decap_12
XFILLER_93_1491 VGND VGND VPWR VPWR sky130_fd_sc_hd__decap_6
XTAP_TAPCELL_ROW_60_2_4115 VGND VPWR sky130_fd_sc_hd__tapvpwrvgnd_1
XTAP_TAPCELL_ROW_59_2_4109 VGND VPWR sky130_fd_sc_hd__tapvpwrvgnd_1
XFILLER_187_279 VGND VGND VPWR VPWR sky130_fd_sc_hd__fill_1
XTAP_TAPCELL_ROW_190_2005 VGND VPWR sky130_fd_sc_hd__tapvpwrvgnd_1
XFILLER_141_1423 VPWR VGND VPWR VGND sky130_ef_sc_hd__decap_12
XTAP_TAPCELL_ROW_190_2016 VGND VPWR sky130_fd_sc_hd__tapvpwrvgnd_1
XFILLER_180_1483 VGND VGND VPWR VPWR sky130_fd_sc_hd__fill_1
XTAP_TAPCELL_ROW_190_2027 VGND VPWR sky130_fd_sc_hd__tapvpwrvgnd_1
XTAP_TAPCELL_ROW_215_2701 VGND VPWR sky130_fd_sc_hd__tapvpwrvgnd_1
XFILLER_50_1339 VPWR VGND VPWR VGND sky130_ef_sc_hd__decap_12
XFILLER_102_1407 VGND VGND VPWR VPWR sky130_fd_sc_hd__decap_6
XFILLER_141_1467 VPWR VGND VPWR VGND sky130_ef_sc_hd__decap_12
XFILLER_183_441 VGND VGND VPWR VPWR sky130_fd_sc_hd__decap_6
Xwire563 net65 VGND VGND VPWR VPWR net563 sky130_fd_sc_hd__clkbuf_1
XFILLER_195_51 VGND VGND VPWR VPWR sky130_fd_sc_hd__decap_4
XPHY_EDGE_ROW_50_2_Left_552 VGND VGND VPWR VPWR sky130_fd_sc_hd__decap_3
Xwire574 dout0_q\[11\] VGND VGND VPWR VPWR net574 sky130_fd_sc_hd__clkbuf_1
Xwire585 dout0_q\[3\] VGND VGND VPWR VPWR net585 sky130_fd_sc_hd__clkbuf_1
XFILLER_6_153 VGND VGND VPWR VPWR sky130_fd_sc_hd__decap_8
XFILLER_183_485 VPWR VGND VPWR VGND sky130_ef_sc_hd__decap_12
XFILLER_87_1273 VGND VGND VPWR VPWR sky130_fd_sc_hd__fill_1
XFILLER_217_1505 VGND VGND VPWR VPWR sky130_fd_sc_hd__decap_6
XFILLER_252_1429 VPWR VGND VPWR VGND sky130_ef_sc_hd__decap_12
XFILLER_3_871 VGND VGND VPWR VPWR sky130_fd_sc_hd__decap_8
XFILLER_139_1385 VGND VGND VPWR VPWR sky130_fd_sc_hd__fill_1
XFILLER_3_893 VGND VGND VPWR VPWR sky130_fd_sc_hd__decap_3
XFILLER_170_1129 VPWR VGND VPWR VGND sky130_ef_sc_hd__decap_12
XTAP_TAPCELL_ROW_209_2516 VGND VPWR sky130_fd_sc_hd__tapvpwrvgnd_1
XFILLER_239_921 VPWR VGND VPWR VGND sky130_ef_sc_hd__decap_12
XTAP_TAPCELL_ROW_209_2527 VGND VPWR sky130_fd_sc_hd__tapvpwrvgnd_1
XTAP_TAPCELL_ROW_209_2538 VGND VPWR sky130_fd_sc_hd__tapvpwrvgnd_1
XFILLER_61_1435 VGND VGND VPWR VPWR sky130_fd_sc_hd__decap_6
XFILLER_239_965 VPWR VGND VPWR VGND sky130_ef_sc_hd__decap_12
XFILLER_61_1479 VPWR VGND VPWR VGND sky130_ef_sc_hd__decap_12
XFILLER_19_3 VPWR VGND VPWR VGND sky130_ef_sc_hd__decap_12
XFILLER_250_1197 VGND VGND VPWR VPWR sky130_fd_sc_hd__decap_6
XFILLER_238_475 VGND VGND VPWR VPWR sky130_fd_sc_hd__fill_1
XFILLER_226_637 VGND VGND VPWR VPWR sky130_fd_sc_hd__decap_6
XPHY_EDGE_ROW_127_1_Left_382 VGND VGND VPWR VPWR sky130_fd_sc_hd__decap_3
XFILLER_225_125 VPWR VGND VPWR VGND sky130_ef_sc_hd__decap_12
XFILLER_4_1373 VPWR VGND VPWR VGND sky130_ef_sc_hd__decap_12
XFILLER_254_979 VGND VGND VPWR VPWR sky130_fd_sc_hd__fill_1
XFILLER_59_1331 VPWR VGND VPWR VGND sky130_ef_sc_hd__decap_12
XFILLER_20_1165 VPWR VGND VPWR VGND sky130_ef_sc_hd__decap_12
XFILLER_225_169 VPWR VGND VPWR VGND sky130_ef_sc_hd__decap_12
XFILLER_241_629 VPWR VGND VPWR VGND sky130_ef_sc_hd__decap_12
XFILLER_146_1301 VGND VGND VPWR VPWR sky130_fd_sc_hd__fill_1
XFILLER_207_895 VGND VGND VPWR VPWR sky130_fd_sc_hd__fill_1
XFILLER_234_681 VPWR VGND VPWR VGND sky130_ef_sc_hd__decap_12
XFILLER_209_1033 VPWR VGND VPWR VGND sky130_ef_sc_hd__decap_12
XFILLER_248_1093 VPWR VGND VPWR VGND sky130_ef_sc_hd__decap_12
XFILLER_55_1217 VGND VGND VPWR VPWR sky130_fd_sc_hd__fill_1
XFILLER_240_139 VGND VGND VPWR VPWR sky130_fd_sc_hd__fill_1
XFILLER_224_1509 VGND VGND VPWR VPWR sky130_fd_sc_hd__decap_6
XFILLER_181_1225 VGND VGND VPWR VPWR sky130_fd_sc_hd__decap_6
XFILLER_209_1077 VPWR VGND VPWR VGND sky130_ef_sc_hd__decap_12
XFILLER_107_1329 VGND VGND VPWR VPWR sky130_fd_sc_hd__fill_1
XFILLER_167_909 VPWR VGND VPWR VGND sky130_ef_sc_hd__decap_12
XFILLER_181_1269 VPWR VGND VPWR VGND sky130_ef_sc_hd__decap_12
XFILLER_166_419 VGND VGND VPWR VPWR sky130_fd_sc_hd__fill_1
XFILLER_193_205 VPWR VGND VPWR VGND sky130_ef_sc_hd__decap_12
XTAP_TAPCELL_ROW_177_1660 VGND VPWR sky130_fd_sc_hd__tapvpwrvgnd_1
XTAP_TAPCELL_ROW_177_1671 VGND VPWR sky130_fd_sc_hd__tapvpwrvgnd_1
XFILLER_239_55 VGND VGND VPWR VPWR sky130_fd_sc_hd__fill_1
XFILLER_120_1507 VGND VGND VPWR VPWR sky130_fd_sc_hd__decap_8
XFILLER_175_953 VPWR VGND VPWR VGND sky130_ef_sc_hd__decap_12
XFILLER_193_249 VPWR VGND VPWR VGND sky130_ef_sc_hd__decap_12
XFILLER_179_1121 VPWR VGND VPWR VGND sky130_ef_sc_hd__decap_12
XTAP_TAPCELL_ROW_173_1546 VGND VPWR sky130_fd_sc_hd__tapvpwrvgnd_1
XTAP_TAPCELL_ROW_173_1557 VGND VPWR sky130_fd_sc_hd__tapvpwrvgnd_1
XTAP_TAPCELL_ROW_173_1568 VGND VPWR sky130_fd_sc_hd__tapvpwrvgnd_1
XFILLER_190_923 VGND VGND VPWR VPWR sky130_fd_sc_hd__fill_1
XTAP_TAPCELL_ROW_105_2_4382 VGND VPWR sky130_fd_sc_hd__tapvpwrvgnd_1
XFILLER_175_1007 VGND VGND VPWR VPWR sky130_fd_sc_hd__fill_1
XFILLER_108_15 VPWR VGND VPWR VGND sky130_ef_sc_hd__decap_12
XFILLER_157_1441 VGND VGND VPWR VPWR sky130_fd_sc_hd__fill_1
XTAP_TAPCELL_ROW_73_2_4193 VGND VPWR sky130_fd_sc_hd__tapvpwrvgnd_1
XFILLER_0_307 VGND VGND VPWR VPWR sky130_fd_sc_hd__fill_1
XFILLER_66_1357 VGND VGND VPWR VPWR sky130_fd_sc_hd__fill_1
XTAP_TAPCELL_ROW_186_1907 VGND VPWR sky130_fd_sc_hd__tapvpwrvgnd_1
XFILLER_192_1365 VGND VGND VPWR VPWR sky130_fd_sc_hd__decap_6
XFILLER_249_729 VPWR VGND VPWR VGND sky130_ef_sc_hd__decap_12
XTAP_TAPCELL_ROW_186_1918 VGND VPWR sky130_fd_sc_hd__tapvpwrvgnd_1
XFILLER_216_1037 VPWR VGND VPWR VGND sky130_ef_sc_hd__decap_12
XFILLER_118_1469 VGND VGND VPWR VPWR sky130_fd_sc_hd__fill_1
XFILLER_9_1273 VPWR VGND VPWR VGND sky130_ef_sc_hd__decap_12
XFILLER_244_401 VPWR VGND VPWR VGND sky130_ef_sc_hd__decap_12
XFILLER_84_29 VPWR VGND VPWR VGND sky130_ef_sc_hd__decap_12
XFILLER_217_615 VGND VGND VPWR VPWR sky130_fd_sc_hd__fill_1
XFILLER_229_497 VGND VGND VPWR VPWR sky130_fd_sc_hd__decap_6
XFILLER_244_445 VPWR VGND VPWR VGND sky130_ef_sc_hd__decap_12
XFILLER_99_1177 VPWR VGND VPWR VGND sky130_ef_sc_hd__decap_12
XTAP_TAPCELL_ROW_0_830 VGND VPWR sky130_fd_sc_hd__tapvpwrvgnd_1
XFILLER_186_1147 VGND VGND VPWR VPWR sky130_fd_sc_hd__fill_1
XTAP_TAPCELL_ROW_0_841 VGND VPWR sky130_fd_sc_hd__tapvpwrvgnd_1
XFILLER_204_309 VPWR VGND VPWR VGND sky130_ef_sc_hd__decap_12
XFILLER_244_489 VPWR VGND VPWR VGND sky130_ef_sc_hd__decap_12
XTAP_TAPCELL_ROW_0_852 VGND VPWR sky130_fd_sc_hd__tapvpwrvgnd_1
XTAP_TAPCELL_ROW_0_863 VGND VPWR sky130_fd_sc_hd__tapvpwrvgnd_1
XFILLER_38_1415 VPWR VGND VPWR VGND sky130_ef_sc_hd__decap_12
XTAP_TAPCELL_ROW_0_874 VGND VPWR sky130_fd_sc_hd__tapvpwrvgnd_1
XFILLER_213_821 VPWR VGND VPWR VGND sky130_ef_sc_hd__decap_12
XFILLER_227_1133 VPWR VGND VPWR VGND sky130_ef_sc_hd__decap_12
XFILLER_77_1497 VGND VGND VPWR VPWR sky130_fd_sc_hd__fill_1
XFILLER_213_865 VPWR VGND VPWR VGND sky130_ef_sc_hd__decap_12
XFILLER_227_1177 VPWR VGND VPWR VGND sky130_ef_sc_hd__decap_12
XTAP_TAPCELL_ROW_255_3760 VGND VPWR sky130_fd_sc_hd__tapvpwrvgnd_1
XTAP_TAPCELL_ROW_255_3771 VGND VPWR sky130_fd_sc_hd__tapvpwrvgnd_1
XTAP_TAPCELL_ROW_255_3782 VGND VPWR sky130_fd_sc_hd__tapvpwrvgnd_1
XFILLER_169_279 VGND VGND VPWR VPWR sky130_fd_sc_hd__fill_1
XTAP_TAPCELL_ROW_255_3793 VGND VPWR sky130_fd_sc_hd__tapvpwrvgnd_1
XTAP_TAPCELL_ROW_251_3657 VGND VPWR sky130_fd_sc_hd__tapvpwrvgnd_1
XFILLER_149_55 VGND VGND VPWR VPWR sky130_fd_sc_hd__fill_1
XFILLER_162_1191 VPWR VGND VPWR VGND sky130_ef_sc_hd__decap_12
XTAP_TAPCELL_ROW_251_3668 VGND VPWR sky130_fd_sc_hd__tapvpwrvgnd_1
XFILLER_123_3 VPWR VGND VPWR VGND sky130_ef_sc_hd__decap_12
XFILLER_10_1301 VGND VGND VPWR VPWR sky130_fd_sc_hd__fill_1
XFILLER_193_783 VGND VGND VPWR VPWR sky130_fd_sc_hd__fill_1
XFILLER_158_1227 VPWR VGND VPWR VGND sky130_ef_sc_hd__decap_12
XFILLER_181_945 VGND VGND VPWR VPWR sky130_fd_sc_hd__decap_6
XFILLER_49_1511 VGND VGND VPWR VPWR sky130_fd_sc_hd__decap_4
XFILLER_180_433 VPWR VGND VPWR VGND sky130_ef_sc_hd__decap_12
XFILLER_197_1287 VGND VGND VPWR VPWR sky130_fd_sc_hd__fill_1
XFILLER_84_1413 VGND VGND VPWR VPWR sky130_fd_sc_hd__fill_1
XFILLER_181_989 VPWR VGND VPWR VGND sky130_ef_sc_hd__decap_12
XFILLER_180_477 VPWR VGND VPWR VGND sky130_ef_sc_hd__decap_12
XFILLER_238_1273 VPWR VGND VPWR VGND sky130_ef_sc_hd__decap_12
XFILLER_3_167 VGND VGND VPWR VPWR sky130_fd_sc_hd__fill_1
XTAP_TAPCELL_ROW_249_3597 VGND VPWR sky130_fd_sc_hd__tapvpwrvgnd_1
XFILLER_3_189 VGND VGND VPWR VPWR sky130_fd_sc_hd__decap_6
XFILLER_239_217 VGND VGND VPWR VPWR sky130_fd_sc_hd__decap_6
XFILLER_0_841 VGND VGND VPWR VPWR sky130_fd_sc_hd__decap_8
XFILLER_171_1449 VGND VGND VPWR VPWR sky130_fd_sc_hd__decap_6
XFILLER_58_41 VPWR VGND VPWR VGND sky130_ef_sc_hd__decap_12
XTAP_TAPCELL_ROW_162_2_4725 VGND VPWR sky130_fd_sc_hd__tapvpwrvgnd_1
XFILLER_134_1271 VPWR VGND VPWR VGND sky130_ef_sc_hd__decap_12
XFILLER_254_209 VPWR VGND VPWR VGND sky130_ef_sc_hd__decap_12
XFILLER_43_1165 VPWR VGND VPWR VGND sky130_ef_sc_hd__decap_12
XFILLER_247_261 VPWR VGND VPWR VGND sky130_ef_sc_hd__decap_12
XFILLER_169_1301 VPWR VGND VPWR VGND sky130_ef_sc_hd__decap_12
XTAP_TAPCELL_ROW_204_2402 VGND VPWR sky130_fd_sc_hd__tapvpwrvgnd_1
XFILLER_208_637 VGND VGND VPWR VPWR sky130_fd_sc_hd__decap_6
XFILLER_207_125 VPWR VGND VPWR VGND sky130_ef_sc_hd__decap_12
XFILLER_21_1441 VGND VGND VPWR VPWR sky130_fd_sc_hd__fill_1
XFILLER_236_979 VGND VGND VPWR VPWR sky130_fd_sc_hd__fill_1
XFILLER_1_1513 VGND VGND VPWR VPWR sky130_fd_sc_hd__fill_2
XFILLER_169_1345 VPWR VGND VPWR VGND sky130_ef_sc_hd__decap_12
XFILLER_78_1239 VGND VGND VPWR VPWR sky130_fd_sc_hd__decap_6
XFILLER_207_169 VPWR VGND VPWR VGND sky130_ef_sc_hd__decap_12
XFILLER_223_629 VPWR VGND VPWR VGND sky130_ef_sc_hd__decap_12
XFILLER_216_681 VPWR VGND VPWR VGND sky130_ef_sc_hd__decap_12
XFILLER_245_1233 VPWR VGND VPWR VGND sky130_ef_sc_hd__decap_12
XFILLER_222_139 VGND VGND VPWR VPWR sky130_fd_sc_hd__fill_1
XFILLER_188_533 VPWR VGND VPWR VGND sky130_ef_sc_hd__decap_12
XFILLER_200_27 VGND VGND VPWR VPWR sky130_fd_sc_hd__fill_1
XFILLER_206_1217 VPWR VGND VPWR VGND sky130_ef_sc_hd__decap_12
XFILLER_241_1119 VGND VGND VPWR VPWR sky130_fd_sc_hd__fill_1
XFILLER_231_673 VPWR VGND VPWR VGND sky130_ef_sc_hd__decap_12
XFILLER_15_1201 VPWR VGND VPWR VGND sky130_ef_sc_hd__decap_12
XFILLER_175_205 VPWR VGND VPWR VGND sky130_ef_sc_hd__decap_12
XFILLER_54_1283 VPWR VGND VPWR VGND sky130_ef_sc_hd__decap_12
XFILLER_106_1351 VGND VGND VPWR VPWR sky130_fd_sc_hd__decap_6
XFILLER_141_1231 VPWR VGND VPWR VGND sky130_ef_sc_hd__decap_12
XFILLER_175_249 VPWR VGND VPWR VGND sky130_ef_sc_hd__decap_12
XFILLER_191_709 VPWR VGND VPWR VGND sky130_ef_sc_hd__decap_12
XFILLER_198_1029 VGND VGND VPWR VPWR sky130_fd_sc_hd__decap_6
XFILLER_15_1267 VGND VGND VPWR VPWR sky130_fd_sc_hd__decap_6
XFILLER_102_1215 VPWR VGND VPWR VGND sky130_ef_sc_hd__decap_12
XFILLER_106_1395 VPWR VGND VPWR VGND sky130_ef_sc_hd__decap_12
XFILLER_141_1275 VPWR VGND VPWR VGND sky130_ef_sc_hd__decap_12
Xwire360 net361 VGND VGND VPWR VPWR net360 sky130_fd_sc_hd__clkbuf_1
XFILLER_172_923 VGND VGND VPWR VPWR sky130_fd_sc_hd__fill_1
Xwire371 net372 VGND VGND VPWR VPWR net371 sky130_fd_sc_hd__clkbuf_1
Xmax_cap104 _240_ VGND VGND VPWR VPWR net104 sky130_fd_sc_hd__clkbuf_1
XFILLER_102_1259 VPWR VGND VPWR VGND sky130_ef_sc_hd__decap_12
Xwire382 net383 VGND VGND VPWR VPWR net382 sky130_fd_sc_hd__clkbuf_1
Xmax_cap115 _202_ VGND VGND VPWR VPWR net115 sky130_fd_sc_hd__clkbuf_1
Xwire393 net394 VGND VGND VPWR VPWR net393 sky130_fd_sc_hd__clkbuf_1
XFILLER_89_1379 VGND VGND VPWR VPWR sky130_fd_sc_hd__decap_6
XFILLER_209_69 VPWR VGND VPWR VGND sky130_ef_sc_hd__decap_12
XFILLER_183_293 VPWR VGND VPWR VGND sky130_ef_sc_hd__decap_12
Xmax_cap137 net138 VGND VGND VPWR VPWR net137 sky130_fd_sc_hd__clkbuf_1
Xmax_cap148 _185_ VGND VGND VPWR VPWR net148 sky130_fd_sc_hd__clkbuf_1
Xmax_cap159 _156_ VGND VGND VPWR VPWR net159 sky130_fd_sc_hd__clkbuf_1
XFILLER_217_1313 VPWR VGND VPWR VGND sky130_ef_sc_hd__decap_12
XFILLER_217_1357 VPWR VGND VPWR VGND sky130_ef_sc_hd__decap_12
XFILLER_174_1073 VPWR VGND VPWR VGND sky130_ef_sc_hd__decap_12
XFILLER_225_57 VPWR VGND VPWR VGND sky130_ef_sc_hd__decap_12
XFILLER_252_1259 VGND VGND VPWR VPWR sky130_fd_sc_hd__fill_1
XFILLER_61_1243 VPWR VGND VPWR VGND sky130_ef_sc_hd__decap_12
XFILLER_113_1311 VPWR VGND VPWR VGND sky130_ef_sc_hd__decap_12
XPHY_EDGE_ROW_249_Left_504 VGND VGND VPWR VPWR sky130_fd_sc_hd__decap_3
XFILLER_117_1491 VGND VGND VPWR VPWR sky130_fd_sc_hd__decap_6
XFILLER_152_1371 VPWR VGND VPWR VGND sky130_ef_sc_hd__decap_12
XFILLER_22_1227 VPWR VGND VPWR VGND sky130_ef_sc_hd__decap_12
XTAP_TAPCELL_ROW_166_1361 VGND VPWR sky130_fd_sc_hd__tapvpwrvgnd_1
XFILLER_226_401 VPWR VGND VPWR VGND sky130_ef_sc_hd__decap_12
XFILLER_61_1287 VPWR VGND VPWR VGND sky130_ef_sc_hd__decap_12
XFILLER_187_1401 VPWR VGND VPWR VGND sky130_ef_sc_hd__decap_12
XFILLER_113_1355 VPWR VGND VPWR VGND sky130_ef_sc_hd__decap_12
XTAP_TAPCELL_ROW_166_1372 VGND VPWR sky130_fd_sc_hd__tapvpwrvgnd_1
XFILLER_226_445 VPWR VGND VPWR VGND sky130_ef_sc_hd__decap_12
XFILLER_242_905 VPWR VGND VPWR VGND sky130_ef_sc_hd__decap_12
XFILLER_96_1339 VPWR VGND VPWR VGND sky130_ef_sc_hd__decap_12
XFILLER_113_1399 VPWR VGND VPWR VGND sky130_ef_sc_hd__decap_12
XFILLER_148_1407 VGND VGND VPWR VPWR sky130_fd_sc_hd__decap_6
XFILLER_199_809 VPWR VGND VPWR VGND sky130_ef_sc_hd__decap_12
XFILLER_226_489 VPWR VGND VPWR VGND sky130_ef_sc_hd__decap_12
XFILLER_242_949 VPWR VGND VPWR VGND sky130_ef_sc_hd__decap_12
XFILLER_0_81 VGND VGND VPWR VPWR sky130_fd_sc_hd__decap_3
XTAP_TAPCELL_ROW_179_1711 VGND VPWR sky130_fd_sc_hd__tapvpwrvgnd_1
XFILLER_228_1453 VPWR VGND VPWR VGND sky130_ef_sc_hd__decap_12
XTAP_TAPCELL_ROW_179_1722 VGND VPWR sky130_fd_sc_hd__tapvpwrvgnd_1
XTAP_TAPCELL_ROW_16_2_3852 VGND VPWR sky130_fd_sc_hd__tapvpwrvgnd_1
XFILLER_0_1089 VGND VGND VPWR VPWR sky130_fd_sc_hd__decap_3
XFILLER_110_27 VGND VGND VPWR VPWR sky130_fd_sc_hd__fill_1
XFILLER_181_1033 VPWR VGND VPWR VGND sky130_ef_sc_hd__decap_12
XFILLER_224_1317 VPWR VGND VPWR VGND sky130_ef_sc_hd__decap_12
XFILLER_210_813 VPWR VGND VPWR VGND sky130_ef_sc_hd__decap_12
XFILLER_228_1497 VPWR VGND VPWR VGND sky130_ef_sc_hd__decap_12
XFILLER_250_993 VPWR VGND VPWR VGND sky130_ef_sc_hd__decap_12
XTAP_TAPCELL_ROW_175_1608 VGND VPWR sky130_fd_sc_hd__tapvpwrvgnd_1
XFILLER_221_161 VGND VGND VPWR VPWR sky130_fd_sc_hd__decap_6
XTAP_TAPCELL_ROW_175_1619 VGND VPWR sky130_fd_sc_hd__tapvpwrvgnd_1
XFILLER_181_1077 VPWR VGND VPWR VGND sky130_ef_sc_hd__decap_12
XFILLER_194_525 VGND VGND VPWR VPWR sky130_fd_sc_hd__decap_6
XFILLER_33_1323 VGND VGND VPWR VPWR sky130_fd_sc_hd__decap_6
XFILLER_72_1383 VPWR VGND VPWR VGND sky130_ef_sc_hd__decap_12
XFILLER_124_1451 VPWR VGND VPWR VGND sky130_ef_sc_hd__decap_12
XFILLER_194_569 VPWR VGND VPWR VGND sky130_ef_sc_hd__decap_12
XFILLER_33_1367 VPWR VGND VPWR VGND sky130_ef_sc_hd__decap_12
XFILLER_120_1315 VPWR VGND VPWR VGND sky130_ef_sc_hd__decap_12
XFILLER_222_1085 VGND VGND VPWR VPWR sky130_fd_sc_hd__decap_6
XFILLER_124_1495 VPWR VGND VPWR VGND sky130_ef_sc_hd__decap_12
XFILLER_175_783 VGND VGND VPWR VPWR sky130_fd_sc_hd__fill_1
XFILLER_120_1359 VPWR VGND VPWR VGND sky130_ef_sc_hd__decap_12
XFILLER_119_69 VGND VGND VPWR VPWR sky130_fd_sc_hd__fill_2
XFILLER_194_1427 VGND VGND VPWR VPWR sky130_fd_sc_hd__fill_1
XFILLER_235_1413 VPWR VGND VPWR VGND sky130_ef_sc_hd__decap_12
XFILLER_66_1165 VPWR VGND VPWR VGND sky130_ef_sc_hd__decap_12
XFILLER_235_1457 VPWR VGND VPWR VGND sky130_ef_sc_hd__decap_12
XFILLER_192_1173 VPWR VGND VPWR VGND sky130_ef_sc_hd__decap_12
XFILLER_0_137 VGND VGND VPWR VPWR sky130_fd_sc_hd__decap_3
XFILLER_135_57 VPWR VGND VPWR VGND sky130_ef_sc_hd__decap_12
XTAP_TAPCELL_ROW_147_2_4638 VGND VPWR sky130_fd_sc_hd__tapvpwrvgnd_1
XFILLER_249_559 VGND VGND VPWR VPWR sky130_fd_sc_hd__fill_1
XFILLER_95_39 VPWR VGND VPWR VGND sky130_ef_sc_hd__decap_12
XTAP_TAPCELL_ROW_244_3461 VGND VPWR sky130_fd_sc_hd__tapvpwrvgnd_1
XTAP_TAPCELL_ROW_244_3472 VGND VPWR sky130_fd_sc_hd__tapvpwrvgnd_1
XFILLER_236_209 VPWR VGND VPWR VGND sky130_ef_sc_hd__decap_12
XFILLER_44_1463 VGND VGND VPWR VPWR sky130_fd_sc_hd__decap_6
XFILLER_131_1411 VPWR VGND VPWR VGND sky130_ef_sc_hd__decap_12
XTAP_TAPCELL_ROW_244_3483 VGND VPWR sky130_fd_sc_hd__tapvpwrvgnd_1
XFILLER_229_261 VPWR VGND VPWR VGND sky130_ef_sc_hd__decap_12
XFILLER_40_1327 VPWR VGND VPWR VGND sky130_ef_sc_hd__decap_12
XFILLER_245_721 VGND VGND VPWR VPWR sky130_fd_sc_hd__decap_6
XTAP_TAPCELL_ROW_5_988 VGND VPWR sky130_fd_sc_hd__tapvpwrvgnd_1
XFILLER_131_1455 VPWR VGND VPWR VGND sky130_ef_sc_hd__decap_12
XFILLER_28_66 VGND VGND VPWR VPWR sky130_fd_sc_hd__fill_2
XTAP_TAPCELL_ROW_5_999 VGND VPWR sky130_fd_sc_hd__tapvpwrvgnd_1
XTAP_TAPCELL_ROW_240_3358 VGND VPWR sky130_fd_sc_hd__tapvpwrvgnd_1
XTAP_TAPCELL_ROW_240_3369 VGND VPWR sky130_fd_sc_hd__tapvpwrvgnd_1
XTAP_TAPCELL_ROW_127_2_4514 VGND VPWR sky130_fd_sc_hd__tapvpwrvgnd_1
XFILLER_245_765 VPWR VGND VPWR VGND sky130_ef_sc_hd__decap_12
X_560_ net663 VGND VGND VPWR VPWR _042_ sky130_fd_sc_hd__inv_2
XFILLER_218_979 VGND VGND VPWR VPWR sky130_fd_sc_hd__fill_1
XFILLER_131_1499 VPWR VGND VPWR VGND sky130_ef_sc_hd__decap_12
XFILLER_244_253 VPWR VGND VPWR VGND sky130_ef_sc_hd__decap_12
XFILLER_205_629 VPWR VGND VPWR VGND sky130_ef_sc_hd__decap_12
X_491_ net92 _251_ VGND VGND VPWR VPWR acc_core.adder.cla_blocks\[4\].block.sum\[1\]
+ sky130_fd_sc_hd__nor2_1
XTAP_TAPCELL_ROW_95_2_4325 VGND VPWR sky130_fd_sc_hd__tapvpwrvgnd_1
XFILLER_204_139 VGND VGND VPWR VPWR sky130_fd_sc_hd__fill_1
XFILLER_44_54 VPWR VGND VPWR VGND sky130_ef_sc_hd__decap_12
XTAP_TAPCELL_ROW_253_3708 VGND VPWR sky130_fd_sc_hd__tapvpwrvgnd_1
XFILLER_38_1245 VGND VGND VPWR VPWR sky130_fd_sc_hd__fill_1
XTAP_TAPCELL_ROW_253_3719 VGND VPWR sky130_fd_sc_hd__tapvpwrvgnd_1
XFILLER_240_3 VPWR VGND VPWR VGND sky130_ef_sc_hd__decap_12
XFILLER_213_673 VPWR VGND VPWR VGND sky130_ef_sc_hd__decap_12
XFILLER_185_503 VGND VGND VPWR VPWR sky130_fd_sc_hd__fill_1
XFILLER_200_301 VGND VGND VPWR VPWR sky130_fd_sc_hd__decap_6
XTAP_TAPCELL_ROW_238_3298 VGND VPWR sky130_fd_sc_hd__tapvpwrvgnd_1
XFILLER_197_385 VGND VGND VPWR VPWR sky130_fd_sc_hd__decap_6
XFILLER_51_1423 VPWR VGND VPWR VGND sky130_ef_sc_hd__decap_12
XFILLER_240_1141 VGND VGND VPWR VPWR sky130_fd_sc_hd__decap_6
XFILLER_8_226 VGND VGND VPWR VPWR sky130_fd_sc_hd__decap_6
XFILLER_200_345 VPWR VGND VPWR VGND sky130_ef_sc_hd__decap_12
XFILLER_90_1483 VPWR VGND VPWR VGND sky130_ef_sc_hd__decap_12
XFILLER_173_709 VPWR VGND VPWR VGND sky130_ef_sc_hd__decap_12
XFILLER_12_1407 VGND VGND VPWR VPWR sky130_fd_sc_hd__decap_6
XFILLER_60_53 VPWR VGND VPWR VGND sky130_ef_sc_hd__decap_12
XFILLER_51_1467 VPWR VGND VPWR VGND sky130_ef_sc_hd__decap_12
XFILLER_200_389 VPWR VGND VPWR VGND sky130_ef_sc_hd__decap_12
XFILLER_240_1185 VPWR VGND VPWR VGND sky130_ef_sc_hd__decap_12
XFILLER_176_53 VPWR VGND VPWR VGND sky130_ef_sc_hd__decap_12
XFILLER_5_933 VPWR VGND VPWR VGND sky130_ef_sc_hd__decap_12
XFILLER_201_1169 VGND VGND VPWR VPWR sky130_fd_sc_hd__decap_6
XFILLER_4_410 VGND VGND VPWR VPWR sky130_fd_sc_hd__fill_1
XFILLER_165_293 VPWR VGND VPWR VGND sky130_ef_sc_hd__decap_12
XFILLER_176_97 VPWR VGND VPWR VGND sky130_ef_sc_hd__decap_12
XFILLER_181_753 VPWR VGND VPWR VGND sky130_ef_sc_hd__decap_12
XFILLER_5_977 VPWR VGND VPWR VGND sky130_ef_sc_hd__decap_12
XFILLER_253_1513 VGND VGND VPWR VPWR sky130_fd_sc_hd__fill_2
XFILLER_181_797 VPWR VGND VPWR VGND sky130_ef_sc_hd__decap_12
XFILLER_69_51 VGND VGND VPWR VPWR sky130_fd_sc_hd__decap_4
XFILLER_49_1385 VGND VGND VPWR VPWR sky130_fd_sc_hd__fill_1
XFILLER_45_1216 VGND VGND VPWR VPWR sky130_fd_sc_hd__fill_2
XFILLER_171_1213 VPWR VGND VPWR VGND sky130_ef_sc_hd__decap_12
XFILLER_192_41 VPWR VGND VPWR VGND sky130_ef_sc_hd__decap_12
XFILLER_175_1393 VGND VGND VPWR VPWR sky130_fd_sc_hd__decap_6
XPHY_EDGE_ROW_194_Right_39 VGND VGND VPWR VPWR sky130_fd_sc_hd__decap_3
XFILLER_171_1257 VPWR VGND VPWR VGND sky130_ef_sc_hd__decap_12
XFILLER_192_85 VPWR VGND VPWR VGND sky130_ef_sc_hd__decap_12
XFILLER_251_1281 VGND VGND VPWR VPWR sky130_fd_sc_hd__decap_6
XFILLER_255_529 VGND VGND VPWR VPWR sky130_fd_sc_hd__decap_3
XFILLER_0_693 VGND VGND VPWR VPWR sky130_fd_sc_hd__decap_3
XTAP_TAPCELL_ROW_22_2_3884 VGND VPWR sky130_fd_sc_hd__tapvpwrvgnd_1
XFILLER_208_401 VPWR VGND VPWR VGND sky130_ef_sc_hd__decap_12
XFILLER_248_581 VGND VGND VPWR VPWR sky130_fd_sc_hd__decap_6
XFILLER_208_445 VPWR VGND VPWR VGND sky130_ef_sc_hd__decap_12
XFILLER_224_905 VPWR VGND VPWR VGND sky130_ef_sc_hd__decap_12
XFILLER_208_489 VPWR VGND VPWR VGND sky130_ef_sc_hd__decap_12
XFILLER_211_15 VPWR VGND VPWR VGND sky130_ef_sc_hd__decap_12
XFILLER_1_1343 VGND VGND VPWR VPWR sky130_fd_sc_hd__fill_1
XFILLER_169_1175 VGND VGND VPWR VPWR sky130_fd_sc_hd__fill_1
XFILLER_224_949 VPWR VGND VPWR VGND sky130_ef_sc_hd__decap_12
XTAP_TAPCELL_ROW_223_2899 VGND VPWR sky130_fd_sc_hd__tapvpwrvgnd_1
XFILLER_56_1301 VGND VGND VPWR VPWR sky130_fd_sc_hd__fill_1
XFILLER_250_245 VGND VGND VPWR VPWR sky130_fd_sc_hd__decap_6
XFILLER_189_853 VPWR VGND VPWR VGND sky130_ef_sc_hd__decap_12
XFILLER_108_1413 VGND VGND VPWR VPWR sky130_fd_sc_hd__fill_1
XFILLER_245_1063 VGND VGND VPWR VPWR sky130_fd_sc_hd__fill_1
XFILLER_182_1353 VPWR VGND VPWR VGND sky130_ef_sc_hd__decap_12
XFILLER_210_109 VPWR VGND VPWR VGND sky130_ef_sc_hd__decap_12
XFILLER_250_289 VPWR VGND VPWR VGND sky130_ef_sc_hd__decap_12
XFILLER_203_161 VGND VGND VPWR VPWR sky130_fd_sc_hd__decap_6
XFILLER_232_993 VPWR VGND VPWR VGND sky130_ef_sc_hd__decap_12
XFILLER_17_1329 VGND VGND VPWR VPWR sky130_fd_sc_hd__fill_1
XFILLER_188_363 VGND VGND VPWR VPWR sky130_fd_sc_hd__fill_1
XFILLER_189_897 VPWR VGND VPWR VGND sky130_ef_sc_hd__decap_12
XFILLER_176_525 VGND VGND VPWR VPWR sky130_fd_sc_hd__decap_6
XFILLER_182_1397 VPWR VGND VPWR VGND sky130_ef_sc_hd__decap_12
XFILLER_86_3 VPWR VGND VPWR VGND sky130_ef_sc_hd__decap_12
XPHY_EDGE_ROW_130_1_Right_786 VGND VGND VPWR VPWR sky130_fd_sc_hd__decap_3
XFILLER_176_569 VPWR VGND VPWR VGND sky130_ef_sc_hd__decap_12
XFILLER_30_1507 VGND VGND VPWR VPWR sky130_fd_sc_hd__decap_8
XFILLER_191_517 VPWR VGND VPWR VGND sky130_ef_sc_hd__decap_12
XFILLER_89_1165 VPWR VGND VPWR VGND sky130_ef_sc_hd__decap_12
XFILLER_67_1441 VGND VGND VPWR VPWR sky130_fd_sc_hd__fill_1
XFILLER_217_1121 VPWR VGND VPWR VGND sky130_ef_sc_hd__decap_12
XTAP_TAPCELL_ROW_122_1_1257 VGND VPWR sky130_fd_sc_hd__tapvpwrvgnd_1
XPHY_EDGE_ROW_13_2_Left_515 VGND VGND VPWR VPWR sky130_fd_sc_hd__decap_3
XTAP_TAPCELL_ROW_168_1412 VGND VPWR sky130_fd_sc_hd__tapvpwrvgnd_1
XFILLER_193_1493 VPWR VGND VPWR VGND sky130_ef_sc_hd__decap_12
XTAP_TAPCELL_ROW_168_1423 VGND VPWR sky130_fd_sc_hd__tapvpwrvgnd_1
XFILLER_213_1007 VGND VGND VPWR VPWR sky130_fd_sc_hd__fill_1
XFILLER_28_1469 VGND VGND VPWR VPWR sky130_fd_sc_hd__fill_1
XTAP_TAPCELL_ROW_168_1434 VGND VPWR sky130_fd_sc_hd__tapvpwrvgnd_1
XFILLER_105_27 VPWR VGND VPWR VGND sky130_ef_sc_hd__decap_12
XPHY_EDGE_ROW_138_2_Left_640 VGND VGND VPWR VPWR sky130_fd_sc_hd__decap_3
XFILLER_218_209 VPWR VGND VPWR VGND sky130_ef_sc_hd__decap_12
XTAP_TAPCELL_ROW_2_903 VGND VPWR sky130_fd_sc_hd__tapvpwrvgnd_1
XTAP_TAPCELL_ROW_2_914 VGND VPWR sky130_fd_sc_hd__tapvpwrvgnd_1
XTAP_TAPCELL_ROW_113_2_4433 VGND VPWR sky130_fd_sc_hd__tapvpwrvgnd_1
XFILLER_227_721 VGND VGND VPWR VPWR sky130_fd_sc_hd__decap_6
XFILLER_252_77 VGND VGND VPWR VPWR sky130_fd_sc_hd__decap_6
XTAP_TAPCELL_ROW_2_925 VGND VPWR sky130_fd_sc_hd__tapvpwrvgnd_1
XFILLER_230_1365 VGND VGND VPWR VPWR sky130_fd_sc_hd__decap_6
XFILLER_2_1129 VPWR VGND VPWR VGND sky130_ef_sc_hd__decap_12
XFILLER_187_1231 VGND VGND VPWR VPWR sky130_fd_sc_hd__fill_1
XFILLER_227_765 VPWR VGND VPWR VGND sky130_ef_sc_hd__decap_12
XFILLER_226_253 VPWR VGND VPWR VGND sky130_ef_sc_hd__decap_12
XFILLER_242_713 VPWR VGND VPWR VGND sky130_ef_sc_hd__decap_12
XFILLER_121_15 VPWR VGND VPWR VGND sky130_ef_sc_hd__decap_12
XFILLER_148_1215 VPWR VGND VPWR VGND sky130_ef_sc_hd__decap_12
XFILLER_199_617 VPWR VGND VPWR VGND sky130_ef_sc_hd__decap_12
XFILLER_242_757 VPWR VGND VPWR VGND sky130_ef_sc_hd__decap_12
XFILLER_241_223 VGND VGND VPWR VPWR sky130_fd_sc_hd__fill_1
XFILLER_148_1259 VPWR VGND VPWR VGND sky130_ef_sc_hd__decap_12
XFILLER_228_1261 VPWR VGND VPWR VGND sky130_ef_sc_hd__decap_12
XTAP_TAPCELL_ROW_61_2_4120 VGND VPWR sky130_fd_sc_hd__tapvpwrvgnd_1
XFILLER_167_503 VGND VGND VPWR VPWR sky130_fd_sc_hd__fill_1
XFILLER_201_81 VPWR VGND VPWR VGND sky130_ef_sc_hd__decap_12
XFILLER_224_1147 VGND VGND VPWR VPWR sky130_fd_sc_hd__fill_1
XFILLER_179_385 VGND VGND VPWR VPWR sky130_fd_sc_hd__decap_6
XFILLER_210_643 VGND VGND VPWR VPWR sky130_fd_sc_hd__fill_1
XFILLER_194_333 VPWR VGND VPWR VGND sky130_ef_sc_hd__decap_12
XFILLER_72_1191 VPWR VGND VPWR VGND sky130_ef_sc_hd__decap_12
XFILLER_195_889 VGND VGND VPWR VPWR sky130_fd_sc_hd__decap_6
XTAP_TAPCELL_ROW_233_3173 VGND VPWR sky130_fd_sc_hd__tapvpwrvgnd_1
XFILLER_194_377 VPWR VGND VPWR VGND sky130_ef_sc_hd__decap_12
XTAP_TAPCELL_ROW_233_3184 VGND VPWR sky130_fd_sc_hd__tapvpwrvgnd_1
XFILLER_159_1311 VPWR VGND VPWR VGND sky130_ef_sc_hd__decap_12
XFILLER_198_1371 VGND VGND VPWR VPWR sky130_fd_sc_hd__fill_1
XFILLER_68_1227 VPWR VGND VPWR VGND sky130_ef_sc_hd__decap_12
XFILLER_30_67 VGND VGND VPWR VPWR sky130_fd_sc_hd__decap_4
XFILLER_120_1189 VGND VGND VPWR VPWR sky130_fd_sc_hd__fill_1
XFILLER_159_1355 VPWR VGND VPWR VGND sky130_ef_sc_hd__decap_12
XFILLER_2_914 VGND VGND VPWR VPWR sky130_fd_sc_hd__decap_8
XFILLER_2_925 VPWR VGND VPWR VGND sky130_ef_sc_hd__decap_12
XFILLER_155_1219 VPWR VGND VPWR VGND sky130_ef_sc_hd__decap_12
XFILLER_1_413 VGND VGND VPWR VPWR sky130_fd_sc_hd__fill_1
XFILLER_159_1399 VPWR VGND VPWR VGND sky130_ef_sc_hd__decap_12
XTAP_TAPCELL_ROW_246_3523 VGND VPWR sky130_fd_sc_hd__tapvpwrvgnd_1
XTAP_TAPCELL_ROW_246_3534 VGND VPWR sky130_fd_sc_hd__tapvpwrvgnd_1
XTAP_TAPCELL_ROW_242_3409 VGND VPWR sky130_fd_sc_hd__tapvpwrvgnd_1
XFILLER_7_1007 VGND VGND VPWR VPWR sky130_fd_sc_hd__fill_1
XFILLER_235_1287 VGND VGND VPWR VPWR sky130_fd_sc_hd__fill_1
XFILLER_190_3 VPWR VGND VPWR VGND sky130_ef_sc_hd__decap_12
XFILLER_237_529 VPWR VGND VPWR VGND sky130_ef_sc_hd__decap_12
XFILLER_44_1271 VPWR VGND VPWR VGND sky130_ef_sc_hd__decap_12
XFILLER_188_1017 VPWR VGND VPWR VGND sky130_ef_sc_hd__decap_12
XTAP_TAPCELL_ROW_8_1068 VGND VPWR sky130_fd_sc_hd__tapvpwrvgnd_1
XTAP_TAPCELL_ROW_8_1079 VGND VPWR sky130_fd_sc_hd__tapvpwrvgnd_1
X_612_ clknet_3_6__leaf_clk dout0\[10\] _020_ VGND VGND VPWR VPWR dout0_q\[10\] sky130_fd_sc_hd__dfrtp_1
XFILLER_79_1323 VGND VGND VPWR VPWR sky130_fd_sc_hd__decap_6
XFILLER_206_905 VPWR VGND VPWR VGND sky130_ef_sc_hd__decap_12
XFILLER_245_573 VPWR VGND VPWR VGND sky130_ef_sc_hd__decap_12
XFILLER_79_1367 VPWR VGND VPWR VGND sky130_ef_sc_hd__decap_12
XFILLER_166_1315 VGND VGND VPWR VPWR sky130_fd_sc_hd__fill_1
X_543_ net667 VGND VGND VPWR VPWR _025_ sky130_fd_sc_hd__inv_2
XFILLER_206_949 VPWR VGND VPWR VGND sky130_ef_sc_hd__decap_12
XFILLER_189_105 VGND VGND VPWR VPWR sky130_fd_sc_hd__decap_6
XFILLER_232_245 VGND VGND VPWR VPWR sky130_fd_sc_hd__decap_6
XFILLER_207_1301 VPWR VGND VPWR VGND sky130_ef_sc_hd__decap_12
X_474_ net159 net99 VGND VGND VPWR VPWR acc_core.adder.cla_blocks\[2\].block.sum\[2\]
+ sky130_fd_sc_hd__xnor2_1
XFILLER_189_149 VPWR VGND VPWR VGND sky130_ef_sc_hd__decap_12
XFILLER_242_1203 VGND VGND VPWR VPWR sky130_fd_sc_hd__fill_1
XFILLER_214_993 VPWR VGND VPWR VGND sky130_ef_sc_hd__decap_12
XFILLER_232_289 VPWR VGND VPWR VGND sky130_ef_sc_hd__decap_12
XFILLER_207_1345 VPWR VGND VPWR VGND sky130_ef_sc_hd__decap_12
XFILLER_197_193 VPWR VGND VPWR VGND sky130_ef_sc_hd__decap_12
XFILLER_199_1113 VGND VGND VPWR VPWR sky130_fd_sc_hd__decap_6
XFILLER_186_867 VGND VGND VPWR VPWR sky130_fd_sc_hd__fill_1
XFILLER_201_665 VGND VGND VPWR VPWR sky130_fd_sc_hd__decap_6
XFILLER_51_1231 VPWR VGND VPWR VGND sky130_ef_sc_hd__decap_12
XFILLER_16_1351 VGND VGND VPWR VPWR sky130_fd_sc_hd__decap_6
XFILLER_200_153 VPWR VGND VPWR VGND sky130_ef_sc_hd__decap_12
XPHY_EDGE_ROW_11_1_Left_266 VGND VGND VPWR VPWR sky130_fd_sc_hd__decap_3
XFILLER_173_517 VPWR VGND VPWR VGND sky130_ef_sc_hd__decap_12
XFILLER_199_1157 VPWR VGND VPWR VGND sky130_ef_sc_hd__decap_12
XFILLER_12_1215 VPWR VGND VPWR VGND sky130_ef_sc_hd__decap_12
XFILLER_51_1275 VPWR VGND VPWR VGND sky130_ef_sc_hd__decap_12
XFILLER_16_1395 VPWR VGND VPWR VGND sky130_ef_sc_hd__decap_12
XFILLER_103_1343 VPWR VGND VPWR VGND sky130_ef_sc_hd__decap_12
XFILLER_200_197 VPWR VGND VPWR VGND sky130_ef_sc_hd__decap_12
XFILLER_12_1259 VPWR VGND VPWR VGND sky130_ef_sc_hd__decap_12
XFILLER_86_1327 VPWR VGND VPWR VGND sky130_ef_sc_hd__decap_12
XFILLER_103_1387 VPWR VGND VPWR VGND sky130_ef_sc_hd__decap_12
XPHY_EDGE_ROW_136_1_Left_391 VGND VGND VPWR VPWR sky130_fd_sc_hd__decap_3
XFILLER_177_1455 VGND VGND VPWR VPWR sky130_fd_sc_hd__fill_1
XFILLER_181_561 VPWR VGND VPWR VGND sky130_ef_sc_hd__decap_12
XFILLER_4_251 VGND VGND VPWR VPWR sky130_fd_sc_hd__fill_1
XFILLER_236_1029 VGND VGND VPWR VPWR sky130_fd_sc_hd__decap_6
XFILLER_138_1439 VPWR VGND VPWR VGND sky130_ef_sc_hd__decap_12
XFILLER_218_1441 VPWR VGND VPWR VGND sky130_ef_sc_hd__decap_12
XFILLER_206_15 VPWR VGND VPWR VGND sky130_ef_sc_hd__decap_12
XFILLER_253_1343 VGND VGND VPWR VPWR sky130_fd_sc_hd__fill_1
XFILLER_171_1021 VPWR VGND VPWR VGND sky130_ef_sc_hd__decap_12
XFILLER_218_1485 VPWR VGND VPWR VGND sky130_ef_sc_hd__decap_12
XFILLER_171_1065 VPWR VGND VPWR VGND sky130_ef_sc_hd__decap_12
XFILLER_23_1311 VPWR VGND VPWR VGND sky130_ef_sc_hd__decap_12
XFILLER_62_1371 VPWR VGND VPWR VGND sky130_ef_sc_hd__decap_12
XFILLER_27_1491 VGND VGND VPWR VPWR sky130_fd_sc_hd__decap_6
XFILLER_209_721 VGND VGND VPWR VPWR sky130_fd_sc_hd__decap_6
XFILLER_255_337 VPWR VGND VPWR VGND sky130_ef_sc_hd__decap_12
XFILLER_23_1355 VPWR VGND VPWR VGND sky130_ef_sc_hd__decap_12
XFILLER_110_1303 VPWR VGND VPWR VGND sky130_ef_sc_hd__decap_12
XFILLER_97_1423 VPWR VGND VPWR VGND sky130_ef_sc_hd__decap_12
XFILLER_114_1483 VPWR VGND VPWR VGND sky130_ef_sc_hd__decap_12
XFILLER_212_1073 VPWR VGND VPWR VGND sky130_ef_sc_hd__decap_12
XFILLER_209_765 VPWR VGND VPWR VGND sky130_ef_sc_hd__decap_12
XFILLER_3_1449 VGND VGND VPWR VPWR sky130_fd_sc_hd__decap_6
XFILLER_208_253 VPWR VGND VPWR VGND sky130_ef_sc_hd__decap_12
XFILLER_224_713 VPWR VGND VPWR VGND sky130_ef_sc_hd__decap_12
XFILLER_58_1407 VGND VGND VPWR VPWR sky130_fd_sc_hd__decap_6
XFILLER_23_1399 VPWR VGND VPWR VGND sky130_ef_sc_hd__decap_12
XFILLER_97_1467 VPWR VGND VPWR VGND sky130_ef_sc_hd__decap_12
XFILLER_223_223 VGND VGND VPWR VPWR sky130_fd_sc_hd__fill_1
XFILLER_224_757 VPWR VGND VPWR VGND sky130_ef_sc_hd__decap_12
XFILLER_247_1169 VGND VGND VPWR VPWR sky130_fd_sc_hd__decap_6
XFILLER_225_1401 VPWR VGND VPWR VGND sky130_ef_sc_hd__decap_12
XTAP_TAPCELL_ROW_46_2_4033 VGND VPWR sky130_fd_sc_hd__tapvpwrvgnd_1
XFILLER_211_429 VPWR VGND VPWR VGND sky130_ef_sc_hd__decap_12
XFILLER_182_1161 VPWR VGND VPWR VGND sky130_ef_sc_hd__decap_12
XFILLER_176_333 VPWR VGND VPWR VGND sky130_ef_sc_hd__decap_12
XFILLER_34_1451 VPWR VGND VPWR VGND sky130_ef_sc_hd__decap_12
XPHY_EDGE_ROW_131_1_Right_787 VGND VGND VPWR VPWR sky130_fd_sc_hd__decap_3
XFILLER_143_1189 VPWR VGND VPWR VGND sky130_ef_sc_hd__decap_12
XFILLER_177_889 VGND VGND VPWR VPWR sky130_fd_sc_hd__decap_6
XFILLER_176_377 VPWR VGND VPWR VGND sky130_ef_sc_hd__decap_12
XFILLER_192_837 VPWR VGND VPWR VGND sky130_ef_sc_hd__decap_12
XFILLER_30_1315 VPWR VGND VPWR VGND sky130_ef_sc_hd__decap_12
XFILLER_34_1495 VPWR VGND VPWR VGND sky130_ef_sc_hd__decap_12
XFILLER_121_1443 VPWR VGND VPWR VGND sky130_ef_sc_hd__decap_12
XFILLER_247_55 VGND VGND VPWR VPWR sky130_fd_sc_hd__fill_1
XFILLER_195_1511 VGND VGND VPWR VPWR sky130_fd_sc_hd__fill_1
XFILLER_30_1359 VPWR VGND VPWR VGND sky130_ef_sc_hd__decap_12
XFILLER_254_1129 VPWR VGND VPWR VGND sky130_ef_sc_hd__decap_12
XFILLER_116_15 VPWR VGND VPWR VGND sky130_ef_sc_hd__decap_12
XFILLER_232_1427 VGND VGND VPWR VPWR sky130_fd_sc_hd__fill_1
XTAP_TAPCELL_ROW_163_2_4730 VGND VPWR sky130_fd_sc_hd__tapvpwrvgnd_1
XFILLER_219_529 VPWR VGND VPWR VGND sky130_ef_sc_hd__decap_12
XFILLER_41_1411 VPWR VGND VPWR VGND sky130_ef_sc_hd__decap_12
XFILLER_80_1471 VPWR VGND VPWR VGND sky130_ef_sc_hd__decap_12
XFILLER_189_1337 VGND VGND VPWR VPWR sky130_fd_sc_hd__decap_6
XFILLER_41_1455 VPWR VGND VPWR VGND sky130_ef_sc_hd__decap_12
XFILLER_6_1073 VPWR VGND VPWR VGND sky130_ef_sc_hd__decap_12
XFILLER_230_1173 VPWR VGND VPWR VGND sky130_ef_sc_hd__decap_12
XFILLER_227_573 VPWR VGND VPWR VGND sky130_ef_sc_hd__decap_12
XFILLER_255_893 VGND VGND VPWR VPWR sky130_fd_sc_hd__decap_3
XFILLER_41_1499 VPWR VGND VPWR VGND sky130_ef_sc_hd__decap_12
XFILLER_76_1507 VGND VGND VPWR VPWR sky130_fd_sc_hd__decap_8
XFILLER_92_29 VPWR VGND VPWR VGND sky130_ef_sc_hd__decap_12
XFILLER_199_447 VGND VGND VPWR VPWR sky130_fd_sc_hd__fill_1
XFILLER_214_245 VGND VGND VPWR VPWR sky130_fd_sc_hd__decap_6
XFILLER_187_609 VGND VGND VPWR VPWR sky130_fd_sc_hd__decap_6
XFILLER_242_587 VGND VGND VPWR VPWR sky130_fd_sc_hd__fill_1
XFILLER_214_289 VPWR VGND VPWR VGND sky130_ef_sc_hd__decap_12
XFILLER_161_1201 VPWR VGND VPWR VGND sky130_ef_sc_hd__decap_12
XFILLER_230_749 VGND VGND VPWR VPWR sky130_fd_sc_hd__decap_6
XTAP_TAPCELL_ROW_235_3224 VGND VPWR sky130_fd_sc_hd__tapvpwrvgnd_1
XFILLER_228_1091 VGND VGND VPWR VPWR sky130_fd_sc_hd__fill_1
XTAP_TAPCELL_ROW_235_3235 VGND VPWR sky130_fd_sc_hd__tapvpwrvgnd_1
XFILLER_179_193 VPWR VGND VPWR VGND sky130_ef_sc_hd__decap_12
XFILLER_168_867 VGND VGND VPWR VPWR sky130_fd_sc_hd__fill_1
XFILLER_195_653 VPWR VGND VPWR VGND sky130_ef_sc_hd__decap_12
XFILLER_161_1267 VGND VGND VPWR VPWR sky130_fd_sc_hd__decap_6
XFILLER_194_141 VPWR VGND VPWR VGND sky130_ef_sc_hd__decap_12
XFILLER_195_697 VPWR VGND VPWR VGND sky130_ef_sc_hd__decap_12
XFILLER_202_1253 VGND VGND VPWR VPWR sky130_fd_sc_hd__decap_6
XFILLER_157_55 VGND VGND VPWR VPWR sky130_fd_sc_hd__fill_1
XFILLER_202_1297 VPWR VGND VPWR VGND sky130_ef_sc_hd__decap_12
XTAP_TAPCELL_ROW_104_2_4378 VGND VPWR sky130_fd_sc_hd__tapvpwrvgnd_1
XFILLER_203_3 VPWR VGND VPWR VGND sky130_ef_sc_hd__decap_12
XFILLER_2_755 VGND VGND VPWR VPWR sky130_fd_sc_hd__fill_1
XTAP_TAPCELL_ROW_72_2_4189 VGND VPWR sky130_fd_sc_hd__tapvpwrvgnd_1
XFILLER_81_1213 VGND VGND VPWR VPWR sky130_fd_sc_hd__decap_4
XFILLER_172_1341 VPWR VGND VPWR VGND sky130_ef_sc_hd__decap_12
XFILLER_238_805 VGND VGND VPWR VPWR sky130_fd_sc_hd__decap_6
XFILLER_2_27 VGND VGND VPWR VPWR sky130_fd_sc_hd__fill_1
XFILLER_172_1385 VPWR VGND VPWR VGND sky130_ef_sc_hd__decap_12
XFILLER_238_849 VPWR VGND VPWR VGND sky130_ef_sc_hd__decap_12
XFILLER_237_337 VPWR VGND VPWR VGND sky130_ef_sc_hd__decap_12
XFILLER_66_41 VPWR VGND VPWR VGND sky130_ef_sc_hd__decap_12
XTAP_TAPCELL_ROW_52_2_4065 VGND VPWR sky130_fd_sc_hd__tapvpwrvgnd_1
XFILLER_252_307 VGND VGND VPWR VPWR sky130_fd_sc_hd__fill_1
XFILLER_213_1393 VGND VGND VPWR VPWR sky130_fd_sc_hd__decap_6
XPHY_EDGE_ROW_204_Left_459 VGND VGND VPWR VPWR sky130_fd_sc_hd__decap_3
XFILLER_206_713 VPWR VGND VPWR VGND sky130_ef_sc_hd__decap_12
XFILLER_246_893 VPWR VGND VPWR VGND sky130_ef_sc_hd__decap_12
XTAP_TAPCELL_ROW_220_2814 VGND VPWR sky130_fd_sc_hd__tapvpwrvgnd_1
XTAP_TAPCELL_ROW_220_2825 VGND VPWR sky130_fd_sc_hd__tapvpwrvgnd_1
XFILLER_205_223 VGND VGND VPWR VPWR sky130_fd_sc_hd__fill_1
XTAP_TAPCELL_ROW_220_2836 VGND VPWR sky130_fd_sc_hd__tapvpwrvgnd_1
XFILLER_206_757 VPWR VGND VPWR VGND sky130_ef_sc_hd__decap_12
XFILLER_244_1309 VGND VGND VPWR VPWR sky130_fd_sc_hd__decap_6
X_526_ net663 VGND VGND VPWR VPWR _008_ sky130_fd_sc_hd__inv_2
XFILLER_221_727 VGND VGND VPWR VPWR sky130_fd_sc_hd__fill_1
XFILLER_18_1413 VGND VGND VPWR VPWR sky130_fd_sc_hd__fill_1
X_457_ rd_addr\[3\] net621 net624 VGND VGND VPWR VPWR addr0\[3\] sky130_fd_sc_hd__mux2_1
XFILLER_183_1481 VPWR VGND VPWR VGND sky130_ef_sc_hd__decap_12
XTAP_TAPCELL_ROW_197_2194 VGND VPWR sky130_fd_sc_hd__tapvpwrvgnd_1
XTAP_TAPCELL_ROW_30_2_3935 VGND VPWR sky130_fd_sc_hd__tapvpwrvgnd_1
XTAP_TAPCELL_ROW_29_2_3929 VGND VPWR sky130_fd_sc_hd__tapvpwrvgnd_1
XFILLER_207_1175 VGND VGND VPWR VPWR sky130_fd_sc_hd__fill_1
X_388_ net152 net209 VGND VGND VPWR VPWR _177_ sky130_fd_sc_hd__and2b_1
XFILLER_201_473 VPWR VGND VPWR VGND sky130_ef_sc_hd__decap_12
XTAP_TAPCELL_ROW_218_2765 VGND VPWR sky130_fd_sc_hd__tapvpwrvgnd_1
XFILLER_9_365 VPWR VGND VPWR VGND sky130_ef_sc_hd__decap_12
XTAP_TAPCELL_ROW_218_2776 VGND VPWR sky130_fd_sc_hd__tapvpwrvgnd_1
XFILLER_174_837 VPWR VGND VPWR VGND sky130_ef_sc_hd__decap_12
XFILLER_220_1353 VPWR VGND VPWR VGND sky130_ef_sc_hd__decap_12
XPHY_EDGE_ROW_213_Left_468 VGND VGND VPWR VPWR sky130_fd_sc_hd__decap_3
XFILLER_220_1397 VPWR VGND VPWR VGND sky130_ef_sc_hd__decap_12
XFILLER_138_1203 VPWR VGND VPWR VGND sky130_ef_sc_hd__decap_12
XFILLER_182_881 VPWR VGND VPWR VGND sky130_ef_sc_hd__decap_12
XFILLER_49_3 VPWR VGND VPWR VGND sky130_ef_sc_hd__decap_12
XFILLER_138_1247 VPWR VGND VPWR VGND sky130_ef_sc_hd__decap_12
XFILLER_181_391 VGND VGND VPWR VPWR sky130_fd_sc_hd__fill_1
XFILLER_217_69 VPWR VGND VPWR VGND sky130_ef_sc_hd__decap_12
XTAP_TAPCELL_ROW_148_2_4643 VGND VPWR sky130_fd_sc_hd__tapvpwrvgnd_1
XFILLER_190_1441 VPWR VGND VPWR VGND sky130_ef_sc_hd__decap_12
XFILLER_190_1485 VPWR VGND VPWR VGND sky130_ef_sc_hd__decap_12
XFILLER_233_57 VPWR VGND VPWR VGND sky130_ef_sc_hd__decap_12
XPHY_EDGE_ROW_222_Left_477 VGND VGND VPWR VPWR sky130_fd_sc_hd__decap_3
XFILLER_3_1213 VPWR VGND VPWR VGND sky130_ef_sc_hd__decap_12
XFILLER_7_1393 VGND VGND VPWR VPWR sky130_fd_sc_hd__decap_6
XFILLER_231_1493 VPWR VGND VPWR VGND sky130_ef_sc_hd__decap_12
XTAP_TAPCELL_ROW_117_1_1252 VGND VPWR sky130_fd_sc_hd__tapvpwrvgnd_1
XFILLER_97_1231 VPWR VGND VPWR VGND sky130_ef_sc_hd__decap_12
XFILLER_209_573 VPWR VGND VPWR VGND sky130_ef_sc_hd__decap_12
XFILLER_243_329 VGND VGND VPWR VPWR sky130_fd_sc_hd__decap_6
XFILLER_3_1257 VPWR VGND VPWR VGND sky130_ef_sc_hd__decap_12
XFILLER_58_1215 VPWR VGND VPWR VGND sky130_ef_sc_hd__decap_12
XTAP_TAPCELL_ROW_182_1795 VGND VPWR sky130_fd_sc_hd__tapvpwrvgnd_1
XTAP_TAPCELL_ROW_96_2_4330 VGND VPWR sky130_fd_sc_hd__tapvpwrvgnd_1
XFILLER_97_1275 VPWR VGND VPWR VGND sky130_ef_sc_hd__decap_12
XFILLER_149_1343 VPWR VGND VPWR VGND sky130_ef_sc_hd__decap_12
XFILLER_110_1177 VPWR VGND VPWR VGND sky130_ef_sc_hd__decap_12
XFILLER_58_1259 VPWR VGND VPWR VGND sky130_ef_sc_hd__decap_12
XFILLER_169_609 VGND VGND VPWR VPWR sky130_fd_sc_hd__decap_6
XFILLER_149_1387 VPWR VGND VPWR VGND sky130_ef_sc_hd__decap_12
XFILLER_224_587 VGND VGND VPWR VPWR sky130_fd_sc_hd__fill_1
XFILLER_251_373 VPWR VGND VPWR VGND sky130_ef_sc_hd__decap_12
XFILLER_212_749 VGND VGND VPWR VPWR sky130_fd_sc_hd__decap_6
XFILLER_225_1231 VGND VGND VPWR VPWR sky130_fd_sc_hd__fill_1
XFILLER_211_237 VPWR VGND VPWR VGND sky130_ef_sc_hd__decap_12
XFILLER_177_653 VPWR VGND VPWR VGND sky130_ef_sc_hd__decap_12
XFILLER_176_141 VPWR VGND VPWR VGND sky130_ef_sc_hd__decap_12
XFILLER_192_601 VPWR VGND VPWR VGND sky130_ef_sc_hd__decap_12
XPHY_EDGE_ROW_231_Left_486 VGND VGND VPWR VPWR sky130_fd_sc_hd__decap_3
XFILLER_220_793 VPWR VGND VPWR VGND sky130_ef_sc_hd__decap_12
XFILLER_165_837 VGND VGND VPWR VPWR sky130_fd_sc_hd__decap_3
XFILLER_177_697 VPWR VGND VPWR VGND sky130_ef_sc_hd__decap_12
XFILLER_178_1005 VPWR VGND VPWR VGND sky130_ef_sc_hd__decap_12
XFILLER_191_111 VGND VGND VPWR VPWR sky130_fd_sc_hd__fill_1
XPHY_EDGE_ROW_132_1_Right_788 VGND VGND VPWR VPWR sky130_fd_sc_hd__decap_3
XFILLER_192_645 VPWR VGND VPWR VGND sky130_ef_sc_hd__decap_12
XFILLER_69_1311 VPWR VGND VPWR VGND sky130_ef_sc_hd__decap_12
XFILLER_178_1049 VPWR VGND VPWR VGND sky130_ef_sc_hd__decap_12
XFILLER_121_1273 VGND VGND VPWR VPWR sky130_fd_sc_hd__fill_1
XFILLER_69_1355 VPWR VGND VPWR VGND sky130_ef_sc_hd__decap_12
XFILLER_156_1303 VPWR VGND VPWR VGND sky130_ef_sc_hd__decap_12
XFILLER_30_1189 VGND VGND VPWR VPWR sky130_fd_sc_hd__fill_1
XFILLER_11_69 VGND VGND VPWR VPWR sky130_fd_sc_hd__fill_2
XFILLER_65_1219 VPWR VGND VPWR VGND sky130_ef_sc_hd__decap_12
XFILLER_127_69 VGND VGND VPWR VPWR sky130_fd_sc_hd__fill_2
XFILLER_219_1057 VGND VGND VPWR VPWR sky130_fd_sc_hd__decap_6
XFILLER_69_1399 VPWR VGND VPWR VGND sky130_ef_sc_hd__decap_12
XFILLER_236_1371 VGND VGND VPWR VPWR sky130_fd_sc_hd__fill_1
XTAP_TAPCELL_ROW_228_3050 VGND VPWR sky130_fd_sc_hd__tapvpwrvgnd_1
XPHY_EDGE_ROW_240_Left_495 VGND VGND VPWR VPWR sky130_fd_sc_hd__decap_3
XTAP_TAPCELL_ROW_9_1130 VGND VPWR sky130_fd_sc_hd__tapvpwrvgnd_1
XTAP_TAPCELL_ROW_9_1141 VGND VPWR sky130_fd_sc_hd__tapvpwrvgnd_1
XFILLER_189_1101 VPWR VGND VPWR VGND sky130_ef_sc_hd__decap_12
XFILLER_143_57 VPWR VGND VPWR VGND sky130_ef_sc_hd__decap_12
XFILLER_219_337 VPWR VGND VPWR VGND sky130_ef_sc_hd__decap_12
XTAP_TAPCELL_ROW_5_1005 VGND VPWR sky130_fd_sc_hd__tapvpwrvgnd_1
XFILLER_189_1145 VPWR VGND VPWR VGND sky130_ef_sc_hd__decap_12
XFILLER_234_307 VGND VGND VPWR VPWR sky130_fd_sc_hd__fill_1
XFILLER_185_1009 VPWR VGND VPWR VGND sky130_ef_sc_hd__decap_12
XFILLER_246_189 VGND VGND VPWR VPWR sky130_fd_sc_hd__decap_6
XFILLER_189_1189 VPWR VGND VPWR VGND sky130_ef_sc_hd__decap_12
XFILLER_228_893 VPWR VGND VPWR VGND sky130_ef_sc_hd__decap_12
XFILLER_243_841 VPWR VGND VPWR VGND sky130_ef_sc_hd__decap_12
XFILLER_76_1315 VPWR VGND VPWR VGND sky130_ef_sc_hd__decap_12
XFILLER_76_1359 VPWR VGND VPWR VGND sky130_ef_sc_hd__decap_12
XFILLER_226_1017 VPWR VGND VPWR VGND sky130_ef_sc_hd__decap_12
XFILLER_128_1427 VPWR VGND VPWR VGND sky130_ef_sc_hd__decap_12
XFILLER_203_727 VGND VGND VPWR VPWR sky130_fd_sc_hd__fill_1
XFILLER_153_3 VPWR VGND VPWR VGND sky130_ef_sc_hd__decap_12
XFILLER_230_513 VPWR VGND VPWR VGND sky130_ef_sc_hd__decap_12
XFILLER_163_1329 VGND VGND VPWR VPWR sky130_fd_sc_hd__fill_1
XFILLER_187_417 VPWR VGND VPWR VGND sky130_ef_sc_hd__decap_12
X_311_ net596 dout0_q\[27\] net528 VGND VGND VPWR VPWR _100_ sky130_fd_sc_hd__and3_1
XPHY_EDGE_ROW_94_1_Right_750 VGND VGND VPWR VPWR sky130_fd_sc_hd__decap_3
XFILLER_230_557 VPWR VGND VPWR VGND sky130_ef_sc_hd__decap_12
XFILLER_39_1192 VPWR VGND VPWR VGND sky130_ef_sc_hd__decap_12
XTAP_TAPCELL_ROW_200_2290 VGND VPWR sky130_fd_sc_hd__tapvpwrvgnd_1
XFILLER_204_1315 VGND VGND VPWR VPWR sky130_fd_sc_hd__fill_1
XFILLER_196_973 VGND VGND VPWR VPWR sky130_fd_sc_hd__decap_6
XFILLER_195_461 VPWR VGND VPWR VGND sky130_ef_sc_hd__decap_12
XFILLER_168_65 VPWR VGND VPWR VGND sky130_ef_sc_hd__decap_12
XFILLER_6_302 VGND VGND VPWR VPWR sky130_fd_sc_hd__decap_6
Xinput19 wr_data[18] VGND VGND VPWR VPWR net19 sky130_fd_sc_hd__clkbuf_1
XTAP_TAPCELL_ROW_192_2080 VGND VPWR sky130_fd_sc_hd__tapvpwrvgnd_1
XFILLER_196_1105 VPWR VGND VPWR VGND sky130_ef_sc_hd__decap_12
XFILLER_13_1343 VPWR VGND VPWR VGND sky130_ef_sc_hd__decap_12
XFILLER_182_133 VGND VGND VPWR VPWR sky130_fd_sc_hd__decap_6
XFILLER_202_1061 VPWR VGND VPWR VGND sky130_ef_sc_hd__decap_12
XFILLER_87_1411 VPWR VGND VPWR VGND sky130_ef_sc_hd__decap_12
XFILLER_104_1471 VPWR VGND VPWR VGND sky130_ef_sc_hd__decap_12
XFILLER_196_1149 VPWR VGND VPWR VGND sky130_ef_sc_hd__decap_12
XTAP_TAPCELL_ROW_213_2640 VGND VPWR sky130_fd_sc_hd__tapvpwrvgnd_1
XFILLER_13_1387 VPWR VGND VPWR VGND sky130_ef_sc_hd__decap_12
XFILLER_237_1113 VGND VGND VPWR VPWR sky130_fd_sc_hd__decap_6
XFILLER_182_177 VPWR VGND VPWR VGND sky130_ef_sc_hd__decap_12
XFILLER_87_1455 VPWR VGND VPWR VGND sky130_ef_sc_hd__decap_12
XFILLER_100_1357 VGND VGND VPWR VPWR sky130_fd_sc_hd__fill_1
XFILLER_184_53 VPWR VGND VPWR VGND sky130_ef_sc_hd__decap_12
XFILLER_48_1439 VPWR VGND VPWR VGND sky130_ef_sc_hd__decap_12
XFILLER_237_1157 VPWR VGND VPWR VGND sky130_ef_sc_hd__decap_12
XFILLER_87_1499 VPWR VGND VPWR VGND sky130_ef_sc_hd__decap_12
Xsram0_681 VGND VGND VPWR VPWR sram0_681/HI net681 sky130_fd_sc_hd__conb_1
XFILLER_184_97 VPWR VGND VPWR VGND sky130_ef_sc_hd__decap_12
XFILLER_77_51 VGND VGND VPWR VPWR sky130_fd_sc_hd__decap_4
XFILLER_238_613 VPWR VGND VPWR VGND sky130_ef_sc_hd__decap_12
XFILLER_215_1455 VGND VGND VPWR VPWR sky130_fd_sc_hd__fill_1
XFILLER_238_657 VPWR VGND VPWR VGND sky130_ef_sc_hd__decap_12
XFILLER_133_1177 VPWR VGND VPWR VGND sky130_ef_sc_hd__decap_12
XFILLER_20_1303 VPWR VGND VPWR VGND sky130_ef_sc_hd__decap_12
XFILLER_203_27 VPWR VGND VPWR VGND sky130_ef_sc_hd__decap_12
XTAP_TAPCELL_ROW_207_2466 VGND VPWR sky130_fd_sc_hd__tapvpwrvgnd_1
XFILLER_237_167 VGND VGND VPWR VPWR sky130_fd_sc_hd__fill_1
XFILLER_24_1483 VPWR VGND VPWR VGND sky130_ef_sc_hd__decap_12
XTAP_TAPCELL_ROW_207_2477 VGND VPWR sky130_fd_sc_hd__tapvpwrvgnd_1
XFILLER_168_1229 VPWR VGND VPWR VGND sky130_ef_sc_hd__decap_12
XFILLER_225_329 VGND VGND VPWR VPWR sky130_fd_sc_hd__decap_6
XFILLER_94_1415 VPWR VGND VPWR VGND sky130_ef_sc_hd__decap_12
XTAP_TAPCELL_ROW_199_2245 VGND VPWR sky130_fd_sc_hd__tapvpwrvgnd_1
XFILLER_248_1253 VGND VGND VPWR VPWR sky130_fd_sc_hd__decap_6
XTAP_TAPCELL_ROW_199_2256 VGND VPWR sky130_fd_sc_hd__tapvpwrvgnd_1
XFILLER_111_1497 VGND VGND VPWR VPWR sky130_fd_sc_hd__fill_1
XTAP_TAPCELL_ROW_199_2267 VGND VPWR sky130_fd_sc_hd__tapvpwrvgnd_1
XFILLER_244_1117 VPWR VGND VPWR VGND sky130_ef_sc_hd__decap_12
XFILLER_248_1297 VPWR VGND VPWR VGND sky130_ef_sc_hd__decap_12
XFILLER_233_373 VPWR VGND VPWR VGND sky130_ef_sc_hd__decap_12
XFILLER_206_587 VGND VGND VPWR VPWR sky130_fd_sc_hd__fill_1
XPHY_EDGE_ROW_30_2_Right_121 VGND VGND VPWR VPWR sky130_fd_sc_hd__decap_3
X_509_ net524 net187 VGND VGND VPWR VPWR _260_ sky130_fd_sc_hd__xor2_1
XPHY_EDGE_ROW_22_2_Left_524 VGND VGND VPWR VPWR sky130_fd_sc_hd__decap_3
XFILLER_187_951 VGND VGND VPWR VPWR sky130_fd_sc_hd__fill_1
XFILLER_105_1213 VGND VGND VPWR VPWR sky130_fd_sc_hd__decap_4
XFILLER_174_601 VPWR VGND VPWR VGND sky130_ef_sc_hd__decap_12
XFILLER_202_793 VPWR VGND VPWR VGND sky130_ef_sc_hd__decap_12
XFILLER_144_1295 VGND VGND VPWR VPWR sky130_fd_sc_hd__decap_6
XFILLER_201_281 VPWR VGND VPWR VGND sky130_ef_sc_hd__decap_12
XFILLER_53_1189 VPWR VGND VPWR VGND sky130_ef_sc_hd__decap_12
XFILLER_173_111 VGND VGND VPWR VPWR sky130_fd_sc_hd__fill_1
XFILLER_179_1325 VPWR VGND VPWR VGND sky130_ef_sc_hd__decap_12
XFILLER_174_645 VPWR VGND VPWR VGND sky130_ef_sc_hd__decap_12
XFILLER_31_1443 VPWR VGND VPWR VGND sky130_ef_sc_hd__decap_12
XFILLER_9_195 VGND VGND VPWR VPWR sky130_fd_sc_hd__fill_1
XFILLER_220_1161 VPWR VGND VPWR VGND sky130_ef_sc_hd__decap_12
XFILLER_179_1369 VPWR VGND VPWR VGND sky130_ef_sc_hd__decap_12
XTAP_TAPCELL_ROW_171_1496 VGND VPWR sky130_fd_sc_hd__tapvpwrvgnd_1
XFILLER_255_1257 VGND VGND VPWR VPWR sky130_fd_sc_hd__decap_3
XFILLER_233_1511 VGND VGND VPWR VPWR sky130_fd_sc_hd__fill_1
XTAP_TAPCELL_ROW_188_1960 VGND VPWR sky130_fd_sc_hd__tapvpwrvgnd_1
XTAP_TAPCELL_ROW_188_1971 VGND VPWR sky130_fd_sc_hd__tapvpwrvgnd_1
XFILLER_3_81 VPWR VGND VPWR VGND sky130_ef_sc_hd__decap_12
XFILLER_151_1255 VPWR VGND VPWR VGND sky130_ef_sc_hd__decap_12
XTAP_TAPCELL_ROW_184_1846 VGND VPWR sky130_fd_sc_hd__tapvpwrvgnd_1
XTAP_TAPCELL_ROW_184_1857 VGND VPWR sky130_fd_sc_hd__tapvpwrvgnd_1
XFILLER_112_1239 VGND VGND VPWR VPWR sky130_fd_sc_hd__decap_6
XFILLER_3_1021 VPWR VGND VPWR VGND sky130_ef_sc_hd__decap_12
XFILLER_113_27 VPWR VGND VPWR VGND sky130_ef_sc_hd__decap_12
XFILLER_151_1299 VPWR VGND VPWR VGND sky130_ef_sc_hd__decap_12
XFILLER_216_307 VGND VGND VPWR VPWR sky130_fd_sc_hd__fill_1
XFILLER_228_189 VGND VGND VPWR VPWR sky130_fd_sc_hd__decap_6
XFILLER_186_1329 VPWR VGND VPWR VGND sky130_ef_sc_hd__decap_12
XFILLER_243_137 VPWR VGND VPWR VGND sky130_ef_sc_hd__decap_12
XFILLER_3_1065 VPWR VGND VPWR VGND sky130_ef_sc_hd__decap_12
XFILLER_225_841 VPWR VGND VPWR VGND sky130_ef_sc_hd__decap_12
XFILLER_240_811 VGND VGND VPWR VPWR sky130_fd_sc_hd__fill_1
XFILLER_212_513 VPWR VGND VPWR VGND sky130_ef_sc_hd__decap_12
XFILLER_227_1337 VGND VGND VPWR VPWR sky130_fd_sc_hd__decap_6
XFILLER_252_693 VGND VGND VPWR VPWR sky130_fd_sc_hd__decap_6
XFILLER_169_417 VPWR VGND VPWR VGND sky130_ef_sc_hd__decap_12
XFILLER_251_181 VPWR VGND VPWR VGND sky130_ef_sc_hd__decap_12
XFILLER_71_1201 VPWR VGND VPWR VGND sky130_ef_sc_hd__decap_12
XFILLER_212_557 VPWR VGND VPWR VGND sky130_ef_sc_hd__decap_12
XFILLER_162_1351 VGND VGND VPWR VPWR sky130_fd_sc_hd__decap_6
XPHY_EDGE_ROW_79_2_Left_581 VGND VGND VPWR VPWR sky130_fd_sc_hd__decap_3
XFILLER_178_973 VGND VGND VPWR VPWR sky130_fd_sc_hd__decap_6
XFILLER_165_601 VPWR VGND VPWR VGND sky130_ef_sc_hd__decap_12
XFILLER_177_461 VPWR VGND VPWR VGND sky130_ef_sc_hd__decap_12
XFILLER_71_1267 VGND VGND VPWR VPWR sky130_fd_sc_hd__decap_6
XTAP_TAPCELL_ROW_140_2_4594 VGND VPWR sky130_fd_sc_hd__tapvpwrvgnd_1
XFILLER_193_921 VPWR VGND VPWR VGND sky130_ef_sc_hd__decap_12
XTAP_TAPCELL_ROW_139_2_4588 VGND VPWR sky130_fd_sc_hd__tapvpwrvgnd_1
XFILLER_162_1395 VPWR VGND VPWR VGND sky130_ef_sc_hd__decap_12
XFILLER_165_645 VPWR VGND VPWR VGND sky130_ef_sc_hd__decap_12
XFILLER_197_1425 VPWR VGND VPWR VGND sky130_ef_sc_hd__decap_12
XFILLER_123_1379 VGND VGND VPWR VPWR sky130_fd_sc_hd__decap_6
XFILLER_193_965 VPWR VGND VPWR VGND sky130_ef_sc_hd__decap_12
XFILLER_203_1381 VPWR VGND VPWR VGND sky130_ef_sc_hd__decap_12
XPHY_EDGE_ROW_133_1_Right_789 VGND VGND VPWR VPWR sky130_fd_sc_hd__decap_3
XFILLER_192_475 VGND VGND VPWR VPWR sky130_fd_sc_hd__fill_1
XFILLER_197_1469 VPWR VGND VPWR VGND sky130_ef_sc_hd__decap_12
XFILLER_180_637 VGND VGND VPWR VPWR sky130_fd_sc_hd__decap_6
XFILLER_238_1477 VGND VGND VPWR VPWR sky130_fd_sc_hd__decap_6
XTAP_TAPCELL_ROW_87_2_4275 VGND VPWR sky130_fd_sc_hd__tapvpwrvgnd_1
XFILLER_156_1177 VPWR VGND VPWR VGND sky130_ef_sc_hd__decap_12
XFILLER_191_1057 VGND VGND VPWR VPWR sky130_fd_sc_hd__decap_6
XTAP_TAPCELL_ROW_24_1_1159 VGND VPWR sky130_fd_sc_hd__tapvpwrvgnd_1
XFILLER_169_1505 VGND VGND VPWR VPWR sky130_fd_sc_hd__decap_6
XTAP_TAPCELL_ROW_112_2_4429 VGND VPWR sky130_fd_sc_hd__tapvpwrvgnd_1
XFILLER_130_1339 VPWR VGND VPWR VGND sky130_ef_sc_hd__decap_12
XFILLER_219_167 VGND VGND VPWR VPWR sky130_fd_sc_hd__fill_1
XFILLER_47_65 VGND VGND VPWR VPWR sky130_fd_sc_hd__decap_6
XFILLER_207_329 VGND VGND VPWR VPWR sky130_fd_sc_hd__decap_6
XFILLER_210_1341 VPWR VGND VPWR VGND sky130_ef_sc_hd__decap_12
XPHY_EDGE_ROW_20_1_Left_275 VGND VGND VPWR VPWR sky130_fd_sc_hd__decap_3
XFILLER_170_77 VGND VGND VPWR VPWR sky130_fd_sc_hd__decap_6
XFILLER_210_1385 VPWR VGND VPWR VGND sky130_ef_sc_hd__decap_12
XTAP_TAPCELL_ROW_202_2330 VGND VPWR sky130_fd_sc_hd__tapvpwrvgnd_1
XTAP_TAPCELL_ROW_202_2341 VGND VPWR sky130_fd_sc_hd__tapvpwrvgnd_1
XTAP_TAPCELL_ROW_202_2352 VGND VPWR sky130_fd_sc_hd__tapvpwrvgnd_1
XFILLER_243_671 VGND VGND VPWR VPWR sky130_fd_sc_hd__fill_1
XFILLER_245_1437 VPWR VGND VPWR VGND sky130_ef_sc_hd__decap_12
XFILLER_215_373 VPWR VGND VPWR VGND sky130_ef_sc_hd__decap_12
XFILLER_231_833 VGND VGND VPWR VPWR sky130_fd_sc_hd__decap_6
XFILLER_188_737 VPWR VGND VPWR VGND sky130_ef_sc_hd__decap_12
XFILLER_230_321 VPWR VGND VPWR VGND sky130_ef_sc_hd__decap_12
XFILLER_76_1189 VGND VGND VPWR VPWR sky130_fd_sc_hd__fill_1
XFILLER_187_225 VPWR VGND VPWR VGND sky130_ef_sc_hd__decap_12
XTAP_TAPCELL_ROW_194_2120 VGND VPWR sky130_fd_sc_hd__tapvpwrvgnd_1
XTAP_TAPCELL_ROW_194_2131 VGND VPWR sky130_fd_sc_hd__tapvpwrvgnd_1
XFILLER_231_877 VPWR VGND VPWR VGND sky130_ef_sc_hd__decap_12
XFILLER_169_951 VGND VGND VPWR VPWR sky130_fd_sc_hd__fill_1
XFILLER_230_365 VPWR VGND VPWR VGND sky130_ef_sc_hd__decap_12
XTAP_TAPCELL_ROW_60_2_4116 VGND VPWR sky130_fd_sc_hd__tapvpwrvgnd_1
XFILLER_8_15 VPWR VGND VPWR VGND sky130_ef_sc_hd__decap_12
XPHY_EDGE_ROW_95_1_Right_751 VGND VGND VPWR VPWR sky130_fd_sc_hd__decap_3
XTAP_TAPCELL_ROW_190_2006 VGND VPWR sky130_fd_sc_hd__tapvpwrvgnd_1
XTAP_TAPCELL_ROW_190_2017 VGND VPWR sky130_fd_sc_hd__tapvpwrvgnd_1
XFILLER_141_1435 VGND VGND VPWR VPWR sky130_fd_sc_hd__decap_6
XTAP_TAPCELL_ROW_190_2028 VGND VPWR sky130_fd_sc_hd__tapvpwrvgnd_1
XFILLER_196_781 VPWR VGND VPWR VGND sky130_ef_sc_hd__decap_12
XTAP_TAPCELL_ROW_215_2702 VGND VPWR sky130_fd_sc_hd__tapvpwrvgnd_1
Xwire542 net48 VGND VGND VPWR VPWR net542 sky130_fd_sc_hd__clkbuf_1
XFILLER_6_121 VPWR VGND VPWR VGND sky130_ef_sc_hd__decap_12
Xwire553 net71 VGND VGND VPWR VPWR net553 sky130_fd_sc_hd__buf_1
XFILLER_141_1479 VPWR VGND VPWR VGND sky130_ef_sc_hd__decap_12
XFILLER_7_666 VGND VGND VPWR VPWR sky130_fd_sc_hd__fill_1
XFILLER_221_1481 VPWR VGND VPWR VGND sky130_ef_sc_hd__decap_12
Xwire575 dout0_q\[10\] VGND VGND VPWR VPWR net575 sky130_fd_sc_hd__clkbuf_1
XFILLER_171_615 VGND VGND VPWR VPWR sky130_fd_sc_hd__fill_1
XFILLER_176_1509 VGND VGND VPWR VPWR sky130_fd_sc_hd__decap_6
Xwire586 net587 VGND VGND VPWR VPWR net586 sky130_fd_sc_hd__clkbuf_1
XPHY_EDGE_ROW_164_1_Left_419 VGND VGND VPWR VPWR sky130_fd_sc_hd__decap_3
XFILLER_183_497 VGND VGND VPWR VPWR sky130_fd_sc_hd__decap_6
XFILLER_48_1203 VPWR VGND VPWR VGND sky130_ef_sc_hd__decap_12
XFILLER_100_1165 VPWR VGND VPWR VGND sky130_ef_sc_hd__decap_12
XFILLER_139_1331 VPWR VGND VPWR VGND sky130_ef_sc_hd__decap_12
XFILLER_48_1247 VPWR VGND VPWR VGND sky130_ef_sc_hd__decap_12
XFILLER_135_1217 VGND VGND VPWR VPWR sky130_fd_sc_hd__fill_1
XTAP_TAPCELL_ROW_209_2517 VGND VPWR sky130_fd_sc_hd__tapvpwrvgnd_1
XTAP_TAPCELL_ROW_209_2528 VGND VPWR sky130_fd_sc_hd__tapvpwrvgnd_1
XFILLER_239_933 VPWR VGND VPWR VGND sky130_ef_sc_hd__decap_12
XTAP_TAPCELL_ROW_209_2539 VGND VPWR sky130_fd_sc_hd__tapvpwrvgnd_1
XFILLER_214_15 VPWR VGND VPWR VGND sky130_ef_sc_hd__decap_12
XFILLER_238_421 VPWR VGND VPWR VGND sky130_ef_sc_hd__decap_12
XFILLER_239_977 VPWR VGND VPWR VGND sky130_ef_sc_hd__decap_12
XFILLER_254_925 VPWR VGND VPWR VGND sky130_ef_sc_hd__decap_12
XFILLER_4_1341 VPWR VGND VPWR VGND sky130_ef_sc_hd__decap_12
XFILLER_0_1205 VPWR VGND VPWR VGND sky130_ef_sc_hd__decap_12
XFILLER_168_1037 VPWR VGND VPWR VGND sky130_ef_sc_hd__decap_12
XFILLER_207_841 VPWR VGND VPWR VGND sky130_ef_sc_hd__decap_12
XFILLER_225_137 VPWR VGND VPWR VGND sky130_ef_sc_hd__decap_12
XFILLER_4_1385 VPWR VGND VPWR VGND sky130_ef_sc_hd__decap_12
XFILLER_59_1343 VPWR VGND VPWR VGND sky130_ef_sc_hd__decap_12
XFILLER_209_1001 VGND VGND VPWR VPWR sky130_fd_sc_hd__decap_6
XFILLER_248_1061 VPWR VGND VPWR VGND sky130_ef_sc_hd__decap_12
XFILLER_20_1177 VPWR VGND VPWR VGND sky130_ef_sc_hd__decap_12
XFILLER_222_811 VGND VGND VPWR VPWR sky130_fd_sc_hd__fill_1
XFILLER_94_1245 VGND VGND VPWR VPWR sky130_fd_sc_hd__fill_1
XFILLER_234_693 VGND VGND VPWR VPWR sky130_fd_sc_hd__decap_6
XFILLER_59_1387 VPWR VGND VPWR VGND sky130_ef_sc_hd__decap_12
XFILLER_209_1045 VPWR VGND VPWR VGND sky130_ef_sc_hd__decap_12
XFILLER_233_181 VPWR VGND VPWR VGND sky130_ef_sc_hd__decap_12
XFILLER_146_1357 VGND VGND VPWR VPWR sky130_fd_sc_hd__fill_1
XPHY_EDGE_ROW_31_2_Right_122 VGND VGND VPWR VPWR sky130_fd_sc_hd__decap_3
XFILLER_209_1089 VPWR VGND VPWR VGND sky130_ef_sc_hd__decap_12
XFILLER_175_921 VPWR VGND VPWR VGND sky130_ef_sc_hd__decap_12
XTAP_TAPCELL_ROW_177_1661 VGND VPWR sky130_fd_sc_hd__tapvpwrvgnd_1
XFILLER_193_217 VGND VGND VPWR VPWR sky130_fd_sc_hd__decap_6
XTAP_TAPCELL_ROW_177_1672 VGND VPWR sky130_fd_sc_hd__tapvpwrvgnd_1
XFILLER_175_965 VPWR VGND VPWR VGND sky130_ef_sc_hd__decap_12
XTAP_TAPCELL_ROW_173_1547 VGND VPWR sky130_fd_sc_hd__tapvpwrvgnd_1
XFILLER_179_1133 VPWR VGND VPWR VGND sky130_ef_sc_hd__decap_12
XTAP_TAPCELL_ROW_173_1558 VGND VPWR sky130_fd_sc_hd__tapvpwrvgnd_1
XTAP_TAPCELL_ROW_173_1569 VGND VPWR sky130_fd_sc_hd__tapvpwrvgnd_1
XTAP_TAPCELL_ROW_105_2_4383 VGND VPWR sky130_fd_sc_hd__tapvpwrvgnd_1
XFILLER_174_475 VGND VGND VPWR VPWR sky130_fd_sc_hd__fill_1
XFILLER_31_1273 VGND VGND VPWR VPWR sky130_fd_sc_hd__fill_1
XFILLER_179_1177 VPWR VGND VPWR VGND sky130_ef_sc_hd__decap_12
XFILLER_66_1303 VPWR VGND VPWR VGND sky130_ef_sc_hd__decap_12
XFILLER_108_27 VGND VGND VPWR VPWR sky130_fd_sc_hd__fill_1
XFILLER_255_1021 VPWR VGND VPWR VGND sky130_ef_sc_hd__decap_12
XFILLER_190_979 VGND VGND VPWR VPWR sky130_fd_sc_hd__fill_1
XTAP_TAPCELL_ROW_73_2_4194 VGND VPWR sky130_fd_sc_hd__tapvpwrvgnd_1
XFILLER_118_1415 VPWR VGND VPWR VGND sky130_ef_sc_hd__decap_12
XFILLER_216_1005 VPWR VGND VPWR VGND sky130_ef_sc_hd__decap_12
XFILLER_255_1065 VPWR VGND VPWR VGND sky130_ef_sc_hd__decap_12
XTAP_TAPCELL_ROW_186_1908 VGND VPWR sky130_fd_sc_hd__tapvpwrvgnd_1
XFILLER_170_681 VPWR VGND VPWR VGND sky130_ef_sc_hd__decap_12
XFILLER_157_1497 VGND VGND VPWR VPWR sky130_fd_sc_hd__fill_1
XTAP_TAPCELL_ROW_186_1919 VGND VPWR sky130_fd_sc_hd__tapvpwrvgnd_1
XFILLER_216_1049 VPWR VGND VPWR VGND sky130_ef_sc_hd__decap_12
XFILLER_124_15 VPWR VGND VPWR VGND sky130_ef_sc_hd__decap_12
XTAP_TAPCELL_ROW_53_2_4070 VGND VPWR sky130_fd_sc_hd__tapvpwrvgnd_1
XFILLER_9_1285 VGND VGND VPWR VPWR sky130_fd_sc_hd__decap_3
XFILLER_244_413 VGND VGND VPWR VPWR sky130_fd_sc_hd__decap_6
XFILLER_244_457 VPWR VGND VPWR VGND sky130_ef_sc_hd__decap_12
XFILLER_99_1189 VPWR VGND VPWR VGND sky130_ef_sc_hd__decap_12
XTAP_TAPCELL_ROW_0_831 VGND VPWR sky130_fd_sc_hd__tapvpwrvgnd_1
XFILLER_17_57 VPWR VGND VPWR VGND sky130_ef_sc_hd__decap_12
XTAP_TAPCELL_ROW_0_842 VGND VPWR sky130_fd_sc_hd__tapvpwrvgnd_1
XTAP_TAPCELL_ROW_0_853 VGND VPWR sky130_fd_sc_hd__tapvpwrvgnd_1
XFILLER_77_1443 VPWR VGND VPWR VGND sky130_ef_sc_hd__decap_12
XFILLER_129_1511 VGND VGND VPWR VPWR sky130_fd_sc_hd__decap_4
XFILLER_227_1101 VPWR VGND VPWR VGND sky130_ef_sc_hd__decap_12
XFILLER_225_671 VGND VGND VPWR VPWR sky130_fd_sc_hd__fill_1
XTAP_TAPCELL_ROW_0_864 VGND VPWR sky130_fd_sc_hd__tapvpwrvgnd_1
XTAP_TAPCELL_ROW_0_875 VGND VPWR sky130_fd_sc_hd__tapvpwrvgnd_1
XFILLER_164_1413 VGND VGND VPWR VPWR sky130_fd_sc_hd__fill_1
XFILLER_38_1427 VPWR VGND VPWR VGND sky130_ef_sc_hd__decap_12
XFILLER_213_833 VGND VGND VPWR VPWR sky130_fd_sc_hd__decap_6
XFILLER_212_321 VPWR VGND VPWR VGND sky130_ef_sc_hd__decap_12
XFILLER_227_1145 VPWR VGND VPWR VGND sky130_ef_sc_hd__decap_12
XFILLER_73_1329 VGND VGND VPWR VPWR sky130_fd_sc_hd__fill_1
XFILLER_169_225 VPWR VGND VPWR VGND sky130_ef_sc_hd__decap_12
XFILLER_213_877 VPWR VGND VPWR VGND sky130_ef_sc_hd__decap_12
XFILLER_223_1009 VPWR VGND VPWR VGND sky130_ef_sc_hd__decap_12
XTAP_TAPCELL_ROW_31_2_3940 VGND VPWR sky130_fd_sc_hd__tapvpwrvgnd_1
XTAP_TAPCELL_ROW_255_3761 VGND VPWR sky130_fd_sc_hd__tapvpwrvgnd_1
XFILLER_9_909 VPWR VGND VPWR VGND sky130_ef_sc_hd__decap_12
XFILLER_212_365 VPWR VGND VPWR VGND sky130_ef_sc_hd__decap_12
XFILLER_227_1189 VPWR VGND VPWR VGND sky130_ef_sc_hd__decap_12
XTAP_TAPCELL_ROW_255_3772 VGND VPWR sky130_fd_sc_hd__tapvpwrvgnd_1
XTAP_TAPCELL_ROW_255_3783 VGND VPWR sky130_fd_sc_hd__tapvpwrvgnd_1
XFILLER_185_729 VPWR VGND VPWR VGND sky130_ef_sc_hd__decap_12
XTAP_TAPCELL_ROW_255_3794 VGND VPWR sky130_fd_sc_hd__tapvpwrvgnd_1
XFILLER_8_419 VGND VGND VPWR VPWR sky130_fd_sc_hd__fill_1
XFILLER_178_781 VPWR VGND VPWR VGND sky130_ef_sc_hd__decap_12
XTAP_TAPCELL_ROW_251_3658 VGND VPWR sky130_fd_sc_hd__tapvpwrvgnd_1
XTAP_TAPCELL_ROW_251_3669 VGND VPWR sky130_fd_sc_hd__tapvpwrvgnd_1
XFILLER_123_1165 VPWR VGND VPWR VGND sky130_ef_sc_hd__decap_12
XFILLER_197_1233 VPWR VGND VPWR VGND sky130_ef_sc_hd__decap_12
XFILLER_14_1471 VPWR VGND VPWR VGND sky130_ef_sc_hd__decap_12
XFILLER_180_401 VPWR VGND VPWR VGND sky130_ef_sc_hd__decap_12
XFILLER_116_3 VPWR VGND VPWR VGND sky130_ef_sc_hd__decap_12
XFILLER_101_1441 VGND VGND VPWR VPWR sky130_fd_sc_hd__fill_1
XFILLER_3_113 VPWR VGND VPWR VGND sky130_ef_sc_hd__decap_12
XFILLER_158_1239 VGND VGND VPWR VPWR sky130_fd_sc_hd__decap_6
XFILLER_193_1119 VGND VGND VPWR VPWR sky130_fd_sc_hd__fill_1
XFILLER_180_445 VPWR VGND VPWR VGND sky130_ef_sc_hd__decap_12
XFILLER_238_1241 VPWR VGND VPWR VGND sky130_ef_sc_hd__decap_12
XFILLER_10_1357 VGND VGND VPWR VPWR sky130_fd_sc_hd__fill_1
XTAP_TAPCELL_ROW_140_1_1275 VGND VPWR sky130_fd_sc_hd__tapvpwrvgnd_1
XFILLER_234_1105 VPWR VGND VPWR VGND sky130_ef_sc_hd__decap_12
XFILLER_180_489 VPWR VGND VPWR VGND sky130_ef_sc_hd__decap_12
XFILLER_238_1285 VPWR VGND VPWR VGND sky130_ef_sc_hd__decap_12
XTAP_TAPCELL_ROW_249_3598 VGND VPWR sky130_fd_sc_hd__tapvpwrvgnd_1
XFILLER_84_1469 VGND VGND VPWR VPWR sky130_fd_sc_hd__fill_1
XFILLER_234_1149 VPWR VGND VPWR VGND sky130_ef_sc_hd__decap_12
XFILLER_58_53 VPWR VGND VPWR VGND sky130_ef_sc_hd__decap_12
XTAP_TAPCELL_ROW_162_2_4726 VGND VPWR sky130_fd_sc_hd__tapvpwrvgnd_1
XFILLER_0_897 VGND VGND VPWR VPWR sky130_fd_sc_hd__decap_8
XFILLER_134_1283 VPWR VGND VPWR VGND sky130_ef_sc_hd__decap_12
XFILLER_236_925 VPWR VGND VPWR VGND sky130_ef_sc_hd__decap_12
XFILLER_43_1177 VPWR VGND VPWR VGND sky130_ef_sc_hd__decap_12
XTAP_TAPCELL_ROW_204_2403 VGND VPWR sky130_fd_sc_hd__tapvpwrvgnd_1
XFILLER_247_273 VGND VGND VPWR VPWR sky130_fd_sc_hd__decap_6
XFILLER_169_1313 VPWR VGND VPWR VGND sky130_ef_sc_hd__decap_12
XFILLER_207_137 VPWR VGND VPWR VGND sky130_ef_sc_hd__decap_12
XFILLER_74_41 VPWR VGND VPWR VGND sky130_ef_sc_hd__decap_12
XFILLER_169_1357 VPWR VGND VPWR VGND sky130_ef_sc_hd__decap_12
XFILLER_245_1201 VPWR VGND VPWR VGND sky130_ef_sc_hd__decap_12
XFILLER_204_811 VGND VGND VPWR VPWR sky130_fd_sc_hd__fill_1
XFILLER_249_1381 VPWR VGND VPWR VGND sky130_ef_sc_hd__decap_12
XFILLER_21_1497 VGND VGND VPWR VPWR sky130_fd_sc_hd__fill_1
XFILLER_188_501 VPWR VGND VPWR VGND sky130_ef_sc_hd__decap_12
XFILLER_216_693 VGND VGND VPWR VPWR sky130_fd_sc_hd__decap_6
XFILLER_245_1245 VPWR VGND VPWR VGND sky130_ef_sc_hd__decap_12
XFILLER_215_181 VPWR VGND VPWR VGND sky130_ef_sc_hd__decap_12
XFILLER_231_641 VPWR VGND VPWR VGND sky130_ef_sc_hd__decap_12
XFILLER_188_545 VPWR VGND VPWR VGND sky130_ef_sc_hd__decap_12
XFILLER_206_1229 VPWR VGND VPWR VGND sky130_ef_sc_hd__decap_12
XFILLER_245_1289 VPWR VGND VPWR VGND sky130_ef_sc_hd__decap_12
XFILLER_231_685 VPWR VGND VPWR VGND sky130_ef_sc_hd__decap_12
XFILLER_188_589 VPWR VGND VPWR VGND sky130_ef_sc_hd__decap_12
XFILLER_15_1213 VGND VGND VPWR VPWR sky130_fd_sc_hd__decap_4
XFILLER_175_217 VGND VGND VPWR VPWR sky130_fd_sc_hd__decap_6
XFILLER_230_195 VGND VGND VPWR VPWR sky130_fd_sc_hd__fill_1
XPHY_EDGE_ROW_96_1_Right_752 VGND VGND VPWR VPWR sky130_fd_sc_hd__decap_3
XFILLER_54_1295 VGND VGND VPWR VPWR sky130_fd_sc_hd__decap_6
XFILLER_141_1243 VPWR VGND VPWR VGND sky130_ef_sc_hd__decap_12
XFILLER_209_15 VPWR VGND VPWR VGND sky130_ef_sc_hd__decap_12
XFILLER_102_1227 VPWR VGND VPWR VGND sky130_ef_sc_hd__decap_12
Xwire350 net351 VGND VGND VPWR VPWR net350 sky130_fd_sc_hd__clkbuf_1
XFILLER_190_209 VPWR VGND VPWR VGND sky130_ef_sc_hd__decap_12
Xwire361 net362 VGND VGND VPWR VPWR net361 sky130_fd_sc_hd__clkbuf_1
XFILLER_141_1287 VPWR VGND VPWR VGND sky130_ef_sc_hd__decap_12
Xwire372 net373 VGND VGND VPWR VPWR net372 sky130_fd_sc_hd__clkbuf_1
Xmax_cap105 net106 VGND VGND VPWR VPWR net105 sky130_fd_sc_hd__clkbuf_1
XFILLER_183_261 VPWR VGND VPWR VGND sky130_ef_sc_hd__decap_12
Xwire383 net384 VGND VGND VPWR VPWR net383 sky130_fd_sc_hd__clkbuf_1
XFILLER_176_1317 VPWR VGND VPWR VGND sky130_ef_sc_hd__decap_12
Xmax_cap116 _199_ VGND VGND VPWR VPWR net116 sky130_fd_sc_hd__clkbuf_1
Xwire394 net395 VGND VGND VPWR VPWR net394 sky130_fd_sc_hd__clkbuf_1
Xmax_cap127 _110_ VGND VGND VPWR VPWR net127 sky130_fd_sc_hd__clkbuf_1
Xmax_cap138 _108_ VGND VGND VPWR VPWR net138 sky130_fd_sc_hd__clkbuf_1
XFILLER_172_979 VGND VGND VPWR VPWR sky130_fd_sc_hd__fill_1
XFILLER_252_1205 VPWR VGND VPWR VGND sky130_ef_sc_hd__decap_12
XFILLER_217_1325 VPWR VGND VPWR VGND sky130_ef_sc_hd__decap_12
XFILLER_3_680 VGND VGND VPWR VPWR sky130_fd_sc_hd__fill_1
XFILLER_31_3 VPWR VGND VPWR VGND sky130_ef_sc_hd__decap_12
XFILLER_174_1085 VGND VGND VPWR VPWR sky130_fd_sc_hd__decap_6
XFILLER_217_1369 VPWR VGND VPWR VGND sky130_ef_sc_hd__decap_12
XFILLER_225_69 VPWR VGND VPWR VGND sky130_ef_sc_hd__decap_12
XFILLER_239_741 VPWR VGND VPWR VGND sky130_ef_sc_hd__decap_12
XFILLER_61_1255 VPWR VGND VPWR VGND sky130_ef_sc_hd__decap_12
XFILLER_113_1323 VGND VGND VPWR VPWR sky130_fd_sc_hd__decap_6
XFILLER_239_785 VPWR VGND VPWR VGND sky130_ef_sc_hd__decap_12
XFILLER_238_251 VGND VGND VPWR VPWR sky130_fd_sc_hd__fill_1
XFILLER_152_1383 VPWR VGND VPWR VGND sky130_ef_sc_hd__decap_12
XTAP_TAPCELL_ROW_166_1362 VGND VPWR sky130_fd_sc_hd__tapvpwrvgnd_1
XFILLER_22_1239 VGND VGND VPWR VPWR sky130_fd_sc_hd__decap_6
XTAP_TAPCELL_ROW_166_1373 VGND VPWR sky130_fd_sc_hd__tapvpwrvgnd_1
XFILLER_226_413 VGND VGND VPWR VPWR sky130_fd_sc_hd__decap_6
XFILLER_61_1299 VPWR VGND VPWR VGND sky130_ef_sc_hd__decap_12
XFILLER_113_1367 VPWR VGND VPWR VGND sky130_ef_sc_hd__decap_12
XFILLER_187_1413 VPWR VGND VPWR VGND sky130_ef_sc_hd__decap_12
XFILLER_254_755 VGND VGND VPWR VPWR sky130_fd_sc_hd__fill_1
XFILLER_241_57 VPWR VGND VPWR VGND sky130_ef_sc_hd__decap_12
XFILLER_187_1457 VPWR VGND VPWR VGND sky130_ef_sc_hd__decap_12
XFILLER_226_457 VPWR VGND VPWR VGND sky130_ef_sc_hd__decap_12
XFILLER_242_917 VGND VGND VPWR VPWR sky130_fd_sc_hd__decap_6
XFILLER_241_405 VPWR VGND VPWR VGND sky130_ef_sc_hd__decap_12
XFILLER_198_309 VPWR VGND VPWR VGND sky130_ef_sc_hd__decap_12
XFILLER_207_671 VGND VGND VPWR VPWR sky130_fd_sc_hd__fill_1
XFILLER_228_1421 VGND VGND VPWR VPWR sky130_fd_sc_hd__decap_6
XFILLER_241_449 VPWR VGND VPWR VGND sky130_ef_sc_hd__decap_12
XFILLER_181_1001 VGND VGND VPWR VPWR sky130_fd_sc_hd__decap_6
XTAP_TAPCELL_ROW_179_1712 VGND VPWR sky130_fd_sc_hd__tapvpwrvgnd_1
XTAP_TAPCELL_ROW_179_1723 VGND VPWR sky130_fd_sc_hd__tapvpwrvgnd_1
XFILLER_228_1465 VPWR VGND VPWR VGND sky130_ef_sc_hd__decap_12
XFILLER_250_961 VPWR VGND VPWR VGND sky130_ef_sc_hd__decap_12
XTAP_TAPCELL_ROW_16_2_3853 VGND VPWR sky130_fd_sc_hd__tapvpwrvgnd_1
XFILLER_146_1165 VPWR VGND VPWR VGND sky130_ef_sc_hd__decap_12
XFILLER_181_1045 VPWR VGND VPWR VGND sky130_ef_sc_hd__decap_12
XFILLER_224_1329 VPWR VGND VPWR VGND sky130_ef_sc_hd__decap_12
XPHY_EDGE_ROW_172_Left_427 VGND VGND VPWR VPWR sky130_fd_sc_hd__decap_3
XFILLER_210_825 VPWR VGND VPWR VGND sky130_ef_sc_hd__decap_12
XFILLER_167_729 VPWR VGND VPWR VGND sky130_ef_sc_hd__decap_12
XTAP_TAPCELL_ROW_175_1609 VGND VPWR sky130_fd_sc_hd__tapvpwrvgnd_1
XFILLER_72_1351 VGND VGND VPWR VPWR sky130_fd_sc_hd__decap_6
XPHY_EDGE_ROW_32_2_Right_123 VGND VGND VPWR VPWR sky130_fd_sc_hd__decap_3
XFILLER_181_1089 VPWR VGND VPWR VGND sky130_ef_sc_hd__decap_12
XFILLER_210_869 VPWR VGND VPWR VGND sky130_ef_sc_hd__decap_12
XFILLER_72_1395 VPWR VGND VPWR VGND sky130_ef_sc_hd__decap_12
XFILLER_124_1463 VGND VGND VPWR VPWR sky130_fd_sc_hd__decap_6
XFILLER_119_15 VPWR VGND VPWR VGND sky130_ef_sc_hd__decap_12
XFILLER_33_1379 VGND VGND VPWR VPWR sky130_fd_sc_hd__decap_6
XFILLER_120_1327 VPWR VGND VPWR VGND sky130_ef_sc_hd__decap_12
XFILLER_200_1373 VPWR VGND VPWR VGND sky130_ef_sc_hd__decap_12
XFILLER_235_1425 VPWR VGND VPWR VGND sky130_ef_sc_hd__decap_12
XFILLER_1_617 VGND VGND VPWR VPWR sky130_fd_sc_hd__fill_1
XFILLER_192_1141 VGND VGND VPWR VPWR sky130_fd_sc_hd__decap_6
XFILLER_249_505 VPWR VGND VPWR VGND sky130_ef_sc_hd__decap_12
XPHY_EDGE_ROW_181_Left_436 VGND VGND VPWR VPWR sky130_fd_sc_hd__decap_3
XFILLER_66_1177 VPWR VGND VPWR VGND sky130_ef_sc_hd__decap_12
XFILLER_118_1245 VGND VGND VPWR VPWR sky130_fd_sc_hd__fill_1
XFILLER_235_1469 VPWR VGND VPWR VGND sky130_ef_sc_hd__decap_12
XFILLER_192_1185 VPWR VGND VPWR VGND sky130_ef_sc_hd__decap_12
XFILLER_135_69 VGND VGND VPWR VPWR sky130_fd_sc_hd__fill_2
XTAP_TAPCELL_ROW_147_2_4639 VGND VPWR sky130_fd_sc_hd__tapvpwrvgnd_1
XFILLER_83_1491 VGND VGND VPWR VPWR sky130_fd_sc_hd__decap_6
XTAP_TAPCELL_ROW_244_3462 VGND VPWR sky130_fd_sc_hd__tapvpwrvgnd_1
XTAP_TAPCELL_ROW_244_3473 VGND VPWR sky130_fd_sc_hd__tapvpwrvgnd_1
XFILLER_131_1423 VPWR VGND VPWR VGND sky130_ef_sc_hd__decap_12
XTAP_TAPCELL_ROW_244_3484 VGND VPWR sky130_fd_sc_hd__tapvpwrvgnd_1
XFILLER_9_1093 VPWR VGND VPWR VGND sky130_ef_sc_hd__decap_12
XFILLER_28_45 VGND VGND VPWR VPWR sky130_fd_sc_hd__fill_1
XFILLER_170_1483 VGND VGND VPWR VPWR sky130_fd_sc_hd__fill_1
XFILLER_218_925 VPWR VGND VPWR VGND sky130_ef_sc_hd__decap_12
XTAP_TAPCELL_ROW_5_989 VGND VPWR sky130_fd_sc_hd__tapvpwrvgnd_1
XFILLER_229_273 VGND VGND VPWR VPWR sky130_fd_sc_hd__decap_6
XFILLER_40_1339 VPWR VGND VPWR VGND sky130_ef_sc_hd__decap_12
XTAP_TAPCELL_ROW_240_3359 VGND VPWR sky130_fd_sc_hd__tapvpwrvgnd_1
XFILLER_131_1467 VPWR VGND VPWR VGND sky130_ef_sc_hd__decap_12
XFILLER_244_221 VPWR VGND VPWR VGND sky130_ef_sc_hd__decap_12
XTAP_TAPCELL_ROW_127_2_4515 VGND VPWR sky130_fd_sc_hd__tapvpwrvgnd_1
XFILLER_151_57 VPWR VGND VPWR VGND sky130_ef_sc_hd__decap_12
XFILLER_245_777 VGND VGND VPWR VPWR sky130_fd_sc_hd__decap_6
XFILLER_244_265 VPWR VGND VPWR VGND sky130_ef_sc_hd__decap_12
X_490_ net173 net493 net102 VGND VGND VPWR VPWR _251_ sky130_fd_sc_hd__and3_1
XTAP_TAPCELL_ROW_95_2_4326 VGND VPWR sky130_fd_sc_hd__tapvpwrvgnd_1
XFILLER_77_1273 VGND VGND VPWR VPWR sky130_fd_sc_hd__fill_1
XFILLER_207_1505 VGND VGND VPWR VPWR sky130_fd_sc_hd__decap_6
XPHY_EDGE_ROW_190_Left_445 VGND VGND VPWR VPWR sky130_fd_sc_hd__decap_3
XFILLER_213_641 VPWR VGND VPWR VGND sky130_ef_sc_hd__decap_12
XTAP_TAPCELL_ROW_253_3709 VGND VPWR sky130_fd_sc_hd__tapvpwrvgnd_1
XFILLER_44_66 VGND VGND VPWR VPWR sky130_fd_sc_hd__fill_2
XTAP_TAPCELL_ROW_19_1_1154 VGND VPWR sky130_fd_sc_hd__tapvpwrvgnd_1
XFILLER_242_1429 VPWR VGND VPWR VGND sky130_ef_sc_hd__decap_12
XFILLER_129_1385 VGND VGND VPWR VPWR sky130_fd_sc_hd__fill_1
XFILLER_213_685 VPWR VGND VPWR VGND sky130_ef_sc_hd__decap_12
XTAP_TAPCELL_ROW_238_3299 VGND VPWR sky130_fd_sc_hd__tapvpwrvgnd_1
XFILLER_90_1451 VPWR VGND VPWR VGND sky130_ef_sc_hd__decap_12
XFILLER_233_3 VPWR VGND VPWR VGND sky130_ef_sc_hd__decap_12
XTAP_TAPCELL_ROW_75_2_4202 VGND VPWR sky130_fd_sc_hd__tapvpwrvgnd_1
XFILLER_212_195 VGND VGND VPWR VPWR sky130_fd_sc_hd__fill_1
XFILLER_51_1435 VGND VGND VPWR VPWR sky130_fd_sc_hd__decap_6
XFILLER_200_357 VGND VGND VPWR VPWR sky130_fd_sc_hd__decap_6
XFILLER_90_1495 VPWR VGND VPWR VGND sky130_ef_sc_hd__decap_12
XFILLER_185_559 VGND VGND VPWR VPWR sky130_fd_sc_hd__fill_1
XFILLER_60_65 VGND VGND VPWR VPWR sky130_fd_sc_hd__decap_6
XFILLER_51_1479 VPWR VGND VPWR VGND sky130_ef_sc_hd__decap_12
XFILLER_172_209 VPWR VGND VPWR VGND sky130_ef_sc_hd__decap_12
XFILLER_240_1197 VGND VGND VPWR VPWR sky130_fd_sc_hd__decap_6
XFILLER_176_65 VPWR VGND VPWR VGND sky130_ef_sc_hd__decap_12
XFILLER_181_721 VGND VGND VPWR VPWR sky130_fd_sc_hd__decap_6
XFILLER_197_1063 VGND VGND VPWR VPWR sky130_fd_sc_hd__fill_1
XFILLER_5_945 VGND VGND VPWR VPWR sky130_fd_sc_hd__decap_6
XFILLER_181_765 VPWR VGND VPWR VGND sky130_ef_sc_hd__decap_12
XFILLER_49_1331 VPWR VGND VPWR VGND sky130_ef_sc_hd__decap_12
XFILLER_180_253 VPWR VGND VPWR VGND sky130_ef_sc_hd__decap_12
XFILLER_10_1165 VPWR VGND VPWR VGND sky130_ef_sc_hd__decap_12
XFILLER_5_989 VPWR VGND VPWR VGND sky130_ef_sc_hd__decap_12
XFILLER_136_1301 VGND VGND VPWR VPWR sky130_fd_sc_hd__fill_1
XFILLER_238_1093 VPWR VGND VPWR VGND sky130_ef_sc_hd__decap_12
XFILLER_171_1225 VGND VGND VPWR VPWR sky130_fd_sc_hd__decap_6
XFILLER_192_53 VPWR VGND VPWR VGND sky130_ef_sc_hd__decap_12
XFILLER_214_1509 VGND VGND VPWR VPWR sky130_fd_sc_hd__decap_6
XFILLER_171_1269 VPWR VGND VPWR VGND sky130_ef_sc_hd__decap_12
XFILLER_192_97 VPWR VGND VPWR VGND sky130_ef_sc_hd__decap_12
XPHY_EDGE_ROW_31_2_Left_533 VGND VGND VPWR VPWR sky130_fd_sc_hd__decap_3
XTAP_TAPCELL_ROW_22_2_3885 VGND VPWR sky130_fd_sc_hd__tapvpwrvgnd_1
XFILLER_85_51 VGND VGND VPWR VPWR sky130_fd_sc_hd__decap_4
XFILLER_208_413 VGND VGND VPWR VPWR sky130_fd_sc_hd__decap_6
XFILLER_110_1507 VGND VGND VPWR VPWR sky130_fd_sc_hd__decap_8
XFILLER_236_755 VGND VGND VPWR VPWR sky130_fd_sc_hd__fill_1
XFILLER_169_1121 VPWR VGND VPWR VGND sky130_ef_sc_hd__decap_12
XFILLER_208_457 VPWR VGND VPWR VGND sky130_ef_sc_hd__decap_12
XFILLER_224_917 VGND VGND VPWR VPWR sky130_fd_sc_hd__decap_6
XFILLER_223_405 VPWR VGND VPWR VGND sky130_ef_sc_hd__decap_12
XFILLER_211_27 VPWR VGND VPWR VGND sky130_ef_sc_hd__decap_12
XFILLER_189_821 VPWR VGND VPWR VGND sky130_ef_sc_hd__decap_12
XFILLER_223_449 VPWR VGND VPWR VGND sky130_ef_sc_hd__decap_12
XFILLER_147_1441 VGND VGND VPWR VPWR sky130_fd_sc_hd__fill_1
XFILLER_1_1399 VGND VGND VPWR VPWR sky130_fd_sc_hd__fill_1
XFILLER_232_961 VPWR VGND VPWR VGND sky130_ef_sc_hd__decap_12
XFILLER_189_865 VPWR VGND VPWR VGND sky130_ef_sc_hd__decap_12
XFILLER_56_1357 VGND VGND VPWR VPWR sky130_fd_sc_hd__fill_1
XFILLER_182_1365 VGND VGND VPWR VPWR sky130_fd_sc_hd__decap_6
XFILLER_206_1037 VPWR VGND VPWR VGND sky130_ef_sc_hd__decap_12
XFILLER_108_1469 VGND VGND VPWR VPWR sky130_fd_sc_hd__fill_1
XPHY_EDGE_ROW_108_1_Left_363 VGND VGND VPWR VPWR sky130_fd_sc_hd__decap_3
XFILLER_79_3 VPWR VGND VPWR VGND sky130_ef_sc_hd__decap_12
XPHY_EDGE_ROW_97_1_Right_753 VGND VGND VPWR VPWR sky130_fd_sc_hd__decap_3
XFILLER_191_529 VPWR VGND VPWR VGND sky130_ef_sc_hd__decap_12
XFILLER_184_581 VGND VGND VPWR VPWR sky130_fd_sc_hd__decap_6
XPHY_EDGE_ROW_45_1_Left_300 VGND VGND VPWR VPWR sky130_fd_sc_hd__decap_3
XFILLER_89_1177 VPWR VGND VPWR VGND sky130_ef_sc_hd__decap_12
XFILLER_176_1147 VGND VGND VPWR VPWR sky130_fd_sc_hd__fill_1
XFILLER_28_1415 VPWR VGND VPWR VGND sky130_ef_sc_hd__decap_12
XFILLER_217_1133 VPWR VGND VPWR VGND sky130_ef_sc_hd__decap_12
XTAP_TAPCELL_ROW_88_2_4280 VGND VPWR sky130_fd_sc_hd__tapvpwrvgnd_1
XFILLER_252_1035 VGND VGND VPWR VPWR sky130_fd_sc_hd__fill_1
XFILLER_8_1509 VGND VGND VPWR VPWR sky130_fd_sc_hd__decap_6
XFILLER_67_1497 VGND VGND VPWR VPWR sky130_fd_sc_hd__fill_1
XTAP_TAPCELL_ROW_168_1413 VGND VPWR sky130_fd_sc_hd__tapvpwrvgnd_1
XTAP_TAPCELL_ROW_168_1424 VGND VPWR sky130_fd_sc_hd__tapvpwrvgnd_1
XFILLER_217_1177 VPWR VGND VPWR VGND sky130_ef_sc_hd__decap_12
XFILLER_105_39 VPWR VGND VPWR VGND sky130_ef_sc_hd__decap_12
XTAP_TAPCELL_ROW_2_904 VGND VPWR sky130_fd_sc_hd__tapvpwrvgnd_1
XPHY_EDGE_ROW_88_2_Left_590 VGND VGND VPWR VPWR sky130_fd_sc_hd__decap_3
XTAP_TAPCELL_ROW_2_915 VGND VPWR sky130_fd_sc_hd__tapvpwrvgnd_1
XTAP_TAPCELL_ROW_113_2_4434 VGND VPWR sky130_fd_sc_hd__tapvpwrvgnd_1
XTAP_TAPCELL_ROW_2_926 VGND VPWR sky130_fd_sc_hd__tapvpwrvgnd_1
XFILLER_152_1191 VPWR VGND VPWR VGND sky130_ef_sc_hd__decap_12
XFILLER_226_221 VPWR VGND VPWR VGND sky130_ef_sc_hd__decap_12
XFILLER_227_777 VGND VGND VPWR VPWR sky130_fd_sc_hd__decap_6
XFILLER_226_265 VPWR VGND VPWR VGND sky130_ef_sc_hd__decap_12
XFILLER_242_725 VPWR VGND VPWR VGND sky130_ef_sc_hd__decap_12
XFILLER_121_27 VPWR VGND VPWR VGND sky130_ef_sc_hd__decap_12
XFILLER_148_1227 VPWR VGND VPWR VGND sky130_ef_sc_hd__decap_12
XFILLER_199_629 VPWR VGND VPWR VGND sky130_ef_sc_hd__decap_12
XFILLER_39_1511 VGND VGND VPWR VPWR sky130_fd_sc_hd__decap_4
XFILLER_187_1287 VGND VGND VPWR VPWR sky130_fd_sc_hd__fill_1
XFILLER_242_769 VPWR VGND VPWR VGND sky130_ef_sc_hd__decap_12
XFILLER_74_1413 VGND VGND VPWR VPWR sky130_fd_sc_hd__fill_1
XFILLER_198_139 VGND VGND VPWR VPWR sky130_fd_sc_hd__fill_1
XFILLER_228_1273 VPWR VGND VPWR VGND sky130_ef_sc_hd__decap_12
XFILLER_241_279 VGND VGND VPWR VPWR sky130_fd_sc_hd__fill_1
XTAP_TAPCELL_ROW_61_2_4121 VGND VPWR sky130_fd_sc_hd__tapvpwrvgnd_1
XFILLER_194_301 VGND VGND VPWR VPWR sky130_fd_sc_hd__decap_6
XFILLER_201_93 VPWR VGND VPWR VGND sky130_ef_sc_hd__decap_12
XFILLER_167_559 VGND VGND VPWR VPWR sky130_fd_sc_hd__fill_1
XFILLER_194_345 VPWR VGND VPWR VGND sky130_ef_sc_hd__decap_12
XPHY_EDGE_ROW_33_2_Right_124 VGND VGND VPWR VPWR sky130_fd_sc_hd__decap_3
XTAP_TAPCELL_ROW_233_3163 VGND VPWR sky130_fd_sc_hd__tapvpwrvgnd_1
XFILLER_124_1271 VPWR VGND VPWR VGND sky130_ef_sc_hd__decap_12
XFILLER_210_699 VGND VGND VPWR VPWR sky130_fd_sc_hd__fill_1
XTAP_TAPCELL_ROW_233_3174 VGND VPWR sky130_fd_sc_hd__tapvpwrvgnd_1
XFILLER_33_1165 VPWR VGND VPWR VGND sky130_ef_sc_hd__decap_12
XTAP_TAPCELL_ROW_233_3185 VGND VPWR sky130_fd_sc_hd__tapvpwrvgnd_1
XFILLER_194_389 VPWR VGND VPWR VGND sky130_ef_sc_hd__decap_12
XFILLER_159_1323 VGND VGND VPWR VPWR sky130_fd_sc_hd__decap_6
XFILLER_194_1203 VGND VGND VPWR VPWR sky130_fd_sc_hd__fill_1
XFILLER_11_1441 VGND VGND VPWR VPWR sky130_fd_sc_hd__fill_1
XFILLER_68_1239 VGND VGND VPWR VPWR sky130_fd_sc_hd__decap_6
XFILLER_159_1367 VPWR VGND VPWR VGND sky130_ef_sc_hd__decap_12
XFILLER_2_937 VPWR VGND VPWR VGND sky130_ef_sc_hd__decap_12
XTAP_TAPCELL_ROW_246_3524 VGND VPWR sky130_fd_sc_hd__tapvpwrvgnd_1
XTAP_TAPCELL_ROW_246_3535 VGND VPWR sky130_fd_sc_hd__tapvpwrvgnd_1
XFILLER_235_1233 VPWR VGND VPWR VGND sky130_ef_sc_hd__decap_12
XFILLER_249_335 VGND VGND VPWR VPWR sky130_fd_sc_hd__fill_1
XFILLER_231_1119 VGND VGND VPWR VPWR sky130_fd_sc_hd__fill_1
XFILLER_39_55 VGND VGND VPWR VPWR sky130_fd_sc_hd__fill_1
XFILLER_44_1283 VPWR VGND VPWR VGND sky130_ef_sc_hd__decap_12
XFILLER_131_1231 VPWR VGND VPWR VGND sky130_ef_sc_hd__decap_12
XTAP_TAPCELL_ROW_135_1_1270 VGND VPWR sky130_fd_sc_hd__tapvpwrvgnd_1
XTAP_TAPCELL_ROW_8_1069 VGND VPWR sky130_fd_sc_hd__tapvpwrvgnd_1
XFILLER_183_3 VPWR VGND VPWR VGND sky130_ef_sc_hd__decap_12
XFILLER_188_1029 VGND VGND VPWR VPWR sky130_fd_sc_hd__decap_6
X_611_ clknet_3_6__leaf_clk dout0\[9\] _019_ VGND VGND VPWR VPWR dout0_q\[9\] sky130_fd_sc_hd__dfrtp_1
XFILLER_245_541 VPWR VGND VPWR VGND sky130_ef_sc_hd__decap_12
XFILLER_218_755 VGND VGND VPWR VPWR sky130_fd_sc_hd__fill_1
XFILLER_131_1275 VPWR VGND VPWR VGND sky130_ef_sc_hd__decap_12
XFILLER_206_917 VGND VGND VPWR VPWR sky130_fd_sc_hd__decap_6
XFILLER_205_405 VPWR VGND VPWR VGND sky130_ef_sc_hd__decap_12
XFILLER_245_585 VPWR VGND VPWR VGND sky130_ef_sc_hd__decap_12
X_542_ net667 VGND VGND VPWR VPWR _024_ sky130_fd_sc_hd__inv_2
XFILLER_79_1379 VGND VGND VPWR VPWR sky130_fd_sc_hd__decap_6
XFILLER_205_449 VPWR VGND VPWR VGND sky130_ef_sc_hd__decap_12
XFILLER_221_909 VPWR VGND VPWR VGND sky130_ef_sc_hd__decap_12
X_473_ net160 _243_ VGND VGND VPWR VPWR acc_core.adder.cla_blocks\[2\].block.sum\[3\]
+ sky130_fd_sc_hd__xor2_1
XFILLER_214_961 VPWR VGND VPWR VGND sky130_ef_sc_hd__decap_12
XFILLER_207_1313 VPWR VGND VPWR VGND sky130_ef_sc_hd__decap_12
XFILLER_246_1373 VPWR VGND VPWR VGND sky130_ef_sc_hd__decap_12
XFILLER_220_419 VGND VGND VPWR VPWR sky130_fd_sc_hd__fill_1
XFILLER_186_813 VPWR VGND VPWR VGND sky130_ef_sc_hd__decap_12
XFILLER_9_503 VGND VGND VPWR VPWR sky130_fd_sc_hd__fill_1
XFILLER_197_161 VGND VGND VPWR VPWR sky130_fd_sc_hd__decap_6
XFILLER_207_1357 VPWR VGND VPWR VGND sky130_ef_sc_hd__decap_12
XFILLER_242_1259 VGND VGND VPWR VPWR sky130_fd_sc_hd__fill_1
XFILLER_200_121 VPWR VGND VPWR VGND sky130_ef_sc_hd__decap_12
XFILLER_51_1243 VPWR VGND VPWR VGND sky130_ef_sc_hd__decap_12
XFILLER_103_1311 VPWR VGND VPWR VGND sky130_ef_sc_hd__decap_12
XFILLER_200_165 VPWR VGND VPWR VGND sky130_ef_sc_hd__decap_12
XFILLER_142_1371 VPWR VGND VPWR VGND sky130_ef_sc_hd__decap_12
XFILLER_107_1491 VGND VGND VPWR VPWR sky130_fd_sc_hd__decap_6
XFILLER_173_529 VPWR VGND VPWR VGND sky130_ef_sc_hd__decap_12
XFILLER_199_1169 VGND VGND VPWR VPWR sky130_fd_sc_hd__decap_6
XFILLER_12_1227 VPWR VGND VPWR VGND sky130_ef_sc_hd__decap_12
XFILLER_177_1401 VPWR VGND VPWR VGND sky130_ef_sc_hd__decap_12
XFILLER_51_1287 VPWR VGND VPWR VGND sky130_ef_sc_hd__decap_12
XFILLER_103_1355 VPWR VGND VPWR VGND sky130_ef_sc_hd__decap_12
XFILLER_166_581 VGND VGND VPWR VPWR sky130_fd_sc_hd__decap_6
XFILLER_5_742 VPWR VGND VPWR VGND sky130_ef_sc_hd__decap_12
XFILLER_86_1339 VPWR VGND VPWR VGND sky130_ef_sc_hd__decap_12
XFILLER_103_1399 VPWR VGND VPWR VGND sky130_ef_sc_hd__decap_12
XFILLER_138_1407 VGND VGND VPWR VPWR sky130_fd_sc_hd__decap_6
XFILLER_181_573 VPWR VGND VPWR VGND sky130_ef_sc_hd__decap_12
XFILLER_218_1453 VPWR VGND VPWR VGND sky130_ef_sc_hd__decap_12
XFILLER_206_27 VGND VGND VPWR VPWR sky130_fd_sc_hd__fill_1
XFILLER_214_1317 VPWR VGND VPWR VGND sky130_ef_sc_hd__decap_12
XFILLER_171_1033 VPWR VGND VPWR VGND sky130_ef_sc_hd__decap_12
XFILLER_218_1497 VPWR VGND VPWR VGND sky130_ef_sc_hd__decap_12
XFILLER_253_1399 VGND VGND VPWR VPWR sky130_fd_sc_hd__fill_1
XFILLER_255_305 VGND VGND VPWR VPWR sky130_fd_sc_hd__decap_3
XFILLER_171_1077 VPWR VGND VPWR VGND sky130_ef_sc_hd__decap_12
XFILLER_23_1323 VGND VGND VPWR VPWR sky130_fd_sc_hd__decap_6
XFILLER_62_1383 VPWR VGND VPWR VGND sky130_ef_sc_hd__decap_12
XFILLER_114_1451 VPWR VGND VPWR VGND sky130_ef_sc_hd__decap_12
XFILLER_222_15 VPWR VGND VPWR VGND sky130_ef_sc_hd__decap_12
XFILLER_255_349 VPWR VGND VPWR VGND sky130_ef_sc_hd__decap_12
XFILLER_208_221 VPWR VGND VPWR VGND sky130_ef_sc_hd__decap_12
XFILLER_23_1367 VPWR VGND VPWR VGND sky130_ef_sc_hd__decap_12
XFILLER_110_1315 VPWR VGND VPWR VGND sky130_ef_sc_hd__decap_12
XFILLER_97_1435 VGND VGND VPWR VPWR sky130_fd_sc_hd__decap_6
XFILLER_114_1495 VPWR VGND VPWR VGND sky130_ef_sc_hd__decap_12
XFILLER_209_777 VGND VGND VPWR VPWR sky130_fd_sc_hd__decap_6
XFILLER_212_1085 VGND VGND VPWR VPWR sky130_fd_sc_hd__decap_6
XFILLER_208_265 VPWR VGND VPWR VGND sky130_ef_sc_hd__decap_12
XFILLER_224_725 VPWR VGND VPWR VGND sky130_ef_sc_hd__decap_12
XFILLER_110_1359 VPWR VGND VPWR VGND sky130_ef_sc_hd__decap_12
XFILLER_97_1479 VPWR VGND VPWR VGND sky130_ef_sc_hd__decap_12
XFILLER_184_1427 VGND VGND VPWR VPWR sky130_fd_sc_hd__fill_1
XFILLER_224_769 VPWR VGND VPWR VGND sky130_ef_sc_hd__decap_12
XFILLER_225_1413 VPWR VGND VPWR VGND sky130_ef_sc_hd__decap_12
XFILLER_223_279 VGND VGND VPWR VPWR sky130_fd_sc_hd__fill_1
XFILLER_189_673 VPWR VGND VPWR VGND sky130_ef_sc_hd__decap_12
XFILLER_56_1165 VPWR VGND VPWR VGND sky130_ef_sc_hd__decap_12
XFILLER_176_301 VGND VGND VPWR VPWR sky130_fd_sc_hd__decap_6
XFILLER_182_1173 VPWR VGND VPWR VGND sky130_ef_sc_hd__decap_12
XFILLER_225_1457 VPWR VGND VPWR VGND sky130_ef_sc_hd__decap_12
XPHY_EDGE_ROW_160_2_Right_251 VGND VGND VPWR VPWR sky130_fd_sc_hd__decap_3
XFILLER_176_345 VPWR VGND VPWR VGND sky130_ef_sc_hd__decap_12
XFILLER_192_805 VGND VGND VPWR VPWR sky130_fd_sc_hd__decap_6
XFILLER_34_1463 VGND VGND VPWR VPWR sky130_fd_sc_hd__decap_6
XFILLER_121_1411 VPWR VGND VPWR VGND sky130_ef_sc_hd__decap_12
XFILLER_160_1471 VPWR VGND VPWR VGND sky130_ef_sc_hd__decap_12
XFILLER_176_389 VPWR VGND VPWR VGND sky130_ef_sc_hd__decap_12
XFILLER_30_1327 VPWR VGND VPWR VGND sky130_ef_sc_hd__decap_12
XFILLER_192_849 VPWR VGND VPWR VGND sky130_ef_sc_hd__decap_12
XFILLER_121_1455 VPWR VGND VPWR VGND sky130_ef_sc_hd__decap_12
XFILLER_191_337 VPWR VGND VPWR VGND sky130_ef_sc_hd__decap_12
XPHY_EDGE_ROW_98_1_Right_754 VGND VGND VPWR VPWR sky130_fd_sc_hd__decap_3
XFILLER_121_1499 VPWR VGND VPWR VGND sky130_ef_sc_hd__decap_12
XFILLER_156_1507 VGND VGND VPWR VPWR sky130_fd_sc_hd__decap_8
XFILLER_116_27 VGND VGND VPWR VPWR sky130_fd_sc_hd__fill_1
XFILLER_28_1245 VGND VGND VPWR VPWR sky130_fd_sc_hd__fill_1
XFILLER_8_1317 VPWR VGND VPWR VGND sky130_ef_sc_hd__decap_12
XTAP_TAPCELL_ROW_163_2_4731 VGND VPWR sky130_fd_sc_hd__tapvpwrvgnd_1
XFILLER_247_839 VGND VGND VPWR VPWR sky130_fd_sc_hd__fill_1
XFILLER_41_1423 VPWR VGND VPWR VGND sky130_ef_sc_hd__decap_12
XFILLER_80_1483 VPWR VGND VPWR VGND sky130_ef_sc_hd__decap_12
XFILLER_230_1141 VGND VGND VPWR VPWR sky130_fd_sc_hd__decap_6
XFILLER_132_15 VPWR VGND VPWR VGND sky130_ef_sc_hd__decap_12
XFILLER_41_1467 VPWR VGND VPWR VGND sky130_ef_sc_hd__decap_12
XFILLER_227_541 VPWR VGND VPWR VGND sky130_ef_sc_hd__decap_12
XFILLER_6_1085 VGND VGND VPWR VPWR sky130_fd_sc_hd__decap_6
XFILLER_230_1185 VPWR VGND VPWR VGND sky130_ef_sc_hd__decap_12
XFILLER_227_585 VPWR VGND VPWR VGND sky130_ef_sc_hd__decap_12
XFILLER_242_533 VPWR VGND VPWR VGND sky130_ef_sc_hd__decap_12
XFILLER_203_909 VPWR VGND VPWR VGND sky130_ef_sc_hd__decap_12
XTAP_TAPCELL_ROW_239_3350 VGND VPWR sky130_fd_sc_hd__tapvpwrvgnd_1
XFILLER_243_1513 VGND VGND VPWR VPWR sky130_fd_sc_hd__fill_2
XFILLER_202_419 VGND VGND VPWR VPWR sky130_fd_sc_hd__fill_1
XFILLER_168_813 VPWR VGND VPWR VGND sky130_ef_sc_hd__decap_12
XFILLER_186_109 VPWR VGND VPWR VGND sky130_ef_sc_hd__decap_12
XTAP_TAPCELL_ROW_235_3225 VGND VPWR sky130_fd_sc_hd__tapvpwrvgnd_1
XFILLER_161_1213 VGND VGND VPWR VPWR sky130_fd_sc_hd__decap_4
XFILLER_39_1385 VGND VGND VPWR VPWR sky130_fd_sc_hd__fill_1
XFILLER_179_161 VGND VGND VPWR VPWR sky130_fd_sc_hd__decap_6
XTAP_TAPCELL_ROW_235_3236 VGND VPWR sky130_fd_sc_hd__tapvpwrvgnd_1
XFILLER_211_953 VPWR VGND VPWR VGND sky130_ef_sc_hd__decap_12
XFILLER_195_665 VGND VGND VPWR VPWR sky130_fd_sc_hd__decap_6
XFILLER_194_153 VPWR VGND VPWR VGND sky130_ef_sc_hd__decap_12
XFILLER_241_1281 VGND VGND VPWR VPWR sky130_fd_sc_hd__decap_6
XFILLER_196_1309 VGND VGND VPWR VPWR sky130_fd_sc_hd__decap_6
XPHY_EDGE_ROW_34_2_Right_125 VGND VGND VPWR VPWR sky130_fd_sc_hd__decap_3
XFILLER_194_197 VPWR VGND VPWR VGND sky130_ef_sc_hd__decap_12
XTAP_TAPCELL_ROW_104_2_4379 VGND VPWR sky130_fd_sc_hd__tapvpwrvgnd_1
XFILLER_46_1301 VGND VGND VPWR VPWR sky130_fd_sc_hd__fill_1
XFILLER_9_3 VGND VGND VPWR VPWR sky130_fd_sc_hd__fill_2
XTAP_TAPCELL_ROW_211_2590 VGND VPWR sky130_fd_sc_hd__tapvpwrvgnd_1
XFILLER_173_55 VGND VGND VPWR VPWR sky130_fd_sc_hd__fill_1
XFILLER_235_1063 VGND VGND VPWR VPWR sky130_fd_sc_hd__fill_1
XFILLER_1_255 VPWR VGND VPWR VGND sky130_ef_sc_hd__decap_12
XFILLER_172_1353 VPWR VGND VPWR VGND sky130_ef_sc_hd__decap_12
XFILLER_237_305 VPWR VGND VPWR VGND sky130_ef_sc_hd__decap_12
XFILLER_172_1397 VPWR VGND VPWR VGND sky130_ef_sc_hd__decap_12
XFILLER_237_349 VPWR VGND VPWR VGND sky130_ef_sc_hd__decap_12
XTAP_TAPCELL_ROW_52_2_4066 VGND VPWR sky130_fd_sc_hd__tapvpwrvgnd_1
XFILLER_253_809 VPWR VGND VPWR VGND sky130_ef_sc_hd__decap_12
XFILLER_66_53 VPWR VGND VPWR VGND sky130_ef_sc_hd__decap_12
XFILLER_20_1507 VGND VGND VPWR VPWR sky130_fd_sc_hd__decap_8
XTAP_TAPCELL_ROW_224_2940 VGND VPWR sky130_fd_sc_hd__tapvpwrvgnd_1
XFILLER_246_861 VGND VGND VPWR VPWR sky130_fd_sc_hd__decap_6
XFILLER_206_725 VPWR VGND VPWR VGND sky130_ef_sc_hd__decap_12
XTAP_TAPCELL_ROW_220_2815 VGND VPWR sky130_fd_sc_hd__tapvpwrvgnd_1
XTAP_TAPCELL_ROW_220_2826 VGND VPWR sky130_fd_sc_hd__tapvpwrvgnd_1
XFILLER_79_1165 VPWR VGND VPWR VGND sky130_ef_sc_hd__decap_12
XTAP_TAPCELL_ROW_220_2837 VGND VPWR sky130_fd_sc_hd__tapvpwrvgnd_1
XFILLER_245_393 VPWR VGND VPWR VGND sky130_ef_sc_hd__decap_12
X_525_ net664 VGND VGND VPWR VPWR _007_ sky130_fd_sc_hd__inv_2
XFILLER_2_1483 VGND VGND VPWR VPWR sky130_fd_sc_hd__fill_1
XFILLER_206_769 VPWR VGND VPWR VGND sky130_ef_sc_hd__decap_12
XFILLER_82_41 VPWR VGND VPWR VGND sky130_ef_sc_hd__decap_12
XFILLER_57_1441 VGND VGND VPWR VPWR sky130_fd_sc_hd__fill_1
XFILLER_205_279 VGND VGND VPWR VPWR sky130_fd_sc_hd__fill_1
XFILLER_198_41 VPWR VGND VPWR VGND sky130_ef_sc_hd__decap_12
XFILLER_207_1121 VPWR VGND VPWR VGND sky130_ef_sc_hd__decap_12
X_456_ rd_addr\[2\] net627 net624 VGND VGND VPWR VPWR addr0\[2\] sky130_fd_sc_hd__mux2_1
XTAP_TAPCELL_ROW_197_2195 VGND VPWR sky130_fd_sc_hd__tapvpwrvgnd_1
XFILLER_183_1493 VPWR VGND VPWR VGND sky130_ef_sc_hd__decap_12
XTAP_TAPCELL_ROW_30_2_3936 VGND VPWR sky130_fd_sc_hd__tapvpwrvgnd_1
XFILLER_198_85 VPWR VGND VPWR VGND sky130_ef_sc_hd__decap_12
XFILLER_201_441 VGND VGND VPWR VPWR sky130_fd_sc_hd__decap_6
XFILLER_203_1007 VGND VGND VPWR VPWR sky130_fd_sc_hd__fill_1
XFILLER_18_1469 VGND VGND VPWR VPWR sky130_fd_sc_hd__fill_1
XFILLER_186_643 VGND VGND VPWR VPWR sky130_fd_sc_hd__fill_1
X_387_ net590 net583 net70 VGND VGND VPWR VPWR _176_ sky130_fd_sc_hd__and3_1
XFILLER_174_805 VGND VGND VPWR VPWR sky130_fd_sc_hd__decap_6
XFILLER_201_485 VPWR VGND VPWR VGND sky130_ef_sc_hd__decap_12
XTAP_TAPCELL_ROW_218_2766 VGND VPWR sky130_fd_sc_hd__tapvpwrvgnd_1
XTAP_TAPCELL_ROW_218_2777 VGND VPWR sky130_fd_sc_hd__tapvpwrvgnd_1
XFILLER_9_377 VPWR VGND VPWR VGND sky130_ef_sc_hd__decap_12
XFILLER_174_849 VPWR VGND VPWR VGND sky130_ef_sc_hd__decap_12
XFILLER_173_337 VPWR VGND VPWR VGND sky130_ef_sc_hd__decap_12
XFILLER_220_1365 VGND VGND VPWR VPWR sky130_fd_sc_hd__decap_6
XTAP_TAPCELL_ROW_10_2_3812 VGND VPWR sky130_fd_sc_hd__tapvpwrvgnd_1
XFILLER_177_1231 VGND VGND VPWR VPWR sky130_fd_sc_hd__fill_1
XFILLER_217_15 VPWR VGND VPWR VGND sky130_ef_sc_hd__decap_12
XFILLER_5_561 VGND VGND VPWR VPWR sky130_fd_sc_hd__fill_2
XFILLER_138_1215 VPWR VGND VPWR VGND sky130_ef_sc_hd__decap_12
XFILLER_182_893 VPWR VGND VPWR VGND sky130_ef_sc_hd__decap_12
XFILLER_138_1259 VPWR VGND VPWR VGND sky130_ef_sc_hd__decap_12
XFILLER_218_1261 VPWR VGND VPWR VGND sky130_ef_sc_hd__decap_12
XTAP_TAPCELL_ROW_148_2_4644 VGND VPWR sky130_fd_sc_hd__tapvpwrvgnd_1
XFILLER_190_1453 VPWR VGND VPWR VGND sky130_ef_sc_hd__decap_12
XFILLER_214_1147 VGND VGND VPWR VPWR sky130_fd_sc_hd__fill_1
XFILLER_229_839 VGND VGND VPWR VPWR sky130_fd_sc_hd__fill_1
XTAP_TAPCELL_ROW_42_1_1177 VGND VPWR sky130_fd_sc_hd__tapvpwrvgnd_1
XFILLER_190_1497 VPWR VGND VPWR VGND sky130_ef_sc_hd__decap_12
XFILLER_255_113 VPWR VGND VPWR VGND sky130_ef_sc_hd__decap_12
XFILLER_233_69 VPWR VGND VPWR VGND sky130_ef_sc_hd__decap_12
XFILLER_62_1191 VPWR VGND VPWR VGND sky130_ef_sc_hd__decap_12
XTAP_TAPCELL_ROW_128_2_4520 VGND VPWR sky130_fd_sc_hd__tapvpwrvgnd_1
XFILLER_209_541 VPWR VGND VPWR VGND sky130_ef_sc_hd__decap_12
XFILLER_3_1225 VGND VGND VPWR VPWR sky130_fd_sc_hd__decap_6
XFILLER_97_1243 VPWR VGND VPWR VGND sky130_ef_sc_hd__decap_12
XFILLER_149_1311 VPWR VGND VPWR VGND sky130_ef_sc_hd__decap_12
XFILLER_209_585 VPWR VGND VPWR VGND sky130_ef_sc_hd__decap_12
XFILLER_3_1269 VPWR VGND VPWR VGND sky130_ef_sc_hd__decap_12
XFILLER_188_1371 VGND VGND VPWR VPWR sky130_fd_sc_hd__fill_1
XTAP_TAPCELL_ROW_182_1796 VGND VPWR sky130_fd_sc_hd__tapvpwrvgnd_1
XFILLER_102_29 VPWR VGND VPWR VGND sky130_ef_sc_hd__decap_12
XFILLER_224_533 VPWR VGND VPWR VGND sky130_ef_sc_hd__decap_12
XFILLER_58_1227 VPWR VGND VPWR VGND sky130_ef_sc_hd__decap_12
XTAP_TAPCELL_ROW_96_2_4331 VGND VPWR sky130_fd_sc_hd__tapvpwrvgnd_1
XFILLER_97_1287 VPWR VGND VPWR VGND sky130_ef_sc_hd__decap_12
XFILLER_149_1355 VPWR VGND VPWR VGND sky130_ef_sc_hd__decap_12
XFILLER_110_1189 VGND VGND VPWR VPWR sky130_fd_sc_hd__fill_1
XFILLER_145_1219 VPWR VGND VPWR VGND sky130_ef_sc_hd__decap_12
XFILLER_211_205 VPWR VGND VPWR VGND sky130_ef_sc_hd__decap_12
XFILLER_251_385 VGND VGND VPWR VPWR sky130_fd_sc_hd__decap_6
XPHY_EDGE_ROW_119_2_Left_621 VGND VGND VPWR VPWR sky130_fd_sc_hd__decap_3
XFILLER_149_1399 VPWR VGND VPWR VGND sky130_ef_sc_hd__decap_12
XFILLER_168_109 VPWR VGND VPWR VGND sky130_ef_sc_hd__decap_12
XFILLER_211_249 VPWR VGND VPWR VGND sky130_ef_sc_hd__decap_12
XFILLER_177_665 VGND VGND VPWR VPWR sky130_fd_sc_hd__decap_6
XFILLER_225_1287 VGND VGND VPWR VPWR sky130_fd_sc_hd__fill_1
XFILLER_176_153 VPWR VGND VPWR VGND sky130_ef_sc_hd__decap_12
XPHY_EDGE_ROW_161_2_Right_252 VGND VGND VPWR VPWR sky130_fd_sc_hd__decap_3
XFILLER_192_613 VPWR VGND VPWR VGND sky130_ef_sc_hd__decap_12
XTAP_TAPCELL_ROW_230_3100 VGND VPWR sky130_fd_sc_hd__tapvpwrvgnd_1
XFILLER_34_1271 VPWR VGND VPWR VGND sky130_ef_sc_hd__decap_12
XFILLER_178_1017 VPWR VGND VPWR VGND sky130_ef_sc_hd__decap_12
XFILLER_176_197 VPWR VGND VPWR VGND sky130_ef_sc_hd__decap_12
XFILLER_11_15 VPWR VGND VPWR VGND sky130_ef_sc_hd__decap_12
XFILLER_192_657 VPWR VGND VPWR VGND sky130_ef_sc_hd__decap_12
XFILLER_69_1323 VGND VGND VPWR VPWR sky130_fd_sc_hd__decap_6
XFILLER_127_15 VPWR VGND VPWR VGND sky130_ef_sc_hd__decap_12
XFILLER_191_167 VGND VGND VPWR VPWR sky130_fd_sc_hd__fill_1
XPHY_EDGE_ROW_99_1_Right_755 VGND VGND VPWR VPWR sky130_fd_sc_hd__decap_3
XFILLER_69_1367 VPWR VGND VPWR VGND sky130_ef_sc_hd__decap_12
XFILLER_156_1315 VPWR VGND VPWR VGND sky130_ef_sc_hd__decap_12
XFILLER_156_1359 VPWR VGND VPWR VGND sky130_ef_sc_hd__decap_12
XTAP_TAPCELL_ROW_228_3040 VGND VPWR sky130_fd_sc_hd__tapvpwrvgnd_1
XTAP_TAPCELL_ROW_228_3051 VGND VPWR sky130_fd_sc_hd__tapvpwrvgnd_1
XFILLER_232_1203 VGND VGND VPWR VPWR sky130_fd_sc_hd__fill_1
XFILLER_207_81 VPWR VGND VPWR VGND sky130_ef_sc_hd__decap_12
XTAP_TAPCELL_ROW_9_1120 VGND VPWR sky130_fd_sc_hd__tapvpwrvgnd_1
XFILLER_8_1147 VGND VGND VPWR VPWR sky130_fd_sc_hd__fill_1
XFILLER_219_305 VPWR VGND VPWR VGND sky130_ef_sc_hd__decap_12
XTAP_TAPCELL_ROW_9_1131 VGND VPWR sky130_fd_sc_hd__tapvpwrvgnd_1
XTAP_TAPCELL_ROW_23_2_3890 VGND VPWR sky130_fd_sc_hd__tapvpwrvgnd_1
XTAP_TAPCELL_ROW_9_1142 VGND VPWR sky130_fd_sc_hd__tapvpwrvgnd_1
XFILLER_189_1113 VGND VGND VPWR VPWR sky130_fd_sc_hd__decap_6
XFILLER_41_1231 VPWR VGND VPWR VGND sky130_ef_sc_hd__decap_12
XFILLER_143_69 VGND VGND VPWR VPWR sky130_fd_sc_hd__fill_2
XFILLER_219_349 VPWR VGND VPWR VGND sky130_ef_sc_hd__decap_12
XFILLER_235_809 VPWR VGND VPWR VGND sky130_ef_sc_hd__decap_12
XTAP_TAPCELL_ROW_5_1006 VGND VPWR sky130_fd_sc_hd__tapvpwrvgnd_1
XFILLER_189_1157 VPWR VGND VPWR VGND sky130_ef_sc_hd__decap_12
XFILLER_228_861 VGND VGND VPWR VPWR sky130_fd_sc_hd__decap_6
XFILLER_41_1275 VPWR VGND VPWR VGND sky130_ef_sc_hd__decap_12
XFILLER_227_393 VPWR VGND VPWR VGND sky130_ef_sc_hd__decap_12
XFILLER_243_853 VPWR VGND VPWR VGND sky130_ef_sc_hd__decap_12
XFILLER_76_1327 VPWR VGND VPWR VGND sky130_ef_sc_hd__decap_12
XFILLER_199_223 VGND VGND VPWR VPWR sky130_fd_sc_hd__fill_1
XFILLER_167_1455 VGND VGND VPWR VPWR sky130_fd_sc_hd__fill_1
XFILLER_242_363 VGND VGND VPWR VPWR sky130_fd_sc_hd__fill_1
XFILLER_243_897 VPWR VGND VPWR VGND sky130_ef_sc_hd__decap_12
XFILLER_128_1439 VPWR VGND VPWR VGND sky130_ef_sc_hd__decap_12
XFILLER_226_1029 VGND VGND VPWR VPWR sky130_fd_sc_hd__decap_6
X_310_ _096_ _098_ VGND VGND VPWR VPWR _099_ sky130_fd_sc_hd__or2_1
XFILLER_208_1441 VPWR VGND VPWR VGND sky130_ef_sc_hd__decap_12
XFILLER_230_525 VGND VGND VPWR VPWR sky130_fd_sc_hd__decap_6
XFILLER_187_429 VPWR VGND VPWR VGND sky130_ef_sc_hd__decap_12
XFILLER_243_1343 VGND VGND VPWR VPWR sky130_fd_sc_hd__fill_1
XFILLER_146_3 VPWR VGND VPWR VGND sky130_ef_sc_hd__decap_12
XTAP_TAPCELL_ROW_200_2280 VGND VPWR sky130_fd_sc_hd__tapvpwrvgnd_1
XFILLER_230_569 VPWR VGND VPWR VGND sky130_ef_sc_hd__decap_12
XFILLER_168_643 VGND VGND VPWR VPWR sky130_fd_sc_hd__fill_1
XTAP_TAPCELL_ROW_200_2291 VGND VPWR sky130_fd_sc_hd__tapvpwrvgnd_1
XFILLER_208_1485 VPWR VGND VPWR VGND sky130_ef_sc_hd__decap_12
XFILLER_211_783 VGND VGND VPWR VPWR sky130_fd_sc_hd__fill_1
XFILLER_13_1311 VPWR VGND VPWR VGND sky130_ef_sc_hd__decap_12
XFILLER_195_473 VPWR VGND VPWR VGND sky130_ef_sc_hd__decap_12
XPHY_EDGE_ROW_40_2_Left_542 VGND VGND VPWR VPWR sky130_fd_sc_hd__decap_3
XFILLER_168_77 VGND VGND VPWR VPWR sky130_fd_sc_hd__decap_6
XTAP_TAPCELL_ROW_192_2070 VGND VPWR sky130_fd_sc_hd__tapvpwrvgnd_1
XFILLER_52_1371 VPWR VGND VPWR VGND sky130_ef_sc_hd__decap_12
XFILLER_17_1491 VGND VGND VPWR VPWR sky130_fd_sc_hd__decap_6
XTAP_TAPCELL_ROW_154_2_4676 VGND VPWR sky130_fd_sc_hd__tapvpwrvgnd_1
XTAP_TAPCELL_ROW_192_2081 VGND VPWR sky130_fd_sc_hd__tapvpwrvgnd_1
XFILLER_196_1117 VPWR VGND VPWR VGND sky130_ef_sc_hd__decap_12
XFILLER_13_1355 VPWR VGND VPWR VGND sky130_ef_sc_hd__decap_12
XFILLER_6_336 VGND VGND VPWR VPWR sky130_fd_sc_hd__fill_1
XFILLER_100_1303 VPWR VGND VPWR VGND sky130_ef_sc_hd__decap_12
XFILLER_202_1073 VPWR VGND VPWR VGND sky130_ef_sc_hd__decap_12
XTAP_TAPCELL_ROW_213_2630 VGND VPWR sky130_fd_sc_hd__tapvpwrvgnd_1
XPHY_EDGE_ROW_35_2_Right_126 VGND VGND VPWR VPWR sky130_fd_sc_hd__decap_3
XFILLER_87_1423 VPWR VGND VPWR VGND sky130_ef_sc_hd__decap_12
XFILLER_104_1483 VPWR VGND VPWR VGND sky130_ef_sc_hd__decap_12
XTAP_TAPCELL_ROW_213_2641 VGND VPWR sky130_fd_sc_hd__tapvpwrvgnd_1
XFILLER_170_307 VGND VGND VPWR VPWR sky130_fd_sc_hd__fill_1
XFILLER_48_1407 VGND VGND VPWR VPWR sky130_fd_sc_hd__decap_6
XFILLER_13_1399 VPWR VGND VPWR VGND sky130_ef_sc_hd__decap_12
XPHY_EDGE_ROW_10_1_Right_821 VGND VGND VPWR VPWR sky130_fd_sc_hd__decap_3
XFILLER_182_189 VGND VGND VPWR VPWR sky130_fd_sc_hd__decap_6
XFILLER_87_1467 VPWR VGND VPWR VGND sky130_ef_sc_hd__decap_12
XFILLER_184_65 VPWR VGND VPWR VGND sky130_ef_sc_hd__decap_12
XFILLER_237_1169 VGND VGND VPWR VPWR sky130_fd_sc_hd__decap_6
Xsram0_682 VGND VGND VPWR VPWR sram0_682/HI net682 sky130_fd_sc_hd__conb_1
XFILLER_215_1401 VPWR VGND VPWR VGND sky130_ef_sc_hd__decap_12
XFILLER_254_1483 VGND VGND VPWR VPWR sky130_fd_sc_hd__fill_1
XFILLER_172_1161 VPWR VGND VPWR VGND sky130_ef_sc_hd__decap_12
XFILLER_238_625 VPWR VGND VPWR VGND sky130_ef_sc_hd__decap_12
XFILLER_237_113 VPWR VGND VPWR VGND sky130_ef_sc_hd__decap_12
XFILLER_238_669 VPWR VGND VPWR VGND sky130_ef_sc_hd__decap_12
XFILLER_24_1451 VPWR VGND VPWR VGND sky130_ef_sc_hd__decap_12
XPHY_EDGE_ROW_117_1_Left_372 VGND VGND VPWR VPWR sky130_fd_sc_hd__decap_3
XFILLER_133_1189 VPWR VGND VPWR VGND sky130_ef_sc_hd__decap_12
XFILLER_253_617 VPWR VGND VPWR VGND sky130_ef_sc_hd__decap_12
XTAP_TAPCELL_ROW_207_2467 VGND VPWR sky130_fd_sc_hd__tapvpwrvgnd_1
XFILLER_20_1315 VPWR VGND VPWR VGND sky130_ef_sc_hd__decap_12
XFILLER_203_39 VPWR VGND VPWR VGND sky130_ef_sc_hd__decap_12
XTAP_TAPCELL_ROW_207_2478 VGND VPWR sky130_fd_sc_hd__tapvpwrvgnd_1
XFILLER_24_1495 VPWR VGND VPWR VGND sky130_ef_sc_hd__decap_12
XFILLER_111_1443 VPWR VGND VPWR VGND sky130_ef_sc_hd__decap_12
XFILLER_93_51 VGND VGND VPWR VPWR sky130_fd_sc_hd__decap_4
XFILLER_185_1511 VGND VGND VPWR VPWR sky130_fd_sc_hd__fill_1
XFILLER_206_533 VPWR VGND VPWR VGND sky130_ef_sc_hd__decap_12
XFILLER_20_1359 VPWR VGND VPWR VGND sky130_ef_sc_hd__decap_12
XTAP_TAPCELL_ROW_199_2246 VGND VPWR sky130_fd_sc_hd__tapvpwrvgnd_1
XFILLER_94_1427 VPWR VGND VPWR VGND sky130_ef_sc_hd__decap_12
XTAP_TAPCELL_ROW_199_2257 VGND VPWR sky130_fd_sc_hd__tapvpwrvgnd_1
XTAP_TAPCELL_ROW_199_2268 VGND VPWR sky130_fd_sc_hd__tapvpwrvgnd_1
XFILLER_221_503 VGND VGND VPWR VPWR sky130_fd_sc_hd__fill_1
XFILLER_244_1129 VPWR VGND VPWR VGND sky130_ef_sc_hd__decap_12
XFILLER_233_385 VGND VGND VPWR VPWR sky130_fd_sc_hd__decap_6
X_508_ net596 dout0_q\[31\] VGND VGND VPWR VPWR _259_ sky130_fd_sc_hd__nand2_1
X_439_ net118 _227_ VGND VGND VPWR VPWR _228_ sky130_fd_sc_hd__nand2_1
XFILLER_222_1427 VGND VGND VPWR VPWR sky130_fd_sc_hd__fill_1
XFILLER_9_141 VGND VGND VPWR VPWR sky130_fd_sc_hd__decap_6
XFILLER_174_613 VPWR VGND VPWR VGND sky130_ef_sc_hd__decap_12
XFILLER_31_1411 VPWR VGND VPWR VGND sky130_ef_sc_hd__decap_12
XFILLER_70_1471 VPWR VGND VPWR VGND sky130_ef_sc_hd__decap_12
XFILLER_201_293 VPWR VGND VPWR VGND sky130_ef_sc_hd__decap_12
XFILLER_179_1337 VGND VGND VPWR VPWR sky130_fd_sc_hd__decap_6
XFILLER_174_657 VPWR VGND VPWR VGND sky130_ef_sc_hd__decap_12
XFILLER_31_1455 VPWR VGND VPWR VGND sky130_ef_sc_hd__decap_12
XFILLER_61_3 VPWR VGND VPWR VGND sky130_ef_sc_hd__decap_12
XFILLER_220_1173 VPWR VGND VPWR VGND sky130_ef_sc_hd__decap_12
XFILLER_173_167 VGND VGND VPWR VPWR sky130_fd_sc_hd__fill_1
XFILLER_66_1507 VGND VGND VPWR VPWR sky130_fd_sc_hd__decap_8
XFILLER_31_1499 VPWR VGND VPWR VGND sky130_ef_sc_hd__decap_12
XTAP_TAPCELL_ROW_171_1497 VGND VPWR sky130_fd_sc_hd__tapvpwrvgnd_1
XFILLER_5_391 VGND VGND VPWR VPWR sky130_fd_sc_hd__fill_1
XFILLER_9_1401 VPWR VGND VPWR VGND sky130_ef_sc_hd__decap_12
XTAP_TAPCELL_ROW_188_1950 VGND VPWR sky130_fd_sc_hd__tapvpwrvgnd_1
XFILLER_151_1201 VPWR VGND VPWR VGND sky130_ef_sc_hd__decap_12
XTAP_TAPCELL_ROW_188_1961 VGND VPWR sky130_fd_sc_hd__tapvpwrvgnd_1
XTAP_TAPCELL_ROW_188_1972 VGND VPWR sky130_fd_sc_hd__tapvpwrvgnd_1
XFILLER_190_1261 VPWR VGND VPWR VGND sky130_ef_sc_hd__decap_12
XFILLER_218_1091 VGND VGND VPWR VPWR sky130_fd_sc_hd__fill_1
XTAP_TAPCELL_ROW_184_1847 VGND VPWR sky130_fd_sc_hd__tapvpwrvgnd_1
XFILLER_3_93 VPWR VGND VPWR VGND sky130_ef_sc_hd__decap_12
XFILLER_151_1267 VGND VGND VPWR VPWR sky130_fd_sc_hd__decap_6
XTAP_TAPCELL_ROW_184_1858 VGND VPWR sky130_fd_sc_hd__tapvpwrvgnd_1
XFILLER_217_809 VPWR VGND VPWR VGND sky130_ef_sc_hd__decap_12
XFILLER_249_1007 VGND VGND VPWR VPWR sky130_fd_sc_hd__fill_1
XFILLER_113_39 VPWR VGND VPWR VGND sky130_ef_sc_hd__decap_12
XFILLER_243_105 VGND VGND VPWR VPWR sky130_fd_sc_hd__decap_6
XFILLER_3_1033 VPWR VGND VPWR VGND sky130_ef_sc_hd__decap_12
XFILLER_209_393 VPWR VGND VPWR VGND sky130_ef_sc_hd__decap_12
XFILLER_243_149 VPWR VGND VPWR VGND sky130_ef_sc_hd__decap_12
XFILLER_3_1077 VPWR VGND VPWR VGND sky130_ef_sc_hd__decap_12
XFILLER_225_853 VPWR VGND VPWR VGND sky130_ef_sc_hd__decap_12
XFILLER_224_363 VGND VGND VPWR VPWR sky130_fd_sc_hd__fill_1
XFILLER_225_897 VPWR VGND VPWR VGND sky130_ef_sc_hd__decap_12
Xwire88 net89 VGND VGND VPWR VPWR net88 sky130_fd_sc_hd__clkbuf_1
XFILLER_212_525 VGND VGND VPWR VPWR sky130_fd_sc_hd__decap_6
XFILLER_197_727 VGND VGND VPWR VPWR sky130_fd_sc_hd__fill_1
XFILLER_169_429 VPWR VGND VPWR VGND sky130_ef_sc_hd__decap_12
XFILLER_251_193 VPWR VGND VPWR VGND sky130_ef_sc_hd__decap_12
XFILLER_240_867 VGND VGND VPWR VPWR sky130_fd_sc_hd__fill_1
XFILLER_71_1213 VGND VGND VPWR VPWR sky130_fd_sc_hd__decap_4
XFILLER_212_569 VPWR VGND VPWR VGND sky130_ef_sc_hd__decap_12
XTAP_TAPCELL_ROW_140_2_4595 VGND VPWR sky130_fd_sc_hd__tapvpwrvgnd_1
XFILLER_165_613 VGND VGND VPWR VPWR sky130_fd_sc_hd__decap_3
XFILLER_177_473 VPWR VGND VPWR VGND sky130_ef_sc_hd__decap_12
XTAP_TAPCELL_ROW_139_2_4589 VGND VPWR sky130_fd_sc_hd__tapvpwrvgnd_1
XFILLER_193_933 VPWR VGND VPWR VGND sky130_ef_sc_hd__decap_12
XFILLER_192_421 VPWR VGND VPWR VGND sky130_ef_sc_hd__decap_12
XPHY_EDGE_ROW_162_2_Right_253 VGND VGND VPWR VPWR sky130_fd_sc_hd__decap_3
XFILLER_165_657 VPWR VGND VPWR VGND sky130_ef_sc_hd__decap_12
XFILLER_197_1437 VPWR VGND VPWR VGND sky130_ef_sc_hd__decap_12
XFILLER_193_977 VPWR VGND VPWR VGND sky130_ef_sc_hd__decap_12
XFILLER_203_1393 VGND VGND VPWR VPWR sky130_fd_sc_hd__decap_6
XFILLER_98_29 VPWR VGND VPWR VGND sky130_ef_sc_hd__decap_12
XFILLER_234_1309 VGND VGND VPWR VPWR sky130_fd_sc_hd__decap_6
XTAP_TAPCELL_ROW_87_2_4276 VGND VPWR sky130_fd_sc_hd__tapvpwrvgnd_1
XFILLER_156_1189 VGND VGND VPWR VPWR sky130_fd_sc_hd__fill_1
XFILLER_248_923 VGND VGND VPWR VPWR sky130_fd_sc_hd__fill_1
XFILLER_173_1481 VPWR VGND VPWR VGND sky130_ef_sc_hd__decap_12
XFILLER_219_113 VPWR VGND VPWR VGND sky130_ef_sc_hd__decap_12
XFILLER_47_55 VGND VGND VPWR VPWR sky130_fd_sc_hd__fill_1
XFILLER_235_617 VPWR VGND VPWR VGND sky130_ef_sc_hd__decap_12
XFILLER_210_1353 VPWR VGND VPWR VGND sky130_ef_sc_hd__decap_12
XFILLER_210_1397 VPWR VGND VPWR VGND sky130_ef_sc_hd__decap_12
XTAP_TAPCELL_ROW_202_2331 VGND VPWR sky130_fd_sc_hd__tapvpwrvgnd_1
XFILLER_128_1203 VPWR VGND VPWR VGND sky130_ef_sc_hd__decap_12
XTAP_TAPCELL_ROW_202_2342 VGND VPWR sky130_fd_sc_hd__tapvpwrvgnd_1
XFILLER_203_503 VGND VGND VPWR VPWR sky130_fd_sc_hd__fill_1
XFILLER_245_1449 VGND VGND VPWR VPWR sky130_fd_sc_hd__decap_6
XFILLER_215_385 VGND VGND VPWR VPWR sky130_fd_sc_hd__decap_6
XFILLER_128_1247 VPWR VGND VPWR VGND sky130_ef_sc_hd__decap_12
XTAP_TAPCELL_ROW_194_2110 VGND VPWR sky130_fd_sc_hd__tapvpwrvgnd_1
XFILLER_188_749 VGND VGND VPWR VPWR sky130_fd_sc_hd__decap_6
XTAP_TAPCELL_ROW_194_2121 VGND VPWR sky130_fd_sc_hd__tapvpwrvgnd_1
XFILLER_230_333 VPWR VGND VPWR VGND sky130_ef_sc_hd__decap_12
XFILLER_187_237 VPWR VGND VPWR VGND sky130_ef_sc_hd__decap_12
XTAP_TAPCELL_ROW_194_2132 VGND VPWR sky130_fd_sc_hd__tapvpwrvgnd_1
XFILLER_180_1441 VPWR VGND VPWR VGND sky130_ef_sc_hd__decap_12
XFILLER_231_889 VGND VGND VPWR VPWR sky130_fd_sc_hd__decap_6
XTAP_TAPCELL_ROW_60_2_4117 VGND VPWR sky130_fd_sc_hd__tapvpwrvgnd_1
XFILLER_230_377 VPWR VGND VPWR VGND sky130_ef_sc_hd__decap_12
XFILLER_8_27 VGND VGND VPWR VPWR sky130_fd_sc_hd__fill_1
XTAP_TAPCELL_ROW_190_2007 VGND VPWR sky130_fd_sc_hd__tapvpwrvgnd_1
XTAP_TAPCELL_ROW_190_2018 VGND VPWR sky130_fd_sc_hd__tapvpwrvgnd_1
XFILLER_180_1485 VPWR VGND VPWR VGND sky130_ef_sc_hd__decap_12
XTAP_TAPCELL_ROW_215_2703 VGND VPWR sky130_fd_sc_hd__tapvpwrvgnd_1
XFILLER_196_793 VPWR VGND VPWR VGND sky130_ef_sc_hd__decap_12
XFILLER_195_281 VPWR VGND VPWR VGND sky130_ef_sc_hd__decap_12
XFILLER_6_133 VGND VGND VPWR VPWR sky130_fd_sc_hd__decap_6
Xwire565 net566 VGND VGND VPWR VPWR net565 sky130_fd_sc_hd__clkbuf_1
Xwire576 dout0_q\[9\] VGND VGND VPWR VPWR net576 sky130_fd_sc_hd__clkbuf_1
Xwire587 dout0_q\[2\] VGND VGND VPWR VPWR net587 sky130_fd_sc_hd__clkbuf_1
XFILLER_221_1493 VPWR VGND VPWR VGND sky130_ef_sc_hd__decap_12
XFILLER_87_1231 VPWR VGND VPWR VGND sky130_ef_sc_hd__decap_12
Xwire598 net599 VGND VGND VPWR VPWR net598 sky130_fd_sc_hd__clkbuf_1
XPHY_EDGE_ROW_36_2_Right_127 VGND VGND VPWR VPWR sky130_fd_sc_hd__decap_3
XFILLER_48_1215 VPWR VGND VPWR VGND sky130_ef_sc_hd__decap_12
XFILLER_87_1275 VPWR VGND VPWR VGND sky130_ef_sc_hd__decap_12
XFILLER_139_1343 VPWR VGND VPWR VGND sky130_ef_sc_hd__decap_12
XFILLER_100_1177 VPWR VGND VPWR VGND sky130_ef_sc_hd__decap_12
XFILLER_252_1409 VPWR VGND VPWR VGND sky130_ef_sc_hd__decap_12
XFILLER_48_1259 VPWR VGND VPWR VGND sky130_ef_sc_hd__decap_12
XFILLER_139_1387 VPWR VGND VPWR VGND sky130_ef_sc_hd__decap_12
XFILLER_215_1231 VGND VGND VPWR VPWR sky130_fd_sc_hd__fill_1
XTAP_TAPCELL_ROW_209_2518 VGND VPWR sky130_fd_sc_hd__tapvpwrvgnd_1
XTAP_TAPCELL_ROW_209_2529 VGND VPWR sky130_fd_sc_hd__tapvpwrvgnd_1
XFILLER_239_945 VGND VGND VPWR VPWR sky130_fd_sc_hd__decap_6
XFILLER_214_27 VGND VGND VPWR VPWR sky130_fd_sc_hd__fill_1
XFILLER_238_433 VPWR VGND VPWR VGND sky130_ef_sc_hd__decap_12
XFILLER_239_989 VPWR VGND VPWR VGND sky130_ef_sc_hd__decap_12
XFILLER_238_477 VPWR VGND VPWR VGND sky130_ef_sc_hd__decap_12
XFILLER_254_937 VPWR VGND VPWR VGND sky130_ef_sc_hd__decap_12
XFILLER_225_105 VGND VGND VPWR VPWR sky130_fd_sc_hd__decap_6
XFILLER_168_1005 VPWR VGND VPWR VGND sky130_ef_sc_hd__decap_12
XFILLER_4_1353 VPWR VGND VPWR VGND sky130_ef_sc_hd__decap_12
XFILLER_253_447 VGND VGND VPWR VPWR sky130_fd_sc_hd__fill_1
XFILLER_59_1311 VPWR VGND VPWR VGND sky130_ef_sc_hd__decap_12
XFILLER_0_1217 VPWR VGND VPWR VGND sky130_ef_sc_hd__decap_12
XFILLER_225_149 VPWR VGND VPWR VGND sky130_ef_sc_hd__decap_12
XFILLER_230_15 VPWR VGND VPWR VGND sky130_ef_sc_hd__decap_12
XFILLER_241_609 VGND VGND VPWR VPWR sky130_fd_sc_hd__decap_6
XFILLER_98_1371 VPWR VGND VPWR VGND sky130_ef_sc_hd__decap_12
XFILLER_111_1273 VGND VGND VPWR VPWR sky130_fd_sc_hd__fill_1
XFILLER_168_1049 VPWR VGND VPWR VGND sky130_ef_sc_hd__decap_12
XFILLER_207_853 VPWR VGND VPWR VGND sky130_ef_sc_hd__decap_12
XFILLER_4_1397 VPWR VGND VPWR VGND sky130_ef_sc_hd__decap_12
XFILLER_59_1355 VPWR VGND VPWR VGND sky130_ef_sc_hd__decap_12
XFILLER_146_1303 VPWR VGND VPWR VGND sky130_ef_sc_hd__decap_12
XFILLER_248_1073 VPWR VGND VPWR VGND sky130_ef_sc_hd__decap_12
XFILLER_20_1189 VGND VGND VPWR VPWR sky130_fd_sc_hd__fill_1
XFILLER_206_363 VGND VGND VPWR VPWR sky130_fd_sc_hd__fill_1
XFILLER_207_897 VPWR VGND VPWR VGND sky130_ef_sc_hd__decap_12
XTAP_TAPCELL_ROW_37_1_1172 VGND VPWR sky130_fd_sc_hd__tapvpwrvgnd_1
XFILLER_179_727 VGND VGND VPWR VPWR sky130_fd_sc_hd__fill_1
XFILLER_55_1219 VPWR VGND VPWR VGND sky130_ef_sc_hd__decap_12
XFILLER_59_1399 VPWR VGND VPWR VGND sky130_ef_sc_hd__decap_12
XFILLER_209_1057 VGND VGND VPWR VPWR sky130_fd_sc_hd__decap_6
XFILLER_222_867 VGND VGND VPWR VPWR sky130_fd_sc_hd__fill_1
XFILLER_233_193 VPWR VGND VPWR VGND sky130_ef_sc_hd__decap_12
XFILLER_226_1371 VGND VGND VPWR VPWR sky130_fd_sc_hd__fill_1
XTAP_TAPCELL_ROW_177_1651 VGND VPWR sky130_fd_sc_hd__tapvpwrvgnd_1
XTAP_TAPCELL_ROW_177_1662 VGND VPWR sky130_fd_sc_hd__tapvpwrvgnd_1
XFILLER_239_57 VPWR VGND VPWR VGND sky130_ef_sc_hd__decap_12
XFILLER_175_933 VPWR VGND VPWR VGND sky130_ef_sc_hd__decap_12
XTAP_TAPCELL_ROW_177_1673 VGND VPWR sky130_fd_sc_hd__tapvpwrvgnd_1
XFILLER_174_421 VPWR VGND VPWR VGND sky130_ef_sc_hd__decap_12
XFILLER_179_1101 VPWR VGND VPWR VGND sky130_ef_sc_hd__decap_12
XTAP_TAPCELL_ROW_173_1548 VGND VPWR sky130_fd_sc_hd__tapvpwrvgnd_1
XFILLER_175_977 VPWR VGND VPWR VGND sky130_ef_sc_hd__decap_12
XTAP_TAPCELL_ROW_173_1559 VGND VPWR sky130_fd_sc_hd__tapvpwrvgnd_1
XFILLER_179_1145 VPWR VGND VPWR VGND sky130_ef_sc_hd__decap_12
XFILLER_190_925 VPWR VGND VPWR VGND sky130_ef_sc_hd__decap_12
XTAP_TAPCELL_ROW_105_2_4384 VGND VPWR sky130_fd_sc_hd__tapvpwrvgnd_1
XFILLER_175_1009 VPWR VGND VPWR VGND sky130_ef_sc_hd__decap_12
XFILLER_179_1189 VPWR VGND VPWR VGND sky130_ef_sc_hd__decap_12
XFILLER_66_1315 VPWR VGND VPWR VGND sky130_ef_sc_hd__decap_12
XFILLER_255_1033 VGND VGND VPWR VPWR sky130_fd_sc_hd__decap_3
XFILLER_157_1443 VPWR VGND VPWR VGND sky130_ef_sc_hd__decap_12
XTAP_TAPCELL_ROW_73_2_4195 VGND VPWR sky130_fd_sc_hd__tapvpwrvgnd_1
XFILLER_216_1017 VPWR VGND VPWR VGND sky130_ef_sc_hd__decap_12
XFILLER_249_709 VPWR VGND VPWR VGND sky130_ef_sc_hd__decap_12
XFILLER_66_1359 VPWR VGND VPWR VGND sky130_ef_sc_hd__decap_12
XFILLER_0_309 VGND VGND VPWR VPWR sky130_fd_sc_hd__decap_3
XFILLER_118_1427 VPWR VGND VPWR VGND sky130_ef_sc_hd__decap_12
XFILLER_255_1077 VPWR VGND VPWR VGND sky130_ef_sc_hd__decap_12
XTAP_TAPCELL_ROW_186_1909 VGND VPWR sky130_fd_sc_hd__tapvpwrvgnd_1
XFILLER_153_1329 VGND VGND VPWR VPWR sky130_fd_sc_hd__fill_1
XFILLER_170_693 VGND VGND VPWR VPWR sky130_fd_sc_hd__decap_6
XFILLER_124_27 VGND VGND VPWR VPWR sky130_fd_sc_hd__fill_1
XFILLER_190_1091 VGND VGND VPWR VPWR sky130_fd_sc_hd__fill_1
XTAP_TAPCELL_ROW_53_2_4071 VGND VPWR sky130_fd_sc_hd__tapvpwrvgnd_1
XFILLER_217_617 VPWR VGND VPWR VGND sky130_ef_sc_hd__decap_12
XFILLER_186_1105 VPWR VGND VPWR VGND sky130_ef_sc_hd__decap_12
XFILLER_77_1411 VPWR VGND VPWR VGND sky130_ef_sc_hd__decap_12
XTAP_TAPCELL_ROW_0_832 VGND VPWR sky130_fd_sc_hd__tapvpwrvgnd_1
XFILLER_140_15 VPWR VGND VPWR VGND sky130_ef_sc_hd__decap_12
XFILLER_186_1149 VPWR VGND VPWR VGND sky130_ef_sc_hd__decap_12
XFILLER_244_469 VGND VGND VPWR VPWR sky130_fd_sc_hd__decap_6
XFILLER_17_69 VGND VGND VPWR VPWR sky130_fd_sc_hd__fill_2
XTAP_TAPCELL_ROW_0_843 VGND VPWR sky130_fd_sc_hd__tapvpwrvgnd_1
XTAP_TAPCELL_ROW_84_1_1219 VGND VPWR sky130_fd_sc_hd__tapvpwrvgnd_1
XTAP_TAPCELL_ROW_0_854 VGND VPWR sky130_fd_sc_hd__tapvpwrvgnd_1
XTAP_TAPCELL_ROW_0_865 VGND VPWR sky130_fd_sc_hd__tapvpwrvgnd_1
XFILLER_77_1455 VPWR VGND VPWR VGND sky130_ef_sc_hd__decap_12
XFILLER_227_1113 VGND VGND VPWR VPWR sky130_fd_sc_hd__decap_6
XFILLER_38_1439 VPWR VGND VPWR VGND sky130_ef_sc_hd__decap_12
XFILLER_77_1499 VPWR VGND VPWR VGND sky130_ef_sc_hd__decap_12
XFILLER_212_333 VPWR VGND VPWR VGND sky130_ef_sc_hd__decap_12
XFILLER_227_1157 VPWR VGND VPWR VGND sky130_ef_sc_hd__decap_12
XFILLER_169_237 VPWR VGND VPWR VGND sky130_ef_sc_hd__decap_12
XFILLER_164_1469 VGND VGND VPWR VPWR sky130_fd_sc_hd__fill_1
XTAP_TAPCELL_ROW_255_3762 VGND VPWR sky130_fd_sc_hd__tapvpwrvgnd_1
XTAP_TAPCELL_ROW_31_2_3941 VGND VPWR sky130_fd_sc_hd__tapvpwrvgnd_1
XFILLER_213_889 VGND VGND VPWR VPWR sky130_fd_sc_hd__decap_6
XTAP_TAPCELL_ROW_255_3773 VGND VPWR sky130_fd_sc_hd__tapvpwrvgnd_1
XFILLER_212_377 VPWR VGND VPWR VGND sky130_ef_sc_hd__decap_12
XTAP_TAPCELL_ROW_255_3784 VGND VPWR sky130_fd_sc_hd__tapvpwrvgnd_1
XFILLER_33_57 VGND VGND VPWR VPWR sky130_fd_sc_hd__decap_4
XTAP_TAPCELL_ROW_255_3795 VGND VPWR sky130_fd_sc_hd__tapvpwrvgnd_1
XFILLER_205_1455 VGND VGND VPWR VPWR sky130_fd_sc_hd__fill_1
XFILLER_178_793 VPWR VGND VPWR VGND sky130_ef_sc_hd__decap_12
XPHY_EDGE_ROW_24_1_Right_680 VGND VGND VPWR VPWR sky130_fd_sc_hd__decap_3
XFILLER_149_57 VPWR VGND VPWR VGND sky130_ef_sc_hd__decap_12
XTAP_TAPCELL_ROW_251_3659 VGND VPWR sky130_fd_sc_hd__tapvpwrvgnd_1
XFILLER_165_421 VPWR VGND VPWR VGND sky130_ef_sc_hd__decap_12
XFILLER_177_281 VPWR VGND VPWR VGND sky130_ef_sc_hd__decap_12
XFILLER_197_1201 VPWR VGND VPWR VGND sky130_ef_sc_hd__decap_12
XFILLER_193_741 VPWR VGND VPWR VGND sky130_ef_sc_hd__decap_12
XFILLER_123_1177 VPWR VGND VPWR VGND sky130_ef_sc_hd__decap_12
XFILLER_10_1303 VPWR VGND VPWR VGND sky130_ef_sc_hd__decap_12
XFILLER_192_251 VGND VGND VPWR VPWR sky130_fd_sc_hd__fill_1
XFILLER_197_1245 VPWR VGND VPWR VGND sky130_ef_sc_hd__decap_12
XFILLER_193_785 VPWR VGND VPWR VGND sky130_ef_sc_hd__decap_12
XFILLER_14_1483 VPWR VGND VPWR VGND sky130_ef_sc_hd__decap_12
XPHY_EDGE_ROW_163_2_Right_254 VGND VGND VPWR VPWR sky130_fd_sc_hd__decap_3
XFILLER_180_413 VGND VGND VPWR VPWR sky130_fd_sc_hd__decap_6
XFILLER_197_1289 VPWR VGND VPWR VGND sky130_ef_sc_hd__decap_12
XFILLER_3_125 VPWR VGND VPWR VGND sky130_ef_sc_hd__decap_12
XFILLER_109_3 VPWR VGND VPWR VGND sky130_ef_sc_hd__decap_12
XFILLER_84_1415 VPWR VGND VPWR VGND sky130_ef_sc_hd__decap_12
XFILLER_180_457 VPWR VGND VPWR VGND sky130_ef_sc_hd__decap_12
XFILLER_238_1253 VGND VGND VPWR VPWR sky130_fd_sc_hd__decap_6
XFILLER_101_1497 VGND VGND VPWR VPWR sky130_fd_sc_hd__fill_1
XFILLER_234_1117 VPWR VGND VPWR VGND sky130_ef_sc_hd__decap_12
XTAP_TAPCELL_ROW_249_3599 VGND VPWR sky130_fd_sc_hd__tapvpwrvgnd_1
XFILLER_238_1297 VPWR VGND VPWR VGND sky130_ef_sc_hd__decap_12
XFILLER_0_821 VGND VGND VPWR VPWR sky130_fd_sc_hd__fill_1
XFILLER_58_65 VGND VGND VPWR VPWR sky130_fd_sc_hd__decap_6
XTAP_TAPCELL_ROW_162_2_4727 VGND VPWR sky130_fd_sc_hd__tapvpwrvgnd_1
XFILLER_181_55 VGND VGND VPWR VPWR sky130_fd_sc_hd__fill_1
XFILLER_134_1295 VGND VGND VPWR VPWR sky130_fd_sc_hd__decap_6
XFILLER_236_937 VPWR VGND VPWR VGND sky130_ef_sc_hd__decap_12
XFILLER_43_1189 VPWR VGND VPWR VGND sky130_ef_sc_hd__decap_12
XTAP_TAPCELL_ROW_204_2404 VGND VPWR sky130_fd_sc_hd__tapvpwrvgnd_1
XFILLER_207_105 VGND VGND VPWR VPWR sky130_fd_sc_hd__decap_6
XFILLER_169_1325 VPWR VGND VPWR VGND sky130_ef_sc_hd__decap_12
XFILLER_21_1443 VPWR VGND VPWR VGND sky130_ef_sc_hd__decap_12
XFILLER_235_447 VGND VGND VPWR VPWR sky130_fd_sc_hd__fill_1
XFILLER_210_1161 VPWR VGND VPWR VGND sky130_ef_sc_hd__decap_12
XFILLER_95_1511 VGND VGND VPWR VPWR sky130_fd_sc_hd__decap_4
XFILLER_207_149 VPWR VGND VPWR VGND sky130_ef_sc_hd__decap_12
XFILLER_74_53 VPWR VGND VPWR VGND sky130_ef_sc_hd__decap_12
XFILLER_169_1369 VPWR VGND VPWR VGND sky130_ef_sc_hd__decap_12
XFILLER_223_609 VGND VGND VPWR VPWR sky130_fd_sc_hd__decap_6
XFILLER_244_981 VPWR VGND VPWR VGND sky130_ef_sc_hd__decap_12
XFILLER_245_1213 VPWR VGND VPWR VGND sky130_ef_sc_hd__decap_12
XFILLER_249_1393 VGND VGND VPWR VPWR sky130_fd_sc_hd__decap_6
XFILLER_188_513 VPWR VGND VPWR VGND sky130_ef_sc_hd__decap_12
XFILLER_245_1257 VPWR VGND VPWR VGND sky130_ef_sc_hd__decap_12
XFILLER_215_193 VPWR VGND VPWR VGND sky130_ef_sc_hd__decap_12
XFILLER_200_29 VPWR VGND VPWR VGND sky130_ef_sc_hd__decap_12
XFILLER_204_867 VGND VGND VPWR VPWR sky130_fd_sc_hd__fill_1
XFILLER_231_653 VPWR VGND VPWR VGND sky130_ef_sc_hd__decap_12
XFILLER_188_557 VPWR VGND VPWR VGND sky130_ef_sc_hd__decap_12
XFILLER_230_141 VPWR VGND VPWR VGND sky130_ef_sc_hd__decap_12
XFILLER_90_41 VPWR VGND VPWR VGND sky130_ef_sc_hd__decap_12
XFILLER_223_1511 VGND VGND VPWR VPWR sky130_fd_sc_hd__fill_1
XFILLER_231_697 VPWR VGND VPWR VGND sky130_ef_sc_hd__decap_12
XFILLER_141_1255 VPWR VGND VPWR VGND sky130_ef_sc_hd__decap_12
Xwire340 net341 VGND VGND VPWR VPWR net340 sky130_fd_sc_hd__clkbuf_1
Xwire351 net352 VGND VGND VPWR VPWR net351 sky130_fd_sc_hd__clkbuf_1
XFILLER_209_27 VPWR VGND VPWR VGND sky130_ef_sc_hd__decap_12
XFILLER_102_1239 VGND VGND VPWR VPWR sky130_fd_sc_hd__decap_6
Xwire362 net363 VGND VGND VPWR VPWR net362 sky130_fd_sc_hd__clkbuf_1
XFILLER_141_1299 VPWR VGND VPWR VGND sky130_ef_sc_hd__decap_12
XFILLER_172_925 VPWR VGND VPWR VGND sky130_ef_sc_hd__decap_12
Xwire373 net374 VGND VGND VPWR VPWR net373 sky130_fd_sc_hd__clkbuf_1
Xwire384 net385 VGND VGND VPWR VPWR net384 sky130_fd_sc_hd__clkbuf_1
Xmax_cap117 _111_ VGND VGND VPWR VPWR net117 sky130_fd_sc_hd__clkbuf_1
XFILLER_183_273 VGND VGND VPWR VPWR sky130_fd_sc_hd__decap_6
Xwire395 net396 VGND VGND VPWR VPWR net395 sky130_fd_sc_hd__clkbuf_1
XFILLER_176_1329 VPWR VGND VPWR VGND sky130_ef_sc_hd__decap_12
Xmax_cap128 _219_ VGND VGND VPWR VPWR net128 sky130_fd_sc_hd__clkbuf_1
XPHY_EDGE_ROW_37_2_Right_128 VGND VGND VPWR VPWR sky130_fd_sc_hd__decap_3
XFILLER_252_1217 VPWR VGND VPWR VGND sky130_ef_sc_hd__decap_12
XFILLER_217_1337 VGND VGND VPWR VPWR sky130_fd_sc_hd__decap_6
XFILLER_225_15 VPWR VGND VPWR VGND sky130_ef_sc_hd__decap_12
XPHY_EDGE_ROW_128_2_Left_630 VGND VGND VPWR VPWR sky130_fd_sc_hd__decap_3
XFILLER_61_1201 VPWR VGND VPWR VGND sky130_ef_sc_hd__decap_12
XFILLER_239_753 VPWR VGND VPWR VGND sky130_ef_sc_hd__decap_12
XFILLER_24_3 VPWR VGND VPWR VGND sky130_ef_sc_hd__decap_12
XFILLER_152_1351 VGND VGND VPWR VPWR sky130_fd_sc_hd__decap_6
XFILLER_254_701 VPWR VGND VPWR VGND sky130_ef_sc_hd__decap_12
XFILLER_61_1267 VGND VGND VPWR VPWR sky130_fd_sc_hd__decap_6
XFILLER_239_797 VPWR VGND VPWR VGND sky130_ef_sc_hd__decap_12
XFILLER_152_1395 VPWR VGND VPWR VGND sky130_ef_sc_hd__decap_12
XTAP_TAPCELL_ROW_166_1363 VGND VPWR sky130_fd_sc_hd__tapvpwrvgnd_1
XTAP_TAPCELL_ROW_166_1374 VGND VPWR sky130_fd_sc_hd__tapvpwrvgnd_1
XFILLER_187_1425 VPWR VGND VPWR VGND sky130_ef_sc_hd__decap_12
XFILLER_113_1379 VGND VGND VPWR VPWR sky130_fd_sc_hd__decap_6
XFILLER_4_1161 VPWR VGND VPWR VGND sky130_ef_sc_hd__decap_12
XFILLER_241_69 VPWR VGND VPWR VGND sky130_ef_sc_hd__decap_12
XFILLER_226_469 VGND VGND VPWR VPWR sky130_fd_sc_hd__decap_6
XFILLER_187_1469 VPWR VGND VPWR VGND sky130_ef_sc_hd__decap_12
XFILLER_241_417 VPWR VGND VPWR VGND sky130_ef_sc_hd__decap_12
XTAP_TAPCELL_ROW_179_1713 VGND VPWR sky130_fd_sc_hd__tapvpwrvgnd_1
XTAP_TAPCELL_ROW_179_1724 VGND VPWR sky130_fd_sc_hd__tapvpwrvgnd_1
XFILLER_110_29 VPWR VGND VPWR VGND sky130_ef_sc_hd__decap_12
XFILLER_228_1477 VGND VGND VPWR VPWR sky130_fd_sc_hd__decap_6
XFILLER_250_973 VGND VGND VPWR VPWR sky130_fd_sc_hd__decap_6
XFILLER_146_1177 VPWR VGND VPWR VGND sky130_ef_sc_hd__decap_12
XFILLER_181_1057 VGND VGND VPWR VPWR sky130_fd_sc_hd__decap_6
XFILLER_210_837 VPWR VGND VPWR VGND sky130_ef_sc_hd__decap_12
XFILLER_163_1491 VGND VGND VPWR VPWR sky130_fd_sc_hd__decap_6
XFILLER_9_81 VGND VGND VPWR VPWR sky130_fd_sc_hd__decap_3
XFILLER_175_741 VPWR VGND VPWR VGND sky130_ef_sc_hd__decap_12
XFILLER_119_27 VPWR VGND VPWR VGND sky130_ef_sc_hd__decap_12
XFILLER_120_1339 VPWR VGND VPWR VGND sky130_ef_sc_hd__decap_12
XFILLER_174_251 VGND VGND VPWR VPWR sky130_fd_sc_hd__fill_1
XFILLER_175_785 VPWR VGND VPWR VGND sky130_ef_sc_hd__decap_12
XFILLER_200_1341 VPWR VGND VPWR VGND sky130_ef_sc_hd__decap_12
XFILLER_194_1429 VPWR VGND VPWR VGND sky130_ef_sc_hd__decap_12
XFILLER_190_755 VGND VGND VPWR VPWR sky130_fd_sc_hd__fill_1
XFILLER_200_1385 VPWR VGND VPWR VGND sky130_ef_sc_hd__decap_12
XFILLER_135_15 VPWR VGND VPWR VGND sky130_ef_sc_hd__decap_12
XFILLER_235_1437 VPWR VGND VPWR VGND sky130_ef_sc_hd__decap_12
XFILLER_157_1273 VGND VGND VPWR VPWR sky130_fd_sc_hd__fill_1
XFILLER_249_517 VPWR VGND VPWR VGND sky130_ef_sc_hd__decap_12
XFILLER_66_1189 VGND VGND VPWR VPWR sky130_fd_sc_hd__fill_1
XFILLER_192_1197 VGND VGND VPWR VPWR sky130_fd_sc_hd__decap_6
XFILLER_9_1061 VGND VGND VPWR VPWR sky130_fd_sc_hd__decap_3
XTAP_TAPCELL_ROW_244_3463 VGND VPWR sky130_fd_sc_hd__tapvpwrvgnd_1
XTAP_TAPCELL_ROW_244_3474 VGND VPWR sky130_fd_sc_hd__tapvpwrvgnd_1
XTAP_TAPCELL_ROW_244_3485 VGND VPWR sky130_fd_sc_hd__tapvpwrvgnd_1
XFILLER_215_81 VPWR VGND VPWR VGND sky130_ef_sc_hd__decap_12
XFILLER_131_1435 VGND VGND VPWR VPWR sky130_fd_sc_hd__decap_6
XFILLER_218_937 VPWR VGND VPWR VGND sky130_ef_sc_hd__decap_12
XTAP_TAPCELL_ROW_127_2_4516 VGND VPWR sky130_fd_sc_hd__tapvpwrvgnd_1
XFILLER_131_1479 VPWR VGND VPWR VGND sky130_ef_sc_hd__decap_12
XFILLER_217_447 VGND VGND VPWR VPWR sky130_fd_sc_hd__fill_1
XFILLER_244_233 VPWR VGND VPWR VGND sky130_ef_sc_hd__decap_12
XFILLER_151_69 VGND VGND VPWR VPWR sky130_fd_sc_hd__fill_2
XFILLER_211_1481 VPWR VGND VPWR VGND sky130_ef_sc_hd__decap_12
XFILLER_166_1509 VGND VGND VPWR VPWR sky130_fd_sc_hd__decap_6
XFILLER_205_609 VGND VGND VPWR VPWR sky130_fd_sc_hd__decap_6
XFILLER_244_277 VPWR VGND VPWR VGND sky130_ef_sc_hd__decap_12
XFILLER_226_981 VPWR VGND VPWR VGND sky130_ef_sc_hd__decap_12
XFILLER_38_1203 VPWR VGND VPWR VGND sky130_ef_sc_hd__decap_12
XTAP_TAPCELL_ROW_95_2_4327 VGND VPWR sky130_fd_sc_hd__tapvpwrvgnd_1
XFILLER_198_811 VGND VGND VPWR VPWR sky130_fd_sc_hd__fill_1
XFILLER_129_1331 VPWR VGND VPWR VGND sky130_ef_sc_hd__decap_12
XFILLER_241_951 VGND VGND VPWR VPWR sky130_fd_sc_hd__fill_1
XFILLER_38_1247 VPWR VGND VPWR VGND sky130_ef_sc_hd__decap_12
XFILLER_213_653 VPWR VGND VPWR VGND sky130_ef_sc_hd__decap_12
XFILLER_212_141 VPWR VGND VPWR VGND sky130_ef_sc_hd__decap_12
XFILLER_125_1217 VGND VGND VPWR VPWR sky130_fd_sc_hd__fill_1
XFILLER_185_505 VPWR VGND VPWR VGND sky130_ef_sc_hd__decap_12
XFILLER_213_697 VPWR VGND VPWR VGND sky130_ef_sc_hd__decap_12
XFILLER_9_729 VPWR VGND VPWR VGND sky130_ef_sc_hd__decap_12
XFILLER_90_1463 VGND VGND VPWR VPWR sky130_fd_sc_hd__decap_6
XTAP_TAPCELL_ROW_75_2_4203 VGND VPWR sky130_fd_sc_hd__tapvpwrvgnd_1
XFILLER_8_239 VGND VGND VPWR VPWR sky130_fd_sc_hd__fill_1
XFILLER_226_3 VPWR VGND VPWR VGND sky130_ef_sc_hd__decap_12
XPHY_EDGE_ROW_25_1_Right_681 VGND VGND VPWR VPWR sky130_fd_sc_hd__decap_3
XPHY_EDGE_ROW_126_1_Left_381 VGND VGND VPWR VPWR sky130_fd_sc_hd__decap_3
XFILLER_176_77 VGND VGND VPWR VPWR sky130_fd_sc_hd__decap_6
XFILLER_180_221 VPWR VGND VPWR VGND sky130_ef_sc_hd__decap_12
XPHY_EDGE_ROW_164_2_Right_255 VGND VGND VPWR VPWR sky130_fd_sc_hd__decap_3
XFILLER_181_777 VGND VGND VPWR VPWR sky130_fd_sc_hd__decap_6
XFILLER_49_1343 VPWR VGND VPWR VGND sky130_ef_sc_hd__decap_12
XFILLER_10_1177 VPWR VGND VPWR VGND sky130_ef_sc_hd__decap_12
XFILLER_180_265 VPWR VGND VPWR VGND sky130_ef_sc_hd__decap_12
XFILLER_238_1061 VPWR VGND VPWR VGND sky130_ef_sc_hd__decap_12
XFILLER_84_1245 VGND VGND VPWR VPWR sky130_fd_sc_hd__fill_1
XFILLER_49_1387 VPWR VGND VPWR VGND sky130_ef_sc_hd__decap_12
XFILLER_136_1357 VGND VGND VPWR VPWR sky130_fd_sc_hd__fill_1
XFILLER_192_65 VPWR VGND VPWR VGND sky130_ef_sc_hd__decap_12
XFILLER_0_673 VGND VGND VPWR VPWR sky130_fd_sc_hd__fill_2
XFILLER_236_701 VPWR VGND VPWR VGND sky130_ef_sc_hd__decap_12
XTAP_TAPCELL_ROW_22_2_3886 VGND VPWR sky130_fd_sc_hd__tapvpwrvgnd_1
XFILLER_1_1301 VPWR VGND VPWR VGND sky130_ef_sc_hd__decap_12
XFILLER_169_1133 VPWR VGND VPWR VGND sky130_ef_sc_hd__decap_12
XFILLER_5_1481 VPWR VGND VPWR VGND sky130_ef_sc_hd__decap_12
XFILLER_208_469 VGND VGND VPWR VPWR sky130_fd_sc_hd__decap_6
XFILLER_21_1273 VGND VGND VPWR VPWR sky130_fd_sc_hd__fill_1
XFILLER_1_1345 VPWR VGND VPWR VGND sky130_ef_sc_hd__decap_12
XFILLER_169_1177 VPWR VGND VPWR VGND sky130_ef_sc_hd__decap_12
XFILLER_223_417 VPWR VGND VPWR VGND sky130_ef_sc_hd__decap_12
XFILLER_211_39 VPWR VGND VPWR VGND sky130_ef_sc_hd__decap_12
XFILLER_56_1303 VPWR VGND VPWR VGND sky130_ef_sc_hd__decap_12
XFILLER_245_1021 VPWR VGND VPWR VGND sky130_ef_sc_hd__decap_12
XFILLER_189_833 VGND VGND VPWR VPWR sky130_fd_sc_hd__decap_6
XFILLER_95_1385 VGND VGND VPWR VPWR sky130_fd_sc_hd__fill_1
XFILLER_188_321 VPWR VGND VPWR VGND sky130_ef_sc_hd__decap_12
XFILLER_108_1415 VPWR VGND VPWR VGND sky130_ef_sc_hd__decap_12
XFILLER_206_1005 VPWR VGND VPWR VGND sky130_ef_sc_hd__decap_12
XFILLER_245_1065 VPWR VGND VPWR VGND sky130_ef_sc_hd__decap_12
XFILLER_232_973 VGND VGND VPWR VPWR sky130_fd_sc_hd__decap_6
XFILLER_189_877 VPWR VGND VPWR VGND sky130_ef_sc_hd__decap_12
XFILLER_231_461 VPWR VGND VPWR VGND sky130_ef_sc_hd__decap_12
XFILLER_147_1497 VGND VGND VPWR VPWR sky130_fd_sc_hd__fill_1
XFILLER_188_365 VPWR VGND VPWR VGND sky130_ef_sc_hd__decap_12
XFILLER_206_1049 VPWR VGND VPWR VGND sky130_ef_sc_hd__decap_12
XFILLER_8_751 VGND VGND VPWR VPWR sky130_fd_sc_hd__decap_4
XFILLER_200_881 VPWR VGND VPWR VGND sky130_ef_sc_hd__decap_12
Xwire170 _132_ VGND VGND VPWR VPWR net170 sky130_fd_sc_hd__clkbuf_1
XFILLER_172_755 VGND VGND VPWR VPWR sky130_fd_sc_hd__fill_1
XFILLER_89_1189 VPWR VGND VPWR VGND sky130_ef_sc_hd__decap_12
XFILLER_67_1443 VPWR VGND VPWR VGND sky130_ef_sc_hd__decap_12
XFILLER_217_1101 VPWR VGND VPWR VGND sky130_ef_sc_hd__decap_12
XFILLER_119_1511 VGND VGND VPWR VPWR sky130_fd_sc_hd__decap_4
XFILLER_154_1413 VGND VGND VPWR VPWR sky130_fd_sc_hd__fill_1
XFILLER_28_1427 VPWR VGND VPWR VGND sky130_ef_sc_hd__decap_12
XTAP_TAPCELL_ROW_88_2_4281 VGND VPWR sky130_fd_sc_hd__tapvpwrvgnd_1
XPHY_EDGE_ROW_38_2_Right_129 VGND VGND VPWR VPWR sky130_fd_sc_hd__decap_3
XFILLER_217_1145 VPWR VGND VPWR VGND sky130_ef_sc_hd__decap_12
XFILLER_63_1329 VGND VGND VPWR VPWR sky130_fd_sc_hd__fill_1
XTAP_TAPCELL_ROW_168_1414 VGND VPWR sky130_fd_sc_hd__tapvpwrvgnd_1
XTAP_TAPCELL_ROW_168_1425 VGND VPWR sky130_fd_sc_hd__tapvpwrvgnd_1
XFILLER_213_1009 VPWR VGND VPWR VGND sky130_ef_sc_hd__decap_12
XFILLER_217_1189 VPWR VGND VPWR VGND sky130_ef_sc_hd__decap_12
XPHY_EDGE_ROW_7_Right_7 VGND VGND VPWR VPWR sky130_fd_sc_hd__decap_3
XFILLER_239_561 VPWR VGND VPWR VGND sky130_ef_sc_hd__decap_12
XTAP_TAPCELL_ROW_2_905 VGND VPWR sky130_fd_sc_hd__tapvpwrvgnd_1
XTAP_TAPCELL_ROW_113_2_4435 VGND VPWR sky130_fd_sc_hd__tapvpwrvgnd_1
XTAP_TAPCELL_ROW_2_916 VGND VPWR sky130_fd_sc_hd__tapvpwrvgnd_1
XTAP_TAPCELL_ROW_2_927 VGND VPWR sky130_fd_sc_hd__tapvpwrvgnd_1
XFILLER_254_531 VGND VGND VPWR VPWR sky130_fd_sc_hd__fill_1
XFILLER_113_1165 VPWR VGND VPWR VGND sky130_ef_sc_hd__decap_12
XFILLER_226_233 VPWR VGND VPWR VGND sky130_ef_sc_hd__decap_12
XFILLER_187_1233 VPWR VGND VPWR VGND sky130_ef_sc_hd__decap_12
XFILLER_208_981 VPWR VGND VPWR VGND sky130_ef_sc_hd__decap_12
XFILLER_226_277 VPWR VGND VPWR VGND sky130_ef_sc_hd__decap_12
XFILLER_242_737 VPWR VGND VPWR VGND sky130_ef_sc_hd__decap_12
XFILLER_121_39 VPWR VGND VPWR VGND sky130_ef_sc_hd__decap_12
XFILLER_148_1239 VGND VGND VPWR VPWR sky130_fd_sc_hd__decap_6
XFILLER_183_1119 VGND VGND VPWR VPWR sky130_fd_sc_hd__fill_1
XFILLER_241_225 VPWR VGND VPWR VGND sky130_ef_sc_hd__decap_12
XFILLER_228_1241 VPWR VGND VPWR VGND sky130_ef_sc_hd__decap_12
XFILLER_223_951 VGND VGND VPWR VPWR sky130_fd_sc_hd__fill_1
XFILLER_224_1105 VPWR VGND VPWR VGND sky130_ef_sc_hd__decap_12
XFILLER_210_601 VPWR VGND VPWR VGND sky130_ef_sc_hd__decap_12
XFILLER_228_1285 VPWR VGND VPWR VGND sky130_ef_sc_hd__decap_12
XFILLER_14_15 VPWR VGND VPWR VGND sky130_ef_sc_hd__decap_12
XFILLER_74_1469 VGND VGND VPWR VPWR sky130_fd_sc_hd__fill_1
XFILLER_250_781 VPWR VGND VPWR VGND sky130_ef_sc_hd__decap_12
XTAP_TAPCELL_ROW_61_2_4122 VGND VPWR sky130_fd_sc_hd__tapvpwrvgnd_1
XFILLER_167_505 VPWR VGND VPWR VGND sky130_ef_sc_hd__decap_12
XFILLER_224_1149 VPWR VGND VPWR VGND sky130_ef_sc_hd__decap_12
XFILLER_210_645 VPWR VGND VPWR VGND sky130_ef_sc_hd__decap_12
XTAP_TAPCELL_ROW_79_1_1214 VGND VPWR sky130_fd_sc_hd__tapvpwrvgnd_1
XFILLER_194_357 VGND VGND VPWR VPWR sky130_fd_sc_hd__decap_6
XTAP_TAPCELL_ROW_233_3164 VGND VPWR sky130_fd_sc_hd__tapvpwrvgnd_1
XTAP_TAPCELL_ROW_233_3175 VGND VPWR sky130_fd_sc_hd__tapvpwrvgnd_1
XFILLER_124_1283 VPWR VGND VPWR VGND sky130_ef_sc_hd__decap_12
XTAP_TAPCELL_ROW_233_3186 VGND VPWR sky130_fd_sc_hd__tapvpwrvgnd_1
XFILLER_33_1177 VPWR VGND VPWR VGND sky130_ef_sc_hd__decap_12
XFILLER_198_1373 VPWR VGND VPWR VGND sky130_ef_sc_hd__decap_12
XFILLER_159_1379 VGND VGND VPWR VPWR sky130_fd_sc_hd__decap_6
XFILLER_194_1259 VGND VGND VPWR VPWR sky130_fd_sc_hd__fill_1
XFILLER_235_1201 VPWR VGND VPWR VGND sky130_ef_sc_hd__decap_12
XFILLER_239_1381 VPWR VGND VPWR VGND sky130_ef_sc_hd__decap_12
XFILLER_11_1497 VGND VGND VPWR VPWR sky130_fd_sc_hd__fill_1
XTAP_TAPCELL_ROW_246_3514 VGND VPWR sky130_fd_sc_hd__tapvpwrvgnd_1
XTAP_TAPCELL_ROW_246_3525 VGND VPWR sky130_fd_sc_hd__tapvpwrvgnd_1
XFILLER_2_949 VPWR VGND VPWR VGND sky130_ef_sc_hd__decap_12
XTAP_TAPCELL_ROW_246_3536 VGND VPWR sky130_fd_sc_hd__tapvpwrvgnd_1
Xmax_cap492 net493 VGND VGND VPWR VPWR net492 sky130_fd_sc_hd__clkbuf_1
XFILLER_235_1245 VPWR VGND VPWR VGND sky130_ef_sc_hd__decap_12
XFILLER_1_437 VGND VGND VPWR VPWR sky130_fd_sc_hd__fill_2
XTAP_TAPCELL_ROW_60_1_1195 VGND VPWR sky130_fd_sc_hd__tapvpwrvgnd_1
XFILLER_7_1009 VPWR VGND VPWR VGND sky130_ef_sc_hd__decap_12
XFILLER_235_1289 VPWR VGND VPWR VGND sky130_ef_sc_hd__decap_12
XFILLER_218_701 VPWR VGND VPWR VGND sky130_ef_sc_hd__decap_12
XFILLER_44_1295 VGND VGND VPWR VPWR sky130_fd_sc_hd__decap_6
X_610_ clknet_3_6__leaf_clk dout0\[8\] _018_ VGND VGND VPWR VPWR dout0_q\[8\] sky130_fd_sc_hd__dfrtp_1
XFILLER_131_1243 VPWR VGND VPWR VGND sky130_ef_sc_hd__decap_12
XFILLER_245_553 VGND VGND VPWR VPWR sky130_fd_sc_hd__decap_6
XFILLER_131_1287 VPWR VGND VPWR VGND sky130_ef_sc_hd__decap_12
XFILLER_176_3 VPWR VGND VPWR VGND sky130_ef_sc_hd__decap_12
X_541_ net667 VGND VGND VPWR VPWR _023_ sky130_fd_sc_hd__inv_2
XFILLER_55_55 VGND VGND VPWR VPWR sky130_fd_sc_hd__fill_1
XFILLER_205_417 VPWR VGND VPWR VGND sky130_ef_sc_hd__decap_12
XFILLER_166_1317 VPWR VGND VPWR VGND sky130_ef_sc_hd__decap_12
XFILLER_245_597 VPWR VGND VPWR VGND sky130_ef_sc_hd__decap_12
XFILLER_246_1341 VPWR VGND VPWR VGND sky130_ef_sc_hd__decap_12
X_472_ _155_ _242_ net246 VGND VGND VPWR VPWR _243_ sky130_fd_sc_hd__a21oi_1
XTAP_TAPCELL_ROW_222_2890 VGND VPWR sky130_fd_sc_hd__tapvpwrvgnd_1
XFILLER_214_973 VGND VGND VPWR VPWR sky130_fd_sc_hd__decap_6
XFILLER_242_1205 VPWR VGND VPWR VGND sky130_ef_sc_hd__decap_12
XFILLER_207_1325 VPWR VGND VPWR VGND sky130_ef_sc_hd__decap_12
XFILLER_246_1385 VPWR VGND VPWR VGND sky130_ef_sc_hd__decap_12
XFILLER_213_461 VPWR VGND VPWR VGND sky130_ef_sc_hd__decap_12
XFILLER_186_825 VPWR VGND VPWR VGND sky130_ef_sc_hd__decap_12
XFILLER_207_1369 VPWR VGND VPWR VGND sky130_ef_sc_hd__decap_12
XFILLER_185_335 VGND VGND VPWR VPWR sky130_fd_sc_hd__fill_1
XFILLER_200_133 VGND VGND VPWR VPWR sky130_fd_sc_hd__decap_6
XFILLER_90_1271 VPWR VGND VPWR VGND sky130_ef_sc_hd__decap_12
XFILLER_186_869 VPWR VGND VPWR VGND sky130_ef_sc_hd__decap_12
XFILLER_51_1255 VPWR VGND VPWR VGND sky130_ef_sc_hd__decap_12
XFILLER_103_1323 VGND VGND VPWR VPWR sky130_fd_sc_hd__decap_6
XFILLER_200_177 VPWR VGND VPWR VGND sky130_ef_sc_hd__decap_12
XFILLER_142_1383 VPWR VGND VPWR VGND sky130_ef_sc_hd__decap_12
XFILLER_12_1239 VGND VGND VPWR VPWR sky130_fd_sc_hd__decap_6
XFILLER_177_1413 VPWR VGND VPWR VGND sky130_ef_sc_hd__decap_12
XFILLER_51_1299 VPWR VGND VPWR VGND sky130_ef_sc_hd__decap_12
XPHY_EDGE_ROW_26_1_Right_682 VGND VGND VPWR VPWR sky130_fd_sc_hd__decap_3
XFILLER_103_1367 VPWR VGND VPWR VGND sky130_ef_sc_hd__decap_12
XFILLER_181_541 VPWR VGND VPWR VGND sky130_ef_sc_hd__decap_12
XFILLER_5_754 VGND VGND VPWR VPWR sky130_fd_sc_hd__fill_2
XFILLER_177_1457 VPWR VGND VPWR VGND sky130_ef_sc_hd__decap_12
XFILLER_253_1301 VPWR VGND VPWR VGND sky130_ef_sc_hd__decap_12
XFILLER_4_264 VGND VGND VPWR VPWR sky130_fd_sc_hd__fill_1
XFILLER_181_585 VPWR VGND VPWR VGND sky130_ef_sc_hd__decap_12
XFILLER_218_1421 VGND VGND VPWR VPWR sky130_fd_sc_hd__decap_6
XFILLER_171_1001 VGND VGND VPWR VPWR sky130_fd_sc_hd__decap_6
XFILLER_253_1345 VPWR VGND VPWR VGND sky130_ef_sc_hd__decap_12
XFILLER_218_1465 VPWR VGND VPWR VGND sky130_ef_sc_hd__decap_12
XFILLER_171_1045 VPWR VGND VPWR VGND sky130_ef_sc_hd__decap_12
XFILLER_214_1329 VPWR VGND VPWR VGND sky130_ef_sc_hd__decap_12
XFILLER_136_1165 VPWR VGND VPWR VGND sky130_ef_sc_hd__decap_12
XFILLER_62_1351 VGND VGND VPWR VPWR sky130_fd_sc_hd__decap_6
XFILLER_171_1089 VPWR VGND VPWR VGND sky130_ef_sc_hd__decap_12
XFILLER_62_1395 VPWR VGND VPWR VGND sky130_ef_sc_hd__decap_12
XFILLER_114_1463 VGND VGND VPWR VPWR sky130_fd_sc_hd__decap_6
XFILLER_236_531 VGND VGND VPWR VPWR sky130_fd_sc_hd__fill_1
XFILLER_222_27 VGND VGND VPWR VPWR sky130_fd_sc_hd__fill_1
XFILLER_208_233 VPWR VGND VPWR VGND sky130_ef_sc_hd__decap_12
XTAP_TAPCELL_ROW_66_2_4148 VGND VPWR sky130_fd_sc_hd__tapvpwrvgnd_1
XFILLER_23_1379 VGND VGND VPWR VPWR sky130_fd_sc_hd__decap_6
XFILLER_110_1327 VPWR VGND VPWR VGND sky130_ef_sc_hd__decap_12
XFILLER_208_277 VPWR VGND VPWR VGND sky130_ef_sc_hd__decap_12
XFILLER_224_737 VPWR VGND VPWR VGND sky130_ef_sc_hd__decap_12
XFILLER_223_225 VPWR VGND VPWR VGND sky130_ef_sc_hd__decap_12
XFILLER_1_1175 VGND VGND VPWR VPWR sky130_fd_sc_hd__fill_1
XFILLER_205_951 VGND VGND VPWR VPWR sky130_fd_sc_hd__fill_1
XFILLER_189_641 VPWR VGND VPWR VGND sky130_ef_sc_hd__decap_12
XFILLER_182_1141 VGND VGND VPWR VPWR sky130_fd_sc_hd__decap_6
XFILLER_225_1425 VPWR VGND VPWR VGND sky130_ef_sc_hd__decap_12
XFILLER_232_781 VPWR VGND VPWR VGND sky130_ef_sc_hd__decap_12
XFILLER_91_3 VPWR VGND VPWR VGND sky130_ef_sc_hd__decap_12
XFILLER_56_1177 VPWR VGND VPWR VGND sky130_ef_sc_hd__decap_12
XFILLER_189_685 VPWR VGND VPWR VGND sky130_ef_sc_hd__decap_12
XFILLER_108_1245 VGND VGND VPWR VPWR sky130_fd_sc_hd__fill_1
XFILLER_225_1469 VPWR VGND VPWR VGND sky130_ef_sc_hd__decap_12
XFILLER_182_1185 VPWR VGND VPWR VGND sky130_ef_sc_hd__decap_12
XFILLER_188_195 VGND VGND VPWR VPWR sky130_fd_sc_hd__fill_1
XFILLER_73_1491 VGND VGND VPWR VPWR sky130_fd_sc_hd__decap_6
XFILLER_176_357 VGND VGND VPWR VPWR sky130_fd_sc_hd__decap_6
XFILLER_121_1423 VPWR VGND VPWR VGND sky130_ef_sc_hd__decap_12
XFILLER_191_305 VPWR VGND VPWR VGND sky130_ef_sc_hd__decap_12
XFILLER_160_1483 VPWR VGND VPWR VGND sky130_ef_sc_hd__decap_12
XFILLER_30_1339 VPWR VGND VPWR VGND sky130_ef_sc_hd__decap_12
XFILLER_195_1513 VGND VGND VPWR VPWR sky130_fd_sc_hd__fill_2
XFILLER_247_57 VPWR VGND VPWR VGND sky130_ef_sc_hd__decap_12
XFILLER_121_1467 VPWR VGND VPWR VGND sky130_ef_sc_hd__decap_12
XFILLER_191_349 VPWR VGND VPWR VGND sky130_ef_sc_hd__decap_12
XFILLER_67_1273 VGND VGND VPWR VPWR sky130_fd_sc_hd__fill_1
XFILLER_193_1281 VGND VGND VPWR VPWR sky130_fd_sc_hd__decap_6
XFILLER_8_1329 VPWR VGND VPWR VGND sky130_ef_sc_hd__decap_12
XFILLER_232_1429 VPWR VGND VPWR VGND sky130_ef_sc_hd__decap_12
XFILLER_119_1385 VGND VGND VPWR VPWR sky130_fd_sc_hd__fill_1
XTAP_TAPCELL_ROW_163_2_4732 VGND VPWR sky130_fd_sc_hd__tapvpwrvgnd_1
XTAP_TAPCELL_ROW_241_3400 VGND VPWR sky130_fd_sc_hd__tapvpwrvgnd_1
XFILLER_80_1451 VPWR VGND VPWR VGND sky130_ef_sc_hd__decap_12
XFILLER_41_1435 VGND VGND VPWR VPWR sky130_fd_sc_hd__decap_6
XFILLER_239_391 VGND VGND VPWR VPWR sky130_fd_sc_hd__fill_1
XFILLER_80_1495 VPWR VGND VPWR VGND sky130_ef_sc_hd__decap_12
XFILLER_132_27 VGND VGND VPWR VPWR sky130_fd_sc_hd__fill_1
XFILLER_41_1479 VPWR VGND VPWR VGND sky130_ef_sc_hd__decap_12
XFILLER_227_553 VGND VGND VPWR VPWR sky130_fd_sc_hd__decap_6
XFILLER_230_1197 VGND VGND VPWR VPWR sky130_fd_sc_hd__decap_6
XFILLER_242_501 VPWR VGND VPWR VGND sky130_ef_sc_hd__decap_12
XFILLER_187_1063 VGND VGND VPWR VPWR sky130_fd_sc_hd__fill_1
XFILLER_199_405 VPWR VGND VPWR VGND sky130_ef_sc_hd__decap_12
XFILLER_227_597 VPWR VGND VPWR VGND sky130_ef_sc_hd__decap_12
XFILLER_242_545 VPWR VGND VPWR VGND sky130_ef_sc_hd__decap_12
XTAP_TAPCELL_ROW_239_3340 VGND VPWR sky130_fd_sc_hd__tapvpwrvgnd_1
XFILLER_39_1331 VPWR VGND VPWR VGND sky130_ef_sc_hd__decap_12
XFILLER_25_36 VPWR VGND VPWR VGND sky130_ef_sc_hd__decap_12
XFILLER_199_449 VPWR VGND VPWR VGND sky130_ef_sc_hd__decap_12
XTAP_TAPCELL_ROW_239_3351 VGND VPWR sky130_fd_sc_hd__tapvpwrvgnd_1
XFILLER_242_589 VPWR VGND VPWR VGND sky130_ef_sc_hd__decap_12
XFILLER_126_1301 VGND VGND VPWR VPWR sky130_fd_sc_hd__fill_1
XFILLER_211_921 VPWR VGND VPWR VGND sky130_ef_sc_hd__decap_12
XTAP_TAPCELL_ROW_235_3226 VGND VPWR sky130_fd_sc_hd__tapvpwrvgnd_1
XFILLER_35_1217 VGND VGND VPWR VPWR sky130_fd_sc_hd__fill_1
XFILLER_168_825 VPWR VGND VPWR VGND sky130_ef_sc_hd__decap_12
XFILLER_228_1093 VPWR VGND VPWR VGND sky130_ef_sc_hd__decap_12
XTAP_TAPCELL_ROW_235_3237 VGND VPWR sky130_fd_sc_hd__tapvpwrvgnd_1
XFILLER_204_1509 VGND VGND VPWR VPWR sky130_fd_sc_hd__decap_6
XFILLER_211_965 VPWR VGND VPWR VGND sky130_ef_sc_hd__decap_12
XFILLER_167_335 VGND VGND VPWR VPWR sky130_fd_sc_hd__fill_1
XFILLER_194_121 VPWR VGND VPWR VGND sky130_ef_sc_hd__decap_12
XFILLER_168_869 VPWR VGND VPWR VGND sky130_ef_sc_hd__decap_12
XFILLER_210_475 VGND VGND VPWR VPWR sky130_fd_sc_hd__fill_1
XFILLER_194_165 VPWR VGND VPWR VGND sky130_ef_sc_hd__decap_12
XFILLER_41_57 VGND VGND VPWR VPWR sky130_fd_sc_hd__decap_4
XFILLER_183_839 VGND VGND VPWR VPWR sky130_fd_sc_hd__fill_1
XFILLER_100_1507 VGND VGND VPWR VPWR sky130_fd_sc_hd__decap_8
XFILLER_157_57 VPWR VGND VPWR VGND sky130_ef_sc_hd__decap_12
XFILLER_159_1165 VPWR VGND VPWR VGND sky130_ef_sc_hd__decap_12
XTAP_TAPCELL_ROW_211_2580 VGND VPWR sky130_fd_sc_hd__tapvpwrvgnd_1
XFILLER_2_757 VPWR VGND VPWR VGND sky130_ef_sc_hd__decap_12
XFILLER_137_1441 VGND VGND VPWR VPWR sky130_fd_sc_hd__fill_1
XTAP_TAPCELL_ROW_211_2591 VGND VPWR sky130_fd_sc_hd__tapvpwrvgnd_1
XFILLER_249_111 VGND VGND VPWR VPWR sky130_fd_sc_hd__fill_1
XFILLER_46_1357 VGND VGND VPWR VPWR sky130_fd_sc_hd__fill_1
XFILLER_1_267 VPWR VGND VPWR VGND sky130_ef_sc_hd__decap_12
XFILLER_172_1365 VGND VGND VPWR VPWR sky130_fd_sc_hd__decap_6
XFILLER_2_29 VPWR VGND VPWR VGND sky130_ef_sc_hd__decap_12
XFILLER_237_317 VPWR VGND VPWR VGND sky130_ef_sc_hd__decap_12
XTAP_TAPCELL_ROW_52_2_4067 VGND VPWR sky130_fd_sc_hd__tapvpwrvgnd_1
XFILLER_218_531 VGND VGND VPWR VPWR sky130_fd_sc_hd__fill_1
XFILLER_66_65 VGND VGND VPWR VPWR sky130_fd_sc_hd__decap_6
XTAP_TAPCELL_ROW_224_2930 VGND VPWR sky130_fd_sc_hd__tapvpwrvgnd_1
XTAP_TAPCELL_ROW_224_2941 VGND VPWR sky130_fd_sc_hd__tapvpwrvgnd_1
XFILLER_252_309 VPWR VGND VPWR VGND sky130_ef_sc_hd__decap_12
XFILLER_245_361 VPWR VGND VPWR VGND sky130_ef_sc_hd__decap_12
XTAP_TAPCELL_ROW_220_2816 VGND VPWR sky130_fd_sc_hd__tapvpwrvgnd_1
XFILLER_206_737 VPWR VGND VPWR VGND sky130_ef_sc_hd__decap_12
XTAP_TAPCELL_ROW_220_2827 VGND VPWR sky130_fd_sc_hd__tapvpwrvgnd_1
XFILLER_79_1177 VPWR VGND VPWR VGND sky130_ef_sc_hd__decap_12
XFILLER_205_225 VPWR VGND VPWR VGND sky130_ef_sc_hd__decap_12
XTAP_TAPCELL_ROW_220_2838 VGND VPWR sky130_fd_sc_hd__tapvpwrvgnd_1
X_524_ net664 VGND VGND VPWR VPWR _006_ sky130_fd_sc_hd__inv_2
XFILLER_166_1147 VGND VGND VPWR VPWR sky130_fd_sc_hd__fill_1
XFILLER_82_53 VPWR VGND VPWR VGND sky130_ef_sc_hd__decap_12
XPHY_EDGE_ROW_12_2_Left_514 VGND VGND VPWR VPWR sky130_fd_sc_hd__decap_3
XFILLER_221_729 VPWR VGND VPWR VGND sky130_ef_sc_hd__decap_12
X_455_ net614 net639 net623 VGND VGND VPWR VPWR addr0\[1\] sky130_fd_sc_hd__mux2_1
XFILLER_18_1415 VPWR VGND VPWR VGND sky130_ef_sc_hd__decap_12
XFILLER_207_1133 VPWR VGND VPWR VGND sky130_ef_sc_hd__decap_12
XFILLER_214_781 VPWR VGND VPWR VGND sky130_ef_sc_hd__decap_12
XFILLER_198_53 VPWR VGND VPWR VGND sky130_ef_sc_hd__decap_12
XTAP_TAPCELL_ROW_197_2196 VGND VPWR sky130_fd_sc_hd__tapvpwrvgnd_1
XFILLER_242_1035 VGND VGND VPWR VPWR sky130_fd_sc_hd__fill_1
XFILLER_57_1497 VGND VGND VPWR VPWR sky130_fd_sc_hd__fill_1
XTAP_TAPCELL_ROW_30_2_3937 VGND VPWR sky130_fd_sc_hd__tapvpwrvgnd_1
XFILLER_9_312 VGND VGND VPWR VPWR sky130_fd_sc_hd__decap_4
X_386_ net216 net215 net212 net211 VGND VGND VPWR VPWR _175_ sky130_fd_sc_hd__or4_1
XFILLER_207_1177 VPWR VGND VPWR VGND sky130_ef_sc_hd__decap_12
XFILLER_198_97 VPWR VGND VPWR VGND sky130_ef_sc_hd__decap_12
XTAP_TAPCELL_ROW_218_2767 VGND VPWR sky130_fd_sc_hd__tapvpwrvgnd_1
XFILLER_173_305 VPWR VGND VPWR VGND sky130_ef_sc_hd__decap_12
XTAP_TAPCELL_ROW_218_2778 VGND VPWR sky130_fd_sc_hd__tapvpwrvgnd_1
XFILLER_186_699 VGND VGND VPWR VPWR sky130_fd_sc_hd__fill_1
XFILLER_201_497 VGND VGND VPWR VPWR sky130_fd_sc_hd__decap_6
XFILLER_9_389 VGND VGND VPWR VPWR sky130_fd_sc_hd__decap_3
XFILLER_142_1191 VPWR VGND VPWR VGND sky130_ef_sc_hd__decap_12
XFILLER_173_349 VPWR VGND VPWR VGND sky130_ef_sc_hd__decap_12
XTAP_TAPCELL_ROW_10_2_3813 VGND VPWR sky130_fd_sc_hd__tapvpwrvgnd_1
XFILLER_182_861 VGND VGND VPWR VPWR sky130_fd_sc_hd__decap_6
XPHY_EDGE_ROW_27_1_Right_683 VGND VGND VPWR VPWR sky130_fd_sc_hd__decap_3
XFILLER_217_27 VPWR VGND VPWR VGND sky130_ef_sc_hd__decap_12
XFILLER_255_1429 VPWR VGND VPWR VGND sky130_ef_sc_hd__decap_12
XFILLER_138_1227 VPWR VGND VPWR VGND sky130_ef_sc_hd__decap_12
XFILLER_29_1511 VGND VGND VPWR VPWR sky130_fd_sc_hd__decap_4
XFILLER_177_1287 VGND VGND VPWR VPWR sky130_fd_sc_hd__fill_1
XFILLER_181_393 VPWR VGND VPWR VGND sky130_ef_sc_hd__decap_12
XFILLER_64_1413 VGND VGND VPWR VPWR sky130_fd_sc_hd__fill_1
XFILLER_190_1421 VGND VGND VPWR VPWR sky130_fd_sc_hd__decap_6
XTAP_TAPCELL_ROW_148_2_4645 VGND VPWR sky130_fd_sc_hd__tapvpwrvgnd_1
XFILLER_218_1273 VPWR VGND VPWR VGND sky130_ef_sc_hd__decap_12
XFILLER_253_1175 VGND VGND VPWR VPWR sky130_fd_sc_hd__fill_1
XFILLER_190_1465 VPWR VGND VPWR VGND sky130_ef_sc_hd__decap_12
XFILLER_233_15 VPWR VGND VPWR VGND sky130_ef_sc_hd__decap_12
XFILLER_255_125 VPWR VGND VPWR VGND sky130_ef_sc_hd__decap_12
XTAP_TAPCELL_ROW_128_2_4521 VGND VPWR sky130_fd_sc_hd__tapvpwrvgnd_1
XFILLER_114_1271 VPWR VGND VPWR VGND sky130_ef_sc_hd__decap_12
XFILLER_209_553 VGND VGND VPWR VPWR sky130_fd_sc_hd__decap_6
XFILLER_255_169 VPWR VGND VPWR VGND sky130_ef_sc_hd__decap_12
XFILLER_23_1165 VPWR VGND VPWR VGND sky130_ef_sc_hd__decap_12
XFILLER_224_501 VPWR VGND VPWR VGND sky130_ef_sc_hd__decap_12
XFILLER_237_895 VGND VGND VPWR VPWR sky130_fd_sc_hd__fill_1
XFILLER_97_1255 VPWR VGND VPWR VGND sky130_ef_sc_hd__decap_12
XFILLER_149_1323 VGND VGND VPWR VPWR sky130_fd_sc_hd__decap_6
XTAP_TAPCELL_ROW_182_1786 VGND VPWR sky130_fd_sc_hd__tapvpwrvgnd_1
XFILLER_184_1203 VGND VGND VPWR VPWR sky130_fd_sc_hd__fill_1
XFILLER_209_597 VPWR VGND VPWR VGND sky130_ef_sc_hd__decap_12
XTAP_TAPCELL_ROW_182_1797 VGND VPWR sky130_fd_sc_hd__tapvpwrvgnd_1
XTAP_TAPCELL_ROW_96_2_4332 VGND VPWR sky130_fd_sc_hd__tapvpwrvgnd_1
XFILLER_58_1239 VGND VGND VPWR VPWR sky130_fd_sc_hd__decap_6
XFILLER_224_545 VPWR VGND VPWR VGND sky130_ef_sc_hd__decap_12
XFILLER_97_1299 VPWR VGND VPWR VGND sky130_ef_sc_hd__decap_12
XFILLER_149_1367 VPWR VGND VPWR VGND sky130_ef_sc_hd__decap_12
XFILLER_197_909 VPWR VGND VPWR VGND sky130_ef_sc_hd__decap_12
XFILLER_224_589 VPWR VGND VPWR VGND sky130_ef_sc_hd__decap_12
XFILLER_196_419 VGND VGND VPWR VPWR sky130_fd_sc_hd__fill_1
XFILLER_211_217 VGND VGND VPWR VPWR sky130_fd_sc_hd__decap_6
XFILLER_225_1233 VPWR VGND VPWR VGND sky130_ef_sc_hd__decap_12
XPHY_EDGE_ROW_69_2_Left_571 VGND VGND VPWR VPWR sky130_fd_sc_hd__decap_3
XFILLER_176_121 VPWR VGND VPWR VGND sky130_ef_sc_hd__decap_12
XFILLER_221_1119 VGND VGND VPWR VPWR sky130_fd_sc_hd__fill_1
XPHY_EDGE_ROW_4_Left_260 VGND VGND VPWR VPWR sky130_fd_sc_hd__decap_3
XFILLER_176_165 VPWR VGND VPWR VGND sky130_ef_sc_hd__decap_12
XTAP_TAPCELL_ROW_230_3101 VGND VPWR sky130_fd_sc_hd__tapvpwrvgnd_1
XFILLER_192_625 VPWR VGND VPWR VGND sky130_ef_sc_hd__decap_12
XFILLER_34_1283 VPWR VGND VPWR VGND sky130_ef_sc_hd__decap_12
XFILLER_121_1231 VPWR VGND VPWR VGND sky130_ef_sc_hd__decap_12
XFILLER_191_113 VPWR VGND VPWR VGND sky130_ef_sc_hd__decap_12
XFILLER_178_1029 VGND VGND VPWR VPWR sky130_fd_sc_hd__decap_6
XFILLER_11_27 VPWR VGND VPWR VGND sky130_ef_sc_hd__decap_12
XFILLER_192_669 VPWR VGND VPWR VGND sky130_ef_sc_hd__decap_12
XFILLER_121_1275 VPWR VGND VPWR VGND sky130_ef_sc_hd__decap_12
XFILLER_195_1343 VGND VGND VPWR VPWR sky130_fd_sc_hd__fill_1
XFILLER_127_27 VPWR VGND VPWR VGND sky130_ef_sc_hd__decap_12
XFILLER_69_1379 VGND VGND VPWR VPWR sky130_fd_sc_hd__decap_6
XFILLER_156_1327 VPWR VGND VPWR VGND sky130_ef_sc_hd__decap_12
XTAP_TAPCELL_ROW_228_3030 VGND VPWR sky130_fd_sc_hd__tapvpwrvgnd_1
XTAP_TAPCELL_ROW_228_3041 VGND VPWR sky130_fd_sc_hd__tapvpwrvgnd_1
XFILLER_236_1373 VPWR VGND VPWR VGND sky130_ef_sc_hd__decap_12
XTAP_TAPCELL_ROW_228_3052 VGND VPWR sky130_fd_sc_hd__tapvpwrvgnd_1
XFILLER_143_15 VPWR VGND VPWR VGND sky130_ef_sc_hd__decap_12
XFILLER_207_93 VPWR VGND VPWR VGND sky130_ef_sc_hd__decap_12
XTAP_TAPCELL_ROW_9_1110 VGND VPWR sky130_fd_sc_hd__tapvpwrvgnd_1
XFILLER_247_615 VGND VGND VPWR VPWR sky130_fd_sc_hd__fill_1
XTAP_TAPCELL_ROW_9_1121 VGND VPWR sky130_fd_sc_hd__tapvpwrvgnd_1
XTAP_TAPCELL_ROW_9_1132 VGND VPWR sky130_fd_sc_hd__tapvpwrvgnd_1
XFILLER_219_317 VPWR VGND VPWR VGND sky130_ef_sc_hd__decap_12
XFILLER_232_1259 VGND VGND VPWR VPWR sky130_fd_sc_hd__fill_1
XTAP_TAPCELL_ROW_23_2_3891 VGND VPWR sky130_fd_sc_hd__tapvpwrvgnd_1
XTAP_TAPCELL_ROW_9_1143 VGND VPWR sky130_fd_sc_hd__tapvpwrvgnd_1
XFILLER_41_1243 VPWR VGND VPWR VGND sky130_ef_sc_hd__decap_12
XTAP_TAPCELL_ROW_5_1007 VGND VPWR sky130_fd_sc_hd__tapvpwrvgnd_1
XFILLER_132_1371 VPWR VGND VPWR VGND sky130_ef_sc_hd__decap_12
XFILLER_234_309 VPWR VGND VPWR VGND sky130_ef_sc_hd__decap_12
XFILLER_189_1169 VGND VGND VPWR VPWR sky130_fd_sc_hd__decap_6
XFILLER_167_1401 VPWR VGND VPWR VGND sky130_ef_sc_hd__decap_12
XFILLER_223_81 VPWR VGND VPWR VGND sky130_ef_sc_hd__decap_12
XFILLER_227_361 VPWR VGND VPWR VGND sky130_ef_sc_hd__decap_12
XFILLER_243_821 VPWR VGND VPWR VGND sky130_ef_sc_hd__decap_12
XFILLER_41_1287 VPWR VGND VPWR VGND sky130_ef_sc_hd__decap_12
XPHY_EDGE_ROW_135_1_Left_390 VGND VGND VPWR VPWR sky130_fd_sc_hd__decap_3
XTAP_TAPCELL_ROW_55_1_1190 VGND VPWR sky130_fd_sc_hd__tapvpwrvgnd_1
XFILLER_243_865 VPWR VGND VPWR VGND sky130_ef_sc_hd__decap_12
XFILLER_76_1339 VPWR VGND VPWR VGND sky130_ef_sc_hd__decap_12
XFILLER_128_1407 VGND VGND VPWR VPWR sky130_fd_sc_hd__decap_6
XFILLER_203_729 VPWR VGND VPWR VGND sky130_ef_sc_hd__decap_12
XPHY_EDGE_ROW_204_Right_49 VGND VGND VPWR VPWR sky130_fd_sc_hd__decap_3
XFILLER_199_279 VGND VGND VPWR VPWR sky130_fd_sc_hd__fill_1
XFILLER_208_1453 VPWR VGND VPWR VGND sky130_ef_sc_hd__decap_12
XTAP_TAPCELL_ROW_200_2281 VGND VPWR sky130_fd_sc_hd__tapvpwrvgnd_1
XTAP_TAPCELL_ROW_200_2292 VGND VPWR sky130_fd_sc_hd__tapvpwrvgnd_1
XFILLER_204_1317 VPWR VGND VPWR VGND sky130_ef_sc_hd__decap_12
XFILLER_208_1497 VPWR VGND VPWR VGND sky130_ef_sc_hd__decap_12
XFILLER_195_441 VGND VGND VPWR VPWR sky130_fd_sc_hd__decap_6
XFILLER_243_1399 VGND VGND VPWR VPWR sky130_fd_sc_hd__fill_1
XFILLER_139_3 VPWR VGND VPWR VGND sky130_ef_sc_hd__decap_12
XTAP_TAPCELL_ROW_192_2060 VGND VPWR sky130_fd_sc_hd__tapvpwrvgnd_1
XFILLER_168_699 VGND VGND VPWR VPWR sky130_fd_sc_hd__fill_1
XTAP_TAPCELL_ROW_192_2071 VGND VPWR sky130_fd_sc_hd__tapvpwrvgnd_1
XFILLER_195_485 VPWR VGND VPWR VGND sky130_ef_sc_hd__decap_12
XFILLER_13_1323 VGND VGND VPWR VPWR sky130_fd_sc_hd__decap_6
XTAP_TAPCELL_ROW_192_2082 VGND VPWR sky130_fd_sc_hd__tapvpwrvgnd_1
XFILLER_52_1383 VPWR VGND VPWR VGND sky130_ef_sc_hd__decap_12
XTAP_TAPCELL_ROW_154_2_4677 VGND VPWR sky130_fd_sc_hd__tapvpwrvgnd_1
XFILLER_104_1451 VPWR VGND VPWR VGND sky130_ef_sc_hd__decap_12
XPHY_EDGE_ROW_154_1_Left_409 VGND VGND VPWR VPWR sky130_fd_sc_hd__decap_3
XFILLER_196_1129 VPWR VGND VPWR VGND sky130_ef_sc_hd__decap_12
XFILLER_171_809 VPWR VGND VPWR VGND sky130_ef_sc_hd__decap_12
XFILLER_13_1367 VPWR VGND VPWR VGND sky130_ef_sc_hd__decap_12
XFILLER_100_1315 VPWR VGND VPWR VGND sky130_ef_sc_hd__decap_12
XTAP_TAPCELL_ROW_213_2631 VGND VPWR sky130_fd_sc_hd__tapvpwrvgnd_1
XFILLER_104_1495 VPWR VGND VPWR VGND sky130_ef_sc_hd__decap_12
XFILLER_202_1085 VGND VGND VPWR VPWR sky130_fd_sc_hd__decap_6
XTAP_TAPCELL_ROW_213_2642 VGND VPWR sky130_fd_sc_hd__tapvpwrvgnd_1
XFILLER_87_1435 VGND VGND VPWR VPWR sky130_fd_sc_hd__decap_6
XFILLER_100_1359 VPWR VGND VPWR VGND sky130_ef_sc_hd__decap_12
XFILLER_87_1479 VPWR VGND VPWR VGND sky130_ef_sc_hd__decap_12
XFILLER_174_1427 VGND VGND VPWR VPWR sky130_fd_sc_hd__fill_1
XFILLER_184_77 VGND VGND VPWR VPWR sky130_fd_sc_hd__decap_6
XPHY_EDGE_ROW_213_Right_58 VGND VGND VPWR VPWR sky130_fd_sc_hd__decap_3
Xsram0_683 VGND VGND VPWR VPWR net683 sram0_683/LO sky130_fd_sc_hd__conb_1
XFILLER_215_1413 VPWR VGND VPWR VGND sky130_ef_sc_hd__decap_12
XFILLER_250_1315 VGND VGND VPWR VPWR sky130_fd_sc_hd__fill_1
XFILLER_46_1165 VPWR VGND VPWR VGND sky130_ef_sc_hd__decap_12
XFILLER_172_1173 VPWR VGND VPWR VGND sky130_ef_sc_hd__decap_12
XFILLER_215_1457 VPWR VGND VPWR VGND sky130_ef_sc_hd__decap_12
XFILLER_238_637 VGND VGND VPWR VPWR sky130_fd_sc_hd__decap_6
XTAP_TAPCELL_ROW_114_2_4440 VGND VPWR sky130_fd_sc_hd__tapvpwrvgnd_1
XFILLER_237_125 VPWR VGND VPWR VGND sky130_ef_sc_hd__decap_12
XPHY_EDGE_ROW_90_2_Right_181 VGND VGND VPWR VPWR sky130_fd_sc_hd__decap_3
XFILLER_24_1463 VGND VGND VPWR VPWR sky130_fd_sc_hd__decap_6
XFILLER_111_1411 VPWR VGND VPWR VGND sky130_ef_sc_hd__decap_12
XFILLER_150_1471 VPWR VGND VPWR VGND sky130_ef_sc_hd__decap_12
XTAP_TAPCELL_ROW_207_2468 VGND VPWR sky130_fd_sc_hd__tapvpwrvgnd_1
XFILLER_237_169 VPWR VGND VPWR VGND sky130_ef_sc_hd__decap_12
XFILLER_253_629 VPWR VGND VPWR VGND sky130_ef_sc_hd__decap_12
XFILLER_206_501 VPWR VGND VPWR VGND sky130_ef_sc_hd__decap_12
XTAP_TAPCELL_ROW_207_2479 VGND VPWR sky130_fd_sc_hd__tapvpwrvgnd_1
XFILLER_20_1327 VPWR VGND VPWR VGND sky130_ef_sc_hd__decap_12
XFILLER_219_895 VGND VGND VPWR VPWR sky130_fd_sc_hd__fill_1
XFILLER_246_681 VPWR VGND VPWR VGND sky130_ef_sc_hd__decap_12
XFILLER_111_1455 VPWR VGND VPWR VGND sky130_ef_sc_hd__decap_12
XFILLER_252_139 VGND VGND VPWR VPWR sky130_fd_sc_hd__fill_1
XTAP_TAPCELL_ROW_199_2247 VGND VPWR sky130_fd_sc_hd__tapvpwrvgnd_1
XFILLER_206_545 VPWR VGND VPWR VGND sky130_ef_sc_hd__decap_12
XTAP_TAPCELL_ROW_199_2258 VGND VPWR sky130_fd_sc_hd__tapvpwrvgnd_1
XFILLER_94_1439 VPWR VGND VPWR VGND sky130_ef_sc_hd__decap_12
XFILLER_111_1499 VPWR VGND VPWR VGND sky130_ef_sc_hd__decap_12
XFILLER_146_1507 VGND VGND VPWR VPWR sky130_fd_sc_hd__decap_8
XTAP_TAPCELL_ROW_199_2269 VGND VPWR sky130_fd_sc_hd__tapvpwrvgnd_1
XPHY_EDGE_ROW_222_Right_67 VGND VGND VPWR VPWR sky130_fd_sc_hd__decap_3
XFILLER_179_909 VPWR VGND VPWR VGND sky130_ef_sc_hd__decap_12
XFILLER_206_589 VPWR VGND VPWR VGND sky130_ef_sc_hd__decap_12
X_507_ net174 net91 VGND VGND VPWR VPWR acc_core.adder.cla_blocks\[6\].block.sum\[0\]
+ sky130_fd_sc_hd__xnor2_1
XFILLER_178_419 VGND VGND VPWR VPWR sky130_fd_sc_hd__fill_1
XFILLER_221_559 VGND VGND VPWR VPWR sky130_fd_sc_hd__fill_1
XFILLER_18_1245 VGND VGND VPWR VPWR sky130_fd_sc_hd__fill_1
X_438_ _225_ net189 VGND VGND VPWR VPWR _227_ sky130_fd_sc_hd__nor2_1
XFILLER_187_953 VPWR VGND VPWR VGND sky130_ef_sc_hd__decap_12
XFILLER_201_261 VPWR VGND VPWR VGND sky130_ef_sc_hd__decap_12
X_369_ net592 net576 net549 VGND VGND VPWR VPWR _158_ sky130_fd_sc_hd__nand3_1
XFILLER_174_625 VPWR VGND VPWR VGND sky130_ef_sc_hd__decap_12
XFILLER_31_1423 VPWR VGND VPWR VGND sky130_ef_sc_hd__decap_12
XFILLER_173_113 VPWR VGND VPWR VGND sky130_ef_sc_hd__decap_12
XFILLER_228_15 VPWR VGND VPWR VGND sky130_ef_sc_hd__decap_12
XFILLER_70_1483 VPWR VGND VPWR VGND sky130_ef_sc_hd__decap_12
XFILLER_220_1141 VGND VGND VPWR VPWR sky130_fd_sc_hd__decap_6
XFILLER_9_197 VPWR VGND VPWR VGND sky130_ef_sc_hd__decap_12
XFILLER_174_669 VPWR VGND VPWR VGND sky130_ef_sc_hd__decap_12
XFILLER_31_1467 VPWR VGND VPWR VGND sky130_ef_sc_hd__decap_12
XFILLER_220_1185 VPWR VGND VPWR VGND sky130_ef_sc_hd__decap_12
XPHY_EDGE_ROW_231_Right_76 VGND VGND VPWR VPWR sky130_fd_sc_hd__decap_3
XFILLER_54_3 VPWR VGND VPWR VGND sky130_ef_sc_hd__decap_12
XPHY_EDGE_ROW_28_1_Right_684 VGND VGND VPWR VPWR sky130_fd_sc_hd__decap_3
XTAP_TAPCELL_ROW_171_1498 VGND VPWR sky130_fd_sc_hd__tapvpwrvgnd_1
XFILLER_9_1413 VPWR VGND VPWR VGND sky130_ef_sc_hd__decap_12
XFILLER_233_1513 VGND VGND VPWR VPWR sky130_fd_sc_hd__fill_2
XTAP_TAPCELL_ROW_188_1951 VGND VPWR sky130_fd_sc_hd__tapvpwrvgnd_1
XTAP_TAPCELL_ROW_188_1962 VGND VPWR sky130_fd_sc_hd__tapvpwrvgnd_1
XFILLER_29_1385 VGND VGND VPWR VPWR sky130_fd_sc_hd__fill_1
XFILLER_9_1457 VPWR VGND VPWR VGND sky130_ef_sc_hd__decap_12
XFILLER_151_1213 VGND VGND VPWR VPWR sky130_fd_sc_hd__decap_4
XTAP_TAPCELL_ROW_188_1973 VGND VPWR sky130_fd_sc_hd__tapvpwrvgnd_1
XFILLER_229_615 VGND VGND VPWR VPWR sky130_fd_sc_hd__fill_1
XFILLER_190_1273 VPWR VGND VPWR VGND sky130_ef_sc_hd__decap_12
XTAP_TAPCELL_ROW_184_1848 VGND VPWR sky130_fd_sc_hd__tapvpwrvgnd_1
XTAP_TAPCELL_ROW_184_1859 VGND VPWR sky130_fd_sc_hd__tapvpwrvgnd_1
XFILLER_3_1001 VGND VGND VPWR VPWR sky130_fd_sc_hd__decap_6
XFILLER_216_309 VPWR VGND VPWR VGND sky130_ef_sc_hd__decap_12
XFILLER_231_1281 VGND VGND VPWR VPWR sky130_fd_sc_hd__decap_6
XFILLER_186_1309 VGND VGND VPWR VPWR sky130_fd_sc_hd__decap_6
XFILLER_209_361 VPWR VGND VPWR VGND sky130_ef_sc_hd__decap_12
XPHY_EDGE_ROW_240_Right_85 VGND VGND VPWR VPWR sky130_fd_sc_hd__decap_3
XFILLER_3_1045 VPWR VGND VPWR VGND sky130_ef_sc_hd__decap_12
XFILLER_225_821 VPWR VGND VPWR VGND sky130_ef_sc_hd__decap_12
XFILLER_3_1089 VPWR VGND VPWR VGND sky130_ef_sc_hd__decap_12
XFILLER_225_865 VPWR VGND VPWR VGND sky130_ef_sc_hd__decap_12
XFILLER_240_813 VPWR VGND VPWR VGND sky130_ef_sc_hd__decap_12
Xwire78 _253_ VGND VGND VPWR VPWR net78 sky130_fd_sc_hd__clkbuf_1
XFILLER_251_161 VGND VGND VPWR VPWR sky130_fd_sc_hd__decap_6
XFILLER_36_1301 VGND VGND VPWR VPWR sky130_fd_sc_hd__fill_1
XFILLER_225_1063 VGND VGND VPWR VPWR sky130_fd_sc_hd__fill_1
XFILLER_177_441 VGND VGND VPWR VPWR sky130_fd_sc_hd__decap_6
XFILLER_22_15 VPWR VGND VPWR VGND sky130_ef_sc_hd__decap_12
XTAP_TAPCELL_ROW_140_2_4596 VGND VPWR sky130_fd_sc_hd__tapvpwrvgnd_1
XFILLER_220_581 VGND VGND VPWR VPWR sky130_fd_sc_hd__decap_6
XFILLER_177_485 VPWR VGND VPWR VGND sky130_ef_sc_hd__decap_12
XFILLER_138_15 VPWR VGND VPWR VGND sky130_ef_sc_hd__decap_12
XFILLER_193_945 VGND VGND VPWR VPWR sky130_fd_sc_hd__decap_6
XFILLER_192_433 VPWR VGND VPWR VGND sky130_ef_sc_hd__decap_12
XFILLER_10_1507 VGND VGND VPWR VPWR sky130_fd_sc_hd__decap_8
XFILLER_165_669 VGND VGND VPWR VPWR sky130_fd_sc_hd__decap_3
XFILLER_197_1449 VGND VGND VPWR VPWR sky130_fd_sc_hd__decap_6
XFILLER_193_989 VPWR VGND VPWR VGND sky130_ef_sc_hd__decap_12
XFILLER_192_477 VPWR VGND VPWR VGND sky130_ef_sc_hd__decap_12
XTAP_TAPCELL_ROW_120_2_4472 VGND VPWR sky130_fd_sc_hd__tapvpwrvgnd_1
XFILLER_3_329 VGND VGND VPWR VPWR sky130_fd_sc_hd__fill_1
XTAP_TAPCELL_ROW_119_2_4466 VGND VPWR sky130_fd_sc_hd__tapvpwrvgnd_1
XFILLER_69_1165 VPWR VGND VPWR VGND sky130_ef_sc_hd__decap_12
XFILLER_47_1441 VGND VGND VPWR VPWR sky130_fd_sc_hd__fill_1
XTAP_TAPCELL_ROW_87_2_4277 VGND VPWR sky130_fd_sc_hd__tapvpwrvgnd_1
XFILLER_173_1493 VPWR VGND VPWR VGND sky130_ef_sc_hd__decap_12
XFILLER_219_125 VPWR VGND VPWR VGND sky130_ef_sc_hd__decap_12
XFILLER_248_979 VGND VGND VPWR VPWR sky130_fd_sc_hd__fill_1
XFILLER_219_169 VPWR VGND VPWR VGND sky130_ef_sc_hd__decap_12
XFILLER_235_629 VPWR VGND VPWR VGND sky130_ef_sc_hd__decap_12
XFILLER_228_681 VPWR VGND VPWR VGND sky130_ef_sc_hd__decap_12
XFILLER_210_1365 VGND VGND VPWR VPWR sky130_fd_sc_hd__decap_6
XFILLER_234_139 VGND VGND VPWR VPWR sky130_fd_sc_hd__fill_1
XFILLER_103_51 VGND VGND VPWR VPWR sky130_fd_sc_hd__decap_4
XFILLER_167_1231 VGND VGND VPWR VPWR sky130_fd_sc_hd__fill_1
XTAP_TAPCELL_ROW_202_2332 VGND VPWR sky130_fd_sc_hd__tapvpwrvgnd_1
XTAP_TAPCELL_ROW_202_2343 VGND VPWR sky130_fd_sc_hd__tapvpwrvgnd_1
XFILLER_243_673 VPWR VGND VPWR VGND sky130_ef_sc_hd__decap_12
XFILLER_128_1215 VPWR VGND VPWR VGND sky130_ef_sc_hd__decap_12
XPHY_EDGE_ROW_129_2_Right_220 VGND VGND VPWR VPWR sky130_fd_sc_hd__decap_3
XFILLER_230_301 VGND VGND VPWR VPWR sky130_fd_sc_hd__decap_6
XFILLER_63_55 VGND VGND VPWR VPWR sky130_fd_sc_hd__fill_1
XFILLER_187_205 VPWR VGND VPWR VGND sky130_ef_sc_hd__decap_12
XTAP_TAPCELL_ROW_163_1_1298 VGND VPWR sky130_fd_sc_hd__tapvpwrvgnd_1
XTAP_TAPCELL_ROW_194_2111 VGND VPWR sky130_fd_sc_hd__tapvpwrvgnd_1
XFILLER_128_1259 VPWR VGND VPWR VGND sky130_ef_sc_hd__decap_12
XTAP_TAPCELL_ROW_194_2122 VGND VPWR sky130_fd_sc_hd__tapvpwrvgnd_1
XFILLER_179_55 VGND VGND VPWR VPWR sky130_fd_sc_hd__fill_1
XTAP_TAPCELL_ROW_194_2133 VGND VPWR sky130_fd_sc_hd__tapvpwrvgnd_1
XFILLER_203_559 VGND VGND VPWR VPWR sky130_fd_sc_hd__fill_1
XFILLER_230_345 VPWR VGND VPWR VGND sky130_ef_sc_hd__decap_12
XFILLER_208_1261 VPWR VGND VPWR VGND sky130_ef_sc_hd__decap_12
XFILLER_169_953 VPWR VGND VPWR VGND sky130_ef_sc_hd__decap_12
XFILLER_187_249 VPWR VGND VPWR VGND sky130_ef_sc_hd__decap_12
XFILLER_180_1453 VPWR VGND VPWR VGND sky130_ef_sc_hd__decap_12
XTAP_TAPCELL_ROW_190_2008 VGND VPWR sky130_fd_sc_hd__tapvpwrvgnd_1
XFILLER_230_389 VPWR VGND VPWR VGND sky130_ef_sc_hd__decap_12
XTAP_TAPCELL_ROW_190_2019 VGND VPWR sky130_fd_sc_hd__tapvpwrvgnd_1
XFILLER_184_923 VGND VGND VPWR VPWR sky130_fd_sc_hd__fill_1
XFILLER_204_1147 VGND VGND VPWR VPWR sky130_fd_sc_hd__fill_1
XFILLER_180_1497 VPWR VGND VPWR VGND sky130_ef_sc_hd__decap_12
Xwire522 _083_ VGND VGND VPWR VPWR net522 sky130_fd_sc_hd__clkbuf_1
Xwire544 net47 VGND VGND VPWR VPWR net544 sky130_fd_sc_hd__clkbuf_1
XFILLER_195_293 VPWR VGND VPWR VGND sky130_ef_sc_hd__decap_12
Xwire555 net556 VGND VGND VPWR VPWR net555 sky130_fd_sc_hd__buf_1
XFILLER_52_1191 VPWR VGND VPWR VGND sky130_ef_sc_hd__decap_12
Xwire566 net54 VGND VGND VPWR VPWR net566 sky130_fd_sc_hd__clkbuf_1
Xwire577 dout0_q\[8\] VGND VGND VPWR VPWR net577 sky130_fd_sc_hd__clkbuf_1
XFILLER_7_679 VGND VGND VPWR VPWR sky130_fd_sc_hd__fill_1
Xwire588 dout0_q\[1\] VGND VGND VPWR VPWR net588 sky130_fd_sc_hd__clkbuf_1
XFILLER_171_617 VPWR VGND VPWR VGND sky130_ef_sc_hd__decap_12
Xwire599 net600 VGND VGND VPWR VPWR net599 sky130_fd_sc_hd__clkbuf_1
XFILLER_87_1243 VPWR VGND VPWR VGND sky130_ef_sc_hd__decap_12
XFILLER_139_1311 VPWR VGND VPWR VGND sky130_ef_sc_hd__decap_12
XFILLER_178_1371 VGND VGND VPWR VPWR sky130_fd_sc_hd__fill_1
XFILLER_48_1227 VPWR VGND VPWR VGND sky130_ef_sc_hd__decap_12
XFILLER_87_1287 VPWR VGND VPWR VGND sky130_ef_sc_hd__decap_12
XFILLER_88_41 VPWR VGND VPWR VGND sky130_ef_sc_hd__decap_12
XFILLER_139_1355 VPWR VGND VPWR VGND sky130_ef_sc_hd__decap_12
XFILLER_100_1189 VGND VGND VPWR VPWR sky130_fd_sc_hd__fill_1
XFILLER_135_1219 VPWR VGND VPWR VGND sky130_ef_sc_hd__decap_12
XFILLER_139_1399 VPWR VGND VPWR VGND sky130_ef_sc_hd__decap_12
XTAP_TAPCELL_ROW_209_2519 VGND VPWR sky130_fd_sc_hd__tapvpwrvgnd_1
XFILLER_238_401 VPWR VGND VPWR VGND sky130_ef_sc_hd__decap_12
XFILLER_238_445 VPWR VGND VPWR VGND sky130_ef_sc_hd__decap_12
XFILLER_215_1287 VGND VGND VPWR VPWR sky130_fd_sc_hd__fill_1
XFILLER_254_905 VPWR VGND VPWR VGND sky130_ef_sc_hd__decap_12
XPHY_EDGE_ROW_91_2_Right_182 VGND VGND VPWR VPWR sky130_fd_sc_hd__decap_3
XFILLER_238_489 VPWR VGND VPWR VGND sky130_ef_sc_hd__decap_12
XFILLER_24_1271 VPWR VGND VPWR VGND sky130_ef_sc_hd__decap_12
XFILLER_254_949 VPWR VGND VPWR VGND sky130_ef_sc_hd__decap_12
XFILLER_168_1017 VPWR VGND VPWR VGND sky130_ef_sc_hd__decap_12
XFILLER_207_821 VPWR VGND VPWR VGND sky130_ef_sc_hd__decap_12
XFILLER_4_1365 VGND VGND VPWR VPWR sky130_fd_sc_hd__decap_6
XFILLER_59_1323 VGND VGND VPWR VPWR sky130_fd_sc_hd__decap_6
XFILLER_94_1203 VPWR VGND VPWR VGND sky130_ef_sc_hd__decap_12
XFILLER_0_1229 VGND VGND VPWR VPWR sky130_fd_sc_hd__decap_3
XFILLER_98_1383 VPWR VGND VPWR VGND sky130_ef_sc_hd__decap_12
XFILLER_207_865 VPWR VGND VPWR VGND sky130_ef_sc_hd__decap_12
XFILLER_230_27 VGND VGND VPWR VPWR sky130_fd_sc_hd__fill_1
XFILLER_240_109 VPWR VGND VPWR VGND sky130_ef_sc_hd__decap_12
XFILLER_222_813 VPWR VGND VPWR VGND sky130_ef_sc_hd__decap_12
XFILLER_59_1367 VPWR VGND VPWR VGND sky130_ef_sc_hd__decap_12
XFILLER_94_1247 VPWR VGND VPWR VGND sky130_ef_sc_hd__decap_12
XFILLER_146_1315 VPWR VGND VPWR VGND sky130_ef_sc_hd__decap_12
XFILLER_248_1085 VGND VGND VPWR VPWR sky130_fd_sc_hd__decap_6
XFILLER_233_161 VGND VGND VPWR VPWR sky130_fd_sc_hd__decap_6
XFILLER_146_1359 VPWR VGND VPWR VGND sky130_ef_sc_hd__decap_12
XFILLER_222_1203 VGND VGND VPWR VPWR sky130_fd_sc_hd__fill_1
XTAP_TAPCELL_ROW_177_1652 VGND VPWR sky130_fd_sc_hd__tapvpwrvgnd_1
XTAP_TAPCELL_ROW_177_1663 VGND VPWR sky130_fd_sc_hd__tapvpwrvgnd_1
XFILLER_187_783 VGND VGND VPWR VPWR sky130_fd_sc_hd__fill_1
XFILLER_202_581 VGND VGND VPWR VPWR sky130_fd_sc_hd__decap_6
XTAP_TAPCELL_ROW_177_1674 VGND VPWR sky130_fd_sc_hd__tapvpwrvgnd_1
XFILLER_239_69 VPWR VGND VPWR VGND sky130_ef_sc_hd__decap_12
XFILLER_175_945 VGND VGND VPWR VPWR sky130_fd_sc_hd__decap_6
XFILLER_174_433 VPWR VGND VPWR VGND sky130_ef_sc_hd__decap_12
XFILLER_179_1113 VGND VGND VPWR VPWR sky130_fd_sc_hd__decap_6
XFILLER_31_1231 VPWR VGND VPWR VGND sky130_ef_sc_hd__decap_12
XTAP_TAPCELL_ROW_173_1549 VGND VPWR sky130_fd_sc_hd__tapvpwrvgnd_1
XFILLER_175_989 VPWR VGND VPWR VGND sky130_ef_sc_hd__decap_12
XTAP_TAPCELL_ROW_105_2_4385 VGND VPWR sky130_fd_sc_hd__tapvpwrvgnd_1
XFILLER_174_477 VPWR VGND VPWR VGND sky130_ef_sc_hd__decap_12
XFILLER_179_1157 VPWR VGND VPWR VGND sky130_ef_sc_hd__decap_12
XFILLER_190_937 VPWR VGND VPWR VGND sky130_ef_sc_hd__decap_12
XFILLER_31_1275 VPWR VGND VPWR VGND sky130_ef_sc_hd__decap_12
XFILLER_157_1411 VPWR VGND VPWR VGND sky130_ef_sc_hd__decap_12
XFILLER_108_29 VPWR VGND VPWR VGND sky130_ef_sc_hd__decap_12
XFILLER_255_57 VPWR VGND VPWR VGND sky130_ef_sc_hd__decap_12
XFILLER_66_1327 VPWR VGND VPWR VGND sky130_ef_sc_hd__decap_12
XFILLER_157_1455 VPWR VGND VPWR VGND sky130_ef_sc_hd__decap_12
XPHY_EDGE_ROW_219_Left_474 VGND VGND VPWR VPWR sky130_fd_sc_hd__decap_3
XPHY_EDGE_ROW_29_1_Right_685 VGND VGND VPWR VPWR sky130_fd_sc_hd__decap_3
XFILLER_216_1029 VGND VGND VPWR VPWR sky130_fd_sc_hd__decap_6
XFILLER_255_1089 VGND VGND VPWR VPWR sky130_fd_sc_hd__decap_3
XFILLER_118_1439 VPWR VGND VPWR VGND sky130_ef_sc_hd__decap_12
XFILLER_157_1499 VPWR VGND VPWR VGND sky130_ef_sc_hd__decap_12
XFILLER_248_209 VPWR VGND VPWR VGND sky130_ef_sc_hd__decap_12
XFILLER_233_1343 VGND VGND VPWR VPWR sky130_fd_sc_hd__fill_1
XTAP_TAPCELL_ROW_53_2_4072 VGND VPWR sky130_fd_sc_hd__tapvpwrvgnd_1
XFILLER_217_629 VPWR VGND VPWR VGND sky130_ef_sc_hd__decap_12
XFILLER_42_1371 VPWR VGND VPWR VGND sky130_ef_sc_hd__decap_12
XFILLER_17_15 VPWR VGND VPWR VGND sky130_ef_sc_hd__decap_12
XFILLER_186_1117 VPWR VGND VPWR VGND sky130_ef_sc_hd__decap_12
XFILLER_204_83 VGND VGND VPWR VPWR sky130_fd_sc_hd__fill_1
XFILLER_216_139 VGND VGND VPWR VPWR sky130_fd_sc_hd__fill_1
XTAP_TAPCELL_ROW_0_822 VGND VPWR sky130_fd_sc_hd__tapvpwrvgnd_1
XTAP_TAPCELL_ROW_0_833 VGND VPWR sky130_fd_sc_hd__tapvpwrvgnd_1
XFILLER_77_1423 VPWR VGND VPWR VGND sky130_ef_sc_hd__decap_12
XTAP_TAPCELL_ROW_0_844 VGND VPWR sky130_fd_sc_hd__tapvpwrvgnd_1
XFILLER_140_27 VGND VGND VPWR VPWR sky130_fd_sc_hd__fill_1
XTAP_TAPCELL_ROW_0_855 VGND VPWR sky130_fd_sc_hd__tapvpwrvgnd_1
XFILLER_38_1407 VGND VGND VPWR VPWR sky130_fd_sc_hd__decap_6
XTAP_TAPCELL_ROW_0_866 VGND VPWR sky130_fd_sc_hd__tapvpwrvgnd_1
XFILLER_225_673 VPWR VGND VPWR VGND sky130_ef_sc_hd__decap_12
XPHY_EDGE_ROW_228_Left_483 VGND VGND VPWR VPWR sky130_fd_sc_hd__decap_3
XFILLER_77_1467 VPWR VGND VPWR VGND sky130_ef_sc_hd__decap_12
XFILLER_164_1415 VPWR VGND VPWR VGND sky130_ef_sc_hd__decap_12
XFILLER_197_503 VGND VGND VPWR VPWR sky130_fd_sc_hd__fill_1
XFILLER_212_301 VGND VGND VPWR VPWR sky130_fd_sc_hd__decap_6
XFILLER_169_205 VPWR VGND VPWR VGND sky130_ef_sc_hd__decap_12
XFILLER_240_643 VGND VGND VPWR VPWR sky130_fd_sc_hd__fill_1
XFILLER_227_1169 VGND VGND VPWR VPWR sky130_fd_sc_hd__decap_6
XFILLER_205_1401 VPWR VGND VPWR VGND sky130_ef_sc_hd__decap_12
XFILLER_212_345 VPWR VGND VPWR VGND sky130_ef_sc_hd__decap_12
XFILLER_169_249 VPWR VGND VPWR VGND sky130_ef_sc_hd__decap_12
XTAP_TAPCELL_ROW_255_3763 VGND VPWR sky130_fd_sc_hd__tapvpwrvgnd_1
XTAP_TAPCELL_ROW_31_2_3942 VGND VPWR sky130_fd_sc_hd__tapvpwrvgnd_1
XFILLER_185_709 VPWR VGND VPWR VGND sky130_ef_sc_hd__decap_12
XTAP_TAPCELL_ROW_255_3774 VGND VPWR sky130_fd_sc_hd__tapvpwrvgnd_1
XFILLER_244_1483 VGND VGND VPWR VPWR sky130_fd_sc_hd__fill_1
XTAP_TAPCELL_ROW_255_3785 VGND VPWR sky130_fd_sc_hd__tapvpwrvgnd_1
XFILLER_212_389 VPWR VGND VPWR VGND sky130_ef_sc_hd__decap_12
XTAP_TAPCELL_ROW_255_3796 VGND VPWR sky130_fd_sc_hd__tapvpwrvgnd_1
XFILLER_33_69 VGND VGND VPWR VPWR sky130_fd_sc_hd__fill_2
XFILLER_166_923 VGND VGND VPWR VPWR sky130_fd_sc_hd__fill_1
XTAP_TAPCELL_ROW_251_3649 VGND VPWR sky130_fd_sc_hd__tapvpwrvgnd_1
XFILLER_149_69 VGND VGND VPWR VPWR sky130_fd_sc_hd__fill_2
XFILLER_165_433 VPWR VGND VPWR VGND sky130_ef_sc_hd__decap_12
XFILLER_177_293 VPWR VGND VPWR VGND sky130_ef_sc_hd__decap_12
XFILLER_197_1213 VPWR VGND VPWR VGND sky130_ef_sc_hd__decap_12
XFILLER_193_753 VPWR VGND VPWR VGND sky130_ef_sc_hd__decap_12
XFILLER_14_1451 VPWR VGND VPWR VGND sky130_ef_sc_hd__decap_12
XFILLER_123_1189 VPWR VGND VPWR VGND sky130_ef_sc_hd__decap_12
XFILLER_165_477 VPWR VGND VPWR VGND sky130_ef_sc_hd__decap_12
XFILLER_10_1315 VPWR VGND VPWR VGND sky130_ef_sc_hd__decap_12
XFILLER_197_1257 VPWR VGND VPWR VGND sky130_ef_sc_hd__decap_12
XFILLER_193_797 VPWR VGND VPWR VGND sky130_ef_sc_hd__decap_12
XFILLER_14_1495 VPWR VGND VPWR VGND sky130_ef_sc_hd__decap_12
XFILLER_101_1443 VPWR VGND VPWR VGND sky130_ef_sc_hd__decap_12
XPHY_EDGE_ROW_237_Left_492 VGND VGND VPWR VPWR sky130_fd_sc_hd__decap_3
XFILLER_175_1511 VGND VGND VPWR VPWR sky130_fd_sc_hd__fill_1
XFILLER_10_1359 VPWR VGND VPWR VGND sky130_ef_sc_hd__decap_12
XFILLER_3_137 VPWR VGND VPWR VGND sky130_ef_sc_hd__decap_12
XFILLER_165_57 VPWR VGND VPWR VGND sky130_ef_sc_hd__decap_12
XFILLER_84_1427 VPWR VGND VPWR VGND sky130_ef_sc_hd__decap_12
XFILLER_180_469 VGND VGND VPWR VPWR sky130_fd_sc_hd__decap_6
XFILLER_234_1129 VPWR VGND VPWR VGND sky130_ef_sc_hd__decap_12
XTAP_TAPCELL_ROW_149_2_4650 VGND VPWR sky130_fd_sc_hd__tapvpwrvgnd_1
XPHY_EDGE_ROW_21_2_Left_523 VGND VGND VPWR VPWR sky130_fd_sc_hd__decap_3
XTAP_TAPCELL_ROW_162_2_4728 VGND VPWR sky130_fd_sc_hd__tapvpwrvgnd_1
XFILLER_212_1427 VGND VGND VPWR VPWR sky130_fd_sc_hd__fill_1
XFILLER_236_905 VPWR VGND VPWR VGND sky130_ef_sc_hd__decap_12
XFILLER_21_1411 VPWR VGND VPWR VGND sky130_ef_sc_hd__decap_12
XTAP_TAPCELL_ROW_204_2405 VGND VPWR sky130_fd_sc_hd__tapvpwrvgnd_1
XFILLER_236_949 VPWR VGND VPWR VGND sky130_ef_sc_hd__decap_12
XFILLER_60_1471 VPWR VGND VPWR VGND sky130_ef_sc_hd__decap_12
XFILLER_1_1505 VGND VGND VPWR VPWR sky130_fd_sc_hd__decap_6
XFILLER_169_1337 VGND VGND VPWR VPWR sky130_fd_sc_hd__decap_6
XFILLER_21_1455 VPWR VGND VPWR VGND sky130_ef_sc_hd__decap_12
XTAP_TAPCELL_ROW_142_2_4604 VGND VPWR sky130_fd_sc_hd__tapvpwrvgnd_1
XFILLER_210_1173 VPWR VGND VPWR VGND sky130_ef_sc_hd__decap_12
XFILLER_74_65 VGND VGND VPWR VPWR sky130_fd_sc_hd__decap_6
XFILLER_222_109 VPWR VGND VPWR VGND sky130_ef_sc_hd__decap_12
XFILLER_56_1507 VGND VGND VPWR VPWR sky130_fd_sc_hd__decap_8
XFILLER_21_1499 VPWR VGND VPWR VGND sky130_ef_sc_hd__decap_12
XFILLER_204_813 VPWR VGND VPWR VGND sky130_ef_sc_hd__decap_12
XFILLER_245_1225 VGND VGND VPWR VPWR sky130_fd_sc_hd__decap_6
XFILLER_244_993 VPWR VGND VPWR VGND sky130_ef_sc_hd__decap_12
XFILLER_215_161 VGND VGND VPWR VPWR sky130_fd_sc_hd__decap_6
XFILLER_188_525 VGND VGND VPWR VPWR sky130_fd_sc_hd__decap_6
XFILLER_245_1269 VPWR VGND VPWR VGND sky130_ef_sc_hd__decap_12
XFILLER_231_665 VGND VGND VPWR VPWR sky130_fd_sc_hd__decap_6
XFILLER_188_569 VPWR VGND VPWR VGND sky130_ef_sc_hd__decap_12
XFILLER_230_153 VPWR VGND VPWR VGND sky130_ef_sc_hd__decap_12
XFILLER_90_53 VPWR VGND VPWR VGND sky130_ef_sc_hd__decap_12
XFILLER_141_1201 VPWR VGND VPWR VGND sky130_ef_sc_hd__decap_12
XTAP_TAPCELL_ROW_97_1_1232 VGND VPWR sky130_fd_sc_hd__tapvpwrvgnd_1
XFILLER_180_1261 VPWR VGND VPWR VGND sky130_ef_sc_hd__decap_12
XFILLER_208_1091 VGND VGND VPWR VPWR sky130_fd_sc_hd__fill_1
XFILLER_169_783 VGND VGND VPWR VPWR sky130_fd_sc_hd__fill_1
XTAP_TAPCELL_ROW_111_1_1246 VGND VPWR sky130_fd_sc_hd__tapvpwrvgnd_1
XFILLER_230_197 VPWR VGND VPWR VGND sky130_ef_sc_hd__decap_12
Xwire330 _142_ VGND VGND VPWR VPWR net330 sky130_fd_sc_hd__clkbuf_1
XFILLER_141_1267 VGND VGND VPWR VPWR sky130_fd_sc_hd__decap_6
Xwire341 net342 VGND VGND VPWR VPWR net341 sky130_fd_sc_hd__clkbuf_1
Xwire352 net353 VGND VGND VPWR VPWR net352 sky130_fd_sc_hd__clkbuf_1
XFILLER_239_1007 VGND VGND VPWR VPWR sky130_fd_sc_hd__fill_1
Xwire363 net364 VGND VGND VPWR VPWR net363 sky130_fd_sc_hd__clkbuf_1
XFILLER_209_39 VPWR VGND VPWR VGND sky130_ef_sc_hd__decap_12
Xwire374 net375 VGND VGND VPWR VPWR net374 sky130_fd_sc_hd__clkbuf_1
Xmax_cap107 net108 VGND VGND VPWR VPWR net107 sky130_fd_sc_hd__clkbuf_1
XFILLER_172_937 VPWR VGND VPWR VGND sky130_ef_sc_hd__decap_12
Xmax_cap118 _224_ VGND VGND VPWR VPWR net118 sky130_fd_sc_hd__clkbuf_1
Xwire385 net386 VGND VGND VPWR VPWR net385 sky130_fd_sc_hd__clkbuf_1
XFILLER_99_51 VGND VGND VPWR VPWR sky130_fd_sc_hd__decap_4
Xwire396 net397 VGND VGND VPWR VPWR net396 sky130_fd_sc_hd__clkbuf_1
Xmax_cap129 _200_ VGND VGND VPWR VPWR net129 sky130_fd_sc_hd__clkbuf_1
XFILLER_171_447 VGND VGND VPWR VPWR sky130_fd_sc_hd__fill_1
XFILLER_180_981 VPWR VGND VPWR VGND sky130_ef_sc_hd__decap_12
XFILLER_252_1229 VPWR VGND VPWR VGND sky130_ef_sc_hd__decap_12
XFILLER_3_671 VGND VGND VPWR VPWR sky130_fd_sc_hd__fill_1
XFILLER_225_27 VPWR VGND VPWR VGND sky130_ef_sc_hd__decap_12
XFILLER_239_721 VGND VGND VPWR VPWR sky130_fd_sc_hd__decap_6
XFILLER_61_1213 VGND VGND VPWR VPWR sky130_fd_sc_hd__decap_4
XPHY_EDGE_ROW_78_2_Left_580 VGND VGND VPWR VPWR sky130_fd_sc_hd__decap_3
XFILLER_6_1427 VGND VGND VPWR VPWR sky130_fd_sc_hd__fill_1
XFILLER_239_765 VPWR VGND VPWR VGND sky130_ef_sc_hd__decap_12
XFILLER_238_253 VPWR VGND VPWR VGND sky130_ef_sc_hd__decap_12
XFILLER_254_713 VPWR VGND VPWR VGND sky130_ef_sc_hd__decap_12
XFILLER_241_15 VPWR VGND VPWR VGND sky130_ef_sc_hd__decap_12
XFILLER_17_3 VPWR VGND VPWR VGND sky130_ef_sc_hd__decap_12
XTAP_TAPCELL_ROW_166_1364 VGND VPWR sky130_fd_sc_hd__tapvpwrvgnd_1
XTAP_TAPCELL_ROW_166_1375 VGND VPWR sky130_fd_sc_hd__tapvpwrvgnd_1
XTAP_TAPCELL_ROW_36_2_3968 VGND VPWR sky130_fd_sc_hd__tapvpwrvgnd_1
XFILLER_253_223 VGND VGND VPWR VPWR sky130_fd_sc_hd__fill_1
XPHY_EDGE_ROW_92_2_Right_183 VGND VGND VPWR VPWR sky130_fd_sc_hd__decap_3
XFILLER_187_1437 VPWR VGND VPWR VGND sky130_ef_sc_hd__decap_12
XFILLER_254_757 VPWR VGND VPWR VGND sky130_ef_sc_hd__decap_12
XFILLER_4_1173 VPWR VGND VPWR VGND sky130_ef_sc_hd__decap_12
XFILLER_0_1037 VPWR VGND VPWR VGND sky130_ef_sc_hd__decap_12
XFILLER_98_1191 VPWR VGND VPWR VGND sky130_ef_sc_hd__decap_12
XFILLER_207_673 VPWR VGND VPWR VGND sky130_ef_sc_hd__decap_12
XFILLER_241_429 VPWR VGND VPWR VGND sky130_ef_sc_hd__decap_12
XFILLER_179_503 VGND VGND VPWR VPWR sky130_fd_sc_hd__fill_1
XTAP_TAPCELL_ROW_179_1714 VGND VPWR sky130_fd_sc_hd__tapvpwrvgnd_1
XTAP_TAPCELL_ROW_179_1725 VGND VPWR sky130_fd_sc_hd__tapvpwrvgnd_1
XFILLER_222_643 VGND VGND VPWR VPWR sky130_fd_sc_hd__fill_1
XFILLER_224_1309 VGND VGND VPWR VPWR sky130_fd_sc_hd__decap_6
XFILLER_210_805 VGND VGND VPWR VPWR sky130_fd_sc_hd__decap_6
XFILLER_167_709 VPWR VGND VPWR VGND sky130_ef_sc_hd__decap_12
XFILLER_146_1189 VGND VGND VPWR VPWR sky130_fd_sc_hd__fill_1
XFILLER_210_849 VPWR VGND VPWR VGND sky130_ef_sc_hd__decap_12
XTAP_TAPCELL_ROW_155_2_4682 VGND VPWR sky130_fd_sc_hd__tapvpwrvgnd_1
XFILLER_175_753 VPWR VGND VPWR VGND sky130_ef_sc_hd__decap_12
XFILLER_119_39 VPWR VGND VPWR VGND sky130_ef_sc_hd__decap_12
XFILLER_190_701 VPWR VGND VPWR VGND sky130_ef_sc_hd__decap_12
XFILLER_175_797 VPWR VGND VPWR VGND sky130_ef_sc_hd__decap_12
XFILLER_200_1353 VPWR VGND VPWR VGND sky130_ef_sc_hd__decap_12
XFILLER_200_1397 VPWR VGND VPWR VGND sky130_ef_sc_hd__decap_12
XFILLER_118_1203 VPWR VGND VPWR VGND sky130_ef_sc_hd__decap_12
XFILLER_135_27 VPWR VGND VPWR VGND sky130_ef_sc_hd__decap_12
XFILLER_235_1449 VGND VGND VPWR VPWR sky130_fd_sc_hd__decap_6
XFILLER_118_1247 VPWR VGND VPWR VGND sky130_ef_sc_hd__decap_12
XFILLER_249_529 VPWR VGND VPWR VGND sky130_ef_sc_hd__decap_12
XFILLER_170_1441 VPWR VGND VPWR VGND sky130_ef_sc_hd__decap_12
XTAP_TAPCELL_ROW_244_3464 VGND VPWR sky130_fd_sc_hd__tapvpwrvgnd_1
XFILLER_218_905 VPWR VGND VPWR VGND sky130_ef_sc_hd__decap_12
XTAP_TAPCELL_ROW_244_3475 VGND VPWR sky130_fd_sc_hd__tapvpwrvgnd_1
XTAP_TAPCELL_ROW_244_3486 VGND VPWR sky130_fd_sc_hd__tapvpwrvgnd_1
XFILLER_151_15 VPWR VGND VPWR VGND sky130_ef_sc_hd__decap_12
XFILLER_170_1485 VPWR VGND VPWR VGND sky130_ef_sc_hd__decap_12
XFILLER_215_93 VPWR VGND VPWR VGND sky130_ef_sc_hd__decap_12
XFILLER_218_949 VPWR VGND VPWR VGND sky130_ef_sc_hd__decap_12
XTAP_TAPCELL_ROW_127_2_4517 VGND VPWR sky130_fd_sc_hd__tapvpwrvgnd_1
XFILLER_244_245 VGND VGND VPWR VPWR sky130_fd_sc_hd__decap_6
XPHY_EDGE_ROW_163_1_Left_418 VGND VGND VPWR VPWR sky130_fd_sc_hd__decap_3
XFILLER_211_1493 VPWR VGND VPWR VGND sky130_ef_sc_hd__decap_12
XFILLER_77_1231 VPWR VGND VPWR VGND sky130_ef_sc_hd__decap_12
XFILLER_204_109 VPWR VGND VPWR VGND sky130_ef_sc_hd__decap_12
XFILLER_244_289 VPWR VGND VPWR VGND sky130_ef_sc_hd__decap_12
XFILLER_226_993 VPWR VGND VPWR VGND sky130_ef_sc_hd__decap_12
XFILLER_231_81 VPWR VGND VPWR VGND sky130_ef_sc_hd__decap_12
XFILLER_38_1215 VPWR VGND VPWR VGND sky130_ef_sc_hd__decap_12
XFILLER_77_1275 VPWR VGND VPWR VGND sky130_ef_sc_hd__decap_12
XFILLER_129_1343 VPWR VGND VPWR VGND sky130_ef_sc_hd__decap_12
XFILLER_242_1409 VPWR VGND VPWR VGND sky130_ef_sc_hd__decap_12
XFILLER_164_1245 VGND VGND VPWR VPWR sky130_fd_sc_hd__fill_1
XFILLER_38_1259 VPWR VGND VPWR VGND sky130_ef_sc_hd__decap_12
XFILLER_198_867 VGND VGND VPWR VPWR sky130_fd_sc_hd__fill_1
XFILLER_213_665 VGND VGND VPWR VPWR sky130_fd_sc_hd__decap_6
XFILLER_129_1387 VPWR VGND VPWR VGND sky130_ef_sc_hd__decap_12
XFILLER_212_153 VPWR VGND VPWR VGND sky130_ef_sc_hd__decap_12
XFILLER_100_41 VPWR VGND VPWR VGND sky130_ef_sc_hd__decap_12
XFILLER_185_517 VPWR VGND VPWR VGND sky130_ef_sc_hd__decap_12
XFILLER_205_1231 VGND VGND VPWR VPWR sky130_fd_sc_hd__fill_1
XFILLER_212_197 VPWR VGND VPWR VGND sky130_ef_sc_hd__decap_12
XTAP_TAPCELL_ROW_75_2_4204 VGND VPWR sky130_fd_sc_hd__tapvpwrvgnd_1
XFILLER_121_3 VPWR VGND VPWR VGND sky130_ef_sc_hd__decap_12
XFILLER_197_1021 VPWR VGND VPWR VGND sky130_ef_sc_hd__decap_12
XPHY_EDGE_ROW_245_Left_500 VGND VGND VPWR VPWR sky130_fd_sc_hd__decap_3
XFILLER_193_561 VPWR VGND VPWR VGND sky130_ef_sc_hd__decap_12
XFILLER_219_3 VPWR VGND VPWR VGND sky130_ef_sc_hd__decap_12
XTAP_TAPCELL_ROW_158_1_1293 VGND VPWR sky130_fd_sc_hd__tapvpwrvgnd_1
XFILLER_197_1065 VPWR VGND VPWR VGND sky130_ef_sc_hd__decap_12
XFILLER_5_18 VPWR VGND VPWR VGND sky130_ef_sc_hd__decap_12
XFILLER_49_1311 VPWR VGND VPWR VGND sky130_ef_sc_hd__decap_12
XFILLER_180_233 VPWR VGND VPWR VGND sky130_ef_sc_hd__decap_12
XFILLER_88_1371 VPWR VGND VPWR VGND sky130_ef_sc_hd__decap_12
XFILLER_101_1273 VGND VGND VPWR VPWR sky130_fd_sc_hd__fill_1
XFILLER_253_1505 VGND VGND VPWR VPWR sky130_fd_sc_hd__decap_6
XFILLER_49_1355 VPWR VGND VPWR VGND sky130_ef_sc_hd__decap_12
XFILLER_136_1303 VPWR VGND VPWR VGND sky130_ef_sc_hd__decap_12
XFILLER_238_1073 VPWR VGND VPWR VGND sky130_ef_sc_hd__decap_12
XFILLER_10_1189 VGND VGND VPWR VPWR sky130_fd_sc_hd__fill_1
XFILLER_180_277 VPWR VGND VPWR VGND sky130_ef_sc_hd__decap_12
XFILLER_45_1219 VPWR VGND VPWR VGND sky130_ef_sc_hd__decap_12
XFILLER_49_1399 VPWR VGND VPWR VGND sky130_ef_sc_hd__decap_12
XFILLER_192_77 VGND VGND VPWR VPWR sky130_fd_sc_hd__decap_6
XFILLER_216_1371 VGND VGND VPWR VPWR sky130_fd_sc_hd__fill_1
XFILLER_236_713 VPWR VGND VPWR VGND sky130_ef_sc_hd__decap_12
XTAP_TAPCELL_ROW_22_2_3887 VGND VPWR sky130_fd_sc_hd__tapvpwrvgnd_1
XFILLER_169_1101 VPWR VGND VPWR VGND sky130_ef_sc_hd__decap_12
XFILLER_235_223 VGND VGND VPWR VPWR sky130_fd_sc_hd__fill_1
XFILLER_236_757 VPWR VGND VPWR VGND sky130_ef_sc_hd__decap_12
XTAP_TAPCELL_ROW_4_980 VGND VPWR sky130_fd_sc_hd__tapvpwrvgnd_1
XFILLER_1_1313 VPWR VGND VPWR VGND sky130_ef_sc_hd__decap_12
XFILLER_169_1145 VPWR VGND VPWR VGND sky130_ef_sc_hd__decap_12
XFILLER_5_1493 VPWR VGND VPWR VGND sky130_ef_sc_hd__decap_12
XFILLER_251_727 VGND VGND VPWR VPWR sky130_fd_sc_hd__fill_1
XFILLER_95_1331 VPWR VGND VPWR VGND sky130_ef_sc_hd__decap_12
XFILLER_165_1009 VPWR VGND VPWR VGND sky130_ef_sc_hd__decap_12
XFILLER_1_1357 VPWR VGND VPWR VGND sky130_ef_sc_hd__decap_12
XFILLER_169_1189 VPWR VGND VPWR VGND sky130_ef_sc_hd__decap_12
XFILLER_223_429 VPWR VGND VPWR VGND sky130_ef_sc_hd__decap_12
XFILLER_56_1315 VPWR VGND VPWR VGND sky130_ef_sc_hd__decap_12
XFILLER_245_1033 VPWR VGND VPWR VGND sky130_ef_sc_hd__decap_12
XFILLER_91_1217 VGND VGND VPWR VPWR sky130_fd_sc_hd__fill_1
XFILLER_147_1443 VPWR VGND VPWR VGND sky130_ef_sc_hd__decap_12
XFILLER_204_643 VGND VGND VPWR VPWR sky130_fd_sc_hd__fill_1
XFILLER_188_333 VPWR VGND VPWR VGND sky130_ef_sc_hd__decap_12
XFILLER_56_1359 VPWR VGND VPWR VGND sky130_ef_sc_hd__decap_12
XFILLER_108_1427 VPWR VGND VPWR VGND sky130_ef_sc_hd__decap_12
XFILLER_206_1017 VPWR VGND VPWR VGND sky130_ef_sc_hd__decap_12
XFILLER_245_1077 VPWR VGND VPWR VGND sky130_ef_sc_hd__decap_12
XFILLER_143_1329 VGND VGND VPWR VPWR sky130_fd_sc_hd__fill_1
XFILLER_189_889 VGND VGND VPWR VPWR sky130_fd_sc_hd__decap_6
XFILLER_231_473 VPWR VGND VPWR VGND sky130_ef_sc_hd__decap_12
XFILLER_188_377 VPWR VGND VPWR VGND sky130_ef_sc_hd__decap_12
XFILLER_180_1091 VGND VGND VPWR VPWR sky130_fd_sc_hd__fill_1
XPHY_EDGE_ROW_172_Right_17 VGND VGND VPWR VPWR sky130_fd_sc_hd__decap_3
XFILLER_172_701 VPWR VGND VPWR VGND sky130_ef_sc_hd__decap_12
XFILLER_200_893 VPWR VGND VPWR VGND sky130_ef_sc_hd__decap_12
Xwire160 net161 VGND VGND VPWR VPWR net160 sky130_fd_sc_hd__clkbuf_1
Xwire171 _124_ VGND VGND VPWR VPWR net171 sky130_fd_sc_hd__clkbuf_1
XFILLER_176_1105 VPWR VGND VPWR VGND sky130_ef_sc_hd__decap_12
XFILLER_236_15 VPWR VGND VPWR VGND sky130_ef_sc_hd__decap_12
XFILLER_67_1411 VPWR VGND VPWR VGND sky130_ef_sc_hd__decap_12
XFILLER_176_1149 VPWR VGND VPWR VGND sky130_ef_sc_hd__decap_12
XFILLER_67_1455 VPWR VGND VPWR VGND sky130_ef_sc_hd__decap_12
XFILLER_217_1113 VGND VGND VPWR VPWR sky130_fd_sc_hd__decap_6
XTAP_TAPCELL_ROW_88_2_4282 VGND VPWR sky130_fd_sc_hd__tapvpwrvgnd_1
XFILLER_28_1439 VPWR VGND VPWR VGND sky130_ef_sc_hd__decap_12
XFILLER_252_1037 VPWR VGND VPWR VGND sky130_ef_sc_hd__decap_12
XFILLER_67_1499 VPWR VGND VPWR VGND sky130_ef_sc_hd__decap_12
XTAP_TAPCELL_ROW_168_1415 VGND VPWR sky130_fd_sc_hd__tapvpwrvgnd_1
XFILLER_217_1157 VPWR VGND VPWR VGND sky130_ef_sc_hd__decap_12
XTAP_TAPCELL_ROW_168_1426 VGND VPWR sky130_fd_sc_hd__tapvpwrvgnd_1
XFILLER_154_1469 VGND VGND VPWR VPWR sky130_fd_sc_hd__fill_1
XFILLER_239_573 VPWR VGND VPWR VGND sky130_ef_sc_hd__decap_12
XTAP_TAPCELL_ROW_2_906 VGND VPWR sky130_fd_sc_hd__tapvpwrvgnd_1
XPHY_EDGE_ROW_181_Right_26 VGND VGND VPWR VPWR sky130_fd_sc_hd__decap_3
XTAP_TAPCELL_ROW_2_917 VGND VPWR sky130_fd_sc_hd__tapvpwrvgnd_1
XTAP_TAPCELL_ROW_2_928 VGND VPWR sky130_fd_sc_hd__tapvpwrvgnd_1
XFILLER_187_1201 VPWR VGND VPWR VGND sky130_ef_sc_hd__decap_12
XFILLER_113_1177 VPWR VGND VPWR VGND sky130_ef_sc_hd__decap_12
XPHY_EDGE_ROW_150_1_Right_806 VGND VGND VPWR VPWR sky130_fd_sc_hd__decap_3
XFILLER_226_245 VGND VGND VPWR VPWR sky130_fd_sc_hd__decap_6
XFILLER_187_1245 VPWR VGND VPWR VGND sky130_ef_sc_hd__decap_12
XPHY_EDGE_ROW_93_2_Right_184 VGND VGND VPWR VPWR sky130_fd_sc_hd__decap_3
XFILLER_199_609 VGND VGND VPWR VPWR sky130_fd_sc_hd__decap_6
XFILLER_254_587 VGND VGND VPWR VPWR sky130_fd_sc_hd__fill_1
XFILLER_208_993 VPWR VGND VPWR VGND sky130_ef_sc_hd__decap_12
XFILLER_226_289 VPWR VGND VPWR VGND sky130_ef_sc_hd__decap_12
XFILLER_242_749 VGND VGND VPWR VPWR sky130_fd_sc_hd__decap_6
XFILLER_187_1289 VPWR VGND VPWR VGND sky130_ef_sc_hd__decap_12
XFILLER_241_237 VPWR VGND VPWR VGND sky130_ef_sc_hd__decap_12
XFILLER_74_1415 VPWR VGND VPWR VGND sky130_ef_sc_hd__decap_12
XFILLER_228_1253 VGND VGND VPWR VPWR sky130_fd_sc_hd__decap_6
Xclkbuf_3_5__f_clk clknet_0_clk VGND VGND VPWR VPWR clknet_3_5__leaf_clk sky130_fd_sc_hd__clkbuf_16
XFILLER_201_51 VGND VGND VPWR VPWR sky130_fd_sc_hd__decap_4
XFILLER_224_1117 VPWR VGND VPWR VGND sky130_ef_sc_hd__decap_12
XTAP_TAPCELL_ROW_252_3700 VGND VPWR sky130_fd_sc_hd__tapvpwrvgnd_1
XFILLER_14_27 VGND VGND VPWR VPWR sky130_fd_sc_hd__fill_1
XFILLER_210_613 VPWR VGND VPWR VGND sky130_ef_sc_hd__decap_12
XFILLER_228_1297 VPWR VGND VPWR VGND sky130_ef_sc_hd__decap_12
XTAP_TAPCELL_ROW_61_2_4123 VGND VPWR sky130_fd_sc_hd__tapvpwrvgnd_1
XFILLER_250_793 VPWR VGND VPWR VGND sky130_ef_sc_hd__decap_12
XFILLER_167_517 VPWR VGND VPWR VGND sky130_ef_sc_hd__decap_12
XTAP_TAPCELL_ROW_237_3290 VGND VPWR sky130_fd_sc_hd__tapvpwrvgnd_1
XFILLER_210_657 VPWR VGND VPWR VGND sky130_ef_sc_hd__decap_12
XPHY_EDGE_ROW_190_Right_35 VGND VGND VPWR VPWR sky130_fd_sc_hd__decap_3
XTAP_TAPCELL_ROW_233_3165 VGND VPWR sky130_fd_sc_hd__tapvpwrvgnd_1
XTAP_TAPCELL_ROW_233_3176 VGND VPWR sky130_fd_sc_hd__tapvpwrvgnd_1
XFILLER_175_561 VPWR VGND VPWR VGND sky130_ef_sc_hd__decap_12
XFILLER_198_1341 VPWR VGND VPWR VGND sky130_ef_sc_hd__decap_12
XTAP_TAPCELL_ROW_233_3187 VGND VPWR sky130_fd_sc_hd__tapvpwrvgnd_1
XFILLER_124_1295 VGND VGND VPWR VPWR sky130_fd_sc_hd__decap_6
XFILLER_33_1189 VPWR VGND VPWR VGND sky130_ef_sc_hd__decap_12
XFILLER_30_15 VPWR VGND VPWR VGND sky130_ef_sc_hd__decap_12
XFILLER_194_1205 VPWR VGND VPWR VGND sky130_ef_sc_hd__decap_12
XFILLER_190_531 VGND VGND VPWR VPWR sky130_fd_sc_hd__fill_1
XFILLER_198_1385 VPWR VGND VPWR VGND sky130_ef_sc_hd__decap_12
XFILLER_11_1443 VPWR VGND VPWR VGND sky130_ef_sc_hd__decap_12
XFILLER_146_15 VPWR VGND VPWR VGND sky130_ef_sc_hd__decap_12
XFILLER_85_1511 VGND VGND VPWR VPWR sky130_fd_sc_hd__decap_4
XFILLER_200_1161 VPWR VGND VPWR VGND sky130_ef_sc_hd__decap_12
XTAP_TAPCELL_ROW_246_3515 VGND VPWR sky130_fd_sc_hd__tapvpwrvgnd_1
XFILLER_235_1213 VPWR VGND VPWR VGND sky130_ef_sc_hd__decap_12
XTAP_TAPCELL_ROW_246_3526 VGND VPWR sky130_fd_sc_hd__tapvpwrvgnd_1
XFILLER_239_1393 VGND VGND VPWR VPWR sky130_fd_sc_hd__decap_6
XTAP_TAPCELL_ROW_246_3537 VGND VPWR sky130_fd_sc_hd__tapvpwrvgnd_1
Xmax_cap493 net494 VGND VGND VPWR VPWR net493 sky130_fd_sc_hd__clkbuf_1
XFILLER_235_1257 VPWR VGND VPWR VGND sky130_ef_sc_hd__decap_12
XFILLER_249_337 VPWR VGND VPWR VGND sky130_ef_sc_hd__decap_12
XFILLER_213_1511 VGND VGND VPWR VPWR sky130_fd_sc_hd__fill_1
XFILLER_39_68 VGND VGND VPWR VPWR sky130_fd_sc_hd__decap_3
XFILLER_218_713 VPWR VGND VPWR VGND sky130_ef_sc_hd__decap_12
XFILLER_131_1255 VPWR VGND VPWR VGND sky130_ef_sc_hd__decap_12
XFILLER_217_223 VGND VGND VPWR VPWR sky130_fd_sc_hd__fill_1
XFILLER_218_757 VPWR VGND VPWR VGND sky130_ef_sc_hd__decap_12
X_540_ net667 VGND VGND VPWR VPWR _022_ sky130_fd_sc_hd__inv_2
XFILLER_131_1299 VPWR VGND VPWR VGND sky130_ef_sc_hd__decap_12
XFILLER_233_727 VGND VGND VPWR VPWR sky130_fd_sc_hd__fill_1
XFILLER_166_1329 VPWR VGND VPWR VGND sky130_ef_sc_hd__decap_12
XFILLER_205_429 VPWR VGND VPWR VGND sky130_ef_sc_hd__decap_12
XFILLER_169_3 VPWR VGND VPWR VGND sky130_ef_sc_hd__decap_12
XTAP_TAPCELL_ROW_222_2880 VGND VPWR sky130_fd_sc_hd__tapvpwrvgnd_1
X_471_ _161_ net111 net219 VGND VGND VPWR VPWR _242_ sky130_fd_sc_hd__a21bo_1
XTAP_TAPCELL_ROW_222_2891 VGND VPWR sky130_fd_sc_hd__tapvpwrvgnd_1
XFILLER_246_1353 VPWR VGND VPWR VGND sky130_ef_sc_hd__decap_12
XFILLER_111_51 VGND VGND VPWR VPWR sky130_fd_sc_hd__decap_4
XFILLER_242_1217 VPWR VGND VPWR VGND sky130_ef_sc_hd__decap_12
XFILLER_207_1337 VGND VGND VPWR VPWR sky130_fd_sc_hd__decap_6
XFILLER_246_1397 VPWR VGND VPWR VGND sky130_ef_sc_hd__decap_12
XFILLER_213_473 VPWR VGND VPWR VGND sky130_ef_sc_hd__decap_12
XFILLER_9_505 VPWR VGND VPWR VGND sky130_ef_sc_hd__decap_12
XFILLER_186_837 VPWR VGND VPWR VGND sky130_ef_sc_hd__decap_12
XFILLER_51_1201 VPWR VGND VPWR VGND sky130_ef_sc_hd__decap_12
XFILLER_71_55 VGND VGND VPWR VPWR sky130_fd_sc_hd__fill_1
XFILLER_187_55 VGND VGND VPWR VPWR sky130_fd_sc_hd__fill_1
XFILLER_90_1283 VPWR VGND VPWR VGND sky130_ef_sc_hd__decap_12
XFILLER_142_1351 VGND VGND VPWR VPWR sky130_fd_sc_hd__decap_6
XFILLER_51_1267 VGND VGND VPWR VPWR sky130_fd_sc_hd__decap_6
XFILLER_200_189 VGND VGND VPWR VPWR sky130_fd_sc_hd__decap_6
XFILLER_142_1395 VPWR VGND VPWR VGND sky130_ef_sc_hd__decap_12
XFILLER_194_881 VPWR VGND VPWR VGND sky130_ef_sc_hd__decap_12
XTAP_TAPCELL_ROW_106_2_4390 VGND VPWR sky130_fd_sc_hd__tapvpwrvgnd_1
XFILLER_177_1425 VPWR VGND VPWR VGND sky130_ef_sc_hd__decap_12
XFILLER_103_1379 VGND VGND VPWR VPWR sky130_fd_sc_hd__decap_6
XFILLER_193_391 VGND VGND VPWR VPWR sky130_fd_sc_hd__fill_1
XFILLER_181_553 VGND VGND VPWR VPWR sky130_fd_sc_hd__decap_6
XFILLER_177_1469 VPWR VGND VPWR VGND sky130_ef_sc_hd__decap_12
XFILLER_253_1313 VPWR VGND VPWR VGND sky130_ef_sc_hd__decap_12
XTAP_TAPCELL_ROW_106_1_1241 VGND VPWR sky130_fd_sc_hd__tapvpwrvgnd_1
XFILLER_181_597 VPWR VGND VPWR VGND sky130_ef_sc_hd__decap_12
XFILLER_206_29 VPWR VGND VPWR VGND sky130_ef_sc_hd__decap_12
XFILLER_253_1357 VPWR VGND VPWR VGND sky130_ef_sc_hd__decap_12
XFILLER_218_1477 VGND VGND VPWR VPWR sky130_fd_sc_hd__decap_6
XFILLER_96_41 VPWR VGND VPWR VGND sky130_ef_sc_hd__decap_12
XFILLER_7_1511 VGND VGND VPWR VPWR sky130_fd_sc_hd__fill_1
XFILLER_136_1177 VPWR VGND VPWR VGND sky130_ef_sc_hd__decap_12
XFILLER_171_1057 VGND VGND VPWR VPWR sky130_fd_sc_hd__decap_6
XFILLER_153_1491 VGND VGND VPWR VPWR sky130_fd_sc_hd__decap_6
XTAP_TAPCELL_ROW_66_2_4149 VGND VPWR sky130_fd_sc_hd__tapvpwrvgnd_1
XFILLER_208_245 VGND VGND VPWR VPWR sky130_fd_sc_hd__decap_6
XFILLER_110_1339 VPWR VGND VPWR VGND sky130_ef_sc_hd__decap_12
XFILLER_236_587 VGND VGND VPWR VPWR sky130_fd_sc_hd__fill_1
XFILLER_1_1121 VPWR VGND VPWR VGND sky130_ef_sc_hd__decap_12
XFILLER_184_1429 VPWR VGND VPWR VGND sky130_ef_sc_hd__decap_12
XFILLER_208_289 VPWR VGND VPWR VGND sky130_ef_sc_hd__decap_12
XFILLER_224_749 VGND VGND VPWR VPWR sky130_fd_sc_hd__decap_6
XPHY_EDGE_ROW_109_2_Left_611 VGND VGND VPWR VPWR sky130_fd_sc_hd__decap_3
XFILLER_223_237 VPWR VGND VPWR VGND sky130_ef_sc_hd__decap_12
XFILLER_189_653 VPWR VGND VPWR VGND sky130_ef_sc_hd__decap_12
XFILLER_188_141 VPWR VGND VPWR VGND sky130_ef_sc_hd__decap_12
XFILLER_225_1437 VPWR VGND VPWR VGND sky130_ef_sc_hd__decap_12
XFILLER_147_1273 VGND VGND VPWR VPWR sky130_fd_sc_hd__fill_1
XFILLER_232_793 VPWR VGND VPWR VGND sky130_ef_sc_hd__decap_12
XFILLER_56_1189 VGND VGND VPWR VPWR sky130_fd_sc_hd__fill_1
XFILLER_189_697 VPWR VGND VPWR VGND sky130_ef_sc_hd__decap_12
XFILLER_231_281 VPWR VGND VPWR VGND sky130_ef_sc_hd__decap_12
XFILLER_182_1197 VGND VGND VPWR VPWR sky130_fd_sc_hd__decap_6
XFILLER_84_3 VPWR VGND VPWR VGND sky130_ef_sc_hd__decap_12
XFILLER_160_1451 VPWR VGND VPWR VGND sky130_ef_sc_hd__decap_12
XFILLER_121_1435 VGND VGND VPWR VPWR sky130_fd_sc_hd__decap_6
XFILLER_191_317 VPWR VGND VPWR VGND sky130_ef_sc_hd__decap_12
XFILLER_160_1495 VPWR VGND VPWR VGND sky130_ef_sc_hd__decap_12
XFILLER_247_69 VPWR VGND VPWR VGND sky130_ef_sc_hd__decap_12
XFILLER_121_1479 VPWR VGND VPWR VGND sky130_ef_sc_hd__decap_12
XFILLER_172_531 VGND VGND VPWR VPWR sky130_fd_sc_hd__fill_1
XFILLER_201_1481 VPWR VGND VPWR VGND sky130_ef_sc_hd__decap_12
XFILLER_6_83 VGND VGND VPWR VPWR sky130_fd_sc_hd__fill_1
XFILLER_28_1203 VPWR VGND VPWR VGND sky130_ef_sc_hd__decap_12
XFILLER_119_1331 VPWR VGND VPWR VGND sky130_ef_sc_hd__decap_12
XFILLER_116_29 VPWR VGND VPWR VGND sky130_ef_sc_hd__decap_12
XFILLER_28_1247 VPWR VGND VPWR VGND sky130_ef_sc_hd__decap_12
XFILLER_115_1217 VGND VGND VPWR VPWR sky130_fd_sc_hd__fill_1
XTAP_TAPCELL_ROW_163_2_4733 VGND VPWR sky130_fd_sc_hd__tapvpwrvgnd_1
XTAP_TAPCELL_ROW_241_3401 VGND VPWR sky130_fd_sc_hd__tapvpwrvgnd_1
XFILLER_246_307 VGND VGND VPWR VPWR sky130_fd_sc_hd__fill_1
XFILLER_80_1463 VGND VGND VPWR VPWR sky130_fd_sc_hd__decap_6
XFILLER_255_841 VPWR VGND VPWR VGND sky130_ef_sc_hd__decap_12
XTAP_TAPCELL_ROW_7_1060 VGND VPWR sky130_fd_sc_hd__tapvpwrvgnd_1
XPHY_EDGE_ROW_169_Left_424 VGND VGND VPWR VPWR sky130_fd_sc_hd__decap_3
XFILLER_242_513 VPWR VGND VPWR VGND sky130_ef_sc_hd__decap_12
XFILLER_215_727 VGND VGND VPWR VPWR sky130_fd_sc_hd__fill_1
XPHY_EDGE_ROW_151_1_Right_807 VGND VGND VPWR VPWR sky130_fd_sc_hd__decap_3
XFILLER_199_417 VPWR VGND VPWR VGND sky130_ef_sc_hd__decap_12
XFILLER_25_15 VPWR VGND VPWR VGND sky130_ef_sc_hd__decap_12
XPHY_EDGE_ROW_94_2_Right_185 VGND VGND VPWR VPWR sky130_fd_sc_hd__decap_3
XFILLER_242_557 VPWR VGND VPWR VGND sky130_ef_sc_hd__decap_12
XTAP_TAPCELL_ROW_239_3330 VGND VPWR sky130_fd_sc_hd__tapvpwrvgnd_1
XFILLER_212_83 VGND VGND VPWR VPWR sky130_fd_sc_hd__fill_1
XTAP_TAPCELL_ROW_239_3341 VGND VPWR sky130_fd_sc_hd__tapvpwrvgnd_1
XFILLER_39_1343 VPWR VGND VPWR VGND sky130_ef_sc_hd__decap_12
XFILLER_25_48 VGND VGND VPWR VPWR sky130_fd_sc_hd__fill_1
XFILLER_228_1061 VPWR VGND VPWR VGND sky130_ef_sc_hd__decap_12
XFILLER_74_1245 VGND VGND VPWR VPWR sky130_fd_sc_hd__fill_1
XFILLER_165_1373 VPWR VGND VPWR VGND sky130_ef_sc_hd__decap_12
XFILLER_211_933 VPWR VGND VPWR VGND sky130_ef_sc_hd__decap_12
XTAP_TAPCELL_ROW_235_3227 VGND VPWR sky130_fd_sc_hd__tapvpwrvgnd_1
XFILLER_39_1387 VPWR VGND VPWR VGND sky130_ef_sc_hd__decap_12
XTAP_TAPCELL_ROW_235_3238 VGND VPWR sky130_fd_sc_hd__tapvpwrvgnd_1
XFILLER_168_837 VPWR VGND VPWR VGND sky130_ef_sc_hd__decap_12
XFILLER_210_421 VPWR VGND VPWR VGND sky130_ef_sc_hd__decap_12
XFILLER_126_1357 VGND VGND VPWR VPWR sky130_fd_sc_hd__fill_1
XPHY_EDGE_ROW_30_2_Left_532 VGND VGND VPWR VPWR sky130_fd_sc_hd__decap_3
XFILLER_211_977 VPWR VGND VPWR VGND sky130_ef_sc_hd__decap_12
XFILLER_194_133 VGND VGND VPWR VPWR sky130_fd_sc_hd__decap_6
XFILLER_6_519 VGND VGND VPWR VPWR sky130_fd_sc_hd__fill_1
XFILLER_176_881 VPWR VGND VPWR VGND sky130_ef_sc_hd__decap_12
XFILLER_194_177 VPWR VGND VPWR VGND sky130_ef_sc_hd__decap_12
XPHY_EDGE_ROW_178_Left_433 VGND VGND VPWR VPWR sky130_fd_sc_hd__decap_3
XFILLER_175_391 VGND VGND VPWR VPWR sky130_fd_sc_hd__fill_1
XFILLER_157_69 VGND VGND VPWR VPWR sky130_fd_sc_hd__fill_2
XFILLER_194_1035 VGND VGND VPWR VPWR sky130_fd_sc_hd__fill_1
XFILLER_11_1273 VGND VGND VPWR VPWR sky130_fd_sc_hd__fill_1
XFILLER_191_895 VGND VGND VPWR VPWR sky130_fd_sc_hd__fill_1
XFILLER_159_1177 VPWR VGND VPWR VGND sky130_ef_sc_hd__decap_12
XFILLER_46_1303 VPWR VGND VPWR VGND sky130_ef_sc_hd__decap_12
XTAP_TAPCELL_ROW_211_2570 VGND VPWR sky130_fd_sc_hd__tapvpwrvgnd_1
XFILLER_235_1021 VPWR VGND VPWR VGND sky130_ef_sc_hd__decap_12
XTAP_TAPCELL_ROW_211_2581 VGND VPWR sky130_fd_sc_hd__tapvpwrvgnd_1
XFILLER_85_1385 VGND VGND VPWR VPWR sky130_fd_sc_hd__fill_1
XTAP_TAPCELL_ROW_211_2592 VGND VPWR sky130_fd_sc_hd__tapvpwrvgnd_1
XFILLER_2_769 VGND VGND VPWR VPWR sky130_fd_sc_hd__decap_8
XFILLER_173_57 VPWR VGND VPWR VGND sky130_ef_sc_hd__decap_12
XFILLER_235_1065 VPWR VGND VPWR VGND sky130_ef_sc_hd__decap_12
XFILLER_1_279 VGND VGND VPWR VPWR sky130_fd_sc_hd__fill_1
XFILLER_2_19 VGND VGND VPWR VPWR sky130_fd_sc_hd__decap_8
XFILLER_137_1497 VGND VGND VPWR VPWR sky130_fd_sc_hd__fill_1
XPHY_EDGE_ROW_107_1_Left_362 VGND VGND VPWR VPWR sky130_fd_sc_hd__decap_3
XFILLER_249_167 VGND VGND VPWR VPWR sky130_fd_sc_hd__fill_1
XFILLER_237_329 VGND VGND VPWR VPWR sky130_fd_sc_hd__decap_6
XTAP_TAPCELL_ROW_52_2_4068 VGND VPWR sky130_fd_sc_hd__tapvpwrvgnd_1
XPHY_EDGE_ROW_187_Left_442 VGND VGND VPWR VPWR sky130_fd_sc_hd__decap_3
XTAP_TAPCELL_ROW_224_2920 VGND VPWR sky130_fd_sc_hd__tapvpwrvgnd_1
XTAP_TAPCELL_ROW_224_2931 VGND VPWR sky130_fd_sc_hd__tapvpwrvgnd_1
XTAP_TAPCELL_ROW_224_2942 VGND VPWR sky130_fd_sc_hd__tapvpwrvgnd_1
XFILLER_245_373 VPWR VGND VPWR VGND sky130_ef_sc_hd__decap_12
XFILLER_218_587 VGND VGND VPWR VPWR sky130_fd_sc_hd__fill_1
XTAP_TAPCELL_ROW_220_2817 VGND VPWR sky130_fd_sc_hd__tapvpwrvgnd_1
XFILLER_2_1441 VPWR VGND VPWR VGND sky130_ef_sc_hd__decap_12
XTAP_TAPCELL_ROW_220_2828 VGND VPWR sky130_fd_sc_hd__tapvpwrvgnd_1
XFILLER_206_749 VGND VGND VPWR VPWR sky130_fd_sc_hd__decap_6
X_523_ net664 VGND VGND VPWR VPWR _005_ sky130_fd_sc_hd__inv_2
XFILLER_79_1189 VPWR VGND VPWR VGND sky130_ef_sc_hd__decap_12
XFILLER_205_237 VPWR VGND VPWR VGND sky130_ef_sc_hd__decap_12
XFILLER_2_1485 VPWR VGND VPWR VGND sky130_ef_sc_hd__decap_12
XFILLER_92_1301 VGND VGND VPWR VPWR sky130_fd_sc_hd__fill_1
XFILLER_199_951 VGND VGND VPWR VPWR sky130_fd_sc_hd__fill_1
XFILLER_207_1101 VPWR VGND VPWR VGND sky130_ef_sc_hd__decap_12
XFILLER_57_1443 VPWR VGND VPWR VGND sky130_ef_sc_hd__decap_12
XFILLER_109_1511 VGND VGND VPWR VPWR sky130_fd_sc_hd__decap_4
XFILLER_246_1161 VPWR VGND VPWR VGND sky130_ef_sc_hd__decap_12
X_454_ net623 net651 _082_ VGND VGND VPWR VPWR addr0\[0\] sky130_fd_sc_hd__a21bo_1
XFILLER_82_65 VGND VGND VPWR VPWR sky130_fd_sc_hd__decap_6
XFILLER_144_1413 VGND VGND VPWR VPWR sky130_fd_sc_hd__fill_1
XFILLER_18_1427 VPWR VGND VPWR VGND sky130_ef_sc_hd__decap_12
XFILLER_186_601 VPWR VGND VPWR VGND sky130_ef_sc_hd__decap_12
XFILLER_207_1145 VPWR VGND VPWR VGND sky130_ef_sc_hd__decap_12
XFILLER_214_793 VPWR VGND VPWR VGND sky130_ef_sc_hd__decap_12
XTAP_TAPCELL_ROW_197_2197 VGND VPWR sky130_fd_sc_hd__tapvpwrvgnd_1
XFILLER_198_65 VPWR VGND VPWR VGND sky130_ef_sc_hd__decap_12
XFILLER_213_281 VPWR VGND VPWR VGND sky130_ef_sc_hd__decap_12
XFILLER_53_1329 VGND VGND VPWR VPWR sky130_fd_sc_hd__fill_1
X_385_ _171_ _172_ VGND VGND VPWR VPWR _174_ sky130_fd_sc_hd__or2_1
XFILLER_185_111 VGND VGND VPWR VPWR sky130_fd_sc_hd__fill_1
XFILLER_186_645 VPWR VGND VPWR VGND sky130_ef_sc_hd__decap_12
XFILLER_203_1009 VPWR VGND VPWR VGND sky130_ef_sc_hd__decap_12
XFILLER_207_1189 VPWR VGND VPWR VGND sky130_ef_sc_hd__decap_12
XFILLER_9_335 VGND VGND VPWR VPWR sky130_fd_sc_hd__fill_1
XPHY_EDGE_ROW_196_Left_451 VGND VGND VPWR VPWR sky130_fd_sc_hd__decap_3
XTAP_TAPCELL_ROW_218_2768 VGND VPWR sky130_fd_sc_hd__tapvpwrvgnd_1
XTAP_TAPCELL_ROW_218_2779 VGND VPWR sky130_fd_sc_hd__tapvpwrvgnd_1
XFILLER_173_317 VPWR VGND VPWR VGND sky130_ef_sc_hd__decap_12
XTAP_TAPCELL_ROW_10_2_3814 VGND VPWR sky130_fd_sc_hd__tapvpwrvgnd_1
XFILLER_103_1165 VPWR VGND VPWR VGND sky130_ef_sc_hd__decap_12
XFILLER_177_1233 VPWR VGND VPWR VGND sky130_ef_sc_hd__decap_12
XFILLER_181_361 VPWR VGND VPWR VGND sky130_ef_sc_hd__decap_12
XFILLER_217_39 VPWR VGND VPWR VGND sky130_ef_sc_hd__decap_12
XFILLER_173_1119 VGND VGND VPWR VPWR sky130_fd_sc_hd__fill_1
XFILLER_138_1239 VGND VGND VPWR VPWR sky130_fd_sc_hd__decap_6
XFILLER_253_1121 VPWR VGND VPWR VGND sky130_ef_sc_hd__decap_12
XFILLER_218_1241 VPWR VGND VPWR VGND sky130_ef_sc_hd__decap_12
XPHY_EDGE_ROW_39_1_Left_294 VGND VGND VPWR VPWR sky130_fd_sc_hd__decap_3
XFILLER_214_1105 VPWR VGND VPWR VGND sky130_ef_sc_hd__decap_12
XFILLER_218_1285 VPWR VGND VPWR VGND sky130_ef_sc_hd__decap_12
XFILLER_64_1469 VGND VGND VPWR VPWR sky130_fd_sc_hd__fill_1
XFILLER_190_1477 VGND VGND VPWR VPWR sky130_fd_sc_hd__decap_6
XFILLER_214_1149 VPWR VGND VPWR VGND sky130_ef_sc_hd__decap_12
XFILLER_228_307 VGND VGND VPWR VPWR sky130_fd_sc_hd__fill_1
XFILLER_233_27 VPWR VGND VPWR VGND sky130_ef_sc_hd__decap_12
XFILLER_255_137 VGND VGND VPWR VPWR sky130_fd_sc_hd__decap_3
XFILLER_237_841 VPWR VGND VPWR VGND sky130_ef_sc_hd__decap_12
XFILLER_97_1201 VPWR VGND VPWR VGND sky130_ef_sc_hd__decap_12
XTAP_TAPCELL_ROW_128_2_4522 VGND VPWR sky130_fd_sc_hd__tapvpwrvgnd_1
XFILLER_114_1283 VPWR VGND VPWR VGND sky130_ef_sc_hd__decap_12
XFILLER_252_811 VGND VGND VPWR VPWR sky130_fd_sc_hd__fill_1
XFILLER_23_1177 VPWR VGND VPWR VGND sky130_ef_sc_hd__decap_12
XTAP_TAPCELL_ROW_182_1787 VGND VPWR sky130_fd_sc_hd__tapvpwrvgnd_1
XFILLER_224_513 VPWR VGND VPWR VGND sky130_ef_sc_hd__decap_12
XTAP_TAPCELL_ROW_182_1798 VGND VPWR sky130_fd_sc_hd__tapvpwrvgnd_1
XFILLER_188_1373 VPWR VGND VPWR VGND sky130_ef_sc_hd__decap_12
XFILLER_97_1267 VGND VGND VPWR VPWR sky130_fd_sc_hd__decap_6
XTAP_TAPCELL_ROW_96_2_4333 VGND VPWR sky130_fd_sc_hd__tapvpwrvgnd_1
XFILLER_224_557 VPWR VGND VPWR VGND sky130_ef_sc_hd__decap_12
XFILLER_184_1259 VGND VGND VPWR VPWR sky130_fd_sc_hd__fill_1
XFILLER_149_1379 VGND VGND VPWR VPWR sky130_fd_sc_hd__decap_6
XFILLER_225_1201 VPWR VGND VPWR VGND sky130_ef_sc_hd__decap_12
XFILLER_229_1381 VPWR VGND VPWR VGND sky130_ef_sc_hd__decap_12
XFILLER_189_461 VPWR VGND VPWR VGND sky130_ef_sc_hd__decap_12
XFILLER_225_1245 VPWR VGND VPWR VGND sky130_ef_sc_hd__decap_12
XFILLER_176_133 VGND VGND VPWR VPWR sky130_fd_sc_hd__decap_6
XFILLER_225_1289 VPWR VGND VPWR VGND sky130_ef_sc_hd__decap_12
XTAP_TAPCELL_ROW_230_3102 VGND VPWR sky130_fd_sc_hd__tapvpwrvgnd_1
XFILLER_176_177 VPWR VGND VPWR VGND sky130_ef_sc_hd__decap_12
XFILLER_192_637 VGND VGND VPWR VPWR sky130_fd_sc_hd__decap_6
XFILLER_34_1295 VGND VGND VPWR VPWR sky130_fd_sc_hd__decap_6
XFILLER_121_1243 VPWR VGND VPWR VGND sky130_ef_sc_hd__decap_12
XFILLER_191_125 VPWR VGND VPWR VGND sky130_ef_sc_hd__decap_12
XFILLER_11_39 VPWR VGND VPWR VGND sky130_ef_sc_hd__decap_12
XFILLER_121_1287 VPWR VGND VPWR VGND sky130_ef_sc_hd__decap_12
XFILLER_191_169 VPWR VGND VPWR VGND sky130_ef_sc_hd__decap_12
XPHY_EDGE_ROW_200_Left_455 VGND VGND VPWR VPWR sky130_fd_sc_hd__decap_3
XTAP_TAPCELL_ROW_13_1_1148 VGND VPWR sky130_fd_sc_hd__tapvpwrvgnd_1
XFILLER_127_39 VPWR VGND VPWR VGND sky130_ef_sc_hd__decap_12
XFILLER_173_895 VGND VGND VPWR VPWR sky130_fd_sc_hd__fill_1
XFILLER_156_1339 VPWR VGND VPWR VGND sky130_ef_sc_hd__decap_12
XFILLER_236_1341 VPWR VGND VPWR VGND sky130_ef_sc_hd__decap_12
XFILLER_195_1399 VGND VGND VPWR VPWR sky130_fd_sc_hd__fill_1
XTAP_TAPCELL_ROW_228_3031 VGND VPWR sky130_fd_sc_hd__tapvpwrvgnd_1
XFILLER_8_1105 VPWR VGND VPWR VGND sky130_ef_sc_hd__decap_12
XTAP_TAPCELL_ROW_228_3042 VGND VPWR sky130_fd_sc_hd__tapvpwrvgnd_1
XTAP_TAPCELL_ROW_228_3053 VGND VPWR sky130_fd_sc_hd__tapvpwrvgnd_1
XFILLER_232_1205 VPWR VGND VPWR VGND sky130_ef_sc_hd__decap_12
XFILLER_236_1385 VPWR VGND VPWR VGND sky130_ef_sc_hd__decap_12
XTAP_TAPCELL_ROW_9_1100 VGND VPWR sky130_fd_sc_hd__tapvpwrvgnd_1
XTAP_TAPCELL_ROW_9_1111 VGND VPWR sky130_fd_sc_hd__tapvpwrvgnd_1
XTAP_TAPCELL_ROW_9_1122 VGND VPWR sky130_fd_sc_hd__tapvpwrvgnd_1
XFILLER_8_1149 VPWR VGND VPWR VGND sky130_ef_sc_hd__decap_12
XFILLER_143_27 VPWR VGND VPWR VGND sky130_ef_sc_hd__decap_12
XTAP_TAPCELL_ROW_9_1133 VGND VPWR sky130_fd_sc_hd__tapvpwrvgnd_1
XTAP_TAPCELL_ROW_23_2_3892 VGND VPWR sky130_fd_sc_hd__tapvpwrvgnd_1
XTAP_TAPCELL_ROW_9_1144 VGND VPWR sky130_fd_sc_hd__tapvpwrvgnd_1
XFILLER_219_329 VGND VGND VPWR VPWR sky130_fd_sc_hd__decap_6
XFILLER_80_1271 VPWR VGND VPWR VGND sky130_ef_sc_hd__decap_12
XTAP_TAPCELL_ROW_5_1008 VGND VPWR sky130_fd_sc_hd__tapvpwrvgnd_1
XFILLER_41_1255 VPWR VGND VPWR VGND sky130_ef_sc_hd__decap_12
XFILLER_132_1383 VPWR VGND VPWR VGND sky130_ef_sc_hd__decap_12
XFILLER_167_1413 VPWR VGND VPWR VGND sky130_ef_sc_hd__decap_12
XFILLER_223_93 VPWR VGND VPWR VGND sky130_ef_sc_hd__decap_12
XFILLER_227_373 VPWR VGND VPWR VGND sky130_ef_sc_hd__decap_12
XFILLER_243_833 VGND VGND VPWR VPWR sky130_fd_sc_hd__decap_6
XFILLER_41_1299 VPWR VGND VPWR VGND sky130_ef_sc_hd__decap_12
XFILLER_242_321 VPWR VGND VPWR VGND sky130_ef_sc_hd__decap_12
XFILLER_199_225 VPWR VGND VPWR VGND sky130_ef_sc_hd__decap_12
XFILLER_167_1457 VPWR VGND VPWR VGND sky130_ef_sc_hd__decap_12
XFILLER_243_877 VPWR VGND VPWR VGND sky130_ef_sc_hd__decap_12
XPHY_EDGE_ROW_152_1_Right_808 VGND VGND VPWR VPWR sky130_fd_sc_hd__decap_3
XFILLER_243_1301 VPWR VGND VPWR VGND sky130_ef_sc_hd__decap_12
XFILLER_242_365 VPWR VGND VPWR VGND sky130_ef_sc_hd__decap_12
XFILLER_208_1421 VGND VGND VPWR VPWR sky130_fd_sc_hd__decap_6
XPHY_EDGE_ROW_95_2_Right_186 VGND VGND VPWR VPWR sky130_fd_sc_hd__decap_3
XFILLER_247_1481 VPWR VGND VPWR VGND sky130_ef_sc_hd__decap_12
XFILLER_168_601 VPWR VGND VPWR VGND sky130_ef_sc_hd__decap_12
XFILLER_243_1345 VPWR VGND VPWR VGND sky130_ef_sc_hd__decap_12
XFILLER_208_1465 VPWR VGND VPWR VGND sky130_ef_sc_hd__decap_12
XTAP_TAPCELL_ROW_200_2282 VGND VPWR sky130_fd_sc_hd__tapvpwrvgnd_1
XFILLER_211_741 VPWR VGND VPWR VGND sky130_ef_sc_hd__decap_12
XFILLER_167_111 VGND VGND VPWR VPWR sky130_fd_sc_hd__fill_1
XTAP_TAPCELL_ROW_200_2293 VGND VPWR sky130_fd_sc_hd__tapvpwrvgnd_1
XFILLER_168_645 VPWR VGND VPWR VGND sky130_ef_sc_hd__decap_12
XFILLER_126_1165 VPWR VGND VPWR VGND sky130_ef_sc_hd__decap_12
XFILLER_204_1329 VPWR VGND VPWR VGND sky130_ef_sc_hd__decap_12
XFILLER_210_251 VGND VGND VPWR VPWR sky130_fd_sc_hd__fill_1
XFILLER_211_785 VPWR VGND VPWR VGND sky130_ef_sc_hd__decap_12
XFILLER_52_1351 VGND VGND VPWR VPWR sky130_fd_sc_hd__decap_6
XFILLER_183_615 VGND VGND VPWR VPWR sky130_fd_sc_hd__fill_1
XTAP_TAPCELL_ROW_192_2061 VGND VPWR sky130_fd_sc_hd__tapvpwrvgnd_1
XTAP_TAPCELL_ROW_192_2072 VGND VPWR sky130_fd_sc_hd__tapvpwrvgnd_1
XFILLER_7_839 VGND VGND VPWR VPWR sky130_fd_sc_hd__fill_1
XTAP_TAPCELL_ROW_154_2_4678 VGND VPWR sky130_fd_sc_hd__tapvpwrvgnd_1
XFILLER_195_497 VGND VGND VPWR VPWR sky130_fd_sc_hd__decap_6
XFILLER_52_1395 VPWR VGND VPWR VGND sky130_ef_sc_hd__decap_12
XFILLER_104_1463 VGND VGND VPWR VPWR sky130_fd_sc_hd__decap_6
XTAP_TAPCELL_ROW_213_2632 VGND VPWR sky130_fd_sc_hd__tapvpwrvgnd_1
XFILLER_13_1379 VGND VGND VPWR VPWR sky130_fd_sc_hd__decap_6
XFILLER_100_1327 VPWR VGND VPWR VGND sky130_ef_sc_hd__decap_12
XFILLER_170_309 VPWR VGND VPWR VGND sky130_ef_sc_hd__decap_12
XTAP_TAPCELL_ROW_213_2643 VGND VPWR sky130_fd_sc_hd__tapvpwrvgnd_1
XFILLER_201_3 VPWR VGND VPWR VGND sky130_ef_sc_hd__decap_12
XFILLER_2_533 VGND VGND VPWR VPWR sky130_fd_sc_hd__fill_1
Xsram0_673 VGND VGND VPWR VPWR sram0_673/HI net673 sky130_fd_sc_hd__conb_1
XFILLER_254_1441 VPWR VGND VPWR VGND sky130_ef_sc_hd__decap_12
Xsram0_684 VGND VGND VPWR VPWR net684 sram0_684/LO sky130_fd_sc_hd__conb_1
XFILLER_172_1141 VGND VGND VPWR VPWR sky130_fd_sc_hd__decap_6
XFILLER_215_1425 VPWR VGND VPWR VGND sky130_ef_sc_hd__decap_12
XFILLER_254_1485 VPWR VGND VPWR VGND sky130_ef_sc_hd__decap_12
XFILLER_46_1177 VPWR VGND VPWR VGND sky130_ef_sc_hd__decap_12
XFILLER_172_1185 VPWR VGND VPWR VGND sky130_ef_sc_hd__decap_12
XFILLER_215_1469 VPWR VGND VPWR VGND sky130_ef_sc_hd__decap_12
XTAP_TAPCELL_ROW_114_2_4441 VGND VPWR sky130_fd_sc_hd__tapvpwrvgnd_1
XFILLER_63_1491 VGND VGND VPWR VPWR sky130_fd_sc_hd__decap_6
XFILLER_237_137 VPWR VGND VPWR VGND sky130_ef_sc_hd__decap_12
XFILLER_219_841 VPWR VGND VPWR VGND sky130_ef_sc_hd__decap_12
XFILLER_111_1423 VPWR VGND VPWR VGND sky130_ef_sc_hd__decap_12
XTAP_TAPCELL_ROW_207_2469 VGND VPWR sky130_fd_sc_hd__tapvpwrvgnd_1
XFILLER_150_1483 VPWR VGND VPWR VGND sky130_ef_sc_hd__decap_12
XFILLER_234_811 VGND VGND VPWR VPWR sky130_fd_sc_hd__fill_1
XFILLER_20_1339 VPWR VGND VPWR VGND sky130_ef_sc_hd__decap_12
XFILLER_206_513 VPWR VGND VPWR VGND sky130_ef_sc_hd__decap_12
XFILLER_185_1513 VGND VGND VPWR VPWR sky130_fd_sc_hd__fill_2
XFILLER_246_693 VGND VGND VPWR VPWR sky130_fd_sc_hd__decap_6
XFILLER_94_1407 VGND VGND VPWR VPWR sky130_fd_sc_hd__decap_6
XFILLER_111_1467 VPWR VGND VPWR VGND sky130_ef_sc_hd__decap_12
XFILLER_245_181 VPWR VGND VPWR VGND sky130_ef_sc_hd__decap_12
XTAP_TAPCELL_ROW_199_2248 VGND VPWR sky130_fd_sc_hd__tapvpwrvgnd_1
XTAP_TAPCELL_ROW_199_2259 VGND VPWR sky130_fd_sc_hd__tapvpwrvgnd_1
XFILLER_206_557 VPWR VGND VPWR VGND sky130_ef_sc_hd__decap_12
X_506_ net178 net76 VGND VGND VPWR VPWR acc_core.adder.cla_blocks\[6\].block.sum\[1\]
+ sky130_fd_sc_hd__xor2_1
XFILLER_221_505 VPWR VGND VPWR VGND sky130_ef_sc_hd__decap_12
XFILLER_187_921 VPWR VGND VPWR VGND sky130_ef_sc_hd__decap_12
XFILLER_57_1273 VGND VGND VPWR VPWR sky130_fd_sc_hd__fill_1
X_437_ net597 net535 dout0_q\[20\] VGND VGND VPWR VPWR _226_ sky130_fd_sc_hd__and3_1
XFILLER_183_1281 VGND VGND VPWR VPWR sky130_fd_sc_hd__decap_6
XFILLER_187_965 VPWR VGND VPWR VGND sky130_ef_sc_hd__decap_12
XFILLER_222_1429 VPWR VGND VPWR VGND sky130_ef_sc_hd__decap_12
XFILLER_109_1385 VGND VGND VPWR VPWR sky130_fd_sc_hd__fill_1
X_368_ net161 _156_ VGND VGND VPWR VPWR _157_ sky130_fd_sc_hd__or2_1
XFILLER_70_1451 VPWR VGND VPWR VGND sky130_ef_sc_hd__decap_12
XFILLER_186_475 VGND VGND VPWR VPWR sky130_fd_sc_hd__fill_1
XFILLER_201_273 VGND VGND VPWR VPWR sky130_fd_sc_hd__decap_6
XFILLER_174_637 VGND VGND VPWR VPWR sky130_fd_sc_hd__decap_6
XFILLER_31_1435 VGND VGND VPWR VPWR sky130_fd_sc_hd__decap_6
XFILLER_173_125 VPWR VGND VPWR VGND sky130_ef_sc_hd__decap_12
XFILLER_228_27 VGND VGND VPWR VPWR sky130_fd_sc_hd__fill_1
X_299_ net623 net616 VGND VGND VPWR VPWR _074_ sky130_fd_sc_hd__xnor2_1
XFILLER_70_1495 VPWR VGND VPWR VGND sky130_ef_sc_hd__decap_12
XFILLER_31_1479 VPWR VGND VPWR VGND sky130_ef_sc_hd__decap_12
XFILLER_173_169 VPWR VGND VPWR VGND sky130_ef_sc_hd__decap_12
XFILLER_255_1205 VPWR VGND VPWR VGND sky130_ef_sc_hd__decap_12
XFILLER_220_1197 VGND VGND VPWR VPWR sky130_fd_sc_hd__decap_6
XFILLER_6_872 VPWR VGND VPWR VGND sky130_ef_sc_hd__decap_12
XFILLER_182_681 VPWR VGND VPWR VGND sky130_ef_sc_hd__decap_12
XFILLER_177_1063 VGND VGND VPWR VPWR sky130_fd_sc_hd__fill_1
XTAP_TAPCELL_ROW_171_1499 VGND VPWR sky130_fd_sc_hd__tapvpwrvgnd_1
XFILLER_47_3 VPWR VGND VPWR VGND sky130_ef_sc_hd__decap_12
XFILLER_5_393 VGND VGND VPWR VPWR sky130_fd_sc_hd__fill_1
XFILLER_244_15 VPWR VGND VPWR VGND sky130_ef_sc_hd__decap_12
XFILLER_29_1331 VPWR VGND VPWR VGND sky130_ef_sc_hd__decap_12
XFILLER_9_1425 VGND VGND VPWR VPWR sky130_fd_sc_hd__decap_3
XFILLER_116_1301 VGND VGND VPWR VPWR sky130_fd_sc_hd__fill_1
XTAP_TAPCELL_ROW_188_1952 VGND VPWR sky130_fd_sc_hd__tapvpwrvgnd_1
XFILLER_190_1241 VPWR VGND VPWR VGND sky130_ef_sc_hd__decap_12
XTAP_TAPCELL_ROW_188_1963 VGND VPWR sky130_fd_sc_hd__tapvpwrvgnd_1
XFILLER_25_1217 VGND VGND VPWR VPWR sky130_fd_sc_hd__fill_1
XFILLER_218_1093 VPWR VGND VPWR VGND sky130_ef_sc_hd__decap_12
XFILLER_3_51 VGND VGND VPWR VPWR sky130_fd_sc_hd__decap_4
XTAP_TAPCELL_ROW_188_1974 VGND VPWR sky130_fd_sc_hd__tapvpwrvgnd_1
XFILLER_9_1469 VPWR VGND VPWR VGND sky130_ef_sc_hd__decap_12
XFILLER_190_1285 VPWR VGND VPWR VGND sky130_ef_sc_hd__decap_12
XTAP_TAPCELL_ROW_184_1849 VGND VPWR sky130_fd_sc_hd__tapvpwrvgnd_1
XFILLER_99_1329 VGND VGND VPWR VPWR sky130_fd_sc_hd__fill_1
XFILLER_249_1009 VPWR VGND VPWR VGND sky130_ef_sc_hd__decap_12
XFILLER_237_671 VGND VGND VPWR VPWR sky130_fd_sc_hd__fill_1
XFILLER_209_373 VPWR VGND VPWR VGND sky130_ef_sc_hd__decap_12
XFILLER_3_1057 VGND VGND VPWR VPWR sky130_fd_sc_hd__decap_6
XFILLER_225_833 VGND VGND VPWR VPWR sky130_fd_sc_hd__decap_6
XFILLER_224_321 VPWR VGND VPWR VGND sky130_ef_sc_hd__decap_12
XFILLER_225_877 VPWR VGND VPWR VGND sky130_ef_sc_hd__decap_12
XFILLER_149_1165 VPWR VGND VPWR VGND sky130_ef_sc_hd__decap_12
XFILLER_224_365 VPWR VGND VPWR VGND sky130_ef_sc_hd__decap_12
XFILLER_240_825 VPWR VGND VPWR VGND sky130_ef_sc_hd__decap_12
XFILLER_197_729 VPWR VGND VPWR VGND sky130_ef_sc_hd__decap_12
XFILLER_240_869 VPWR VGND VPWR VGND sky130_ef_sc_hd__decap_12
XFILLER_127_1441 VGND VGND VPWR VPWR sky130_fd_sc_hd__fill_1
XFILLER_36_1357 VGND VGND VPWR VPWR sky130_fd_sc_hd__fill_1
XTAP_TAPCELL_ROW_140_2_4597 VGND VPWR sky130_fd_sc_hd__tapvpwrvgnd_1
XFILLER_22_27 VGND VGND VPWR VPWR sky130_fd_sc_hd__fill_1
XFILLER_192_401 VPWR VGND VPWR VGND sky130_ef_sc_hd__decap_12
XFILLER_177_497 VGND VGND VPWR VPWR sky130_fd_sc_hd__decap_6
XFILLER_138_27 VGND VGND VPWR VPWR sky130_fd_sc_hd__fill_1
XFILLER_192_445 VPWR VGND VPWR VGND sky130_ef_sc_hd__decap_12
XFILLER_192_489 VPWR VGND VPWR VGND sky130_ef_sc_hd__decap_12
XTAP_TAPCELL_ROW_120_2_4473 VGND VPWR sky130_fd_sc_hd__tapvpwrvgnd_1
XTAP_TAPCELL_ROW_119_2_4467 VGND VPWR sky130_fd_sc_hd__tapvpwrvgnd_1
XFILLER_69_1177 VPWR VGND VPWR VGND sky130_ef_sc_hd__decap_12
XFILLER_154_15 VPWR VGND VPWR VGND sky130_ef_sc_hd__decap_12
XTAP_TAPCELL_ROW_87_2_4278 VGND VPWR sky130_fd_sc_hd__tapvpwrvgnd_1
XFILLER_248_925 VPWR VGND VPWR VGND sky130_ef_sc_hd__decap_12
XFILLER_232_1035 VGND VGND VPWR VPWR sky130_fd_sc_hd__fill_1
XFILLER_47_1497 VGND VGND VPWR VPWR sky130_fd_sc_hd__fill_1
XFILLER_219_137 VPWR VGND VPWR VGND sky130_ef_sc_hd__decap_12
XTAP_TAPCELL_ROW_67_2_4154 VGND VPWR sky130_fd_sc_hd__tapvpwrvgnd_1
XFILLER_216_811 VGND VGND VPWR VPWR sky130_fd_sc_hd__fill_1
XFILLER_132_1191 VPWR VGND VPWR VGND sky130_ef_sc_hd__decap_12
XFILLER_228_693 VGND VGND VPWR VPWR sky130_fd_sc_hd__decap_6
XFILLER_227_181 VPWR VGND VPWR VGND sky130_ef_sc_hd__decap_12
XFILLER_243_641 VPWR VGND VPWR VGND sky130_ef_sc_hd__decap_12
XTAP_TAPCELL_ROW_202_2333 VGND VPWR sky130_fd_sc_hd__tapvpwrvgnd_1
XTAP_TAPCELL_ROW_202_2344 VGND VPWR sky130_fd_sc_hd__tapvpwrvgnd_1
XFILLER_203_505 VPWR VGND VPWR VGND sky130_ef_sc_hd__decap_12
XFILLER_243_685 VPWR VGND VPWR VGND sky130_ef_sc_hd__decap_12
XFILLER_128_1227 VPWR VGND VPWR VGND sky130_ef_sc_hd__decap_12
XFILLER_19_1511 VGND VGND VPWR VPWR sky130_fd_sc_hd__decap_4
XFILLER_167_1287 VGND VGND VPWR VPWR sky130_fd_sc_hd__fill_1
XFILLER_151_3 VPWR VGND VPWR VGND sky130_ef_sc_hd__decap_12
XPHY_EDGE_ROW_153_1_Right_809 VGND VGND VPWR VPWR sky130_fd_sc_hd__decap_3
XTAP_TAPCELL_ROW_194_2112 VGND VPWR sky130_fd_sc_hd__tapvpwrvgnd_1
XFILLER_54_1413 VGND VGND VPWR VPWR sky130_fd_sc_hd__fill_1
XFILLER_169_921 VPWR VGND VPWR VGND sky130_ef_sc_hd__decap_12
XFILLER_187_217 VGND VGND VPWR VPWR sky130_fd_sc_hd__decap_6
XFILLER_249_3 VPWR VGND VPWR VGND sky130_ef_sc_hd__decap_12
XFILLER_242_195 VGND VGND VPWR VPWR sky130_fd_sc_hd__fill_1
XTAP_TAPCELL_ROW_194_2123 VGND VPWR sky130_fd_sc_hd__tapvpwrvgnd_1
XPHY_EDGE_ROW_96_2_Right_187 VGND VGND VPWR VPWR sky130_fd_sc_hd__decap_3
XFILLER_180_1421 VGND VGND VPWR VPWR sky130_fd_sc_hd__decap_6
XTAP_TAPCELL_ROW_194_2134 VGND VPWR sky130_fd_sc_hd__tapvpwrvgnd_1
XFILLER_230_357 VGND VGND VPWR VPWR sky130_fd_sc_hd__decap_6
XFILLER_208_1273 VPWR VGND VPWR VGND sky130_ef_sc_hd__decap_12
XFILLER_169_965 VPWR VGND VPWR VGND sky130_ef_sc_hd__decap_12
XFILLER_243_1175 VGND VGND VPWR VPWR sky130_fd_sc_hd__fill_1
XFILLER_8_29 VPWR VGND VPWR VGND sky130_ef_sc_hd__decap_12
XFILLER_180_1465 VPWR VGND VPWR VGND sky130_ef_sc_hd__decap_12
XTAP_TAPCELL_ROW_190_2009 VGND VPWR sky130_fd_sc_hd__tapvpwrvgnd_1
Xwire501 net502 VGND VGND VPWR VPWR net501 sky130_fd_sc_hd__clkbuf_1
Xwire512 _092_ VGND VGND VPWR VPWR net512 sky130_fd_sc_hd__clkbuf_1
XFILLER_168_475 VGND VGND VPWR VPWR sky130_fd_sc_hd__fill_1
XFILLER_195_261 VPWR VGND VPWR VGND sky130_ef_sc_hd__decap_12
Xwire545 net46 VGND VGND VPWR VPWR net545 sky130_fd_sc_hd__clkbuf_1
XFILLER_184_979 VGND VGND VPWR VPWR sky130_fd_sc_hd__fill_1
XFILLER_195_55 VGND VGND VPWR VPWR sky130_fd_sc_hd__fill_1
XFILLER_104_1271 VPWR VGND VPWR VGND sky130_ef_sc_hd__decap_12
XFILLER_13_1165 VPWR VGND VPWR VGND sky130_ef_sc_hd__decap_12
Xwire589 dout0_q\[0\] VGND VGND VPWR VPWR net589 sky130_fd_sc_hd__clkbuf_1
XFILLER_171_629 VPWR VGND VPWR VGND sky130_ef_sc_hd__decap_12
XFILLER_87_1255 VPWR VGND VPWR VGND sky130_ef_sc_hd__decap_12
XFILLER_139_1323 VGND VGND VPWR VPWR sky130_fd_sc_hd__decap_6
XFILLER_174_1203 VGND VGND VPWR VPWR sky130_fd_sc_hd__fill_1
XFILLER_170_139 VGND VGND VPWR VPWR sky130_fd_sc_hd__fill_1
XFILLER_48_1239 VGND VGND VPWR VPWR sky130_fd_sc_hd__decap_6
XFILLER_87_1299 VPWR VGND VPWR VGND sky130_ef_sc_hd__decap_12
XFILLER_88_53 VPWR VGND VPWR VGND sky130_ef_sc_hd__decap_12
XFILLER_139_1367 VPWR VGND VPWR VGND sky130_ef_sc_hd__decap_12
XPHY_EDGE_ROW_118_2_Left_620 VGND VGND VPWR VPWR sky130_fd_sc_hd__decap_3
XFILLER_3_897 VPWR VGND VPWR VGND sky130_ef_sc_hd__decap_12
XFILLER_215_1233 VPWR VGND VPWR VGND sky130_ef_sc_hd__decap_12
XFILLER_238_413 VGND VGND VPWR VPWR sky130_fd_sc_hd__decap_6
XFILLER_214_29 VPWR VGND VPWR VGND sky130_ef_sc_hd__decap_12
XFILLER_211_1119 VGND VGND VPWR VPWR sky130_fd_sc_hd__fill_1
XFILLER_238_457 VPWR VGND VPWR VGND sky130_ef_sc_hd__decap_12
XFILLER_254_917 VGND VGND VPWR VPWR sky130_fd_sc_hd__decap_6
XFILLER_253_405 VPWR VGND VPWR VGND sky130_ef_sc_hd__decap_12
XFILLER_219_671 VGND VGND VPWR VPWR sky130_fd_sc_hd__fill_1
XFILLER_24_1283 VPWR VGND VPWR VGND sky130_ef_sc_hd__decap_12
XFILLER_111_1231 VPWR VGND VPWR VGND sky130_ef_sc_hd__decap_12
XFILLER_98_1351 VGND VGND VPWR VPWR sky130_fd_sc_hd__decap_6
XFILLER_168_1029 VGND VGND VPWR VPWR sky130_fd_sc_hd__decap_6
XFILLER_207_833 VGND VGND VPWR VPWR sky130_fd_sc_hd__decap_6
XFILLER_253_449 VPWR VGND VPWR VGND sky130_ef_sc_hd__decap_12
XFILLER_206_321 VPWR VGND VPWR VGND sky130_ef_sc_hd__decap_12
XFILLER_94_1215 VPWR VGND VPWR VGND sky130_ef_sc_hd__decap_12
XFILLER_111_1275 VPWR VGND VPWR VGND sky130_ef_sc_hd__decap_12
XFILLER_98_1395 VPWR VGND VPWR VGND sky130_ef_sc_hd__decap_12
XFILLER_185_1343 VGND VGND VPWR VPWR sky130_fd_sc_hd__fill_1
XFILLER_207_877 VPWR VGND VPWR VGND sky130_ef_sc_hd__decap_12
XFILLER_206_365 VPWR VGND VPWR VGND sky130_ef_sc_hd__decap_12
XFILLER_222_825 VPWR VGND VPWR VGND sky130_ef_sc_hd__decap_12
XFILLER_59_1379 VGND VGND VPWR VPWR sky130_fd_sc_hd__decap_6
XFILLER_94_1259 VPWR VGND VPWR VGND sky130_ef_sc_hd__decap_12
XFILLER_146_1327 VPWR VGND VPWR VGND sky130_ef_sc_hd__decap_12
XFILLER_179_729 VPWR VGND VPWR VGND sky130_ef_sc_hd__decap_12
XFILLER_221_335 VGND VGND VPWR VPWR sky130_fd_sc_hd__fill_1
XFILLER_222_869 VPWR VGND VPWR VGND sky130_ef_sc_hd__decap_12
XFILLER_226_1373 VPWR VGND VPWR VGND sky130_ef_sc_hd__decap_12
XFILLER_239_15 VPWR VGND VPWR VGND sky130_ef_sc_hd__decap_12
XTAP_TAPCELL_ROW_177_1653 VGND VPWR sky130_fd_sc_hd__tapvpwrvgnd_1
XFILLER_174_401 VPWR VGND VPWR VGND sky130_ef_sc_hd__decap_12
XTAP_TAPCELL_ROW_177_1664 VGND VPWR sky130_fd_sc_hd__tapvpwrvgnd_1
XTAP_TAPCELL_ROW_177_1675 VGND VPWR sky130_fd_sc_hd__tapvpwrvgnd_1
XFILLER_222_1259 VGND VGND VPWR VPWR sky130_fd_sc_hd__fill_1
XFILLER_174_445 VPWR VGND VPWR VGND sky130_ef_sc_hd__decap_12
XFILLER_190_905 VPWR VGND VPWR VGND sky130_ef_sc_hd__decap_12
XFILLER_31_1243 VPWR VGND VPWR VGND sky130_ef_sc_hd__decap_12
XFILLER_122_1371 VPWR VGND VPWR VGND sky130_ef_sc_hd__decap_12
XTAP_TAPCELL_ROW_105_2_4386 VGND VPWR sky130_fd_sc_hd__tapvpwrvgnd_1
XFILLER_174_489 VPWR VGND VPWR VGND sky130_ef_sc_hd__decap_12
XFILLER_179_1169 VGND VGND VPWR VPWR sky130_fd_sc_hd__decap_6
XFILLER_31_1287 VPWR VGND VPWR VGND sky130_ef_sc_hd__decap_12
XFILLER_190_949 VPWR VGND VPWR VGND sky130_ef_sc_hd__decap_12
XFILLER_157_1423 VPWR VGND VPWR VGND sky130_ef_sc_hd__decap_12
XFILLER_196_1483 VGND VGND VPWR VPWR sky130_fd_sc_hd__fill_1
XFILLER_6_691 VGND VGND VPWR VPWR sky130_fd_sc_hd__decap_8
XFILLER_255_69 VPWR VGND VPWR VGND sky130_ef_sc_hd__decap_12
XFILLER_66_1339 VPWR VGND VPWR VGND sky130_ef_sc_hd__decap_12
XFILLER_5_190 VGND VGND VPWR VPWR sky130_fd_sc_hd__fill_1
XFILLER_118_1407 VGND VGND VPWR VPWR sky130_fd_sc_hd__decap_6
XFILLER_157_1467 VPWR VGND VPWR VGND sky130_ef_sc_hd__decap_12
XFILLER_9_1233 VPWR VGND VPWR VGND sky130_ef_sc_hd__decap_12
XFILLER_155_1180 VPWR VGND VPWR VGND sky130_ef_sc_hd__decap_12
XFILLER_124_29 VPWR VGND VPWR VGND sky130_ef_sc_hd__decap_12
XFILLER_190_1093 VPWR VGND VPWR VGND sky130_ef_sc_hd__decap_12
XTAP_TAPCELL_ROW_53_2_4073 VGND VPWR sky130_fd_sc_hd__tapvpwrvgnd_1
XFILLER_5_1119 VGND VGND VPWR VPWR sky130_fd_sc_hd__fill_1
XFILLER_233_1399 VGND VGND VPWR VPWR sky130_fd_sc_hd__fill_1
XFILLER_42_1383 VPWR VGND VPWR VGND sky130_ef_sc_hd__decap_12
XFILLER_17_27 VPWR VGND VPWR VGND sky130_ef_sc_hd__decap_12
XFILLER_186_1129 VPWR VGND VPWR VGND sky130_ef_sc_hd__decap_12
XTAP_TAPCELL_ROW_0_823 VGND VPWR sky130_fd_sc_hd__tapvpwrvgnd_1
XFILLER_209_181 VPWR VGND VPWR VGND sky130_ef_sc_hd__decap_12
XTAP_TAPCELL_ROW_0_834 VGND VPWR sky130_fd_sc_hd__tapvpwrvgnd_1
XFILLER_225_641 VPWR VGND VPWR VGND sky130_ef_sc_hd__decap_12
XTAP_TAPCELL_ROW_0_845 VGND VPWR sky130_fd_sc_hd__tapvpwrvgnd_1
XFILLER_77_1435 VGND VGND VPWR VPWR sky130_fd_sc_hd__decap_6
XTAP_TAPCELL_ROW_0_856 VGND VPWR sky130_fd_sc_hd__tapvpwrvgnd_1
XTAP_TAPCELL_ROW_0_867 VGND VPWR sky130_fd_sc_hd__tapvpwrvgnd_1
XFILLER_225_685 VPWR VGND VPWR VGND sky130_ef_sc_hd__decap_12
XFILLER_77_1479 VPWR VGND VPWR VGND sky130_ef_sc_hd__decap_12
XFILLER_164_1427 VPWR VGND VPWR VGND sky130_ef_sc_hd__decap_12
XFILLER_169_217 VGND VGND VPWR VPWR sky130_fd_sc_hd__decap_6
XFILLER_224_195 VGND VGND VPWR VPWR sky130_fd_sc_hd__fill_1
XFILLER_33_15 VPWR VGND VPWR VGND sky130_ef_sc_hd__decap_12
XTAP_TAPCELL_ROW_31_2_3943 VGND VPWR sky130_fd_sc_hd__tapvpwrvgnd_1
XFILLER_197_559 VGND VGND VPWR VPWR sky130_fd_sc_hd__fill_1
XFILLER_205_1413 VPWR VGND VPWR VGND sky130_ef_sc_hd__decap_12
XFILLER_212_357 VGND VGND VPWR VPWR sky130_fd_sc_hd__decap_6
XFILLER_220_83 VGND VGND VPWR VPWR sky130_fd_sc_hd__fill_1
XTAP_TAPCELL_ROW_255_3764 VGND VPWR sky130_fd_sc_hd__tapvpwrvgnd_1
XTAP_TAPCELL_ROW_255_3775 VGND VPWR sky130_fd_sc_hd__tapvpwrvgnd_1
XFILLER_149_15 VPWR VGND VPWR VGND sky130_ef_sc_hd__decap_12
XTAP_TAPCELL_ROW_255_3786 VGND VPWR sky130_fd_sc_hd__tapvpwrvgnd_1
XFILLER_240_1315 VGND VGND VPWR VPWR sky130_fd_sc_hd__fill_1
XFILLER_240_699 VGND VGND VPWR VPWR sky130_fd_sc_hd__fill_1
XTAP_TAPCELL_ROW_255_3797 VGND VPWR sky130_fd_sc_hd__tapvpwrvgnd_1
XFILLER_36_1165 VPWR VGND VPWR VGND sky130_ef_sc_hd__decap_12
XFILLER_184_209 VPWR VGND VPWR VGND sky130_ef_sc_hd__decap_12
XFILLER_205_1457 VPWR VGND VPWR VGND sky130_ef_sc_hd__decap_12
XFILLER_177_261 VPWR VGND VPWR VGND sky130_ef_sc_hd__decap_12
XFILLER_193_721 VGND VGND VPWR VPWR sky130_fd_sc_hd__decap_6
XPHY_EDGE_ROW_116_1_Left_371 VGND VGND VPWR VPWR sky130_fd_sc_hd__decap_3
XFILLER_165_445 VGND VGND VPWR VPWR sky130_fd_sc_hd__decap_3
XFILLER_166_979 VGND VGND VPWR VPWR sky130_fd_sc_hd__fill_1
XFILLER_197_1225 VGND VGND VPWR VPWR sky130_fd_sc_hd__decap_6
XFILLER_193_765 VPWR VGND VPWR VGND sky130_ef_sc_hd__decap_12
XFILLER_14_1463 VGND VGND VPWR VPWR sky130_fd_sc_hd__decap_6
XFILLER_101_1411 VPWR VGND VPWR VGND sky130_ef_sc_hd__decap_12
XFILLER_192_253 VPWR VGND VPWR VGND sky130_ef_sc_hd__decap_12
XFILLER_140_1471 VPWR VGND VPWR VGND sky130_ef_sc_hd__decap_12
XFILLER_229_81 VPWR VGND VPWR VGND sky130_ef_sc_hd__decap_12
XFILLER_165_489 VPWR VGND VPWR VGND sky130_ef_sc_hd__decap_12
XFILLER_197_1269 VPWR VGND VPWR VGND sky130_ef_sc_hd__decap_12
XFILLER_10_1327 VPWR VGND VPWR VGND sky130_ef_sc_hd__decap_12
XFILLER_3_105 VGND VGND VPWR VPWR sky130_fd_sc_hd__decap_6
XFILLER_101_1455 VPWR VGND VPWR VGND sky130_ef_sc_hd__decap_12
XFILLER_3_149 VPWR VGND VPWR VGND sky130_ef_sc_hd__decap_12
XFILLER_84_1439 VPWR VGND VPWR VGND sky130_ef_sc_hd__decap_12
XFILLER_101_1499 VPWR VGND VPWR VGND sky130_ef_sc_hd__decap_12
XFILLER_165_69 VPWR VGND VPWR VGND sky130_ef_sc_hd__decap_12
XFILLER_136_1507 VGND VGND VPWR VPWR sky130_fd_sc_hd__decap_8
XTAP_TAPCELL_ROW_149_2_4651 VGND VPWR sky130_fd_sc_hd__tapvpwrvgnd_1
XFILLER_251_1455 VGND VGND VPWR VPWR sky130_fd_sc_hd__fill_1
XFILLER_0_867 VGND VGND VPWR VPWR sky130_fd_sc_hd__fill_1
XTAP_TAPCELL_ROW_162_2_4729 VGND VPWR sky130_fd_sc_hd__tapvpwrvgnd_1
XFILLER_248_755 VGND VGND VPWR VPWR sky130_fd_sc_hd__fill_1
XFILLER_199_3 VPWR VGND VPWR VGND sky130_ef_sc_hd__decap_12
XFILLER_181_57 VPWR VGND VPWR VGND sky130_ef_sc_hd__decap_12
XFILLER_236_917 VGND VGND VPWR VPWR sky130_fd_sc_hd__decap_6
XFILLER_235_405 VPWR VGND VPWR VGND sky130_ef_sc_hd__decap_12
XTAP_TAPCELL_ROW_204_2406 VGND VPWR sky130_fd_sc_hd__tapvpwrvgnd_1
XFILLER_21_1423 VPWR VGND VPWR VGND sky130_ef_sc_hd__decap_12
XFILLER_60_1483 VPWR VGND VPWR VGND sky130_ef_sc_hd__decap_12
XFILLER_210_1141 VGND VGND VPWR VPWR sky130_fd_sc_hd__decap_6
XFILLER_235_449 VPWR VGND VPWR VGND sky130_ef_sc_hd__decap_12
XFILLER_251_909 VPWR VGND VPWR VGND sky130_ef_sc_hd__decap_12
XTAP_TAPCELL_ROW_142_2_4605 VGND VPWR sky130_fd_sc_hd__tapvpwrvgnd_1
XFILLER_21_1467 VPWR VGND VPWR VGND sky130_ef_sc_hd__decap_12
XFILLER_244_961 VPWR VGND VPWR VGND sky130_ef_sc_hd__decap_12
XFILLER_210_1185 VPWR VGND VPWR VGND sky130_ef_sc_hd__decap_12
XFILLER_250_419 VGND VGND VPWR VPWR sky130_fd_sc_hd__fill_1
XFILLER_204_825 VPWR VGND VPWR VGND sky130_ef_sc_hd__decap_12
XFILLER_203_335 VGND VGND VPWR VPWR sky130_fd_sc_hd__fill_1
XFILLER_204_869 VPWR VGND VPWR VGND sky130_ef_sc_hd__decap_12
XFILLER_230_121 VPWR VGND VPWR VGND sky130_ef_sc_hd__decap_12
XFILLER_223_1513 VGND VGND VPWR VPWR sky130_fd_sc_hd__fill_2
XFILLER_230_165 VPWR VGND VPWR VGND sky130_ef_sc_hd__decap_12
XFILLER_90_65 VGND VGND VPWR VPWR sky130_fd_sc_hd__decap_6
XPHY_EDGE_ROW_97_2_Right_188 VGND VGND VPWR VPWR sky130_fd_sc_hd__decap_3
XFILLER_19_1385 VGND VGND VPWR VPWR sky130_fd_sc_hd__fill_1
XFILLER_141_1213 VGND VGND VPWR VPWR sky130_fd_sc_hd__decap_4
XFILLER_180_1273 VPWR VGND VPWR VGND sky130_ef_sc_hd__decap_12
XFILLER_8_923 VGND VGND VPWR VPWR sky130_fd_sc_hd__fill_1
XFILLER_196_581 VGND VGND VPWR VPWR sky130_fd_sc_hd__decap_6
Xwire320 net321 VGND VGND VPWR VPWR net320 sky130_fd_sc_hd__clkbuf_1
Xwire342 net343 VGND VGND VPWR VPWR net342 sky130_fd_sc_hd__clkbuf_1
XFILLER_172_905 VPWR VGND VPWR VGND sky130_ef_sc_hd__decap_12
Xwire353 net354 VGND VGND VPWR VPWR net353 sky130_fd_sc_hd__clkbuf_1
Xwire364 net365 VGND VGND VPWR VPWR net364 sky130_fd_sc_hd__clkbuf_1
XFILLER_221_1281 VGND VGND VPWR VPWR sky130_fd_sc_hd__decap_6
Xwire375 net376 VGND VGND VPWR VPWR net375 sky130_fd_sc_hd__clkbuf_1
XFILLER_176_1309 VGND VGND VPWR VPWR sky130_fd_sc_hd__decap_6
Xwire386 net387 VGND VGND VPWR VPWR net386 sky130_fd_sc_hd__clkbuf_1
Xmax_cap119 net120 VGND VGND VPWR VPWR net119 sky130_fd_sc_hd__clkbuf_1
Xwire397 net398 VGND VGND VPWR VPWR net397 sky130_fd_sc_hd__clkbuf_1
XFILLER_172_949 VPWR VGND VPWR VGND sky130_ef_sc_hd__decap_12
XFILLER_180_993 VPWR VGND VPWR VGND sky130_ef_sc_hd__decap_12
XFILLER_225_39 VPWR VGND VPWR VGND sky130_ef_sc_hd__decap_12
XFILLER_26_1301 VGND VGND VPWR VPWR sky130_fd_sc_hd__fill_1
XFILLER_238_221 VPWR VGND VPWR VGND sky130_ef_sc_hd__decap_12
XFILLER_215_1063 VGND VGND VPWR VPWR sky130_fd_sc_hd__fill_1
XFILLER_239_777 VGND VGND VPWR VPWR sky130_fd_sc_hd__decap_6
XTAP_TAPCELL_ROW_166_1354 VGND VPWR sky130_fd_sc_hd__tapvpwrvgnd_1
XFILLER_238_265 VPWR VGND VPWR VGND sky130_ef_sc_hd__decap_12
XTAP_TAPCELL_ROW_166_1365 VGND VPWR sky130_fd_sc_hd__tapvpwrvgnd_1
XFILLER_254_725 VPWR VGND VPWR VGND sky130_ef_sc_hd__decap_12
XFILLER_241_27 VPWR VGND VPWR VGND sky130_ef_sc_hd__decap_12
XTAP_TAPCELL_ROW_166_1376 VGND VPWR sky130_fd_sc_hd__tapvpwrvgnd_1
XTAP_TAPCELL_ROW_36_2_3969 VGND VPWR sky130_fd_sc_hd__tapvpwrvgnd_1
XFILLER_4_1141 VGND VGND VPWR VPWR sky130_fd_sc_hd__decap_6
XFILLER_187_1449 VGND VGND VPWR VPWR sky130_fd_sc_hd__decap_6
XFILLER_254_769 VPWR VGND VPWR VGND sky130_ef_sc_hd__decap_12
XFILLER_0_41 VPWR VGND VPWR VGND sky130_ef_sc_hd__decap_12
XFILLER_0_1005 VGND VGND VPWR VPWR sky130_fd_sc_hd__decap_3
XFILLER_207_641 VPWR VGND VPWR VGND sky130_ef_sc_hd__decap_12
XFILLER_4_1185 VPWR VGND VPWR VGND sky130_ef_sc_hd__decap_12
XFILLER_253_279 VGND VGND VPWR VPWR sky130_fd_sc_hd__fill_1
XFILLER_0_85 VPWR VGND VPWR VGND sky130_ef_sc_hd__decap_12
XFILLER_0_1049 VPWR VGND VPWR VGND sky130_ef_sc_hd__decap_12
XFILLER_207_685 VPWR VGND VPWR VGND sky130_ef_sc_hd__decap_12
XFILLER_59_1165 VPWR VGND VPWR VGND sky130_ef_sc_hd__decap_12
XTAP_TAPCELL_ROW_179_1715 VGND VPWR sky130_fd_sc_hd__tapvpwrvgnd_1
XTAP_TAPCELL_ROW_179_1726 VGND VPWR sky130_fd_sc_hd__tapvpwrvgnd_1
XFILLER_206_195 VGND VGND VPWR VPWR sky130_fd_sc_hd__fill_1
XFILLER_37_1441 VGND VGND VPWR VPWR sky130_fd_sc_hd__fill_1
XFILLER_179_559 VGND VGND VPWR VPWR sky130_fd_sc_hd__fill_1
XFILLER_166_209 VPWR VGND VPWR VGND sky130_ef_sc_hd__decap_12
XFILLER_222_699 VGND VGND VPWR VPWR sky130_fd_sc_hd__fill_1
XFILLER_175_721 VGND VGND VPWR VPWR sky130_fd_sc_hd__decap_6
XTAP_TAPCELL_ROW_155_2_4683 VGND VPWR sky130_fd_sc_hd__tapvpwrvgnd_1
XFILLER_175_765 VPWR VGND VPWR VGND sky130_ef_sc_hd__decap_12
XFILLER_174_253 VPWR VGND VPWR VGND sky130_ef_sc_hd__decap_12
XFILLER_190_713 VPWR VGND VPWR VGND sky130_ef_sc_hd__decap_12
XFILLER_194_1409 VPWR VGND VPWR VGND sky130_ef_sc_hd__decap_12
Xmax_cap620 web0 VGND VGND VPWR VPWR net620 sky130_fd_sc_hd__clkbuf_2
XFILLER_200_1365 VGND VGND VPWR VPWR sky130_fd_sc_hd__decap_6
XFILLER_190_757 VPWR VGND VPWR VGND sky130_ef_sc_hd__decap_12
XFILLER_157_1231 VPWR VGND VPWR VGND sky130_ef_sc_hd__decap_12
XFILLER_118_1215 VPWR VGND VPWR VGND sky130_ef_sc_hd__decap_12
XPHY_EDGE_ROW_59_2_Right_150 VGND VGND VPWR VPWR sky130_fd_sc_hd__decap_3
XFILLER_157_1275 VPWR VGND VPWR VGND sky130_ef_sc_hd__decap_12
XFILLER_135_39 VPWR VGND VPWR VGND sky130_ef_sc_hd__decap_12
XTAP_TAPCELL_ROW_248_3590 VGND VPWR sky130_fd_sc_hd__tapvpwrvgnd_1
XFILLER_118_1259 VPWR VGND VPWR VGND sky130_ef_sc_hd__decap_12
XTAP_TAPCELL_ROW_244_3465 VGND VPWR sky130_fd_sc_hd__tapvpwrvgnd_1
XFILLER_170_1453 VPWR VGND VPWR VGND sky130_ef_sc_hd__decap_12
XTAP_TAPCELL_ROW_244_3476 VGND VPWR sky130_fd_sc_hd__tapvpwrvgnd_1
XFILLER_28_15 VPWR VGND VPWR VGND sky130_ef_sc_hd__decap_12
XFILLER_218_917 VGND VGND VPWR VPWR sky130_fd_sc_hd__decap_6
XFILLER_217_405 VPWR VGND VPWR VGND sky130_ef_sc_hd__decap_12
XFILLER_151_27 VPWR VGND VPWR VGND sky130_ef_sc_hd__decap_12
XFILLER_170_1497 VPWR VGND VPWR VGND sky130_ef_sc_hd__decap_12
XFILLER_42_1180 VGND VGND VPWR VPWR sky130_fd_sc_hd__decap_8
XTAP_TAPCELL_ROW_127_2_4518 VGND VPWR sky130_fd_sc_hd__tapvpwrvgnd_1
XFILLER_42_1191 VPWR VGND VPWR VGND sky130_ef_sc_hd__decap_12
XFILLER_217_449 VPWR VGND VPWR VGND sky130_ef_sc_hd__decap_12
XFILLER_233_909 VPWR VGND VPWR VGND sky130_ef_sc_hd__decap_12
XFILLER_226_961 VPWR VGND VPWR VGND sky130_ef_sc_hd__decap_12
XFILLER_232_419 VGND VGND VPWR VPWR sky130_fd_sc_hd__fill_1
XFILLER_77_1243 VPWR VGND VPWR VGND sky130_ef_sc_hd__decap_12
XFILLER_129_1311 VPWR VGND VPWR VGND sky130_ef_sc_hd__decap_12
XFILLER_168_1371 VGND VGND VPWR VPWR sky130_fd_sc_hd__fill_1
XFILLER_198_813 VPWR VGND VPWR VGND sky130_ef_sc_hd__decap_12
XFILLER_231_93 VPWR VGND VPWR VGND sky130_ef_sc_hd__decap_12
XFILLER_38_1227 VPWR VGND VPWR VGND sky130_ef_sc_hd__decap_12
XFILLER_241_953 VPWR VGND VPWR VGND sky130_ef_sc_hd__decap_12
XFILLER_77_1287 VPWR VGND VPWR VGND sky130_ef_sc_hd__decap_12
XFILLER_129_1355 VPWR VGND VPWR VGND sky130_ef_sc_hd__decap_12
XFILLER_212_121 VPWR VGND VPWR VGND sky130_ef_sc_hd__decap_12
XFILLER_125_1219 VPWR VGND VPWR VGND sky130_ef_sc_hd__decap_12
XFILLER_129_1399 VPWR VGND VPWR VGND sky130_ef_sc_hd__decap_12
XFILLER_212_165 VPWR VGND VPWR VGND sky130_ef_sc_hd__decap_12
XFILLER_201_839 VGND VGND VPWR VPWR sky130_fd_sc_hd__fill_1
XFILLER_100_53 VPWR VGND VPWR VGND sky130_ef_sc_hd__decap_12
XFILLER_185_529 VPWR VGND VPWR VGND sky130_ef_sc_hd__decap_12
XTAP_TAPCELL_ROW_75_2_4205 VGND VPWR sky130_fd_sc_hd__tapvpwrvgnd_1
XFILLER_178_581 VGND VGND VPWR VPWR sky130_fd_sc_hd__decap_6
XFILLER_205_1287 VGND VGND VPWR VPWR sky130_fd_sc_hd__fill_1
XFILLER_165_253 VPWR VGND VPWR VGND sky130_ef_sc_hd__decap_12
XFILLER_197_1033 VPWR VGND VPWR VGND sky130_ef_sc_hd__decap_12
XFILLER_193_573 VPWR VGND VPWR VGND sky130_ef_sc_hd__decap_12
XFILLER_14_1271 VPWR VGND VPWR VGND sky130_ef_sc_hd__decap_12
XFILLER_114_3 VPWR VGND VPWR VGND sky130_ef_sc_hd__decap_12
XTAP_TAPCELL_ROW_189_2000 VGND VPWR sky130_fd_sc_hd__tapvpwrvgnd_1
XFILLER_197_1077 VPWR VGND VPWR VGND sky130_ef_sc_hd__decap_12
XFILLER_109_51 VGND VGND VPWR VPWR sky130_fd_sc_hd__decap_4
XFILLER_49_1323 VGND VGND VPWR VPWR sky130_fd_sc_hd__decap_6
XFILLER_84_1203 VPWR VGND VPWR VGND sky130_ef_sc_hd__decap_12
XFILLER_180_245 VGND VGND VPWR VPWR sky130_fd_sc_hd__decap_6
XFILLER_88_1383 VPWR VGND VPWR VGND sky130_ef_sc_hd__decap_12
XFILLER_69_55 VGND VGND VPWR VPWR sky130_fd_sc_hd__fill_1
XFILLER_49_1367 VPWR VGND VPWR VGND sky130_ef_sc_hd__decap_12
XFILLER_84_1247 VPWR VGND VPWR VGND sky130_ef_sc_hd__decap_12
XFILLER_136_1315 VPWR VGND VPWR VGND sky130_ef_sc_hd__decap_12
XFILLER_238_1085 VGND VGND VPWR VPWR sky130_fd_sc_hd__decap_6
XFILLER_180_289 VPWR VGND VPWR VGND sky130_ef_sc_hd__decap_12
XFILLER_136_1359 VPWR VGND VPWR VGND sky130_ef_sc_hd__decap_12
XFILLER_212_1203 VGND VGND VPWR VPWR sky130_fd_sc_hd__fill_1
XTAP_TAPCELL_ROW_22_2_3888 VGND VPWR sky130_fd_sc_hd__tapvpwrvgnd_1
XFILLER_236_725 VPWR VGND VPWR VGND sky130_ef_sc_hd__decap_12
XFILLER_169_1113 VGND VGND VPWR VPWR sky130_fd_sc_hd__decap_6
XTAP_TAPCELL_ROW_4_970 VGND VPWR sky130_fd_sc_hd__tapvpwrvgnd_1
XFILLER_21_1231 VPWR VGND VPWR VGND sky130_ef_sc_hd__decap_12
XTAP_TAPCELL_ROW_4_981 VGND VPWR sky130_fd_sc_hd__tapvpwrvgnd_1
XFILLER_236_769 VPWR VGND VPWR VGND sky130_ef_sc_hd__decap_12
XFILLER_1_1325 VPWR VGND VPWR VGND sky130_ef_sc_hd__decap_12
XFILLER_169_1157 VPWR VGND VPWR VGND sky130_ef_sc_hd__decap_12
XFILLER_235_279 VGND VGND VPWR VPWR sky130_fd_sc_hd__fill_1
XFILLER_21_1275 VPWR VGND VPWR VGND sky130_ef_sc_hd__decap_12
XFILLER_245_1001 VGND VGND VPWR VPWR sky130_fd_sc_hd__decap_6
XFILLER_95_1343 VPWR VGND VPWR VGND sky130_ef_sc_hd__decap_12
XFILLER_147_1411 VPWR VGND VPWR VGND sky130_ef_sc_hd__decap_12
XFILLER_1_1369 VPWR VGND VPWR VGND sky130_ef_sc_hd__decap_12
XFILLER_188_301 VGND VGND VPWR VPWR sky130_fd_sc_hd__decap_6
XFILLER_56_1327 VPWR VGND VPWR VGND sky130_ef_sc_hd__decap_12
XFILLER_245_1045 VPWR VGND VPWR VGND sky130_ef_sc_hd__decap_12
XFILLER_95_1387 VPWR VGND VPWR VGND sky130_ef_sc_hd__decap_12
XFILLER_147_1455 VPWR VGND VPWR VGND sky130_ef_sc_hd__decap_12
XFILLER_231_441 VGND VGND VPWR VPWR sky130_fd_sc_hd__decap_6
XFILLER_188_345 VPWR VGND VPWR VGND sky130_ef_sc_hd__decap_12
XFILLER_108_1439 VPWR VGND VPWR VGND sky130_ef_sc_hd__decap_12
XFILLER_206_1029 VGND VGND VPWR VPWR sky130_fd_sc_hd__decap_6
XFILLER_245_1089 VPWR VGND VPWR VGND sky130_ef_sc_hd__decap_12
XFILLER_147_1499 VPWR VGND VPWR VGND sky130_ef_sc_hd__decap_12
XFILLER_204_699 VGND VGND VPWR VPWR sky130_fd_sc_hd__fill_1
XFILLER_231_485 VPWR VGND VPWR VGND sky130_ef_sc_hd__decap_12
XFILLER_188_389 VPWR VGND VPWR VGND sky130_ef_sc_hd__decap_12
XFILLER_223_1343 VGND VGND VPWR VPWR sky130_fd_sc_hd__fill_1
XPHY_EDGE_ROW_98_2_Right_189 VGND VGND VPWR VPWR sky130_fd_sc_hd__decap_3
XFILLER_200_861 VGND VGND VPWR VPWR sky130_fd_sc_hd__decap_6
XFILLER_8_775 VPWR VGND VPWR VGND sky130_ef_sc_hd__decap_12
Xwire161 _153_ VGND VGND VPWR VPWR net161 sky130_fd_sc_hd__clkbuf_1
XFILLER_172_713 VPWR VGND VPWR VGND sky130_ef_sc_hd__decap_12
XFILLER_32_1371 VPWR VGND VPWR VGND sky130_ef_sc_hd__decap_12
Xwire172 _120_ VGND VGND VPWR VPWR net172 sky130_fd_sc_hd__clkbuf_1
XFILLER_176_1117 VPWR VGND VPWR VGND sky130_ef_sc_hd__decap_12
XFILLER_171_223 VGND VGND VPWR VPWR sky130_fd_sc_hd__fill_1
XFILLER_172_757 VPWR VGND VPWR VGND sky130_ef_sc_hd__decap_12
XFILLER_236_27 VGND VGND VPWR VPWR sky130_fd_sc_hd__fill_1
XFILLER_67_1423 VPWR VGND VPWR VGND sky130_ef_sc_hd__decap_12
XFILLER_28_1407 VGND VGND VPWR VPWR sky130_fd_sc_hd__decap_6
XFILLER_252_1005 VPWR VGND VPWR VGND sky130_ef_sc_hd__decap_12
XFILLER_67_1467 VPWR VGND VPWR VGND sky130_ef_sc_hd__decap_12
XFILLER_4_981 VPWR VGND VPWR VGND sky130_ef_sc_hd__decap_12
XFILLER_154_1415 VPWR VGND VPWR VGND sky130_ef_sc_hd__decap_12
XTAP_TAPCELL_ROW_88_2_4283 VGND VPWR sky130_fd_sc_hd__tapvpwrvgnd_1
XFILLER_252_1049 VPWR VGND VPWR VGND sky130_ef_sc_hd__decap_12
XTAP_TAPCELL_ROW_168_1416 VGND VPWR sky130_fd_sc_hd__tapvpwrvgnd_1
XTAP_TAPCELL_ROW_168_1427 VGND VPWR sky130_fd_sc_hd__tapvpwrvgnd_1
XFILLER_217_1169 VGND VGND VPWR VPWR sky130_fd_sc_hd__decap_6
XFILLER_252_15 VPWR VGND VPWR VGND sky130_ef_sc_hd__decap_12
XFILLER_6_1203 VGND VGND VPWR VPWR sky130_fd_sc_hd__fill_1
XFILLER_239_541 VPWR VGND VPWR VGND sky130_ef_sc_hd__decap_12
XFILLER_234_1483 VGND VGND VPWR VPWR sky130_fd_sc_hd__fill_1
XTAP_TAPCELL_ROW_2_907 VGND VPWR sky130_fd_sc_hd__tapvpwrvgnd_1
XFILLER_239_585 VPWR VGND VPWR VGND sky130_ef_sc_hd__decap_12
XTAP_TAPCELL_ROW_2_918 VGND VPWR sky130_fd_sc_hd__tapvpwrvgnd_1
XTAP_TAPCELL_ROW_2_929 VGND VPWR sky130_fd_sc_hd__tapvpwrvgnd_1
XFILLER_254_533 VPWR VGND VPWR VGND sky130_ef_sc_hd__decap_12
XFILLER_187_1213 VPWR VGND VPWR VGND sky130_ef_sc_hd__decap_12
XFILLER_215_909 VPWR VGND VPWR VGND sky130_ef_sc_hd__decap_12
XFILLER_113_1189 VPWR VGND VPWR VGND sky130_ef_sc_hd__decap_12
XFILLER_208_961 VPWR VGND VPWR VGND sky130_ef_sc_hd__decap_12
XFILLER_187_1257 VPWR VGND VPWR VGND sky130_ef_sc_hd__decap_12
XFILLER_214_419 VGND VGND VPWR VPWR sky130_fd_sc_hd__fill_1
XFILLER_241_205 VPWR VGND VPWR VGND sky130_ef_sc_hd__decap_12
XFILLER_198_109 VPWR VGND VPWR VGND sky130_ef_sc_hd__decap_12
XFILLER_241_249 VPWR VGND VPWR VGND sky130_ef_sc_hd__decap_12
XFILLER_74_1427 VPWR VGND VPWR VGND sky130_ef_sc_hd__decap_12
XFILLER_223_953 VPWR VGND VPWR VGND sky130_ef_sc_hd__decap_12
XFILLER_224_1129 VPWR VGND VPWR VGND sky130_ef_sc_hd__decap_12
XTAP_TAPCELL_ROW_252_3701 VGND VPWR sky130_fd_sc_hd__tapvpwrvgnd_1
XFILLER_210_625 VPWR VGND VPWR VGND sky130_ef_sc_hd__decap_12
XTAP_TAPCELL_ROW_237_3280 VGND VPWR sky130_fd_sc_hd__tapvpwrvgnd_1
XFILLER_167_529 VPWR VGND VPWR VGND sky130_ef_sc_hd__decap_12
XTAP_TAPCELL_ROW_237_3291 VGND VPWR sky130_fd_sc_hd__tapvpwrvgnd_1
XFILLER_210_669 VPWR VGND VPWR VGND sky130_ef_sc_hd__decap_12
XFILLER_202_1427 VGND VGND VPWR VPWR sky130_fd_sc_hd__fill_1
XTAP_TAPCELL_ROW_233_3166 VGND VPWR sky130_fd_sc_hd__tapvpwrvgnd_1
XTAP_TAPCELL_ROW_233_3177 VGND VPWR sky130_fd_sc_hd__tapvpwrvgnd_1
XTAP_TAPCELL_ROW_233_3188 VGND VPWR sky130_fd_sc_hd__tapvpwrvgnd_1
XTAP_TAPCELL_ROW_41_2_4000 VGND VPWR sky130_fd_sc_hd__tapvpwrvgnd_1
XFILLER_175_573 VPWR VGND VPWR VGND sky130_ef_sc_hd__decap_12
XFILLER_198_1353 VPWR VGND VPWR VGND sky130_ef_sc_hd__decap_12
XFILLER_11_1411 VPWR VGND VPWR VGND sky130_ef_sc_hd__decap_12
XFILLER_50_1471 VPWR VGND VPWR VGND sky130_ef_sc_hd__decap_12
XFILLER_30_27 VGND VGND VPWR VPWR sky130_fd_sc_hd__fill_1
XFILLER_194_1217 VPWR VGND VPWR VGND sky130_ef_sc_hd__decap_12
XFILLER_198_1397 VPWR VGND VPWR VGND sky130_ef_sc_hd__decap_12
XFILLER_11_1455 VPWR VGND VPWR VGND sky130_ef_sc_hd__decap_12
XFILLER_146_27 VGND VGND VPWR VPWR sky130_fd_sc_hd__fill_1
XFILLER_200_1173 VPWR VGND VPWR VGND sky130_ef_sc_hd__decap_12
XFILLER_11_1499 VPWR VGND VPWR VGND sky130_ef_sc_hd__decap_12
XFILLER_190_587 VGND VGND VPWR VPWR sky130_fd_sc_hd__fill_1
XTAP_TAPCELL_ROW_246_3516 VGND VPWR sky130_fd_sc_hd__tapvpwrvgnd_1
XFILLER_46_1507 VGND VGND VPWR VPWR sky130_fd_sc_hd__decap_8
XTAP_TAPCELL_ROW_246_3527 VGND VPWR sky130_fd_sc_hd__tapvpwrvgnd_1
XFILLER_235_1225 VGND VGND VPWR VPWR sky130_fd_sc_hd__decap_6
XTAP_TAPCELL_ROW_246_3538 VGND VPWR sky130_fd_sc_hd__tapvpwrvgnd_1
XFILLER_249_305 VPWR VGND VPWR VGND sky130_ef_sc_hd__decap_12
Xmax_cap494 _130_ VGND VGND VPWR VPWR net494 sky130_fd_sc_hd__clkbuf_1
XFILLER_235_1269 VPWR VGND VPWR VGND sky130_ef_sc_hd__decap_12
XFILLER_249_349 VPWR VGND VPWR VGND sky130_ef_sc_hd__decap_12
XFILLER_162_15 VPWR VGND VPWR VGND sky130_ef_sc_hd__decap_12
XFILLER_131_1201 VPWR VGND VPWR VGND sky130_ef_sc_hd__decap_12
XFILLER_170_1261 VPWR VGND VPWR VGND sky130_ef_sc_hd__decap_12
XFILLER_218_725 VPWR VGND VPWR VGND sky130_ef_sc_hd__decap_12
XFILLER_131_1267 VGND VGND VPWR VPWR sky130_fd_sc_hd__decap_6
XFILLER_218_769 VPWR VGND VPWR VGND sky130_ef_sc_hd__decap_12
XFILLER_229_1007 VGND VGND VPWR VPWR sky130_fd_sc_hd__fill_1
XFILLER_217_279 VGND VGND VPWR VPWR sky130_fd_sc_hd__fill_1
X_470_ net148 net123 VGND VGND VPWR VPWR acc_core.adder.cla_blocks\[1\].block.sum\[0\]
+ sky130_fd_sc_hd__xnor2_1
XTAP_TAPCELL_ROW_222_2870 VGND VPWR sky130_fd_sc_hd__tapvpwrvgnd_1
XTAP_TAPCELL_ROW_222_2881 VGND VPWR sky130_fd_sc_hd__tapvpwrvgnd_1
XTAP_TAPCELL_ROW_222_2892 VGND VPWR sky130_fd_sc_hd__tapvpwrvgnd_1
XFILLER_246_1365 VGND VGND VPWR VPWR sky130_fd_sc_hd__decap_6
XFILLER_198_643 VGND VGND VPWR VPWR sky130_fd_sc_hd__fill_1
XFILLER_213_441 VGND VGND VPWR VPWR sky130_fd_sc_hd__decap_6
XFILLER_186_805 VGND VGND VPWR VPWR sky130_fd_sc_hd__decap_6
XFILLER_242_1229 VPWR VGND VPWR VGND sky130_ef_sc_hd__decap_12
XFILLER_241_783 VGND VGND VPWR VPWR sky130_fd_sc_hd__fill_1
XFILLER_213_485 VPWR VGND VPWR VGND sky130_ef_sc_hd__decap_12
XFILLER_9_517 VPWR VGND VPWR VGND sky130_ef_sc_hd__decap_12
XFILLER_186_849 VPWR VGND VPWR VGND sky130_ef_sc_hd__decap_12
XFILLER_231_3 VPWR VGND VPWR VGND sky130_ef_sc_hd__decap_12
XFILLER_51_1213 VGND VGND VPWR VPWR sky130_fd_sc_hd__decap_4
XFILLER_185_337 VPWR VGND VPWR VGND sky130_ef_sc_hd__decap_12
XFILLER_90_1295 VGND VGND VPWR VPWR sky130_fd_sc_hd__decap_6
XTAP_TAPCELL_ROW_106_2_4391 VGND VPWR sky130_fd_sc_hd__tapvpwrvgnd_1
XFILLER_5_712 VPWR VGND VPWR VGND sky130_ef_sc_hd__decap_12
XFILLER_194_893 VPWR VGND VPWR VGND sky130_ef_sc_hd__decap_12
XTAP_TAPCELL_ROW_31_1_1166 VGND VPWR sky130_fd_sc_hd__tapvpwrvgnd_1
XFILLER_177_1437 VPWR VGND VPWR VGND sky130_ef_sc_hd__decap_12
XFILLER_5_778 VGND VGND VPWR VPWR sky130_fd_sc_hd__decap_3
XFILLER_88_1191 VPWR VGND VPWR VGND sky130_ef_sc_hd__decap_12
XFILLER_253_1325 VPWR VGND VPWR VGND sky130_ef_sc_hd__decap_12
XFILLER_214_1309 VGND VGND VPWR VPWR sky130_fd_sc_hd__decap_6
XFILLER_253_1369 VPWR VGND VPWR VGND sky130_ef_sc_hd__decap_12
XFILLER_96_53 VPWR VGND VPWR VGND sky130_ef_sc_hd__decap_12
XFILLER_136_1189 VGND VGND VPWR VPWR sky130_fd_sc_hd__fill_1
XFILLER_0_483 VGND VGND VPWR VPWR sky130_fd_sc_hd__fill_2
XFILLER_236_533 VPWR VGND VPWR VGND sky130_ef_sc_hd__decap_12
XFILLER_222_29 VPWR VGND VPWR VGND sky130_ef_sc_hd__decap_12
XFILLER_251_503 VGND VGND VPWR VPWR sky130_fd_sc_hd__fill_1
XFILLER_223_205 VPWR VGND VPWR VGND sky130_ef_sc_hd__decap_12
XFILLER_1_1133 VPWR VGND VPWR VGND sky130_ef_sc_hd__decap_12
XFILLER_1_1177 VPWR VGND VPWR VGND sky130_ef_sc_hd__decap_12
XFILLER_205_953 VPWR VGND VPWR VGND sky130_ef_sc_hd__decap_12
XFILLER_223_249 VPWR VGND VPWR VGND sky130_ef_sc_hd__decap_12
XPHY_EDGE_ROW_59_2_Left_561 VGND VGND VPWR VPWR sky130_fd_sc_hd__decap_3
XFILLER_108_1203 VPWR VGND VPWR VGND sky130_ef_sc_hd__decap_12
X_599_ clknet_3_2__leaf_clk _081_ _007_ VGND VGND VPWR VPWR rd_addr\[7\] sky130_fd_sc_hd__dfrtp_1
XFILLER_189_665 VGND VGND VPWR VPWR sky130_fd_sc_hd__decap_6
XFILLER_220_923 VGND VGND VPWR VPWR sky130_fd_sc_hd__fill_1
XFILLER_188_153 VPWR VGND VPWR VGND sky130_ef_sc_hd__decap_12
XFILLER_225_1449 VGND VGND VPWR VPWR sky130_fd_sc_hd__decap_6
XFILLER_108_1247 VPWR VGND VPWR VGND sky130_ef_sc_hd__decap_12
XFILLER_231_293 VPWR VGND VPWR VGND sky130_ef_sc_hd__decap_12
XFILLER_188_197 VPWR VGND VPWR VGND sky130_ef_sc_hd__decap_12
XFILLER_160_1463 VGND VGND VPWR VPWR sky130_fd_sc_hd__decap_6
XFILLER_247_15 VPWR VGND VPWR VGND sky130_ef_sc_hd__decap_12
XFILLER_77_3 VPWR VGND VPWR VGND sky130_ef_sc_hd__decap_12
XFILLER_191_329 VGND VGND VPWR VPWR sky130_fd_sc_hd__decap_6
XFILLER_201_1493 VPWR VGND VPWR VGND sky130_ef_sc_hd__decap_12
XFILLER_67_1231 VPWR VGND VPWR VGND sky130_ef_sc_hd__decap_12
XFILLER_172_587 VGND VGND VPWR VPWR sky130_fd_sc_hd__fill_1
XFILLER_28_1215 VPWR VGND VPWR VGND sky130_ef_sc_hd__decap_12
XFILLER_67_1275 VPWR VGND VPWR VGND sky130_ef_sc_hd__decap_12
XFILLER_119_1343 VPWR VGND VPWR VGND sky130_ef_sc_hd__decap_12
XFILLER_8_1309 VGND VGND VPWR VPWR sky130_fd_sc_hd__decap_6
XFILLER_154_1245 VGND VGND VPWR VPWR sky130_fd_sc_hd__fill_1
XFILLER_232_1409 VPWR VGND VPWR VGND sky130_ef_sc_hd__decap_12
XFILLER_28_1259 VPWR VGND VPWR VGND sky130_ef_sc_hd__decap_12
XFILLER_247_809 VPWR VGND VPWR VGND sky130_ef_sc_hd__decap_12
XFILLER_119_1387 VPWR VGND VPWR VGND sky130_ef_sc_hd__decap_12
XTAP_TAPCELL_ROW_163_2_4734 VGND VPWR sky130_fd_sc_hd__tapvpwrvgnd_1
XTAP_TAPCELL_ROW_241_3402 VGND VPWR sky130_fd_sc_hd__tapvpwrvgnd_1
XFILLER_239_393 VPWR VGND VPWR VGND sky130_ef_sc_hd__decap_12
XFILLER_132_29 VPWR VGND VPWR VGND sky130_ef_sc_hd__decap_12
XFILLER_255_853 VPWR VGND VPWR VGND sky130_ef_sc_hd__decap_12
XTAP_TAPCELL_ROW_7_1050 VGND VPWR sky130_fd_sc_hd__tapvpwrvgnd_1
XPHY_EDGE_ROW_125_1_Left_380 VGND VGND VPWR VPWR sky130_fd_sc_hd__decap_3
XTAP_TAPCELL_ROW_7_1061 VGND VPWR sky130_fd_sc_hd__tapvpwrvgnd_1
XFILLER_187_1021 VPWR VGND VPWR VGND sky130_ef_sc_hd__decap_12
XTAP_TAPCELL_ROW_143_2_4610 VGND VPWR sky130_fd_sc_hd__tapvpwrvgnd_1
XFILLER_255_897 VPWR VGND VPWR VGND sky130_ef_sc_hd__decap_12
XFILLER_254_363 VGND VGND VPWR VPWR sky130_fd_sc_hd__fill_1
XFILLER_242_525 VGND VGND VPWR VPWR sky130_fd_sc_hd__decap_6
XFILLER_187_1065 VPWR VGND VPWR VGND sky130_ef_sc_hd__decap_12
XFILLER_199_429 VPWR VGND VPWR VGND sky130_ef_sc_hd__decap_12
XFILLER_39_1311 VPWR VGND VPWR VGND sky130_ef_sc_hd__decap_12
XTAP_TAPCELL_ROW_239_3331 VGND VPWR sky130_fd_sc_hd__tapvpwrvgnd_1
XFILLER_25_27 VGND VGND VPWR VPWR sky130_fd_sc_hd__decap_6
XFILLER_78_1371 VPWR VGND VPWR VGND sky130_ef_sc_hd__decap_12
XTAP_TAPCELL_ROW_239_3342 VGND VPWR sky130_fd_sc_hd__tapvpwrvgnd_1
XFILLER_243_1505 VGND VGND VPWR VPWR sky130_fd_sc_hd__decap_6
XFILLER_242_569 VPWR VGND VPWR VGND sky130_ef_sc_hd__decap_12
XFILLER_165_1341 VGND VGND VPWR VPWR sky130_fd_sc_hd__decap_3
XFILLER_39_1355 VPWR VGND VPWR VGND sky130_ef_sc_hd__decap_12
XFILLER_126_1303 VPWR VGND VPWR VGND sky130_ef_sc_hd__decap_12
XFILLER_168_805 VGND VGND VPWR VPWR sky130_fd_sc_hd__decap_6
XFILLER_228_1073 VPWR VGND VPWR VGND sky130_ef_sc_hd__decap_12
XTAP_TAPCELL_ROW_235_3217 VGND VPWR sky130_fd_sc_hd__tapvpwrvgnd_1
XFILLER_223_783 VGND VGND VPWR VPWR sky130_fd_sc_hd__fill_1
XTAP_TAPCELL_ROW_235_3228 VGND VPWR sky130_fd_sc_hd__tapvpwrvgnd_1
XFILLER_35_1219 VPWR VGND VPWR VGND sky130_ef_sc_hd__decap_12
XFILLER_165_1385 VPWR VGND VPWR VGND sky130_ef_sc_hd__decap_12
XTAP_TAPCELL_ROW_235_3239 VGND VPWR sky130_fd_sc_hd__tapvpwrvgnd_1
XFILLER_211_945 VGND VGND VPWR VPWR sky130_fd_sc_hd__decap_6
XFILLER_39_1399 VPWR VGND VPWR VGND sky130_ef_sc_hd__decap_12
XFILLER_168_849 VPWR VGND VPWR VGND sky130_ef_sc_hd__decap_12
XFILLER_210_433 VPWR VGND VPWR VGND sky130_ef_sc_hd__decap_12
XFILLER_167_337 VPWR VGND VPWR VGND sky130_ef_sc_hd__decap_12
XFILLER_41_15 VPWR VGND VPWR VGND sky130_ef_sc_hd__decap_12
XFILLER_206_1371 VGND VGND VPWR VPWR sky130_fd_sc_hd__fill_1
XFILLER_211_989 VPWR VGND VPWR VGND sky130_ef_sc_hd__decap_12
XFILLER_210_477 VPWR VGND VPWR VGND sky130_ef_sc_hd__decap_12
XFILLER_157_15 VPWR VGND VPWR VGND sky130_ef_sc_hd__decap_12
XFILLER_182_307 VGND VGND VPWR VPWR sky130_fd_sc_hd__fill_1
XFILLER_176_893 VPWR VGND VPWR VGND sky130_ef_sc_hd__decap_12
XFILLER_194_189 VGND VGND VPWR VPWR sky130_fd_sc_hd__decap_6
XFILLER_198_1161 VPWR VGND VPWR VGND sky130_ef_sc_hd__decap_12
XFILLER_191_841 VPWR VGND VPWR VGND sky130_ef_sc_hd__decap_12
XFILLER_237_81 VPWR VGND VPWR VGND sky130_ef_sc_hd__decap_12
XFILLER_85_1331 VPWR VGND VPWR VGND sky130_ef_sc_hd__decap_12
XFILLER_159_1189 VPWR VGND VPWR VGND sky130_ef_sc_hd__decap_12
XFILLER_46_1315 VPWR VGND VPWR VGND sky130_ef_sc_hd__decap_12
XTAP_TAPCELL_ROW_211_2571 VGND VPWR sky130_fd_sc_hd__tapvpwrvgnd_1
XFILLER_235_1033 VPWR VGND VPWR VGND sky130_ef_sc_hd__decap_12
XTAP_TAPCELL_ROW_211_2582 VGND VPWR sky130_fd_sc_hd__tapvpwrvgnd_1
XFILLER_137_1443 VPWR VGND VPWR VGND sky130_ef_sc_hd__decap_12
XTAP_TAPCELL_ROW_211_2593 VGND VPWR sky130_fd_sc_hd__tapvpwrvgnd_1
XFILLER_249_113 VPWR VGND VPWR VGND sky130_ef_sc_hd__decap_12
XFILLER_81_1217 VGND VGND VPWR VPWR sky130_fd_sc_hd__fill_1
XFILLER_250_1509 VGND VGND VPWR VPWR sky130_fd_sc_hd__decap_6
XFILLER_46_1359 VPWR VGND VPWR VGND sky130_ef_sc_hd__decap_12
XFILLER_173_69 VPWR VGND VPWR VGND sky130_ef_sc_hd__decap_12
XFILLER_235_1077 VPWR VGND VPWR VGND sky130_ef_sc_hd__decap_12
XFILLER_106_41 VPWR VGND VPWR VGND sky130_ef_sc_hd__decap_12
XFILLER_133_1329 VGND VGND VPWR VPWR sky130_fd_sc_hd__fill_1
XTAP_TAPCELL_ROW_52_2_4069 VGND VPWR sky130_fd_sc_hd__tapvpwrvgnd_1
XTAP_TAPCELL_ROW_224_2921 VGND VPWR sky130_fd_sc_hd__tapvpwrvgnd_1
XTAP_TAPCELL_ROW_37_2_3974 VGND VPWR sky130_fd_sc_hd__tapvpwrvgnd_1
XFILLER_170_1091 VGND VGND VPWR VPWR sky130_fd_sc_hd__fill_1
XFILLER_181_3 VPWR VGND VPWR VGND sky130_ef_sc_hd__decap_12
XFILLER_218_533 VPWR VGND VPWR VGND sky130_ef_sc_hd__decap_12
XTAP_TAPCELL_ROW_224_2932 VGND VPWR sky130_fd_sc_hd__tapvpwrvgnd_1
XTAP_TAPCELL_ROW_224_2943 VGND VPWR sky130_fd_sc_hd__tapvpwrvgnd_1
XFILLER_248_1427 VGND VGND VPWR VPWR sky130_fd_sc_hd__fill_1
XFILLER_233_503 VGND VGND VPWR VPWR sky130_fd_sc_hd__fill_1
XFILLER_166_1105 VPWR VGND VPWR VGND sky130_ef_sc_hd__decap_12
XFILLER_205_205 VPWR VGND VPWR VGND sky130_ef_sc_hd__decap_12
XTAP_TAPCELL_ROW_220_2818 VGND VPWR sky130_fd_sc_hd__tapvpwrvgnd_1
XFILLER_245_385 VGND VGND VPWR VPWR sky130_fd_sc_hd__decap_6
X_522_ net664 VGND VGND VPWR VPWR _004_ sky130_fd_sc_hd__inv_2
XFILLER_2_1453 VPWR VGND VPWR VGND sky130_ef_sc_hd__decap_12
XTAP_TAPCELL_ROW_220_2829 VGND VPWR sky130_fd_sc_hd__tapvpwrvgnd_1
XFILLER_57_1411 VPWR VGND VPWR VGND sky130_ef_sc_hd__decap_12
XFILLER_96_1471 VPWR VGND VPWR VGND sky130_ef_sc_hd__decap_12
XFILLER_166_1149 VPWR VGND VPWR VGND sky130_ef_sc_hd__decap_12
XFILLER_205_249 VPWR VGND VPWR VGND sky130_ef_sc_hd__decap_12
XFILLER_2_1497 VPWR VGND VPWR VGND sky130_ef_sc_hd__decap_12
XFILLER_221_709 VPWR VGND VPWR VGND sky130_ef_sc_hd__decap_12
X_453_ net198 _239_ VGND VGND VPWR VPWR acc_core.adder.cla_blocks\[0\].block.p\[0\]
+ sky130_fd_sc_hd__nor2_1
XFILLER_207_1113 VGND VGND VPWR VPWR sky130_fd_sc_hd__decap_6
XFILLER_57_1455 VPWR VGND VPWR VGND sky130_ef_sc_hd__decap_12
XFILLER_246_1173 VPWR VGND VPWR VGND sky130_ef_sc_hd__decap_12
XFILLER_202_923 VGND VGND VPWR VPWR sky130_fd_sc_hd__fill_1
XFILLER_92_1357 VGND VGND VPWR VPWR sky130_fd_sc_hd__fill_1
XFILLER_18_1439 VPWR VGND VPWR VGND sky130_ef_sc_hd__decap_12
XFILLER_186_613 VPWR VGND VPWR VGND sky130_ef_sc_hd__decap_12
XTAP_TAPCELL_ROW_197_2198 VGND VPWR sky130_fd_sc_hd__tapvpwrvgnd_1
XFILLER_242_1037 VPWR VGND VPWR VGND sky130_ef_sc_hd__decap_12
XFILLER_57_1499 VPWR VGND VPWR VGND sky130_ef_sc_hd__decap_12
XFILLER_15_60 VGND VGND VPWR VPWR sky130_fd_sc_hd__decap_8
X_384_ net213 net210 VGND VGND VPWR VPWR _173_ sky130_fd_sc_hd__nor2_1
XFILLER_198_77 VGND VGND VPWR VPWR sky130_fd_sc_hd__decap_6
XFILLER_207_1157 VPWR VGND VPWR VGND sky130_ef_sc_hd__decap_12
XFILLER_213_293 VPWR VGND VPWR VGND sky130_ef_sc_hd__decap_12
XFILLER_144_1469 VGND VGND VPWR VPWR sky130_fd_sc_hd__fill_1
XFILLER_186_657 VPWR VGND VPWR VGND sky130_ef_sc_hd__decap_12
XTAP_TAPCELL_ROW_218_2758 VGND VPWR sky130_fd_sc_hd__tapvpwrvgnd_1
XTAP_TAPCELL_ROW_218_2769 VGND VPWR sky130_fd_sc_hd__tapvpwrvgnd_1
XFILLER_185_167 VGND VGND VPWR VPWR sky130_fd_sc_hd__fill_1
XFILLER_173_329 VGND VGND VPWR VPWR sky130_fd_sc_hd__decap_6
XFILLER_177_1201 VPWR VGND VPWR VGND sky130_ef_sc_hd__decap_12
XTAP_TAPCELL_ROW_10_2_3815 VGND VPWR sky130_fd_sc_hd__tapvpwrvgnd_1
XPHY_EDGE_ROW_80_1_Right_736 VGND VGND VPWR VPWR sky130_fd_sc_hd__decap_3
XFILLER_103_1177 VPWR VGND VPWR VGND sky130_ef_sc_hd__decap_12
XFILLER_177_1245 VPWR VGND VPWR VGND sky130_ef_sc_hd__decap_12
XFILLER_181_373 VPWR VGND VPWR VGND sky130_ef_sc_hd__decap_12
XFILLER_177_1289 VPWR VGND VPWR VGND sky130_ef_sc_hd__decap_12
XFILLER_64_1415 VPWR VGND VPWR VGND sky130_ef_sc_hd__decap_12
XFILLER_253_1133 VPWR VGND VPWR VGND sky130_ef_sc_hd__decap_12
XFILLER_218_1253 VGND VGND VPWR VPWR sky130_fd_sc_hd__decap_6
Xoutput70 net555 VGND VGND VPWR VPWR acc_out[5] sky130_fd_sc_hd__buf_2
XFILLER_214_1117 VPWR VGND VPWR VGND sky130_ef_sc_hd__decap_12
XFILLER_253_1177 VPWR VGND VPWR VGND sky130_ef_sc_hd__decap_12
XFILLER_218_1297 VPWR VGND VPWR VGND sky130_ef_sc_hd__decap_12
XFILLER_229_809 VPWR VGND VPWR VGND sky130_ef_sc_hd__decap_12
XFILLER_233_39 VPWR VGND VPWR VGND sky130_ef_sc_hd__decap_12
XFILLER_237_853 VPWR VGND VPWR VGND sky130_ef_sc_hd__decap_12
XTAP_TAPCELL_ROW_128_2_4523 VGND VPWR sky130_fd_sc_hd__tapvpwrvgnd_1
XFILLER_97_1213 VGND VGND VPWR VPWR sky130_fd_sc_hd__decap_4
XFILLER_114_1295 VGND VGND VPWR VPWR sky130_fd_sc_hd__decap_6
XFILLER_188_1341 VPWR VGND VPWR VGND sky130_ef_sc_hd__decap_12
XFILLER_236_363 VGND VGND VPWR VPWR sky130_fd_sc_hd__fill_1
XFILLER_23_1189 VPWR VGND VPWR VGND sky130_ef_sc_hd__decap_12
XFILLER_237_897 VPWR VGND VPWR VGND sky130_ef_sc_hd__decap_12
XTAP_TAPCELL_ROW_182_1788 VGND VPWR sky130_fd_sc_hd__tapvpwrvgnd_1
XFILLER_184_1205 VPWR VGND VPWR VGND sky130_ef_sc_hd__decap_12
XFILLER_224_525 VGND VGND VPWR VPWR sky130_fd_sc_hd__decap_6
XTAP_TAPCELL_ROW_182_1799 VGND VPWR sky130_fd_sc_hd__tapvpwrvgnd_1
XFILLER_188_1385 VPWR VGND VPWR VGND sky130_ef_sc_hd__decap_12
XFILLER_252_867 VGND VGND VPWR VPWR sky130_fd_sc_hd__fill_1
XFILLER_75_1511 VGND VGND VPWR VPWR sky130_fd_sc_hd__decap_4
XFILLER_224_569 VPWR VGND VPWR VGND sky130_ef_sc_hd__decap_12
XFILLER_225_1213 VPWR VGND VPWR VGND sky130_ef_sc_hd__decap_12
XFILLER_205_783 VGND VGND VPWR VPWR sky130_fd_sc_hd__fill_1
XFILLER_229_1393 VGND VGND VPWR VPWR sky130_fd_sc_hd__decap_6
XFILLER_189_473 VPWR VGND VPWR VGND sky130_ef_sc_hd__decap_12
XFILLER_225_1257 VPWR VGND VPWR VGND sky130_ef_sc_hd__decap_12
XTAP_TAPCELL_ROW_76_2_4210 VGND VPWR sky130_fd_sc_hd__tapvpwrvgnd_1
XFILLER_203_1511 VGND VGND VPWR VPWR sky130_fd_sc_hd__fill_1
XTAP_TAPCELL_ROW_230_3103 VGND VPWR sky130_fd_sc_hd__tapvpwrvgnd_1
XFILLER_160_1271 VPWR VGND VPWR VGND sky130_ef_sc_hd__decap_12
XFILLER_9_881 VPWR VGND VPWR VGND sky130_ef_sc_hd__decap_12
XFILLER_176_189 VGND VGND VPWR VPWR sky130_fd_sc_hd__decap_6
XFILLER_195_1301 VPWR VGND VPWR VGND sky130_ef_sc_hd__decap_12
XFILLER_121_1255 VPWR VGND VPWR VGND sky130_ef_sc_hd__decap_12
XFILLER_173_841 VPWR VGND VPWR VGND sky130_ef_sc_hd__decap_12
XFILLER_191_137 VPWR VGND VPWR VGND sky130_ef_sc_hd__decap_12
XFILLER_199_1481 VPWR VGND VPWR VGND sky130_ef_sc_hd__decap_12
XFILLER_195_1345 VPWR VGND VPWR VGND sky130_ef_sc_hd__decap_12
XFILLER_121_1299 VPWR VGND VPWR VGND sky130_ef_sc_hd__decap_12
XFILLER_236_1353 VPWR VGND VPWR VGND sky130_ef_sc_hd__decap_12
XFILLER_207_51 VGND VGND VPWR VPWR sky130_fd_sc_hd__decap_4
XTAP_TAPCELL_ROW_228_3032 VGND VPWR sky130_fd_sc_hd__tapvpwrvgnd_1
XTAP_TAPCELL_ROW_228_3043 VGND VPWR sky130_fd_sc_hd__tapvpwrvgnd_1
XFILLER_8_1117 VPWR VGND VPWR VGND sky130_ef_sc_hd__decap_12
XTAP_TAPCELL_ROW_228_3054 VGND VPWR sky130_fd_sc_hd__tapvpwrvgnd_1
XFILLER_232_1217 VPWR VGND VPWR VGND sky130_ef_sc_hd__decap_12
XFILLER_236_1397 VPWR VGND VPWR VGND sky130_ef_sc_hd__decap_12
XTAP_TAPCELL_ROW_9_1101 VGND VPWR sky130_fd_sc_hd__tapvpwrvgnd_1
XTAP_TAPCELL_ROW_9_1112 VGND VPWR sky130_fd_sc_hd__tapvpwrvgnd_1
XFILLER_247_617 VPWR VGND VPWR VGND sky130_ef_sc_hd__decap_12
XTAP_TAPCELL_ROW_9_1123 VGND VPWR sky130_fd_sc_hd__tapvpwrvgnd_1
XTAP_TAPCELL_ROW_9_1134 VGND VPWR sky130_fd_sc_hd__tapvpwrvgnd_1
XFILLER_143_39 VPWR VGND VPWR VGND sky130_ef_sc_hd__decap_12
XFILLER_41_1201 VPWR VGND VPWR VGND sky130_ef_sc_hd__decap_12
XTAP_TAPCELL_ROW_23_2_3893 VGND VPWR sky130_fd_sc_hd__tapvpwrvgnd_1
XTAP_TAPCELL_ROW_9_1145 VGND VPWR sky130_fd_sc_hd__tapvpwrvgnd_1
XFILLER_80_1283 VPWR VGND VPWR VGND sky130_ef_sc_hd__decap_12
XFILLER_132_1351 VGND VGND VPWR VPWR sky130_fd_sc_hd__decap_6
XTAP_TAPCELL_ROW_5_1009 VGND VPWR sky130_fd_sc_hd__tapvpwrvgnd_1
XFILLER_41_1267 VGND VGND VPWR VPWR sky130_fd_sc_hd__decap_6
XFILLER_36_15 VPWR VGND VPWR VGND sky130_ef_sc_hd__decap_12
XFILLER_132_1395 VPWR VGND VPWR VGND sky130_ef_sc_hd__decap_12
XFILLER_215_503 VGND VGND VPWR VPWR sky130_fd_sc_hd__fill_1
XFILLER_167_1425 VPWR VGND VPWR VGND sky130_ef_sc_hd__decap_12
XFILLER_227_385 VGND VGND VPWR VPWR sky130_fd_sc_hd__decap_6
XFILLER_242_333 VPWR VGND VPWR VGND sky130_ef_sc_hd__decap_12
XFILLER_199_237 VPWR VGND VPWR VGND sky130_ef_sc_hd__decap_12
XFILLER_203_709 VPWR VGND VPWR VGND sky130_ef_sc_hd__decap_12
XFILLER_167_1469 VPWR VGND VPWR VGND sky130_ef_sc_hd__decap_12
XFILLER_243_889 VGND VGND VPWR VPWR sky130_fd_sc_hd__decap_6
XFILLER_242_377 VPWR VGND VPWR VGND sky130_ef_sc_hd__decap_12
XFILLER_243_1313 VPWR VGND VPWR VGND sky130_ef_sc_hd__decap_12
XFILLER_247_1493 VPWR VGND VPWR VGND sky130_ef_sc_hd__decap_12
XFILLER_168_613 VPWR VGND VPWR VGND sky130_ef_sc_hd__decap_12
XTAP_TAPCELL_ROW_200_2272 VGND VPWR sky130_fd_sc_hd__tapvpwrvgnd_1
XFILLER_243_1357 VPWR VGND VPWR VGND sky130_ef_sc_hd__decap_12
XTAP_TAPCELL_ROW_200_2283 VGND VPWR sky130_fd_sc_hd__tapvpwrvgnd_1
XFILLER_208_1477 VGND VGND VPWR VPWR sky130_fd_sc_hd__decap_6
XTAP_TAPCELL_ROW_200_2294 VGND VPWR sky130_fd_sc_hd__tapvpwrvgnd_1
XFILLER_211_753 VPWR VGND VPWR VGND sky130_ef_sc_hd__decap_12
XFILLER_168_657 VPWR VGND VPWR VGND sky130_ef_sc_hd__decap_12
XFILLER_52_69 VGND VGND VPWR VPWR sky130_fd_sc_hd__fill_2
XFILLER_126_1177 VPWR VGND VPWR VGND sky130_ef_sc_hd__decap_12
XFILLER_167_167 VGND VGND VPWR VPWR sky130_fd_sc_hd__fill_1
XTAP_TAPCELL_ROW_192_2062 VGND VPWR sky130_fd_sc_hd__tapvpwrvgnd_1
XFILLER_211_797 VPWR VGND VPWR VGND sky130_ef_sc_hd__decap_12
XTAP_TAPCELL_ROW_192_2073 VGND VPWR sky130_fd_sc_hd__tapvpwrvgnd_1
XFILLER_143_1491 VGND VGND VPWR VPWR sky130_fd_sc_hd__decap_6
XTAP_TAPCELL_ROW_154_2_4679 VGND VPWR sky130_fd_sc_hd__tapvpwrvgnd_1
XTAP_TAPCELL_ROW_213_2633 VGND VPWR sky130_fd_sc_hd__tapvpwrvgnd_1
XTAP_TAPCELL_ROW_213_2644 VGND VPWR sky130_fd_sc_hd__tapvpwrvgnd_1
XFILLER_100_1339 VPWR VGND VPWR VGND sky130_ef_sc_hd__decap_12
XFILLER_191_671 VGND VGND VPWR VPWR sky130_fd_sc_hd__fill_1
XFILLER_174_1429 VPWR VGND VPWR VGND sky130_ef_sc_hd__decap_12
Xsram0_674 VGND VGND VPWR VPWR sram0_674/HI net674 sky130_fd_sc_hd__conb_1
Xsram0_685 VGND VGND VPWR VPWR net685 sram0_685/LO sky130_fd_sc_hd__conb_1
XFILLER_117_51 VGND VGND VPWR VPWR sky130_fd_sc_hd__decap_4
XFILLER_254_1453 VPWR VGND VPWR VGND sky130_ef_sc_hd__decap_12
XFILLER_250_1317 VPWR VGND VPWR VGND sky130_ef_sc_hd__decap_12
XFILLER_137_1273 VGND VGND VPWR VPWR sky130_fd_sc_hd__fill_1
XFILLER_215_1437 VPWR VGND VPWR VGND sky130_ef_sc_hd__decap_12
XFILLER_254_1497 VPWR VGND VPWR VGND sky130_ef_sc_hd__decap_12
XFILLER_77_55 VGND VGND VPWR VPWR sky130_fd_sc_hd__fill_1
XFILLER_46_1189 VGND VGND VPWR VPWR sky130_fd_sc_hd__fill_1
XTAP_TAPCELL_ROW_26_1_1161 VGND VPWR sky130_fd_sc_hd__tapvpwrvgnd_1
XFILLER_237_105 VGND VGND VPWR VPWR sky130_fd_sc_hd__decap_6
XFILLER_172_1197 VGND VGND VPWR VPWR sky130_fd_sc_hd__decap_6
XFILLER_150_1451 VPWR VGND VPWR VGND sky130_ef_sc_hd__decap_12
XFILLER_237_149 VPWR VGND VPWR VGND sky130_ef_sc_hd__decap_12
XFILLER_219_853 VPWR VGND VPWR VGND sky130_ef_sc_hd__decap_12
XFILLER_253_609 VGND VGND VPWR VPWR sky130_fd_sc_hd__decap_6
XFILLER_111_1435 VGND VGND VPWR VPWR sky130_fd_sc_hd__decap_6
XFILLER_150_1495 VPWR VGND VPWR VGND sky130_ef_sc_hd__decap_12
XFILLER_218_363 VGND VGND VPWR VPWR sky130_fd_sc_hd__fill_1
XFILLER_219_897 VPWR VGND VPWR VGND sky130_ef_sc_hd__decap_12
XFILLER_206_525 VGND VGND VPWR VPWR sky130_fd_sc_hd__decap_6
XFILLER_111_1479 VPWR VGND VPWR VGND sky130_ef_sc_hd__decap_12
XTAP_TAPCELL_ROW_199_2249 VGND VPWR sky130_fd_sc_hd__tapvpwrvgnd_1
XFILLER_245_193 VPWR VGND VPWR VGND sky130_ef_sc_hd__decap_12
XFILLER_2_1261 VPWR VGND VPWR VGND sky130_ef_sc_hd__decap_12
XFILLER_234_867 VGND VGND VPWR VPWR sky130_fd_sc_hd__fill_1
X_505_ _108_ _256_ _258_ VGND VGND VPWR VPWR acc_core.adder.cla_blocks\[6\].block.sum\[2\]
+ sky130_fd_sc_hd__nor3_1
XFILLER_206_569 VPWR VGND VPWR VGND sky130_ef_sc_hd__decap_12
XFILLER_221_517 VPWR VGND VPWR VGND sky130_ef_sc_hd__decap_12
XFILLER_18_1203 VPWR VGND VPWR VGND sky130_ef_sc_hd__decap_12
X_436_ net597 dout0_q\[20\] net535 VGND VGND VPWR VPWR _225_ sky130_fd_sc_hd__a21oi_1
XFILLER_109_1331 VPWR VGND VPWR VGND sky130_ef_sc_hd__decap_12
XFILLER_187_933 VPWR VGND VPWR VGND sky130_ef_sc_hd__decap_12
XFILLER_92_1165 VPWR VGND VPWR VGND sky130_ef_sc_hd__decap_12
XFILLER_18_1247 VPWR VGND VPWR VGND sky130_ef_sc_hd__decap_12
XFILLER_186_421 VPWR VGND VPWR VGND sky130_ef_sc_hd__decap_12
XFILLER_105_1217 VGND VGND VPWR VPWR sky130_fd_sc_hd__fill_1
X_367_ net246 _155_ VGND VGND VPWR VPWR _156_ sky130_fd_sc_hd__nand2b_1
XFILLER_187_977 VPWR VGND VPWR VGND sky130_ef_sc_hd__decap_12
XFILLER_70_1463 VGND VGND VPWR VPWR sky130_fd_sc_hd__decap_6
X_298_ net689 net523 VGND VGND VPWR VPWR _075_ sky130_fd_sc_hd__xnor2_1
XFILLER_173_137 VPWR VGND VPWR VGND sky130_ef_sc_hd__decap_12
XFILLER_170_811 VGND VGND VPWR VPWR sky130_fd_sc_hd__fill_1
XFILLER_255_1217 VPWR VGND VPWR VGND sky130_ef_sc_hd__decap_12
XFILLER_6_884 VPWR VGND VPWR VGND sky130_ef_sc_hd__decap_12
XPHY_EDGE_ROW_81_1_Right_737 VGND VGND VPWR VPWR sky130_fd_sc_hd__decap_3
XTAP_TAPCELL_ROW_171_1489 VGND VPWR sky130_fd_sc_hd__tapvpwrvgnd_1
XFILLER_182_693 VGND VGND VPWR VPWR sky130_fd_sc_hd__decap_6
XFILLER_181_181 VPWR VGND VPWR VGND sky130_ef_sc_hd__decap_12
XFILLER_244_27 VGND VGND VPWR VPWR sky130_fd_sc_hd__fill_1
XFILLER_29_1343 VPWR VGND VPWR VGND sky130_ef_sc_hd__decap_12
XFILLER_218_1061 VPWR VGND VPWR VGND sky130_ef_sc_hd__decap_12
XFILLER_64_1245 VGND VGND VPWR VPWR sky130_fd_sc_hd__fill_1
XTAP_TAPCELL_ROW_73_1_1208 VGND VPWR sky130_fd_sc_hd__tapvpwrvgnd_1
XTAP_TAPCELL_ROW_188_1953 VGND VPWR sky130_fd_sc_hd__tapvpwrvgnd_1
XTAP_TAPCELL_ROW_188_1964 VGND VPWR sky130_fd_sc_hd__tapvpwrvgnd_1
XFILLER_190_1253 VGND VGND VPWR VPWR sky130_fd_sc_hd__decap_6
XFILLER_29_1387 VPWR VGND VPWR VGND sky130_ef_sc_hd__decap_12
XFILLER_229_617 VPWR VGND VPWR VGND sky130_ef_sc_hd__decap_12
XFILLER_116_1357 VGND VGND VPWR VPWR sky130_fd_sc_hd__fill_1
XFILLER_190_1297 VPWR VGND VPWR VGND sky130_ef_sc_hd__decap_12
XFILLER_209_385 VGND VGND VPWR VPWR sky130_fd_sc_hd__decap_6
XFILLER_224_333 VPWR VGND VPWR VGND sky130_ef_sc_hd__decap_12
XFILLER_184_1035 VGND VGND VPWR VPWR sky130_fd_sc_hd__fill_1
XFILLER_225_889 VGND VGND VPWR VPWR sky130_fd_sc_hd__decap_6
XFILLER_149_1177 VPWR VGND VPWR VGND sky130_ef_sc_hd__decap_12
XFILLER_224_377 VPWR VGND VPWR VGND sky130_ef_sc_hd__decap_12
XFILLER_240_837 VPWR VGND VPWR VGND sky130_ef_sc_hd__decap_12
XFILLER_36_1303 VPWR VGND VPWR VGND sky130_ef_sc_hd__decap_12
XFILLER_225_1021 VPWR VGND VPWR VGND sky130_ef_sc_hd__decap_12
XFILLER_75_1385 VGND VGND VPWR VPWR sky130_fd_sc_hd__fill_1
XFILLER_189_281 VPWR VGND VPWR VGND sky130_ef_sc_hd__decap_12
XFILLER_225_1065 VPWR VGND VPWR VGND sky130_ef_sc_hd__decap_12
XFILLER_127_1497 VGND VGND VPWR VPWR sky130_fd_sc_hd__fill_1
XFILLER_192_413 VGND VGND VPWR VPWR sky130_fd_sc_hd__decap_6
XFILLER_192_457 VPWR VGND VPWR VGND sky130_ef_sc_hd__decap_12
XTAP_TAPCELL_ROW_120_2_4474 VGND VPWR sky130_fd_sc_hd__tapvpwrvgnd_1
XFILLER_173_671 VGND VGND VPWR VPWR sky130_fd_sc_hd__fill_1
XTAP_TAPCELL_ROW_119_2_4468 VGND VPWR sky130_fd_sc_hd__tapvpwrvgnd_1
XFILLER_195_1175 VGND VGND VPWR VPWR sky130_fd_sc_hd__fill_1
XFILLER_218_83 VGND VGND VPWR VPWR sky130_fd_sc_hd__fill_1
XFILLER_69_1189 VPWR VGND VPWR VGND sky130_ef_sc_hd__decap_12
XFILLER_82_1301 VGND VGND VPWR VPWR sky130_fd_sc_hd__fill_1
XPHY_EDGE_ROW_11_2_Left_513 VGND VGND VPWR VPWR sky130_fd_sc_hd__decap_3
XFILLER_154_27 VGND VGND VPWR VPWR sky130_fd_sc_hd__fill_1
XFILLER_47_1443 VPWR VGND VPWR VGND sky130_ef_sc_hd__decap_12
XFILLER_236_1161 VPWR VGND VPWR VGND sky130_ef_sc_hd__decap_12
XTAP_TAPCELL_ROW_87_2_4279 VGND VPWR sky130_fd_sc_hd__tapvpwrvgnd_1
XFILLER_134_1413 VGND VGND VPWR VPWR sky130_fd_sc_hd__fill_1
XFILLER_248_937 VPWR VGND VPWR VGND sky130_ef_sc_hd__decap_12
XFILLER_43_1329 VGND VGND VPWR VPWR sky130_fd_sc_hd__fill_1
XFILLER_219_105 VGND VGND VPWR VPWR sky130_fd_sc_hd__decap_6
XFILLER_247_447 VGND VGND VPWR VPWR sky130_fd_sc_hd__fill_1
XFILLER_170_15 VPWR VGND VPWR VGND sky130_ef_sc_hd__decap_12
XFILLER_219_149 VPWR VGND VPWR VGND sky130_ef_sc_hd__decap_12
XFILLER_235_609 VGND VGND VPWR VPWR sky130_fd_sc_hd__decap_6
XTAP_TAPCELL_ROW_67_2_4155 VGND VPWR sky130_fd_sc_hd__tapvpwrvgnd_1
XFILLER_249_1511 VGND VGND VPWR VPWR sky130_fd_sc_hd__fill_1
XFILLER_167_1233 VPWR VGND VPWR VGND sky130_ef_sc_hd__decap_12
XTAP_TAPCELL_ROW_202_2334 VGND VPWR sky130_fd_sc_hd__tapvpwrvgnd_1
XFILLER_216_867 VGND VGND VPWR VPWR sky130_fd_sc_hd__fill_1
XFILLER_227_193 VPWR VGND VPWR VGND sky130_ef_sc_hd__decap_12
XFILLER_243_653 VPWR VGND VPWR VGND sky130_ef_sc_hd__decap_12
XFILLER_242_141 VPWR VGND VPWR VGND sky130_ef_sc_hd__decap_12
XTAP_TAPCELL_ROW_202_2345 VGND VPWR sky130_fd_sc_hd__tapvpwrvgnd_1
XFILLER_203_517 VPWR VGND VPWR VGND sky130_ef_sc_hd__decap_12
XFILLER_243_697 VPWR VGND VPWR VGND sky130_ef_sc_hd__decap_12
XFILLER_63_57 VPWR VGND VPWR VGND sky130_ef_sc_hd__decap_12
XFILLER_93_1441 VGND VGND VPWR VPWR sky130_fd_sc_hd__fill_1
XFILLER_128_1239 VGND VGND VPWR VPWR sky130_fd_sc_hd__decap_6
XTAP_TAPCELL_ROW_194_2113 VGND VPWR sky130_fd_sc_hd__tapvpwrvgnd_1
XFILLER_243_1121 VPWR VGND VPWR VGND sky130_ef_sc_hd__decap_12
XTAP_TAPCELL_ROW_194_2124 VGND VPWR sky130_fd_sc_hd__tapvpwrvgnd_1
XFILLER_208_1241 VPWR VGND VPWR VGND sky130_ef_sc_hd__decap_12
XFILLER_169_933 VPWR VGND VPWR VGND sky130_ef_sc_hd__decap_12
XFILLER_179_57 VPWR VGND VPWR VGND sky130_ef_sc_hd__decap_12
XTAP_TAPCELL_ROW_194_2135 VGND VPWR sky130_fd_sc_hd__tapvpwrvgnd_1
XFILLER_168_421 VPWR VGND VPWR VGND sky130_ef_sc_hd__decap_12
XFILLER_144_3 VPWR VGND VPWR VGND sky130_ef_sc_hd__decap_12
XFILLER_204_1105 VPWR VGND VPWR VGND sky130_ef_sc_hd__decap_12
XFILLER_208_1285 VPWR VGND VPWR VGND sky130_ef_sc_hd__decap_12
XFILLER_54_1469 VGND VGND VPWR VPWR sky130_fd_sc_hd__fill_1
XFILLER_169_977 VPWR VGND VPWR VGND sky130_ef_sc_hd__decap_12
XFILLER_211_561 VPWR VGND VPWR VGND sky130_ef_sc_hd__decap_12
XFILLER_180_1477 VGND VGND VPWR VPWR sky130_fd_sc_hd__decap_6
Xwire502 net503 VGND VGND VPWR VPWR net502 sky130_fd_sc_hd__clkbuf_1
XFILLER_184_925 VPWR VGND VPWR VGND sky130_ef_sc_hd__decap_12
XFILLER_204_1149 VPWR VGND VPWR VGND sky130_ef_sc_hd__decap_12
XFILLER_7_615 VGND VGND VPWR VPWR sky130_fd_sc_hd__fill_1
XFILLER_195_273 VGND VGND VPWR VPWR sky130_fd_sc_hd__decap_6
Xwire557 net558 VGND VGND VPWR VPWR net557 sky130_fd_sc_hd__clkbuf_1
Xwire568 net43 VGND VGND VPWR VPWR net568 sky130_fd_sc_hd__clkbuf_1
XFILLER_87_1201 VPWR VGND VPWR VGND sky130_ef_sc_hd__decap_12
Xwire579 net580 VGND VGND VPWR VPWR net579 sky130_fd_sc_hd__clkbuf_1
XFILLER_104_1283 VPWR VGND VPWR VGND sky130_ef_sc_hd__decap_12
XFILLER_13_1177 VPWR VGND VPWR VGND sky130_ef_sc_hd__decap_12
XFILLER_178_1373 VPWR VGND VPWR VGND sky130_ef_sc_hd__decap_12
XFILLER_3_821 VPWR VGND VPWR VGND sky130_ef_sc_hd__decap_12
XFILLER_87_1267 VGND VGND VPWR VPWR sky130_fd_sc_hd__decap_6
XFILLER_88_65 VGND VGND VPWR VPWR sky130_fd_sc_hd__decap_6
XFILLER_139_1379 VGND VGND VPWR VPWR sky130_fd_sc_hd__decap_6
XFILLER_174_1259 VGND VGND VPWR VPWR sky130_fd_sc_hd__fill_1
XFILLER_215_1201 VPWR VGND VPWR VGND sky130_ef_sc_hd__decap_12
XFILLER_254_1261 VPWR VGND VPWR VGND sky130_ef_sc_hd__decap_12
XPHY_EDGE_ROW_68_2_Left_570 VGND VGND VPWR VPWR sky130_fd_sc_hd__decap_3
XFILLER_219_1381 VPWR VGND VPWR VGND sky130_ef_sc_hd__decap_12
XFILLER_215_1245 VPWR VGND VPWR VGND sky130_ef_sc_hd__decap_12
XFILLER_250_1147 VGND VGND VPWR VPWR sky130_fd_sc_hd__fill_1
XFILLER_215_1289 VPWR VGND VPWR VGND sky130_ef_sc_hd__decap_12
XFILLER_238_469 VGND VGND VPWR VPWR sky130_fd_sc_hd__decap_6
XFILLER_253_417 VPWR VGND VPWR VGND sky130_ef_sc_hd__decap_12
XTAP_TAPCELL_ROW_134_1_1269 VGND VPWR sky130_fd_sc_hd__tapvpwrvgnd_1
XFILLER_24_1295 VGND VGND VPWR VPWR sky130_fd_sc_hd__decap_6
XFILLER_111_1243 VPWR VGND VPWR VGND sky130_ef_sc_hd__decap_12
XFILLER_206_333 VPWR VGND VPWR VGND sky130_ef_sc_hd__decap_12
XFILLER_111_1287 VPWR VGND VPWR VGND sky130_ef_sc_hd__decap_12
XFILLER_230_29 VPWR VGND VPWR VGND sky130_ef_sc_hd__decap_12
XFILLER_94_1227 VPWR VGND VPWR VGND sky130_ef_sc_hd__decap_12
XFILLER_207_889 VGND VGND VPWR VPWR sky130_fd_sc_hd__decap_6
XFILLER_2_1091 VGND VGND VPWR VPWR sky130_fd_sc_hd__fill_1
XFILLER_206_377 VPWR VGND VPWR VGND sky130_ef_sc_hd__decap_12
XFILLER_222_837 VPWR VGND VPWR VGND sky130_ef_sc_hd__decap_12
XFILLER_146_1339 VPWR VGND VPWR VGND sky130_ef_sc_hd__decap_12
XFILLER_185_1399 VGND VGND VPWR VPWR sky130_fd_sc_hd__fill_1
XFILLER_226_1341 VPWR VGND VPWR VGND sky130_ef_sc_hd__decap_12
XFILLER_187_741 VPWR VGND VPWR VGND sky130_ef_sc_hd__decap_12
XFILLER_222_1205 VPWR VGND VPWR VGND sky130_ef_sc_hd__decap_12
X_419_ _145_ _146_ net249 VGND VGND VPWR VPWR _208_ sky130_fd_sc_hd__and3_1
XFILLER_226_1385 VPWR VGND VPWR VGND sky130_ef_sc_hd__decap_12
XFILLER_239_27 VPWR VGND VPWR VGND sky130_ef_sc_hd__decap_12
XTAP_TAPCELL_ROW_177_1654 VGND VPWR sky130_fd_sc_hd__tapvpwrvgnd_1
XFILLER_230_881 VPWR VGND VPWR VGND sky130_ef_sc_hd__decap_12
XTAP_TAPCELL_ROW_177_1665 VGND VPWR sky130_fd_sc_hd__tapvpwrvgnd_1
XFILLER_186_251 VGND VGND VPWR VPWR sky130_fd_sc_hd__fill_1
XTAP_TAPCELL_ROW_177_1676 VGND VPWR sky130_fd_sc_hd__tapvpwrvgnd_1
XFILLER_187_785 VPWR VGND VPWR VGND sky130_ef_sc_hd__decap_12
XFILLER_174_413 VGND VGND VPWR VPWR sky130_fd_sc_hd__decap_6
XFILLER_70_1271 VPWR VGND VPWR VGND sky130_ef_sc_hd__decap_12
XFILLER_174_457 VPWR VGND VPWR VGND sky130_ef_sc_hd__decap_12
XFILLER_31_1255 VPWR VGND VPWR VGND sky130_ef_sc_hd__decap_12
XFILLER_190_917 VGND VGND VPWR VPWR sky130_fd_sc_hd__decap_6
XTAP_TAPCELL_ROW_105_2_4387 VGND VPWR sky130_fd_sc_hd__tapvpwrvgnd_1
XFILLER_122_1383 VPWR VGND VPWR VGND sky130_ef_sc_hd__decap_12
XFILLER_255_15 VPWR VGND VPWR VGND sky130_ef_sc_hd__decap_12
XFILLER_31_1299 VPWR VGND VPWR VGND sky130_ef_sc_hd__decap_12
XFILLER_6_681 VGND VGND VPWR VPWR sky130_fd_sc_hd__decap_6
XFILLER_157_1435 VGND VGND VPWR VPWR sky130_fd_sc_hd__decap_6
XFILLER_192_1315 VGND VGND VPWR VPWR sky130_fd_sc_hd__fill_1
XPHY_EDGE_ROW_82_1_Right_738 VGND VGND VPWR VPWR sky130_fd_sc_hd__decap_3
XFILLER_233_1301 VPWR VGND VPWR VGND sky130_ef_sc_hd__decap_12
XFILLER_9_1201 VGND VGND VPWR VPWR sky130_fd_sc_hd__decap_3
XFILLER_157_1479 VPWR VGND VPWR VGND sky130_ef_sc_hd__decap_12
XFILLER_237_1481 VPWR VGND VPWR VGND sky130_ef_sc_hd__decap_12
XFILLER_233_1345 VPWR VGND VPWR VGND sky130_ef_sc_hd__decap_12
XFILLER_9_1245 VPWR VGND VPWR VGND sky130_ef_sc_hd__decap_12
XFILLER_190_1061 VPWR VGND VPWR VGND sky130_ef_sc_hd__decap_12
XFILLER_155_1192 VPWR VGND VPWR VGND sky130_ef_sc_hd__decap_12
XFILLER_116_1165 VPWR VGND VPWR VGND sky130_ef_sc_hd__decap_12
XTAP_TAPCELL_ROW_53_2_4074 VGND VPWR sky130_fd_sc_hd__tapvpwrvgnd_1
XFILLER_9_1289 VPWR VGND VPWR VGND sky130_ef_sc_hd__decap_12
XFILLER_229_447 VGND VGND VPWR VPWR sky130_fd_sc_hd__fill_1
XFILLER_217_609 VGND VGND VPWR VPWR sky130_fd_sc_hd__decap_6
XFILLER_42_1351 VGND VGND VPWR VPWR sky130_fd_sc_hd__decap_6
XFILLER_204_41 VPWR VGND VPWR VGND sky130_ef_sc_hd__decap_12
XPHY_EDGE_ROW_153_1_Left_408 VGND VGND VPWR VPWR sky130_fd_sc_hd__decap_3
XFILLER_238_981 VPWR VGND VPWR VGND sky130_ef_sc_hd__decap_12
XFILLER_42_1395 VPWR VGND VPWR VGND sky130_ef_sc_hd__decap_12
XFILLER_204_85 VPWR VGND VPWR VGND sky130_ef_sc_hd__decap_12
XFILLER_17_39 VPWR VGND VPWR VGND sky130_ef_sc_hd__decap_12
XTAP_TAPCELL_ROW_0_824 VGND VPWR sky130_fd_sc_hd__tapvpwrvgnd_1
XFILLER_253_951 VGND VGND VPWR VPWR sky130_fd_sc_hd__fill_1
XTAP_TAPCELL_ROW_0_835 VGND VPWR sky130_fd_sc_hd__tapvpwrvgnd_1
XFILLER_209_193 VPWR VGND VPWR VGND sky130_ef_sc_hd__decap_12
XFILLER_140_29 VPWR VGND VPWR VGND sky130_ef_sc_hd__decap_12
XFILLER_225_653 VPWR VGND VPWR VGND sky130_ef_sc_hd__decap_12
XTAP_TAPCELL_ROW_0_846 VGND VPWR sky130_fd_sc_hd__tapvpwrvgnd_1
XTAP_TAPCELL_ROW_0_857 VGND VPWR sky130_fd_sc_hd__tapvpwrvgnd_1
XFILLER_224_141 VPWR VGND VPWR VGND sky130_ef_sc_hd__decap_12
XFILLER_240_601 VPWR VGND VPWR VGND sky130_ef_sc_hd__decap_12
XTAP_TAPCELL_ROW_0_868 VGND VPWR sky130_fd_sc_hd__tapvpwrvgnd_1
XFILLER_197_505 VPWR VGND VPWR VGND sky130_ef_sc_hd__decap_12
XFILLER_225_697 VPWR VGND VPWR VGND sky130_ef_sc_hd__decap_12
XFILLER_164_1439 VPWR VGND VPWR VGND sky130_ef_sc_hd__decap_12
XFILLER_240_645 VPWR VGND VPWR VGND sky130_ef_sc_hd__decap_12
XFILLER_244_1441 VPWR VGND VPWR VGND sky130_ef_sc_hd__decap_12
XFILLER_33_27 VPWR VGND VPWR VGND sky130_ef_sc_hd__decap_12
XTAP_TAPCELL_ROW_255_3765 VGND VPWR sky130_fd_sc_hd__tapvpwrvgnd_1
XFILLER_205_1425 VPWR VGND VPWR VGND sky130_ef_sc_hd__decap_12
XTAP_TAPCELL_ROW_255_3776 VGND VPWR sky130_fd_sc_hd__tapvpwrvgnd_1
XFILLER_244_1485 VPWR VGND VPWR VGND sky130_ef_sc_hd__decap_12
XTAP_TAPCELL_ROW_255_3787 VGND VPWR sky130_fd_sc_hd__tapvpwrvgnd_1
XFILLER_149_27 VPWR VGND VPWR VGND sky130_ef_sc_hd__decap_12
XTAP_TAPCELL_ROW_255_3798 VGND VPWR sky130_fd_sc_hd__tapvpwrvgnd_1
XFILLER_36_1177 VPWR VGND VPWR VGND sky130_ef_sc_hd__decap_12
XFILLER_166_925 VPWR VGND VPWR VGND sky130_ef_sc_hd__decap_12
XFILLER_205_1469 VPWR VGND VPWR VGND sky130_ef_sc_hd__decap_12
XFILLER_177_273 VGND VGND VPWR VPWR sky130_fd_sc_hd__decap_6
XFILLER_192_221 VPWR VGND VPWR VGND sky130_ef_sc_hd__decap_12
XFILLER_53_1491 VGND VGND VPWR VPWR sky130_fd_sc_hd__decap_6
XTAP_TAPCELL_ROW_11_2_3820 VGND VPWR sky130_fd_sc_hd__tapvpwrvgnd_1
XFILLER_193_777 VGND VGND VPWR VPWR sky130_fd_sc_hd__decap_6
XFILLER_101_1423 VPWR VGND VPWR VGND sky130_ef_sc_hd__decap_12
XFILLER_192_265 VPWR VGND VPWR VGND sky130_ef_sc_hd__decap_12
XFILLER_140_1483 VPWR VGND VPWR VGND sky130_ef_sc_hd__decap_12
XFILLER_229_93 VPWR VGND VPWR VGND sky130_ef_sc_hd__decap_12
XFILLER_4_629 VGND VGND VPWR VPWR sky130_fd_sc_hd__fill_1
XFILLER_165_15 VPWR VGND VPWR VGND sky130_ef_sc_hd__decap_12
XFILLER_10_1339 VPWR VGND VPWR VGND sky130_ef_sc_hd__decap_12
XFILLER_175_1513 VGND VGND VPWR VPWR sky130_fd_sc_hd__fill_2
XFILLER_84_1407 VGND VGND VPWR VPWR sky130_fd_sc_hd__decap_6
XFILLER_101_1467 VPWR VGND VPWR VGND sky130_ef_sc_hd__decap_12
XFILLER_251_1401 VPWR VGND VPWR VGND sky130_ef_sc_hd__decap_12
XFILLER_0_813 VGND VGND VPWR VPWR sky130_fd_sc_hd__decap_8
XFILLER_245_81 VPWR VGND VPWR VGND sky130_ef_sc_hd__decap_12
XFILLER_248_701 VPWR VGND VPWR VGND sky130_ef_sc_hd__decap_12
XFILLER_47_1273 VGND VGND VPWR VPWR sky130_fd_sc_hd__fill_1
XFILLER_173_1281 VGND VGND VPWR VPWR sky130_fd_sc_hd__decap_6
XTAP_TAPCELL_ROW_208_2510 VGND VPWR sky130_fd_sc_hd__tapvpwrvgnd_1
XFILLER_212_1429 VPWR VGND VPWR VGND sky130_ef_sc_hd__decap_12
XFILLER_181_69 VPWR VGND VPWR VGND sky130_ef_sc_hd__decap_12
XFILLER_60_1451 VPWR VGND VPWR VGND sky130_ef_sc_hd__decap_12
XFILLER_114_41 VPWR VGND VPWR VGND sky130_ef_sc_hd__decap_12
XFILLER_235_417 VPWR VGND VPWR VGND sky130_ef_sc_hd__decap_12
XFILLER_21_1435 VGND VGND VPWR VPWR sky130_fd_sc_hd__decap_6
XFILLER_60_1495 VPWR VGND VPWR VGND sky130_ef_sc_hd__decap_12
XTAP_TAPCELL_ROW_142_2_4606 VGND VPWR sky130_fd_sc_hd__tapvpwrvgnd_1
XPHY_EDGE_ROW_44_1_Right_700 VGND VGND VPWR VPWR sky130_fd_sc_hd__decap_3
XFILLER_21_1479 VPWR VGND VPWR VGND sky130_ef_sc_hd__decap_12
XFILLER_244_973 VGND VGND VPWR VPWR sky130_fd_sc_hd__decap_6
XFILLER_210_1197 VGND VGND VPWR VPWR sky130_fd_sc_hd__decap_6
XFILLER_243_461 VPWR VGND VPWR VGND sky130_ef_sc_hd__decap_12
XFILLER_167_1063 VGND VGND VPWR VPWR sky130_fd_sc_hd__fill_1
XFILLER_204_837 VPWR VGND VPWR VGND sky130_ef_sc_hd__decap_12
XFILLER_19_1331 VPWR VGND VPWR VGND sky130_ef_sc_hd__decap_12
XFILLER_230_133 VGND VGND VPWR VPWR sky130_fd_sc_hd__decap_6
XFILLER_169_741 VPWR VGND VPWR VGND sky130_ef_sc_hd__decap_12
XFILLER_106_1301 VGND VGND VPWR VPWR sky130_fd_sc_hd__fill_1
XFILLER_180_1241 VPWR VGND VPWR VGND sky130_ef_sc_hd__decap_12
XFILLER_168_251 VGND VGND VPWR VPWR sky130_fd_sc_hd__fill_1
XFILLER_208_1093 VPWR VGND VPWR VGND sky130_ef_sc_hd__decap_12
XFILLER_212_881 VPWR VGND VPWR VGND sky130_ef_sc_hd__decap_12
XFILLER_230_177 VPWR VGND VPWR VGND sky130_ef_sc_hd__decap_12
XFILLER_15_1217 VGND VGND VPWR VPWR sky130_fd_sc_hd__fill_1
XFILLER_169_785 VPWR VGND VPWR VGND sky130_ef_sc_hd__decap_12
Xwire310 net311 VGND VGND VPWR VPWR net310 sky130_fd_sc_hd__clkbuf_1
XFILLER_180_1285 VPWR VGND VPWR VGND sky130_ef_sc_hd__decap_12
XFILLER_211_391 VGND VGND VPWR VPWR sky130_fd_sc_hd__fill_1
Xwire321 net322 VGND VGND VPWR VPWR net321 sky130_fd_sc_hd__clkbuf_1
XFILLER_184_755 VGND VGND VPWR VPWR sky130_fd_sc_hd__fill_1
Xwire343 net344 VGND VGND VPWR VPWR net343 sky130_fd_sc_hd__clkbuf_1
XFILLER_89_1329 VGND VGND VPWR VPWR sky130_fd_sc_hd__fill_1
Xwire354 net355 VGND VGND VPWR VPWR net354 sky130_fd_sc_hd__clkbuf_1
XFILLER_239_1009 VPWR VGND VPWR VGND sky130_ef_sc_hd__decap_12
XFILLER_8_979 VGND VGND VPWR VPWR sky130_fd_sc_hd__fill_1
Xwire365 net366 VGND VGND VPWR VPWR net365 sky130_fd_sc_hd__clkbuf_1
XFILLER_172_917 VGND VGND VPWR VPWR sky130_fd_sc_hd__decap_6
XFILLER_171_405 VPWR VGND VPWR VGND sky130_ef_sc_hd__decap_12
XTAP_TAPCELL_ROW_172_1540 VGND VPWR sky130_fd_sc_hd__tapvpwrvgnd_1
Xwire376 net377 VGND VGND VPWR VPWR net376 sky130_fd_sc_hd__clkbuf_1
Xwire387 net388 VGND VGND VPWR VPWR net387 sky130_fd_sc_hd__clkbuf_1
Xwire398 net399 VGND VGND VPWR VPWR net398 sky130_fd_sc_hd__clkbuf_1
XFILLER_171_449 VPWR VGND VPWR VGND sky130_ef_sc_hd__decap_12
XFILLER_180_961 VPWR VGND VPWR VGND sky130_ef_sc_hd__decap_12
XFILLER_3_651 VGND VGND VPWR VPWR sky130_fd_sc_hd__fill_1
XFILLER_139_1165 VPWR VGND VPWR VGND sky130_ef_sc_hd__decap_12
XFILLER_117_1441 VGND VGND VPWR VPWR sky130_fd_sc_hd__fill_1
XFILLER_254_1091 VGND VGND VPWR VPWR sky130_fd_sc_hd__fill_1
XFILLER_191_1381 VPWR VGND VPWR VGND sky130_ef_sc_hd__decap_12
XFILLER_26_1357 VGND VGND VPWR VPWR sky130_fd_sc_hd__fill_1
XFILLER_6_1429 VPWR VGND VPWR VGND sky130_ef_sc_hd__decap_12
XPHY_EDGE_ROW_219_Right_64 VGND VGND VPWR VPWR sky130_fd_sc_hd__decap_3
XFILLER_238_233 VPWR VGND VPWR VGND sky130_ef_sc_hd__decap_12
XTAP_TAPCELL_ROW_166_1355 VGND VPWR sky130_fd_sc_hd__tapvpwrvgnd_1
XFILLER_238_277 VPWR VGND VPWR VGND sky130_ef_sc_hd__decap_12
XTAP_TAPCELL_ROW_166_1366 VGND VPWR sky130_fd_sc_hd__tapvpwrvgnd_1
XFILLER_254_737 VPWR VGND VPWR VGND sky130_ef_sc_hd__decap_12
XTAP_TAPCELL_ROW_166_1377 VGND VPWR sky130_fd_sc_hd__tapvpwrvgnd_1
XFILLER_241_39 VPWR VGND VPWR VGND sky130_ef_sc_hd__decap_12
XFILLER_253_225 VPWR VGND VPWR VGND sky130_ef_sc_hd__decap_12
XFILLER_235_951 VGND VGND VPWR VPWR sky130_fd_sc_hd__fill_1
XTAP_TAPCELL_ROW_68_1_1203 VGND VPWR sky130_fd_sc_hd__tapvpwrvgnd_1
XFILLER_0_53 VGND VGND VPWR VPWR sky130_fd_sc_hd__decap_3
XFILLER_207_653 VPWR VGND VPWR VGND sky130_ef_sc_hd__decap_12
XFILLER_4_1197 VGND VGND VPWR VPWR sky130_fd_sc_hd__decap_6
XFILLER_206_141 VPWR VGND VPWR VGND sky130_ef_sc_hd__decap_12
XFILLER_222_601 VPWR VGND VPWR VGND sky130_ef_sc_hd__decap_12
XFILLER_179_505 VPWR VGND VPWR VGND sky130_ef_sc_hd__decap_12
XFILLER_0_97 VPWR VGND VPWR VGND sky130_ef_sc_hd__decap_12
XTAP_TAPCELL_ROW_179_1705 VGND VPWR sky130_fd_sc_hd__tapvpwrvgnd_1
XFILLER_207_697 VPWR VGND VPWR VGND sky130_ef_sc_hd__decap_12
XFILLER_59_1177 VPWR VGND VPWR VGND sky130_ef_sc_hd__decap_12
XTAP_TAPCELL_ROW_179_1716 VGND VPWR sky130_fd_sc_hd__tapvpwrvgnd_1
XTAP_TAPCELL_ROW_179_1727 VGND VPWR sky130_fd_sc_hd__tapvpwrvgnd_1
XFILLER_221_111 VGND VGND VPWR VPWR sky130_fd_sc_hd__fill_1
XFILLER_222_645 VPWR VGND VPWR VGND sky130_ef_sc_hd__decap_12
XPHY_EDGE_ROW_228_Right_73 VGND VGND VPWR VPWR sky130_fd_sc_hd__decap_3
XFILLER_222_1035 VGND VGND VPWR VPWR sky130_fd_sc_hd__fill_1
XFILLER_37_1497 VGND VGND VPWR VPWR sky130_fd_sc_hd__fill_1
XTAP_TAPCELL_ROW_155_2_4684 VGND VPWR sky130_fd_sc_hd__tapvpwrvgnd_1
XTAP_TAPCELL_ROW_250_3640 VGND VPWR sky130_fd_sc_hd__tapvpwrvgnd_1
XFILLER_174_221 VPWR VGND VPWR VGND sky130_ef_sc_hd__decap_12
XFILLER_175_777 VGND VGND VPWR VPWR sky130_fd_sc_hd__decap_6
XFILLER_174_265 VPWR VGND VPWR VGND sky130_ef_sc_hd__decap_12
XFILLER_190_725 VPWR VGND VPWR VGND sky130_ef_sc_hd__decap_12
Xmax_cap610 rd_addr\[4\] VGND VGND VPWR VPWR net610 sky130_fd_sc_hd__clkbuf_1
XFILLER_122_1191 VPWR VGND VPWR VGND sky130_ef_sc_hd__decap_12
XFILLER_190_769 VPWR VGND VPWR VGND sky130_ef_sc_hd__decap_12
XFILLER_157_1243 VPWR VGND VPWR VGND sky130_ef_sc_hd__decap_12
XFILLER_0_109 VGND VGND VPWR VPWR sky130_fd_sc_hd__decap_3
XFILLER_118_1227 VPWR VGND VPWR VGND sky130_ef_sc_hd__decap_12
XPHY_EDGE_ROW_83_1_Right_739 VGND VGND VPWR VPWR sky130_fd_sc_hd__decap_3
XFILLER_157_1287 VPWR VGND VPWR VGND sky130_ef_sc_hd__decap_12
XTAP_TAPCELL_ROW_248_3580 VGND VPWR sky130_fd_sc_hd__tapvpwrvgnd_1
XPHY_EDGE_ROW_237_Right_82 VGND VGND VPWR VPWR sky130_fd_sc_hd__decap_3
XTAP_TAPCELL_ROW_248_3591 VGND VPWR sky130_fd_sc_hd__tapvpwrvgnd_1
XFILLER_44_1413 VGND VGND VPWR VPWR sky130_fd_sc_hd__fill_1
XFILLER_170_1421 VGND VGND VPWR VPWR sky130_fd_sc_hd__decap_6
XFILLER_215_51 VGND VGND VPWR VPWR sky130_fd_sc_hd__decap_4
XTAP_TAPCELL_ROW_244_3466 VGND VPWR sky130_fd_sc_hd__tapvpwrvgnd_1
XFILLER_233_1175 VGND VGND VPWR VPWR sky130_fd_sc_hd__fill_1
XTAP_TAPCELL_ROW_244_3477 VGND VPWR sky130_fd_sc_hd__tapvpwrvgnd_1
XFILLER_28_27 VGND VGND VPWR VPWR sky130_fd_sc_hd__fill_1
XFILLER_170_1465 VPWR VGND VPWR VGND sky130_ef_sc_hd__decap_12
XFILLER_217_417 VPWR VGND VPWR VGND sky130_ef_sc_hd__decap_12
XFILLER_151_39 VPWR VGND VPWR VGND sky130_ef_sc_hd__decap_12
XTAP_TAPCELL_ROW_127_2_4519 VGND VPWR sky130_fd_sc_hd__tapvpwrvgnd_1
XFILLER_226_973 VGND VGND VPWR VPWR sky130_fd_sc_hd__decap_6
XFILLER_44_15 VPWR VGND VPWR VGND sky130_ef_sc_hd__decap_12
XFILLER_225_461 VPWR VGND VPWR VGND sky130_ef_sc_hd__decap_12
XFILLER_241_921 VPWR VGND VPWR VGND sky130_ef_sc_hd__decap_12
XFILLER_77_1255 VPWR VGND VPWR VGND sky130_ef_sc_hd__decap_12
XFILLER_164_1203 VPWR VGND VPWR VGND sky130_ef_sc_hd__decap_12
XFILLER_129_1323 VGND VGND VPWR VPWR sky130_fd_sc_hd__decap_6
XFILLER_198_825 VPWR VGND VPWR VGND sky130_ef_sc_hd__decap_12
XFILLER_38_1239 VGND VGND VPWR VPWR sky130_fd_sc_hd__decap_6
XPHY_EDGE_ROW_246_Right_91 VGND VGND VPWR VPWR sky130_fd_sc_hd__decap_3
XFILLER_241_965 VPWR VGND VPWR VGND sky130_ef_sc_hd__decap_12
XFILLER_77_1299 VPWR VGND VPWR VGND sky130_ef_sc_hd__decap_12
XFILLER_129_1367 VPWR VGND VPWR VGND sky130_ef_sc_hd__decap_12
XFILLER_164_1247 VPWR VGND VPWR VGND sky130_ef_sc_hd__decap_12
XFILLER_212_133 VGND VGND VPWR VPWR sky130_fd_sc_hd__decap_6
XFILLER_197_335 VGND VGND VPWR VPWR sky130_fd_sc_hd__fill_1
XFILLER_198_869 VPWR VGND VPWR VGND sky130_ef_sc_hd__decap_12
XFILLER_240_475 VGND VGND VPWR VPWR sky130_fd_sc_hd__fill_1
XFILLER_212_177 VPWR VGND VPWR VGND sky130_ef_sc_hd__decap_12
XFILLER_205_1233 VPWR VGND VPWR VGND sky130_ef_sc_hd__decap_12
XTAP_TAPCELL_ROW_75_2_4206 VGND VPWR sky130_fd_sc_hd__tapvpwrvgnd_1
XFILLER_100_65 VGND VGND VPWR VPWR sky130_fd_sc_hd__decap_6
XFILLER_165_221 VGND VGND VPWR VPWR sky130_fd_sc_hd__decap_3
XFILLER_197_1001 VGND VGND VPWR VPWR sky130_fd_sc_hd__decap_6
XFILLER_166_755 VGND VGND VPWR VPWR sky130_fd_sc_hd__fill_1
XFILLER_193_541 VPWR VGND VPWR VGND sky130_ef_sc_hd__decap_12
XFILLER_201_1119 VGND VGND VPWR VPWR sky130_fd_sc_hd__fill_1
XFILLER_165_265 VPWR VGND VPWR VGND sky130_ef_sc_hd__decap_12
XFILLER_197_1045 VPWR VGND VPWR VGND sky130_ef_sc_hd__decap_12
XFILLER_193_585 VPWR VGND VPWR VGND sky130_ef_sc_hd__decap_12
XFILLER_14_1283 VPWR VGND VPWR VGND sky130_ef_sc_hd__decap_12
XFILLER_101_1231 VPWR VGND VPWR VGND sky130_ef_sc_hd__decap_12
XTAP_TAPCELL_ROW_189_2001 VGND VPWR sky130_fd_sc_hd__tapvpwrvgnd_1
XFILLER_88_1351 VGND VGND VPWR VPWR sky130_fd_sc_hd__decap_6
XFILLER_197_1089 VPWR VGND VPWR VGND sky130_ef_sc_hd__decap_12
XFILLER_84_1215 VPWR VGND VPWR VGND sky130_ef_sc_hd__decap_12
XFILLER_101_1275 VPWR VGND VPWR VGND sky130_ef_sc_hd__decap_12
XFILLER_107_3 VPWR VGND VPWR VGND sky130_ef_sc_hd__decap_12
XFILLER_88_1395 VPWR VGND VPWR VGND sky130_ef_sc_hd__decap_12
XFILLER_175_1343 VGND VGND VPWR VPWR sky130_fd_sc_hd__fill_1
XFILLER_49_1379 VGND VGND VPWR VPWR sky130_fd_sc_hd__decap_6
XFILLER_84_1259 VPWR VGND VPWR VGND sky130_ef_sc_hd__decap_12
XFILLER_136_1327 VPWR VGND VPWR VGND sky130_ef_sc_hd__decap_12
XFILLER_251_1231 VGND VGND VPWR VPWR sky130_fd_sc_hd__fill_1
XFILLER_125_51 VGND VGND VPWR VPWR sky130_fd_sc_hd__decap_4
XFILLER_248_531 VGND VGND VPWR VPWR sky130_fd_sc_hd__fill_1
XFILLER_216_1373 VPWR VGND VPWR VGND sky130_ef_sc_hd__decap_12
XTAP_TAPCELL_ROW_22_2_3889 VGND VPWR sky130_fd_sc_hd__tapvpwrvgnd_1
XFILLER_85_55 VGND VGND VPWR VPWR sky130_fd_sc_hd__fill_1
XFILLER_212_1259 VGND VGND VPWR VPWR sky130_fd_sc_hd__fill_1
XFILLER_236_737 VPWR VGND VPWR VGND sky130_ef_sc_hd__decap_12
XTAP_TAPCELL_ROW_4_960 VGND VPWR sky130_fd_sc_hd__tapvpwrvgnd_1
XTAP_TAPCELL_ROW_4_971 VGND VPWR sky130_fd_sc_hd__tapvpwrvgnd_1
XFILLER_235_225 VPWR VGND VPWR VGND sky130_ef_sc_hd__decap_12
XTAP_TAPCELL_ROW_4_982 VGND VPWR sky130_fd_sc_hd__tapvpwrvgnd_1
XFILLER_21_1243 VPWR VGND VPWR VGND sky130_ef_sc_hd__decap_12
XFILLER_217_951 VGND VGND VPWR VPWR sky130_fd_sc_hd__fill_1
XFILLER_95_1311 VPWR VGND VPWR VGND sky130_ef_sc_hd__decap_12
XFILLER_112_1371 VPWR VGND VPWR VGND sky130_ef_sc_hd__decap_12
XFILLER_1_1337 VGND VGND VPWR VPWR sky130_fd_sc_hd__decap_6
XFILLER_99_1491 VGND VGND VPWR VPWR sky130_fd_sc_hd__decap_6
XFILLER_169_1169 VGND VGND VPWR VPWR sky130_fd_sc_hd__decap_6
XFILLER_251_729 VPWR VGND VPWR VGND sky130_ef_sc_hd__decap_12
XFILLER_204_601 VPWR VGND VPWR VGND sky130_ef_sc_hd__decap_12
XFILLER_21_1287 VPWR VGND VPWR VGND sky130_ef_sc_hd__decap_12
XFILLER_244_781 VPWR VGND VPWR VGND sky130_ef_sc_hd__decap_12
XPHY_EDGE_ROW_45_1_Right_701 VGND VGND VPWR VPWR sky130_fd_sc_hd__decap_3
XFILLER_95_1355 VPWR VGND VPWR VGND sky130_ef_sc_hd__decap_12
XFILLER_147_1423 VPWR VGND VPWR VGND sky130_ef_sc_hd__decap_12
XFILLER_186_1483 VGND VGND VPWR VPWR sky130_fd_sc_hd__fill_1
XFILLER_203_111 VGND VGND VPWR VPWR sky130_fd_sc_hd__fill_1
XFILLER_204_645 VPWR VGND VPWR VGND sky130_ef_sc_hd__decap_12
XFILLER_56_1339 VPWR VGND VPWR VGND sky130_ef_sc_hd__decap_12
XFILLER_91_1219 VPWR VGND VPWR VGND sky130_ef_sc_hd__decap_12
XFILLER_108_1407 VGND VGND VPWR VPWR sky130_fd_sc_hd__decap_6
XFILLER_245_1057 VGND VGND VPWR VPWR sky130_fd_sc_hd__decap_6
XFILLER_95_1399 VPWR VGND VPWR VGND sky130_ef_sc_hd__decap_12
XFILLER_147_1467 VPWR VGND VPWR VGND sky130_ef_sc_hd__decap_12
XFILLER_188_357 VGND VGND VPWR VPWR sky130_fd_sc_hd__decap_6
XTAP_TAPCELL_ROW_129_1_1264 VGND VPWR sky130_fd_sc_hd__tapvpwrvgnd_1
XFILLER_231_497 VGND VGND VPWR VPWR sky130_fd_sc_hd__decap_6
XFILLER_180_1093 VPWR VGND VPWR VGND sky130_ef_sc_hd__decap_12
XFILLER_223_1399 VGND VGND VPWR VPWR sky130_fd_sc_hd__fill_1
XFILLER_172_725 VPWR VGND VPWR VGND sky130_ef_sc_hd__decap_12
XFILLER_8_787 VPWR VGND VPWR VGND sky130_ef_sc_hd__decap_12
XFILLER_32_1383 VPWR VGND VPWR VGND sky130_ef_sc_hd__decap_12
XFILLER_176_1129 VPWR VGND VPWR VGND sky130_ef_sc_hd__decap_12
XFILLER_172_769 VPWR VGND VPWR VGND sky130_ef_sc_hd__decap_12
XFILLER_67_1435 VGND VGND VPWR VPWR sky130_fd_sc_hd__decap_6
XFILLER_171_279 VGND VGND VPWR VPWR sky130_fd_sc_hd__fill_1
XFILLER_252_1017 VPWR VGND VPWR VGND sky130_ef_sc_hd__decap_12
XFILLER_67_1479 VPWR VGND VPWR VGND sky130_ef_sc_hd__decap_12
XFILLER_4_993 VPWR VGND VPWR VGND sky130_ef_sc_hd__decap_12
XTAP_TAPCELL_ROW_88_2_4284 VGND VPWR sky130_fd_sc_hd__tapvpwrvgnd_1
XFILLER_154_1427 VPWR VGND VPWR VGND sky130_ef_sc_hd__decap_12
XTAP_TAPCELL_ROW_168_1417 VGND VPWR sky130_fd_sc_hd__tapvpwrvgnd_1
XTAP_TAPCELL_ROW_168_1428 VGND VPWR sky130_fd_sc_hd__tapvpwrvgnd_1
XFILLER_252_27 VGND VGND VPWR VPWR sky130_fd_sc_hd__fill_1
XFILLER_22_3 VPWR VGND VPWR VGND sky130_ef_sc_hd__decap_12
XFILLER_230_1315 VGND VGND VPWR VPWR sky130_fd_sc_hd__fill_1
XFILLER_239_553 VGND VGND VPWR VPWR sky130_fd_sc_hd__decap_6
XFILLER_26_1165 VPWR VGND VPWR VGND sky130_ef_sc_hd__decap_12
XFILLER_254_501 VPWR VGND VPWR VGND sky130_ef_sc_hd__decap_12
XTAP_TAPCELL_ROW_2_908 VGND VPWR sky130_fd_sc_hd__tapvpwrvgnd_1
XTAP_TAPCELL_ROW_68_2_4160 VGND VPWR sky130_fd_sc_hd__tapvpwrvgnd_1
XFILLER_6_1259 VGND VGND VPWR VPWR sky130_fd_sc_hd__fill_1
XTAP_TAPCELL_ROW_2_919 VGND VPWR sky130_fd_sc_hd__tapvpwrvgnd_1
XFILLER_239_597 VPWR VGND VPWR VGND sky130_ef_sc_hd__decap_12
XFILLER_254_545 VPWR VGND VPWR VGND sky130_ef_sc_hd__decap_12
XFILLER_187_1225 VGND VGND VPWR VPWR sky130_fd_sc_hd__decap_6
XTAP_TAPCELL_ROW_81_2_4238 VGND VPWR sky130_fd_sc_hd__tapvpwrvgnd_1
XFILLER_130_1471 VPWR VGND VPWR VGND sky130_ef_sc_hd__decap_12
XFILLER_208_973 VGND VGND VPWR VPWR sky130_fd_sc_hd__decap_6
XFILLER_254_589 VPWR VGND VPWR VGND sky130_ef_sc_hd__decap_12
XFILLER_187_1269 VPWR VGND VPWR VGND sky130_ef_sc_hd__decap_12
XFILLER_241_217 VGND VGND VPWR VPWR sky130_fd_sc_hd__decap_6
XFILLER_207_461 VPWR VGND VPWR VGND sky130_ef_sc_hd__decap_12
XFILLER_223_921 VPWR VGND VPWR VGND sky130_ef_sc_hd__decap_12
XFILLER_74_1439 VPWR VGND VPWR VGND sky130_ef_sc_hd__decap_12
XFILLER_126_1507 VGND VGND VPWR VPWR sky130_fd_sc_hd__decap_8
XFILLER_179_335 VGND VGND VPWR VPWR sky130_fd_sc_hd__fill_1
XFILLER_223_965 VPWR VGND VPWR VGND sky130_ef_sc_hd__decap_12
XTAP_TAPCELL_ROW_252_3702 VGND VPWR sky130_fd_sc_hd__tapvpwrvgnd_1
XPHY_EDGE_ROW_20_2_Left_522 VGND VGND VPWR VPWR sky130_fd_sc_hd__decap_3
XFILLER_14_29 VPWR VGND VPWR VGND sky130_ef_sc_hd__decap_12
XFILLER_222_475 VGND VGND VPWR VPWR sky130_fd_sc_hd__fill_1
XFILLER_195_839 VGND VGND VPWR VPWR sky130_fd_sc_hd__fill_1
XFILLER_210_637 VGND VGND VPWR VPWR sky130_fd_sc_hd__decap_6
XTAP_TAPCELL_ROW_237_3281 VGND VPWR sky130_fd_sc_hd__tapvpwrvgnd_1
XTAP_TAPCELL_ROW_237_3292 VGND VPWR sky130_fd_sc_hd__tapvpwrvgnd_1
XFILLER_241_1455 VGND VGND VPWR VPWR sky130_fd_sc_hd__fill_1
XFILLER_175_541 VPWR VGND VPWR VGND sky130_ef_sc_hd__decap_12
XTAP_TAPCELL_ROW_233_3167 VGND VPWR sky130_fd_sc_hd__tapvpwrvgnd_1
XTAP_TAPCELL_ROW_233_3178 VGND VPWR sky130_fd_sc_hd__tapvpwrvgnd_1
XTAP_TAPCELL_ROW_233_3189 VGND VPWR sky130_fd_sc_hd__tapvpwrvgnd_1
XTAP_TAPCELL_ROW_41_2_4001 VGND VPWR sky130_fd_sc_hd__tapvpwrvgnd_1
XFILLER_175_585 VPWR VGND VPWR VGND sky130_ef_sc_hd__decap_12
XFILLER_198_1365 VGND VGND VPWR VPWR sky130_fd_sc_hd__decap_6
XFILLER_11_1423 VPWR VGND VPWR VGND sky130_ef_sc_hd__decap_12
XFILLER_200_1141 VGND VGND VPWR VPWR sky130_fd_sc_hd__decap_6
XFILLER_50_1483 VPWR VGND VPWR VGND sky130_ef_sc_hd__decap_12
XFILLER_190_533 VPWR VGND VPWR VGND sky130_ef_sc_hd__decap_12
XFILLER_194_1229 VPWR VGND VPWR VGND sky130_ef_sc_hd__decap_12
XFILLER_11_1467 VPWR VGND VPWR VGND sky130_ef_sc_hd__decap_12
XFILLER_200_1185 VPWR VGND VPWR VGND sky130_ef_sc_hd__decap_12
XTAP_TAPCELL_ROW_246_3517 VGND VPWR sky130_fd_sc_hd__tapvpwrvgnd_1
XTAP_TAPCELL_ROW_246_3528 VGND VPWR sky130_fd_sc_hd__tapvpwrvgnd_1
XTAP_TAPCELL_ROW_246_3539 VGND VPWR sky130_fd_sc_hd__tapvpwrvgnd_1
XFILLER_249_317 VPWR VGND VPWR VGND sky130_ef_sc_hd__decap_12
XFILLER_39_15 VPWR VGND VPWR VGND sky130_ef_sc_hd__decap_12
XFILLER_226_83 VGND VGND VPWR VPWR sky130_fd_sc_hd__fill_1
XFILLER_213_1513 VGND VGND VPWR VPWR sky130_fd_sc_hd__fill_2
XFILLER_162_27 VGND VGND VPWR VPWR sky130_fd_sc_hd__fill_1
XFILLER_131_1213 VGND VGND VPWR VPWR sky130_fd_sc_hd__decap_4
XFILLER_170_1273 VPWR VGND VPWR VGND sky130_ef_sc_hd__decap_12
XFILLER_218_737 VPWR VGND VPWR VGND sky130_ef_sc_hd__decap_12
XFILLER_217_225 VPWR VGND VPWR VGND sky130_ef_sc_hd__decap_12
XFILLER_55_47 VGND VGND VPWR VPWR sky130_fd_sc_hd__fill_1
XFILLER_166_1309 VGND VGND VPWR VPWR sky130_fd_sc_hd__decap_6
XFILLER_211_1281 VGND VGND VPWR VPWR sky130_fd_sc_hd__decap_6
XFILLER_233_729 VPWR VGND VPWR VGND sky130_ef_sc_hd__decap_12
XTAP_TAPCELL_ROW_222_2871 VGND VPWR sky130_fd_sc_hd__tapvpwrvgnd_1
XFILLER_226_781 VPWR VGND VPWR VGND sky130_ef_sc_hd__decap_12
XTAP_TAPCELL_ROW_222_2882 VGND VPWR sky130_fd_sc_hd__tapvpwrvgnd_1
XFILLER_201_615 VGND VGND VPWR VPWR sky130_fd_sc_hd__fill_1
XFILLER_16_1301 VGND VGND VPWR VPWR sky130_fd_sc_hd__fill_1
XFILLER_185_305 VPWR VGND VPWR VGND sky130_ef_sc_hd__decap_12
XFILLER_213_497 VGND VGND VPWR VPWR sky130_fd_sc_hd__decap_6
XFILLER_71_57 VPWR VGND VPWR VGND sky130_ef_sc_hd__decap_12
XFILLER_198_699 VGND VGND VPWR VPWR sky130_fd_sc_hd__fill_1
XFILLER_185_349 VPWR VGND VPWR VGND sky130_ef_sc_hd__decap_12
XFILLER_187_57 VPWR VGND VPWR VGND sky130_ef_sc_hd__decap_12
XFILLER_205_1063 VGND VGND VPWR VPWR sky130_fd_sc_hd__fill_1
XFILLER_224_3 VPWR VGND VPWR VGND sky130_ef_sc_hd__decap_12
XFILLER_194_861 VGND VGND VPWR VPWR sky130_fd_sc_hd__decap_6
XTAP_TAPCELL_ROW_106_2_4392 VGND VPWR sky130_fd_sc_hd__tapvpwrvgnd_1
XFILLER_5_724 VGND VGND VPWR VPWR sky130_fd_sc_hd__decap_4
XFILLER_5_735 VGND VGND VPWR VPWR sky130_fd_sc_hd__fill_1
XFILLER_193_393 VPWR VGND VPWR VGND sky130_ef_sc_hd__decap_12
XFILLER_177_1449 VGND VGND VPWR VPWR sky130_fd_sc_hd__decap_6
XPHY_EDGE_ROW_29_1_Left_284 VGND VGND VPWR VPWR sky130_fd_sc_hd__decap_3
XFILLER_49_1165 VPWR VGND VPWR VGND sky130_ef_sc_hd__decap_12
XFILLER_253_1337 VGND VGND VPWR VPWR sky130_fd_sc_hd__decap_6
XFILLER_27_1441 VGND VGND VPWR VPWR sky130_fd_sc_hd__fill_1
XFILLER_7_1513 VGND VGND VPWR VPWR sky130_fd_sc_hd__fill_2
XFILLER_96_65 VGND VGND VPWR VPWR sky130_fd_sc_hd__decap_6
XFILLER_255_309 VPWR VGND VPWR VGND sky130_ef_sc_hd__decap_12
XFILLER_236_501 VPWR VGND VPWR VGND sky130_ef_sc_hd__decap_12
XFILLER_249_895 VGND VGND VPWR VPWR sky130_fd_sc_hd__fill_1
XFILLER_236_545 VPWR VGND VPWR VGND sky130_ef_sc_hd__decap_12
XFILLER_1_1101 VPWR VGND VPWR VGND sky130_ef_sc_hd__decap_12
XFILLER_5_1281 VGND VGND VPWR VPWR sky130_fd_sc_hd__decap_6
XFILLER_247_1119 VGND VGND VPWR VPWR sky130_fd_sc_hd__fill_1
XFILLER_184_1409 VPWR VGND VPWR VGND sky130_ef_sc_hd__decap_12
XFILLER_236_589 VPWR VGND VPWR VGND sky130_ef_sc_hd__decap_12
XFILLER_1_1145 VPWR VGND VPWR VGND sky130_ef_sc_hd__decap_12
XFILLER_205_921 VPWR VGND VPWR VGND sky130_ef_sc_hd__decap_12
XFILLER_223_217 VGND VGND VPWR VPWR sky130_fd_sc_hd__decap_6
XFILLER_251_559 VGND VGND VPWR VPWR sky130_fd_sc_hd__fill_1
XFILLER_147_1231 VPWR VGND VPWR VGND sky130_ef_sc_hd__decap_12
XPHY_EDGE_ROW_46_1_Right_702 VGND VGND VPWR VPWR sky130_fd_sc_hd__decap_3
XFILLER_1_1189 VPWR VGND VPWR VGND sky130_ef_sc_hd__decap_12
XFILLER_205_965 VPWR VGND VPWR VGND sky130_ef_sc_hd__decap_12
XFILLER_188_121 VPWR VGND VPWR VGND sky130_ef_sc_hd__decap_12
X_598_ clknet_3_2__leaf_clk _080_ _006_ VGND VGND VPWR VPWR rd_addr\[6\] sky130_fd_sc_hd__dfrtp_1
XFILLER_108_1215 VPWR VGND VPWR VGND sky130_ef_sc_hd__decap_12
XFILLER_147_1275 VPWR VGND VPWR VGND sky130_ef_sc_hd__decap_12
XFILLER_204_475 VGND VGND VPWR VPWR sky130_fd_sc_hd__fill_1
XFILLER_231_261 VPWR VGND VPWR VGND sky130_ef_sc_hd__decap_12
XFILLER_188_165 VPWR VGND VPWR VGND sky130_ef_sc_hd__decap_12
XFILLER_177_839 VGND VGND VPWR VPWR sky130_fd_sc_hd__fill_1
XFILLER_108_1259 VPWR VGND VPWR VGND sky130_ef_sc_hd__decap_12
XFILLER_220_979 VGND VGND VPWR VPWR sky130_fd_sc_hd__fill_1
XFILLER_247_27 VPWR VGND VPWR VGND sky130_ef_sc_hd__decap_12
XFILLER_200_681 VPWR VGND VPWR VGND sky130_ef_sc_hd__decap_12
XFILLER_195_1505 VGND VGND VPWR VPWR sky130_fd_sc_hd__decap_6
XPHY_EDGE_ROW_162_1_Left_417 VGND VGND VPWR VPWR sky130_fd_sc_hd__decap_3
XFILLER_172_533 VPWR VGND VPWR VGND sky130_ef_sc_hd__decap_12
XANTENNA_1 dout0\[1\] VGND VGND VPWR VPWR sky130_fd_sc_hd__diode_2
XFILLER_6_41 VPWR VGND VPWR VGND sky130_ef_sc_hd__decap_12
XFILLER_32_1191 VPWR VGND VPWR VGND sky130_ef_sc_hd__decap_12
XFILLER_6_85 VPWR VGND VPWR VGND sky130_ef_sc_hd__decap_12
XFILLER_67_1243 VPWR VGND VPWR VGND sky130_ef_sc_hd__decap_12
XFILLER_119_1311 VPWR VGND VPWR VGND sky130_ef_sc_hd__decap_12
XFILLER_158_1371 VPWR VGND VPWR VGND sky130_ef_sc_hd__decap_12
XFILLER_28_1227 VPWR VGND VPWR VGND sky130_ef_sc_hd__decap_12
XFILLER_67_1287 VPWR VGND VPWR VGND sky130_ef_sc_hd__decap_12
XFILLER_119_1355 VPWR VGND VPWR VGND sky130_ef_sc_hd__decap_12
XFILLER_115_1219 VPWR VGND VPWR VGND sky130_ef_sc_hd__decap_12
XTAP_TAPCELL_ROW_163_2_4735 VGND VPWR sky130_fd_sc_hd__tapvpwrvgnd_1
XFILLER_119_1399 VPWR VGND VPWR VGND sky130_ef_sc_hd__decap_12
XFILLER_246_309 VPWR VGND VPWR VGND sky130_ef_sc_hd__decap_12
XTAP_TAPCELL_ROW_241_3403 VGND VPWR sky130_fd_sc_hd__tapvpwrvgnd_1
XFILLER_239_361 VPWR VGND VPWR VGND sky130_ef_sc_hd__decap_12
XTAP_TAPCELL_ROW_7_1040 VGND VPWR sky130_fd_sc_hd__tapvpwrvgnd_1
XTAP_TAPCELL_ROW_7_1051 VGND VPWR sky130_fd_sc_hd__tapvpwrvgnd_1
XFILLER_255_865 VGND VGND VPWR VPWR sky130_fd_sc_hd__decap_3
XTAP_TAPCELL_ROW_7_1062 VGND VPWR sky130_fd_sc_hd__tapvpwrvgnd_1
XTAP_TAPCELL_ROW_143_2_4611 VGND VPWR sky130_fd_sc_hd__tapvpwrvgnd_1
XFILLER_187_1033 VPWR VGND VPWR VGND sky130_ef_sc_hd__decap_12
XFILLER_212_41 VPWR VGND VPWR VGND sky130_ef_sc_hd__decap_12
XFILLER_215_729 VPWR VGND VPWR VGND sky130_ef_sc_hd__decap_12
XFILLER_187_1077 VPWR VGND VPWR VGND sky130_ef_sc_hd__decap_12
XFILLER_208_781 VPWR VGND VPWR VGND sky130_ef_sc_hd__decap_12
XTAP_TAPCELL_ROW_239_3332 VGND VPWR sky130_fd_sc_hd__tapvpwrvgnd_1
XFILLER_39_1323 VGND VGND VPWR VPWR sky130_fd_sc_hd__decap_6
XFILLER_74_1203 VPWR VGND VPWR VGND sky130_ef_sc_hd__decap_12
XFILLER_212_85 VPWR VGND VPWR VGND sky130_ef_sc_hd__decap_12
XTAP_TAPCELL_ROW_239_3343 VGND VPWR sky130_fd_sc_hd__tapvpwrvgnd_1
XFILLER_78_1383 VPWR VGND VPWR VGND sky130_ef_sc_hd__decap_12
XFILLER_74_1247 VPWR VGND VPWR VGND sky130_ef_sc_hd__decap_12
XFILLER_39_1367 VPWR VGND VPWR VGND sky130_ef_sc_hd__decap_12
XFILLER_126_1315 VPWR VGND VPWR VGND sky130_ef_sc_hd__decap_12
XTAP_TAPCELL_ROW_235_3218 VGND VPWR sky130_fd_sc_hd__tapvpwrvgnd_1
XFILLER_210_401 VPWR VGND VPWR VGND sky130_ef_sc_hd__decap_12
XFILLER_228_1085 VGND VGND VPWR VPWR sky130_fd_sc_hd__decap_6
XFILLER_250_581 VGND VGND VPWR VPWR sky130_fd_sc_hd__decap_6
XTAP_TAPCELL_ROW_235_3229 VGND VPWR sky130_fd_sc_hd__tapvpwrvgnd_1
XFILLER_161_1217 VGND VGND VPWR VPWR sky130_fd_sc_hd__fill_1
XFILLER_167_305 VPWR VGND VPWR VGND sky130_ef_sc_hd__decap_12
XFILLER_165_1397 VGND VGND VPWR VPWR sky130_fd_sc_hd__decap_3
XFILLER_126_1359 VPWR VGND VPWR VGND sky130_ef_sc_hd__decap_12
XFILLER_210_445 VPWR VGND VPWR VGND sky130_ef_sc_hd__decap_12
XFILLER_167_349 VPWR VGND VPWR VGND sky130_ef_sc_hd__decap_12
XFILLER_202_1203 VGND VGND VPWR VPWR sky130_fd_sc_hd__fill_1
XFILLER_41_27 VPWR VGND VPWR VGND sky130_ef_sc_hd__decap_12
XFILLER_183_809 VPWR VGND VPWR VGND sky130_ef_sc_hd__decap_12
XFILLER_176_861 VGND VGND VPWR VPWR sky130_fd_sc_hd__decap_6
XFILLER_210_489 VPWR VGND VPWR VGND sky130_ef_sc_hd__decap_12
XPHY_EDGE_ROW_94_1_Left_349 VGND VGND VPWR VPWR sky130_fd_sc_hd__decap_3
XFILLER_157_27 VPWR VGND VPWR VGND sky130_ef_sc_hd__decap_12
XFILLER_11_1231 VPWR VGND VPWR VGND sky130_ef_sc_hd__decap_12
XFILLER_175_393 VPWR VGND VPWR VGND sky130_ef_sc_hd__decap_12
XFILLER_198_1173 VPWR VGND VPWR VGND sky130_ef_sc_hd__decap_12
XFILLER_191_853 VPWR VGND VPWR VGND sky130_ef_sc_hd__decap_12
XFILLER_194_1037 VPWR VGND VPWR VGND sky130_ef_sc_hd__decap_12
XFILLER_11_1275 VPWR VGND VPWR VGND sky130_ef_sc_hd__decap_12
XFILLER_190_363 VGND VGND VPWR VPWR sky130_fd_sc_hd__fill_1
XFILLER_191_897 VPWR VGND VPWR VGND sky130_ef_sc_hd__decap_12
XFILLER_235_1001 VGND VGND VPWR VPWR sky130_fd_sc_hd__decap_6
XFILLER_237_93 VPWR VGND VPWR VGND sky130_ef_sc_hd__decap_12
XFILLER_85_1343 VPWR VGND VPWR VGND sky130_ef_sc_hd__decap_12
XFILLER_137_1411 VPWR VGND VPWR VGND sky130_ef_sc_hd__decap_12
XFILLER_173_15 VPWR VGND VPWR VGND sky130_ef_sc_hd__decap_12
XTAP_TAPCELL_ROW_91_1_1226 VGND VPWR sky130_fd_sc_hd__tapvpwrvgnd_1
XTAP_TAPCELL_ROW_211_2572 VGND VPWR sky130_fd_sc_hd__tapvpwrvgnd_1
XFILLER_46_1327 VPWR VGND VPWR VGND sky130_ef_sc_hd__decap_12
XTAP_TAPCELL_ROW_211_2583 VGND VPWR sky130_fd_sc_hd__tapvpwrvgnd_1
XFILLER_235_1045 VPWR VGND VPWR VGND sky130_ef_sc_hd__decap_12
XTAP_TAPCELL_ROW_211_2594 VGND VPWR sky130_fd_sc_hd__tapvpwrvgnd_1
XFILLER_85_1387 VPWR VGND VPWR VGND sky130_ef_sc_hd__decap_12
XFILLER_137_1455 VPWR VGND VPWR VGND sky130_ef_sc_hd__decap_12
XFILLER_249_125 VPWR VGND VPWR VGND sky130_ef_sc_hd__decap_12
XFILLER_235_1089 VPWR VGND VPWR VGND sky130_ef_sc_hd__decap_12
XFILLER_106_53 VPWR VGND VPWR VGND sky130_ef_sc_hd__decap_12
XFILLER_137_1499 VPWR VGND VPWR VGND sky130_ef_sc_hd__decap_12
XFILLER_249_169 VPWR VGND VPWR VGND sky130_ef_sc_hd__decap_12
XFILLER_253_81 VPWR VGND VPWR VGND sky130_ef_sc_hd__decap_12
XFILLER_213_1343 VGND VGND VPWR VPWR sky130_fd_sc_hd__fill_1
XFILLER_218_501 VPWR VGND VPWR VGND sky130_ef_sc_hd__decap_12
XTAP_TAPCELL_ROW_224_2922 VGND VPWR sky130_fd_sc_hd__tapvpwrvgnd_1
XTAP_TAPCELL_ROW_224_2933 VGND VPWR sky130_fd_sc_hd__tapvpwrvgnd_1
XTAP_TAPCELL_ROW_37_2_3975 VGND VPWR sky130_fd_sc_hd__tapvpwrvgnd_1
XFILLER_218_545 VPWR VGND VPWR VGND sky130_ef_sc_hd__decap_12
XTAP_TAPCELL_ROW_224_2944 VGND VPWR sky130_fd_sc_hd__tapvpwrvgnd_1
XFILLER_2_1421 VGND VGND VPWR VPWR sky130_fd_sc_hd__decap_6
XFILLER_174_3 VPWR VGND VPWR VGND sky130_ef_sc_hd__decap_12
XFILLER_22_1371 VPWR VGND VPWR VGND sky130_ef_sc_hd__decap_12
XFILLER_122_41 VPWR VGND VPWR VGND sky130_ef_sc_hd__decap_12
XFILLER_218_589 VPWR VGND VPWR VGND sky130_ef_sc_hd__decap_12
XTAP_TAPCELL_ROW_220_2819 VGND VPWR sky130_fd_sc_hd__tapvpwrvgnd_1
X_521_ net664 VGND VGND VPWR VPWR _003_ sky130_fd_sc_hd__inv_2
XFILLER_166_1117 VPWR VGND VPWR VGND sky130_ef_sc_hd__decap_12
XFILLER_205_217 VGND VGND VPWR VPWR sky130_fd_sc_hd__decap_6
XFILLER_2_1465 VPWR VGND VPWR VGND sky130_ef_sc_hd__decap_12
XFILLER_233_559 VGND VGND VPWR VPWR sky130_fd_sc_hd__fill_1
XFILLER_92_1303 VPWR VGND VPWR VGND sky130_ef_sc_hd__decap_12
XFILLER_246_1141 VGND VGND VPWR VPWR sky130_fd_sc_hd__decap_6
XFILLER_57_1423 VPWR VGND VPWR VGND sky130_ef_sc_hd__decap_12
X_452_ net590 net589 net569 VGND VGND VPWR VPWR _239_ sky130_fd_sc_hd__a21oi_1
XFILLER_96_1483 VPWR VGND VPWR VGND sky130_ef_sc_hd__decap_12
XFILLER_199_953 VPWR VGND VPWR VGND sky130_ef_sc_hd__decap_12
XFILLER_18_1407 VGND VGND VPWR VPWR sky130_fd_sc_hd__decap_6
XFILLER_220_209 VPWR VGND VPWR VGND sky130_ef_sc_hd__decap_12
XFILLER_242_1005 VPWR VGND VPWR VGND sky130_ef_sc_hd__decap_12
XFILLER_57_1467 VPWR VGND VPWR VGND sky130_ef_sc_hd__decap_12
XFILLER_144_1415 VPWR VGND VPWR VGND sky130_ef_sc_hd__decap_12
XFILLER_246_1185 VPWR VGND VPWR VGND sky130_ef_sc_hd__decap_12
XFILLER_213_261 VPWR VGND VPWR VGND sky130_ef_sc_hd__decap_12
X_383_ net590 net581 net554 VGND VGND VPWR VPWR _172_ sky130_fd_sc_hd__a21oi_1
XTAP_TAPCELL_ROW_197_2199 VGND VPWR sky130_fd_sc_hd__tapvpwrvgnd_1
XFILLER_186_625 VPWR VGND VPWR VGND sky130_ef_sc_hd__decap_12
XFILLER_242_1049 VPWR VGND VPWR VGND sky130_ef_sc_hd__decap_12
XFILLER_185_113 VPWR VGND VPWR VGND sky130_ef_sc_hd__decap_12
XFILLER_207_1169 VGND VGND VPWR VPWR sky130_fd_sc_hd__decap_6
XFILLER_202_979 VGND VGND VPWR VPWR sky130_fd_sc_hd__fill_1
XFILLER_9_337 VPWR VGND VPWR VGND sky130_ef_sc_hd__decap_12
XFILLER_186_669 VPWR VGND VPWR VGND sky130_ef_sc_hd__decap_12
XTAP_TAPCELL_ROW_218_2759 VGND VPWR sky130_fd_sc_hd__tapvpwrvgnd_1
XFILLER_224_1483 VGND VGND VPWR VPWR sky130_fd_sc_hd__fill_1
XFILLER_177_1213 VPWR VGND VPWR VGND sky130_ef_sc_hd__decap_12
XTAP_TAPCELL_ROW_10_2_3816 VGND VPWR sky130_fd_sc_hd__tapvpwrvgnd_1
XFILLER_103_1189 VPWR VGND VPWR VGND sky130_ef_sc_hd__decap_12
XFILLER_177_1257 VPWR VGND VPWR VGND sky130_ef_sc_hd__decap_12
XFILLER_253_1101 VPWR VGND VPWR VGND sky130_ef_sc_hd__decap_12
XFILLER_5_587 VGND VGND VPWR VPWR sky130_fd_sc_hd__fill_1
XFILLER_181_385 VGND VGND VPWR VPWR sky130_fd_sc_hd__decap_6
XFILLER_155_1511 VGND VGND VPWR VPWR sky130_fd_sc_hd__decap_4
XFILLER_64_1427 VPWR VGND VPWR VGND sky130_ef_sc_hd__decap_12
XFILLER_253_1145 VPWR VGND VPWR VGND sky130_ef_sc_hd__decap_12
Xoutput60 net60 VGND VGND VPWR VPWR acc_out[25] sky130_fd_sc_hd__buf_2
Xoutput71 net553 VGND VGND VPWR VPWR acc_out[6] sky130_fd_sc_hd__buf_2
XFILLER_214_1129 VPWR VGND VPWR VGND sky130_ef_sc_hd__decap_12
XFILLER_253_1189 VPWR VGND VPWR VGND sky130_ef_sc_hd__decap_12
XFILLER_1_782 VGND VGND VPWR VPWR sky130_fd_sc_hd__fill_2
XFILLER_228_309 VPWR VGND VPWR VGND sky130_ef_sc_hd__decap_12
XFILLER_7_1343 VGND VGND VPWR VPWR sky130_fd_sc_hd__fill_1
XFILLER_237_821 VPWR VGND VPWR VGND sky130_ef_sc_hd__decap_12
XFILLER_0_281 VPWR VGND VPWR VGND sky130_ef_sc_hd__decap_12
XTAP_TAPCELL_ROW_128_2_4524 VGND VPWR sky130_fd_sc_hd__tapvpwrvgnd_1
XFILLER_237_865 VPWR VGND VPWR VGND sky130_ef_sc_hd__decap_12
XFILLER_188_1353 VPWR VGND VPWR VGND sky130_ef_sc_hd__decap_12
XFILLER_252_813 VPWR VGND VPWR VGND sky130_ef_sc_hd__decap_12
XFILLER_40_1471 VPWR VGND VPWR VGND sky130_ef_sc_hd__decap_12
XTAP_TAPCELL_ROW_182_1789 VGND VPWR sky130_fd_sc_hd__tapvpwrvgnd_1
XFILLER_184_1217 VPWR VGND VPWR VGND sky130_ef_sc_hd__decap_12
XFILLER_188_1397 VPWR VGND VPWR VGND sky130_ef_sc_hd__decap_12
XTAP_TAPCELL_ROW_108_2_4400 VGND VPWR sky130_fd_sc_hd__tapvpwrvgnd_1
XPHY_EDGE_ROW_169_Right_14 VGND VGND VPWR VPWR sky130_fd_sc_hd__decap_3
XFILLER_189_441 VGND VGND VPWR VPWR sky130_fd_sc_hd__decap_6
XFILLER_36_1507 VGND VGND VPWR VPWR sky130_fd_sc_hd__decap_8
XFILLER_225_1225 VGND VGND VPWR VPWR sky130_fd_sc_hd__decap_6
XPHY_EDGE_ROW_47_1_Right_703 VGND VGND VPWR VPWR sky130_fd_sc_hd__decap_3
XFILLER_232_581 VGND VGND VPWR VPWR sky130_fd_sc_hd__decap_6
XFILLER_189_485 VPWR VGND VPWR VGND sky130_ef_sc_hd__decap_12
XTAP_TAPCELL_ROW_76_2_4211 VGND VPWR sky130_fd_sc_hd__tapvpwrvgnd_1
XFILLER_225_1269 VPWR VGND VPWR VGND sky130_ef_sc_hd__decap_12
XFILLER_165_809 VGND VGND VPWR VPWR sky130_fd_sc_hd__decap_3
XFILLER_121_1201 VPWR VGND VPWR VGND sky130_ef_sc_hd__decap_12
XTAP_TAPCELL_ROW_230_3104 VGND VPWR sky130_fd_sc_hd__tapvpwrvgnd_1
XFILLER_191_105 VGND VGND VPWR VPWR sky130_fd_sc_hd__decap_6
XFILLER_160_1283 VPWR VGND VPWR VGND sky130_ef_sc_hd__decap_12
XFILLER_9_893 VGND VGND VPWR VPWR sky130_fd_sc_hd__decap_3
XFILLER_195_1313 VPWR VGND VPWR VGND sky130_ef_sc_hd__decap_12
XFILLER_121_1267 VGND VGND VPWR VPWR sky130_fd_sc_hd__decap_6
XFILLER_173_853 VPWR VGND VPWR VGND sky130_ef_sc_hd__decap_12
XFILLER_191_149 VPWR VGND VPWR VGND sky130_ef_sc_hd__decap_12
XFILLER_199_1493 VPWR VGND VPWR VGND sky130_ef_sc_hd__decap_12
XFILLER_219_1007 VGND VGND VPWR VPWR sky130_fd_sc_hd__fill_1
XFILLER_172_363 VGND VGND VPWR VPWR sky130_fd_sc_hd__fill_1
XFILLER_195_1357 VPWR VGND VPWR VGND sky130_ef_sc_hd__decap_12
XFILLER_173_897 VPWR VGND VPWR VGND sky130_ef_sc_hd__decap_12
XPHY_EDGE_ROW_178_Right_23 VGND VGND VPWR VPWR sky130_fd_sc_hd__decap_3
XTAP_TAPCELL_ROW_228_3033 VGND VPWR sky130_fd_sc_hd__tapvpwrvgnd_1
XFILLER_236_1365 VGND VGND VPWR VPWR sky130_fd_sc_hd__decap_6
XTAP_TAPCELL_ROW_228_3044 VGND VPWR sky130_fd_sc_hd__tapvpwrvgnd_1
XTAP_TAPCELL_ROW_9_1102 VGND VPWR sky130_fd_sc_hd__tapvpwrvgnd_1
XFILLER_8_1129 VPWR VGND VPWR VGND sky130_ef_sc_hd__decap_12
XFILLER_232_1229 VPWR VGND VPWR VGND sky130_ef_sc_hd__decap_12
XTAP_TAPCELL_ROW_9_1113 VGND VPWR sky130_fd_sc_hd__tapvpwrvgnd_1
XTAP_TAPCELL_ROW_9_1124 VGND VPWR sky130_fd_sc_hd__tapvpwrvgnd_1
XFILLER_247_629 VPWR VGND VPWR VGND sky130_ef_sc_hd__decap_12
XTAP_TAPCELL_ROW_9_1135 VGND VPWR sky130_fd_sc_hd__tapvpwrvgnd_1
XFILLER_41_1213 VGND VGND VPWR VPWR sky130_fd_sc_hd__decap_4
XTAP_TAPCELL_ROW_23_2_3894 VGND VPWR sky130_fd_sc_hd__tapvpwrvgnd_1
XTAP_TAPCELL_ROW_152_1_1287 VGND VPWR sky130_fd_sc_hd__tapvpwrvgnd_1
XFILLER_246_139 VGND VGND VPWR VPWR sky130_fd_sc_hd__fill_1
XFILLER_80_1295 VGND VGND VPWR VPWR sky130_fd_sc_hd__decap_6
XFILLER_223_51 VGND VGND VPWR VPWR sky130_fd_sc_hd__decap_4
XFILLER_255_673 VPWR VGND VPWR VGND sky130_ef_sc_hd__decap_12
XFILLER_36_27 VGND VGND VPWR VPWR sky130_fd_sc_hd__fill_1
XFILLER_242_301 VGND VGND VPWR VPWR sky130_fd_sc_hd__decap_6
XFILLER_199_205 VPWR VGND VPWR VGND sky130_ef_sc_hd__decap_12
XFILLER_167_1437 VPWR VGND VPWR VGND sky130_ef_sc_hd__decap_12
XPHY_EDGE_ROW_187_Right_32 VGND VGND VPWR VPWR sky130_fd_sc_hd__decap_3
XFILLER_242_345 VPWR VGND VPWR VGND sky130_ef_sc_hd__decap_12
XFILLER_215_559 VGND VGND VPWR VPWR sky130_fd_sc_hd__fill_1
XFILLER_199_249 VPWR VGND VPWR VGND sky130_ef_sc_hd__decap_12
XFILLER_78_1191 VPWR VGND VPWR VGND sky130_ef_sc_hd__decap_12
XFILLER_202_209 VPWR VGND VPWR VGND sky130_ef_sc_hd__decap_12
XFILLER_242_389 VPWR VGND VPWR VGND sky130_ef_sc_hd__decap_12
XFILLER_243_1325 VPWR VGND VPWR VGND sky130_ef_sc_hd__decap_12
XFILLER_52_15 VPWR VGND VPWR VGND sky130_ef_sc_hd__decap_12
XFILLER_165_1161 VPWR VGND VPWR VGND sky130_ef_sc_hd__decap_12
XFILLER_196_923 VGND VGND VPWR VPWR sky130_fd_sc_hd__fill_1
XFILLER_211_721 VGND VGND VPWR VPWR sky130_fd_sc_hd__decap_6
XFILLER_168_625 VPWR VGND VPWR VGND sky130_ef_sc_hd__decap_12
XTAP_TAPCELL_ROW_200_2273 VGND VPWR sky130_fd_sc_hd__tapvpwrvgnd_1
XTAP_TAPCELL_ROW_200_2284 VGND VPWR sky130_fd_sc_hd__tapvpwrvgnd_1
XFILLER_204_1309 VGND VGND VPWR VPWR sky130_fd_sc_hd__decap_6
XFILLER_168_15 VPWR VGND VPWR VGND sky130_ef_sc_hd__decap_12
XFILLER_167_113 VPWR VGND VPWR VGND sky130_ef_sc_hd__decap_12
XTAP_TAPCELL_ROW_200_2295 VGND VPWR sky130_fd_sc_hd__tapvpwrvgnd_1
XFILLER_243_1369 VPWR VGND VPWR VGND sky130_ef_sc_hd__decap_12
XFILLER_211_765 VPWR VGND VPWR VGND sky130_ef_sc_hd__decap_12
XFILLER_168_669 VPWR VGND VPWR VGND sky130_ef_sc_hd__decap_12
XFILLER_210_253 VPWR VGND VPWR VGND sky130_ef_sc_hd__decap_12
XFILLER_126_1189 VGND VGND VPWR VPWR sky130_fd_sc_hd__fill_1
XFILLER_183_617 VPWR VGND VPWR VGND sky130_ef_sc_hd__decap_12
XTAP_TAPCELL_ROW_192_2063 VGND VPWR sky130_fd_sc_hd__tapvpwrvgnd_1
XTAP_TAPCELL_ROW_192_2074 VGND VPWR sky130_fd_sc_hd__tapvpwrvgnd_1
XFILLER_6_318 VGND VGND VPWR VPWR sky130_fd_sc_hd__decap_8
XTAP_TAPCELL_ROW_213_2623 VGND VPWR sky130_fd_sc_hd__tapvpwrvgnd_1
XTAP_TAPCELL_ROW_213_2634 VGND VPWR sky130_fd_sc_hd__tapvpwrvgnd_1
XTAP_TAPCELL_ROW_213_2645 VGND VPWR sky130_fd_sc_hd__tapvpwrvgnd_1
XPHY_EDGE_ROW_196_Right_41 VGND VGND VPWR VPWR sky130_fd_sc_hd__decap_3
XPHY_EDGE_ROW_108_2_Left_610 VGND VGND VPWR VPWR sky130_fd_sc_hd__decap_3
XFILLER_254_1421 VGND VGND VPWR VPWR sky130_fd_sc_hd__decap_6
XTAP_TAPCELL_ROW_134_2_4556 VGND VPWR sky130_fd_sc_hd__tapvpwrvgnd_1
Xsram0_675 VGND VGND VPWR VPWR sram0_675/HI net675 sky130_fd_sc_hd__conb_1
Xsram0_686 VGND VGND VPWR VPWR net686 sram0_686/LO sky130_fd_sc_hd__conb_1
XFILLER_254_1465 VPWR VGND VPWR VGND sky130_ef_sc_hd__decap_12
XFILLER_250_1329 VPWR VGND VPWR VGND sky130_ef_sc_hd__decap_12
XFILLER_215_1449 VGND VGND VPWR VPWR sky130_fd_sc_hd__decap_6
XFILLER_219_821 VPWR VGND VPWR VGND sky130_ef_sc_hd__decap_12
XFILLER_133_51 VGND VGND VPWR VPWR sky130_fd_sc_hd__decap_4
XFILLER_150_1463 VGND VGND VPWR VPWR sky130_fd_sc_hd__decap_6
XFILLER_219_865 VPWR VGND VPWR VGND sky130_ef_sc_hd__decap_12
XFILLER_252_109 VPWR VGND VPWR VGND sky130_ef_sc_hd__decap_12
XFILLER_248_1203 VGND VGND VPWR VPWR sky130_fd_sc_hd__fill_1
XFILLER_234_813 VPWR VGND VPWR VGND sky130_ef_sc_hd__decap_12
XFILLER_245_161 VGND VGND VPWR VPWR sky130_fd_sc_hd__decap_6
XFILLER_93_55 VGND VGND VPWR VPWR sky130_fd_sc_hd__fill_1
XFILLER_2_1273 VPWR VGND VPWR VGND sky130_ef_sc_hd__decap_12
X_504_ net179 _255_ net175 _097_ VGND VGND VPWR VPWR _258_ sky130_fd_sc_hd__o211a_1
XFILLER_57_1231 VPWR VGND VPWR VGND sky130_ef_sc_hd__decap_12
XFILLER_221_529 VPWR VGND VPWR VGND sky130_ef_sc_hd__decap_12
XFILLER_18_1215 VPWR VGND VPWR VGND sky130_ef_sc_hd__decap_12
X_435_ _219_ _223_ VGND VGND VPWR VPWR _224_ sky130_fd_sc_hd__nor2_1
XFILLER_214_581 VGND VGND VPWR VPWR sky130_fd_sc_hd__decap_6
XFILLER_57_1275 VPWR VGND VPWR VGND sky130_ef_sc_hd__decap_12
XFILLER_109_1343 VPWR VGND VPWR VGND sky130_ef_sc_hd__decap_12
XFILLER_199_783 VGND VGND VPWR VPWR sky130_fd_sc_hd__fill_1
XFILLER_92_1177 VPWR VGND VPWR VGND sky130_ef_sc_hd__decap_12
XFILLER_187_945 VGND VGND VPWR VPWR sky130_fd_sc_hd__decap_6
XFILLER_222_1409 VPWR VGND VPWR VGND sky130_ef_sc_hd__decap_12
XFILLER_144_1245 VGND VGND VPWR VPWR sky130_fd_sc_hd__fill_1
XFILLER_18_1259 VPWR VGND VPWR VGND sky130_ef_sc_hd__decap_12
XFILLER_186_433 VPWR VGND VPWR VGND sky130_ef_sc_hd__decap_12
X_366_ net592 net575 net548 VGND VGND VPWR VPWR _155_ sky130_fd_sc_hd__a21o_1
XFILLER_109_1387 VPWR VGND VPWR VGND sky130_ef_sc_hd__decap_12
XFILLER_187_989 VPWR VGND VPWR VGND sky130_ef_sc_hd__decap_12
XFILLER_186_477 VPWR VGND VPWR VGND sky130_ef_sc_hd__decap_12
X_297_ net522 _088_ VGND VGND VPWR VPWR _076_ sky130_fd_sc_hd__and2b_1
XFILLER_173_105 VGND VGND VPWR VPWR sky130_fd_sc_hd__decap_6
XFILLER_228_29 VPWR VGND VPWR VGND sky130_ef_sc_hd__decap_12
XFILLER_173_149 VPWR VGND VPWR VGND sky130_ef_sc_hd__decap_12
XFILLER_177_1021 VPWR VGND VPWR VGND sky130_ef_sc_hd__decap_12
XFILLER_5_340 VGND VGND VPWR VPWR sky130_fd_sc_hd__fill_1
XFILLER_255_1229 VGND VGND VPWR VPWR sky130_fd_sc_hd__decap_3
XFILLER_6_896 VPWR VGND VPWR VGND sky130_ef_sc_hd__decap_12
XFILLER_177_1065 VPWR VGND VPWR VGND sky130_ef_sc_hd__decap_12
XFILLER_29_1311 VPWR VGND VPWR VGND sky130_ef_sc_hd__decap_12
XFILLER_68_1371 VPWR VGND VPWR VGND sky130_ef_sc_hd__decap_12
XFILLER_181_193 VPWR VGND VPWR VGND sky130_ef_sc_hd__decap_12
XFILLER_170_867 VGND VGND VPWR VPWR sky130_fd_sc_hd__fill_1
XFILLER_233_1505 VGND VGND VPWR VPWR sky130_fd_sc_hd__decap_6
XFILLER_29_1355 VPWR VGND VPWR VGND sky130_ef_sc_hd__decap_12
XFILLER_116_1303 VPWR VGND VPWR VGND sky130_ef_sc_hd__decap_12
XTAP_TAPCELL_ROW_188_1954 VGND VPWR sky130_fd_sc_hd__tapvpwrvgnd_1
XPHY_EDGE_ROW_200_Right_45 VGND VGND VPWR VPWR sky130_fd_sc_hd__decap_3
XFILLER_218_1073 VPWR VGND VPWR VGND sky130_ef_sc_hd__decap_12
XFILLER_25_1219 VPWR VGND VPWR VGND sky130_ef_sc_hd__decap_12
XTAP_TAPCELL_ROW_188_1965 VGND VPWR sky130_fd_sc_hd__tapvpwrvgnd_1
XFILLER_155_1385 VGND VGND VPWR VPWR sky130_fd_sc_hd__fill_1
XFILLER_29_1399 VPWR VGND VPWR VGND sky130_ef_sc_hd__decap_12
XFILLER_229_629 VPWR VGND VPWR VGND sky130_ef_sc_hd__decap_12
XFILLER_228_139 VGND VGND VPWR VPWR sky130_fd_sc_hd__fill_1
XFILLER_237_673 VPWR VGND VPWR VGND sky130_ef_sc_hd__decap_12
XFILLER_224_301 VGND VGND VPWR VPWR sky130_fd_sc_hd__decap_6
XFILLER_188_1161 VPWR VGND VPWR VGND sky130_ef_sc_hd__decap_12
XFILLER_252_643 VGND VGND VPWR VPWR sky130_fd_sc_hd__fill_1
XFILLER_224_345 VPWR VGND VPWR VGND sky130_ef_sc_hd__decap_12
XFILLER_240_805 VGND VGND VPWR VPWR sky130_fd_sc_hd__decap_6
XPHY_EDGE_ROW_110_2_Right_201 VGND VGND VPWR VPWR sky130_fd_sc_hd__decap_3
XFILLER_75_1331 VPWR VGND VPWR VGND sky130_ef_sc_hd__decap_12
XFILLER_197_709 VPWR VGND VPWR VGND sky130_ef_sc_hd__decap_12
XFILLER_149_1189 VPWR VGND VPWR VGND sky130_ef_sc_hd__decap_12
XFILLER_224_389 VPWR VGND VPWR VGND sky130_ef_sc_hd__decap_12
XFILLER_240_849 VPWR VGND VPWR VGND sky130_ef_sc_hd__decap_12
XFILLER_162_1301 VGND VGND VPWR VPWR sky130_fd_sc_hd__fill_1
XFILLER_36_1315 VPWR VGND VPWR VGND sky130_ef_sc_hd__decap_12
XFILLER_178_923 VGND VGND VPWR VPWR sky130_fd_sc_hd__fill_1
XFILLER_127_1443 VPWR VGND VPWR VGND sky130_ef_sc_hd__decap_12
XFILLER_225_1033 VPWR VGND VPWR VGND sky130_ef_sc_hd__decap_12
XFILLER_71_1217 VGND VGND VPWR VPWR sky130_fd_sc_hd__fill_1
XFILLER_240_1509 VGND VGND VPWR VPWR sky130_fd_sc_hd__decap_6
XPHY_EDGE_ROW_48_1_Right_704 VGND VGND VPWR VPWR sky130_fd_sc_hd__decap_3
XFILLER_189_293 VPWR VGND VPWR VGND sky130_ef_sc_hd__decap_12
XFILLER_36_1359 VPWR VGND VPWR VGND sky130_ef_sc_hd__decap_12
XPHY_EDGE_ROW_106_1_Left_361 VGND VGND VPWR VPWR sky130_fd_sc_hd__decap_3
XFILLER_225_1077 VPWR VGND VPWR VGND sky130_ef_sc_hd__decap_12
XFILLER_123_1329 VGND VGND VPWR VPWR sky130_fd_sc_hd__fill_1
XFILLER_165_617 VPWR VGND VPWR VGND sky130_ef_sc_hd__decap_12
XFILLER_22_29 VPWR VGND VPWR VGND sky130_ef_sc_hd__decap_12
XFILLER_138_29 VPWR VGND VPWR VGND sky130_ef_sc_hd__decap_12
XFILLER_192_469 VGND VGND VPWR VPWR sky130_fd_sc_hd__decap_6
XFILLER_195_1121 VPWR VGND VPWR VGND sky130_ef_sc_hd__decap_12
XFILLER_238_1427 VGND VGND VPWR VPWR sky130_fd_sc_hd__fill_1
XTAP_TAPCELL_ROW_120_2_4475 VGND VPWR sky130_fd_sc_hd__tapvpwrvgnd_1
XTAP_TAPCELL_ROW_119_2_4469 VGND VPWR sky130_fd_sc_hd__tapvpwrvgnd_1
XFILLER_191_1007 VGND VGND VPWR VPWR sky130_fd_sc_hd__fill_1
XFILLER_47_1411 VPWR VGND VPWR VGND sky130_ef_sc_hd__decap_12
XFILLER_86_1471 VPWR VGND VPWR VGND sky130_ef_sc_hd__decap_12
XFILLER_47_1455 VPWR VGND VPWR VGND sky130_ef_sc_hd__decap_12
XFILLER_248_905 VPWR VGND VPWR VGND sky130_ef_sc_hd__decap_12
XFILLER_236_1173 VPWR VGND VPWR VGND sky130_ef_sc_hd__decap_12
XFILLER_82_1357 VGND VGND VPWR VPWR sky130_fd_sc_hd__fill_1
XFILLER_232_1037 VPWR VGND VPWR VGND sky130_ef_sc_hd__decap_12
XFILLER_47_1499 VPWR VGND VPWR VGND sky130_ef_sc_hd__decap_12
XFILLER_248_949 VPWR VGND VPWR VGND sky130_ef_sc_hd__decap_12
XFILLER_47_15 VPWR VGND VPWR VGND sky130_ef_sc_hd__decap_12
XFILLER_134_1469 VGND VGND VPWR VPWR sky130_fd_sc_hd__fill_1
XFILLER_234_83 VGND VGND VPWR VPWR sky130_fd_sc_hd__fill_1
XFILLER_170_27 VGND VGND VPWR VPWR sky130_fd_sc_hd__fill_1
XTAP_TAPCELL_ROW_67_2_4156 VGND VPWR sky130_fd_sc_hd__tapvpwrvgnd_1
XTAP_TAPCELL_ROW_86_1_1221 VGND VPWR sky130_fd_sc_hd__tapvpwrvgnd_1
XFILLER_216_813 VPWR VGND VPWR VGND sky130_ef_sc_hd__decap_12
XFILLER_234_109 VPWR VGND VPWR VGND sky130_ef_sc_hd__decap_12
XTAP_TAPCELL_ROW_206_2460 VGND VPWR sky130_fd_sc_hd__tapvpwrvgnd_1
XTAP_TAPCELL_ROW_100_1_1235 VGND VPWR sky130_fd_sc_hd__tapvpwrvgnd_1
XFILLER_167_1201 VPWR VGND VPWR VGND sky130_ef_sc_hd__decap_12
XFILLER_227_161 VGND VGND VPWR VPWR sky130_fd_sc_hd__decap_6
XTAP_TAPCELL_ROW_202_2335 VGND VPWR sky130_fd_sc_hd__tapvpwrvgnd_1
XFILLER_167_1245 VPWR VGND VPWR VGND sky130_ef_sc_hd__decap_12
XTAP_TAPCELL_ROW_202_2346 VGND VPWR sky130_fd_sc_hd__tapvpwrvgnd_1
XFILLER_243_665 VGND VGND VPWR VPWR sky130_fd_sc_hd__decap_6
XFILLER_242_153 VPWR VGND VPWR VGND sky130_ef_sc_hd__decap_12
XFILLER_167_1289 VPWR VGND VPWR VGND sky130_ef_sc_hd__decap_12
XFILLER_203_529 VPWR VGND VPWR VGND sky130_ef_sc_hd__decap_12
XFILLER_63_69 VGND VGND VPWR VPWR sky130_fd_sc_hd__fill_2
XTAP_TAPCELL_ROW_194_2114 VGND VPWR sky130_fd_sc_hd__tapvpwrvgnd_1
XFILLER_243_1133 VPWR VGND VPWR VGND sky130_ef_sc_hd__decap_12
XFILLER_242_197 VPWR VGND VPWR VGND sky130_ef_sc_hd__decap_12
XFILLER_54_1415 VPWR VGND VPWR VGND sky130_ef_sc_hd__decap_12
XPHY_EDGE_ROW_38_1_Left_293 VGND VGND VPWR VPWR sky130_fd_sc_hd__decap_3
XTAP_TAPCELL_ROW_194_2125 VGND VPWR sky130_fd_sc_hd__tapvpwrvgnd_1
XTAP_TAPCELL_ROW_194_2136 VGND VPWR sky130_fd_sc_hd__tapvpwrvgnd_1
XFILLER_208_1253 VGND VGND VPWR VPWR sky130_fd_sc_hd__decap_6
XTAP_TAPCELL_ROW_219_2810 VGND VPWR sky130_fd_sc_hd__tapvpwrvgnd_1
XFILLER_169_945 VGND VGND VPWR VPWR sky130_fd_sc_hd__decap_6
XFILLER_179_69 VPWR VGND VPWR VGND sky130_ef_sc_hd__decap_12
XFILLER_93_1497 VGND VGND VPWR VPWR sky130_fd_sc_hd__fill_1
XFILLER_168_433 VPWR VGND VPWR VGND sky130_ef_sc_hd__decap_12
XFILLER_204_1117 VPWR VGND VPWR VGND sky130_ef_sc_hd__decap_12
XFILLER_243_1177 VPWR VGND VPWR VGND sky130_ef_sc_hd__decap_12
XFILLER_169_989 VPWR VGND VPWR VGND sky130_ef_sc_hd__decap_12
XFILLER_208_1297 VPWR VGND VPWR VGND sky130_ef_sc_hd__decap_12
XFILLER_211_573 VPWR VGND VPWR VGND sky130_ef_sc_hd__decap_12
Xwire503 net504 VGND VGND VPWR VPWR net503 sky130_fd_sc_hd__clkbuf_1
XFILLER_137_3 VPWR VGND VPWR VGND sky130_ef_sc_hd__decap_12
XFILLER_168_477 VPWR VGND VPWR VGND sky130_ef_sc_hd__decap_12
XFILLER_184_937 VPWR VGND VPWR VGND sky130_ef_sc_hd__decap_12
Xwire558 net69 VGND VGND VPWR VPWR net558 sky130_fd_sc_hd__clkbuf_1
XFILLER_183_447 VGND VGND VPWR VPWR sky130_fd_sc_hd__fill_1
XFILLER_87_1213 VGND VGND VPWR VPWR sky130_fd_sc_hd__decap_4
XFILLER_171_609 VGND VGND VPWR VPWR sky130_fd_sc_hd__decap_6
XFILLER_195_57 VPWR VGND VPWR VGND sky130_ef_sc_hd__decap_12
XFILLER_178_1341 VPWR VGND VPWR VGND sky130_ef_sc_hd__decap_12
XTAP_TAPCELL_ROW_25_2_3902 VGND VPWR sky130_fd_sc_hd__tapvpwrvgnd_1
XFILLER_104_1295 VGND VGND VPWR VPWR sky130_fd_sc_hd__decap_6
XFILLER_13_1189 VPWR VGND VPWR VGND sky130_ef_sc_hd__decap_12
XFILLER_192_981 VPWR VGND VPWR VGND sky130_ef_sc_hd__decap_12
XFILLER_174_1205 VPWR VGND VPWR VGND sky130_ef_sc_hd__decap_12
XFILLER_3_833 VGND VGND VPWR VPWR sky130_fd_sc_hd__decap_4
XFILLER_178_1385 VPWR VGND VPWR VGND sky130_ef_sc_hd__decap_12
XFILLER_65_1511 VGND VGND VPWR VPWR sky130_fd_sc_hd__decap_4
XFILLER_2_321 VGND VGND VPWR VPWR sky130_fd_sc_hd__decap_6
XFILLER_215_1213 VPWR VGND VPWR VGND sky130_ef_sc_hd__decap_12
XFILLER_2_365 VGND VGND VPWR VPWR sky130_fd_sc_hd__fill_1
XFILLER_254_1273 VPWR VGND VPWR VGND sky130_ef_sc_hd__decap_12
XTAP_TAPCELL_ROW_164_2_4740 VGND VPWR sky130_fd_sc_hd__tapvpwrvgnd_1
XFILLER_219_1393 VGND VGND VPWR VPWR sky130_fd_sc_hd__decap_6
XFILLER_215_1257 VPWR VGND VPWR VGND sky130_ef_sc_hd__decap_12
XFILLER_150_1271 VPWR VGND VPWR VGND sky130_ef_sc_hd__decap_12
XFILLER_219_673 VPWR VGND VPWR VGND sky130_ef_sc_hd__decap_12
XFILLER_253_429 VPWR VGND VPWR VGND sky130_ef_sc_hd__decap_12
XFILLER_206_301 VGND VGND VPWR VPWR sky130_fd_sc_hd__decap_6
XFILLER_111_1255 VPWR VGND VPWR VGND sky130_ef_sc_hd__decap_12
XFILLER_185_1301 VPWR VGND VPWR VGND sky130_ef_sc_hd__decap_12
XFILLER_189_1481 VPWR VGND VPWR VGND sky130_ef_sc_hd__decap_12
XFILLER_234_643 VGND VGND VPWR VPWR sky130_fd_sc_hd__fill_1
XFILLER_185_1345 VPWR VGND VPWR VGND sky130_ef_sc_hd__decap_12
XFILLER_206_345 VPWR VGND VPWR VGND sky130_ef_sc_hd__decap_12
XFILLER_94_1239 VGND VGND VPWR VPWR sky130_fd_sc_hd__decap_6
XFILLER_111_1299 VPWR VGND VPWR VGND sky130_ef_sc_hd__decap_12
XFILLER_222_805 VGND VGND VPWR VPWR sky130_fd_sc_hd__decap_6
XFILLER_179_709 VPWR VGND VPWR VGND sky130_ef_sc_hd__decap_12
XFILLER_206_389 VPWR VGND VPWR VGND sky130_ef_sc_hd__decap_12
XFILLER_222_849 VPWR VGND VPWR VGND sky130_ef_sc_hd__decap_12
XFILLER_221_337 VPWR VGND VPWR VGND sky130_ef_sc_hd__decap_12
XFILLER_226_1353 VPWR VGND VPWR VGND sky130_ef_sc_hd__decap_12
X_418_ _160_ net121 net113 net163 VGND VGND VPWR VPWR _207_ sky130_fd_sc_hd__a31o_1
XFILLER_187_753 VPWR VGND VPWR VGND sky130_ef_sc_hd__decap_12
XFILLER_222_1217 VPWR VGND VPWR VGND sky130_ef_sc_hd__decap_12
XFILLER_226_1397 VPWR VGND VPWR VGND sky130_ef_sc_hd__decap_12
XFILLER_239_39 VPWR VGND VPWR VGND sky130_ef_sc_hd__decap_12
XTAP_TAPCELL_ROW_177_1655 VGND VPWR sky130_fd_sc_hd__tapvpwrvgnd_1
XTAP_TAPCELL_ROW_177_1666 VGND VPWR sky130_fd_sc_hd__tapvpwrvgnd_1
XFILLER_230_893 VPWR VGND VPWR VGND sky130_ef_sc_hd__decap_12
XTAP_TAPCELL_ROW_177_1677 VGND VPWR sky130_fd_sc_hd__tapvpwrvgnd_1
XFILLER_31_1201 VPWR VGND VPWR VGND sky130_ef_sc_hd__decap_12
X_349_ net332 VGND VGND VPWR VPWR _138_ sky130_fd_sc_hd__inv_2
XFILLER_187_797 VPWR VGND VPWR VGND sky130_ef_sc_hd__decap_12
XFILLER_70_1283 VPWR VGND VPWR VGND sky130_ef_sc_hd__decap_12
XFILLER_122_1351 VGND VGND VPWR VPWR sky130_fd_sc_hd__decap_6
XFILLER_174_469 VGND VGND VPWR VPWR sky130_fd_sc_hd__decap_6
XFILLER_31_1267 VGND VGND VPWR VPWR sky130_fd_sc_hd__decap_6
XFILLER_196_1441 VPWR VGND VPWR VGND sky130_ef_sc_hd__decap_12
XFILLER_6_660 VGND VGND VPWR VPWR sky130_fd_sc_hd__fill_1
XFILLER_122_1395 VPWR VGND VPWR VGND sky130_ef_sc_hd__decap_12
XFILLER_255_27 VGND VGND VPWR VPWR sky130_fd_sc_hd__fill_1
XFILLER_52_3 VPWR VGND VPWR VGND sky130_ef_sc_hd__decap_12
XFILLER_255_1037 VPWR VGND VPWR VGND sky130_ef_sc_hd__decap_12
XFILLER_196_1485 VPWR VGND VPWR VGND sky130_ef_sc_hd__decap_12
XFILLER_233_1313 VPWR VGND VPWR VGND sky130_ef_sc_hd__decap_12
XFILLER_237_1493 VPWR VGND VPWR VGND sky130_ef_sc_hd__decap_12
XFILLER_233_1357 VPWR VGND VPWR VGND sky130_ef_sc_hd__decap_12
XFILLER_9_1257 VGND VGND VPWR VPWR sky130_fd_sc_hd__decap_3
XFILLER_190_1073 VPWR VGND VPWR VGND sky130_ef_sc_hd__decap_12
XTAP_TAPCELL_ROW_53_2_4075 VGND VPWR sky130_fd_sc_hd__tapvpwrvgnd_1
XFILLER_116_1177 VPWR VGND VPWR VGND sky130_ef_sc_hd__decap_12
XTAP_TAPCELL_ROW_38_2_3980 VGND VPWR sky130_fd_sc_hd__tapvpwrvgnd_1
XFILLER_204_53 VPWR VGND VPWR VGND sky130_ef_sc_hd__decap_12
XFILLER_216_109 VPWR VGND VPWR VGND sky130_ef_sc_hd__decap_12
XFILLER_133_1491 VGND VGND VPWR VPWR sky130_fd_sc_hd__decap_6
XFILLER_238_993 VPWR VGND VPWR VGND sky130_ef_sc_hd__decap_12
XFILLER_209_161 VGND VGND VPWR VPWR sky130_fd_sc_hd__decap_6
XTAP_TAPCELL_ROW_0_825 VGND VPWR sky130_fd_sc_hd__tapvpwrvgnd_1
XFILLER_204_97 VPWR VGND VPWR VGND sky130_ef_sc_hd__decap_12
XTAP_TAPCELL_ROW_0_836 VGND VPWR sky130_fd_sc_hd__tapvpwrvgnd_1
XTAP_TAPCELL_ROW_0_847 VGND VPWR sky130_fd_sc_hd__tapvpwrvgnd_1
XTAP_TAPCELL_ROW_0_858 VGND VPWR sky130_fd_sc_hd__tapvpwrvgnd_1
XFILLER_225_665 VGND VGND VPWR VPWR sky130_fd_sc_hd__decap_6
XFILLER_164_1407 VGND VGND VPWR VPWR sky130_fd_sc_hd__decap_6
XTAP_TAPCELL_ROW_0_869 VGND VPWR sky130_fd_sc_hd__tapvpwrvgnd_1
XFILLER_224_153 VPWR VGND VPWR VGND sky130_ef_sc_hd__decap_12
XFILLER_240_613 VPWR VGND VPWR VGND sky130_ef_sc_hd__decap_12
XFILLER_197_517 VPWR VGND VPWR VGND sky130_ef_sc_hd__decap_12
XFILLER_220_41 VPWR VGND VPWR VGND sky130_ef_sc_hd__decap_12
XPHY_EDGE_ROW_111_2_Right_202 VGND VGND VPWR VPWR sky130_fd_sc_hd__decap_3
XTAP_TAPCELL_ROW_147_1_1282 VGND VPWR sky130_fd_sc_hd__tapvpwrvgnd_1
XFILLER_224_197 VPWR VGND VPWR VGND sky130_ef_sc_hd__decap_12
XFILLER_244_1453 VPWR VGND VPWR VGND sky130_ef_sc_hd__decap_12
XFILLER_240_657 VPWR VGND VPWR VGND sky130_ef_sc_hd__decap_12
XFILLER_220_85 VPWR VGND VPWR VGND sky130_ef_sc_hd__decap_12
XTAP_TAPCELL_ROW_255_3766 VGND VPWR sky130_fd_sc_hd__tapvpwrvgnd_1
XFILLER_33_39 VGND VGND VPWR VPWR sky130_fd_sc_hd__decap_4
XTAP_TAPCELL_ROW_255_3777 VGND VPWR sky130_fd_sc_hd__tapvpwrvgnd_1
XTAP_TAPCELL_ROW_255_3788 VGND VPWR sky130_fd_sc_hd__tapvpwrvgnd_1
XFILLER_240_1317 VPWR VGND VPWR VGND sky130_ef_sc_hd__decap_12
XFILLER_127_1273 VGND VGND VPWR VPWR sky130_fd_sc_hd__fill_1
XFILLER_205_1437 VPWR VGND VPWR VGND sky130_ef_sc_hd__decap_12
XFILLER_244_1497 VPWR VGND VPWR VGND sky130_ef_sc_hd__decap_12
XTAP_TAPCELL_ROW_255_3799 VGND VPWR sky130_fd_sc_hd__tapvpwrvgnd_1
XFILLER_149_39 VPWR VGND VPWR VGND sky130_ef_sc_hd__decap_12
XPHY_EDGE_ROW_49_1_Right_705 VGND VGND VPWR VPWR sky130_fd_sc_hd__decap_3
XFILLER_36_1189 VGND VGND VPWR VPWR sky130_fd_sc_hd__fill_1
XFILLER_166_937 VPWR VGND VPWR VGND sky130_ef_sc_hd__decap_12
XFILLER_192_233 VPWR VGND VPWR VGND sky130_ef_sc_hd__decap_12
XTAP_TAPCELL_ROW_11_2_3821 VGND VPWR sky130_fd_sc_hd__tapvpwrvgnd_1
XFILLER_140_1451 VPWR VGND VPWR VGND sky130_ef_sc_hd__decap_12
XFILLER_101_1435 VGND VGND VPWR VPWR sky130_fd_sc_hd__decap_6
XFILLER_4_619 VGND VGND VPWR VPWR sky130_fd_sc_hd__fill_1
XFILLER_140_1495 VPWR VGND VPWR VGND sky130_ef_sc_hd__decap_12
XFILLER_174_981 VPWR VGND VPWR VGND sky130_ef_sc_hd__decap_12
XFILLER_192_277 VPWR VGND VPWR VGND sky130_ef_sc_hd__decap_12
XFILLER_165_27 VGND VGND VPWR VPWR sky130_fd_sc_hd__fill_1
XFILLER_101_1479 VPWR VGND VPWR VGND sky130_ef_sc_hd__decap_12
XFILLER_251_1413 VPWR VGND VPWR VGND sky130_ef_sc_hd__decap_12
XFILLER_245_93 VPWR VGND VPWR VGND sky130_ef_sc_hd__decap_12
XPHY_EDGE_ROW_206_Left_461 VGND VGND VPWR VPWR sky130_fd_sc_hd__decap_3
XFILLER_248_713 VPWR VGND VPWR VGND sky130_ef_sc_hd__decap_12
XFILLER_181_15 VPWR VGND VPWR VGND sky130_ef_sc_hd__decap_12
XFILLER_82_1165 VPWR VGND VPWR VGND sky130_ef_sc_hd__decap_12
XTAP_TAPCELL_ROW_208_2500 VGND VPWR sky130_fd_sc_hd__tapvpwrvgnd_1
XFILLER_251_1457 VPWR VGND VPWR VGND sky130_ef_sc_hd__decap_12
XFILLER_0_869 VGND VGND VPWR VPWR sky130_fd_sc_hd__fill_1
XTAP_TAPCELL_ROW_208_2511 VGND VPWR sky130_fd_sc_hd__tapvpwrvgnd_1
XFILLER_247_223 VGND VGND VPWR VPWR sky130_fd_sc_hd__fill_1
XFILLER_248_757 VPWR VGND VPWR VGND sky130_ef_sc_hd__decap_12
XFILLER_60_1463 VGND VGND VPWR VPWR sky130_fd_sc_hd__decap_6
XFILLER_114_53 VPWR VGND VPWR VGND sky130_ef_sc_hd__decap_12
XFILLER_235_429 VPWR VGND VPWR VGND sky130_ef_sc_hd__decap_12
XTAP_TAPCELL_ROW_142_2_4607 VGND VPWR sky130_fd_sc_hd__tapvpwrvgnd_1
XFILLER_216_643 VGND VGND VPWR VPWR sky130_fd_sc_hd__fill_1
XFILLER_204_805 VGND VGND VPWR VPWR sky130_fd_sc_hd__decap_6
XFILLER_243_473 VPWR VGND VPWR VGND sky130_ef_sc_hd__decap_12
XFILLER_254_3 VPWR VGND VPWR VGND sky130_ef_sc_hd__decap_12
XFILLER_130_41 VPWR VGND VPWR VGND sky130_ef_sc_hd__decap_12
XFILLER_204_849 VPWR VGND VPWR VGND sky130_ef_sc_hd__decap_12
XFILLER_203_337 VPWR VGND VPWR VGND sky130_ef_sc_hd__decap_12
XPHY_EDGE_ROW_215_Left_470 VGND VGND VPWR VPWR sky130_fd_sc_hd__decap_3
XFILLER_19_1343 VPWR VGND VPWR VGND sky130_ef_sc_hd__decap_12
XFILLER_208_1061 VPWR VGND VPWR VGND sky130_ef_sc_hd__decap_12
XFILLER_169_753 VPWR VGND VPWR VGND sky130_ef_sc_hd__decap_12
XFILLER_54_1245 VGND VGND VPWR VPWR sky130_fd_sc_hd__fill_1
XFILLER_180_1253 VGND VGND VPWR VPWR sky130_fd_sc_hd__decap_6
XFILLER_19_1387 VPWR VGND VPWR VGND sky130_ef_sc_hd__decap_12
XFILLER_184_701 VPWR VGND VPWR VGND sky130_ef_sc_hd__decap_12
XFILLER_230_189 VGND VGND VPWR VPWR sky130_fd_sc_hd__decap_6
XFILLER_212_893 VPWR VGND VPWR VGND sky130_ef_sc_hd__decap_12
XFILLER_8_925 VPWR VGND VPWR VGND sky130_ef_sc_hd__decap_12
Xwire300 net301 VGND VGND VPWR VPWR net300 sky130_fd_sc_hd__clkbuf_1
XFILLER_169_797 VPWR VGND VPWR VGND sky130_ef_sc_hd__decap_12
Xwire311 net312 VGND VGND VPWR VPWR net311 sky130_fd_sc_hd__clkbuf_1
XFILLER_106_1357 VGND VGND VPWR VPWR sky130_fd_sc_hd__fill_1
XFILLER_7_413 VGND VGND VPWR VPWR sky130_fd_sc_hd__fill_1
Xwire322 net323 VGND VGND VPWR VPWR net322 sky130_fd_sc_hd__clkbuf_1
XFILLER_180_1297 VPWR VGND VPWR VGND sky130_ef_sc_hd__decap_12
Xwire344 net345 VGND VGND VPWR VPWR net344 sky130_fd_sc_hd__clkbuf_1
Xwire355 net356 VGND VGND VPWR VPWR net355 sky130_fd_sc_hd__clkbuf_1
Xwire366 net367 VGND VGND VPWR VPWR net366 sky130_fd_sc_hd__clkbuf_1
XTAP_TAPCELL_ROW_172_1530 VGND VPWR sky130_fd_sc_hd__tapvpwrvgnd_1
Xwire377 net378 VGND VGND VPWR VPWR net377 sky130_fd_sc_hd__clkbuf_1
XTAP_TAPCELL_ROW_172_1541 VGND VPWR sky130_fd_sc_hd__tapvpwrvgnd_1
Xwire388 net389 VGND VGND VPWR VPWR net388 sky130_fd_sc_hd__clkbuf_1
XFILLER_165_981 VPWR VGND VPWR VGND sky130_ef_sc_hd__decap_12
XFILLER_171_417 VPWR VGND VPWR VGND sky130_ef_sc_hd__decap_12
Xwire399 net400 VGND VGND VPWR VPWR net399 sky130_fd_sc_hd__clkbuf_1
XFILLER_174_1035 VGND VGND VPWR VPWR sky130_fd_sc_hd__fill_1
XFILLER_180_973 VGND VGND VPWR VPWR sky130_fd_sc_hd__decap_6
XFILLER_139_1177 VPWR VGND VPWR VGND sky130_ef_sc_hd__decap_12
XFILLER_26_1303 VPWR VGND VPWR VGND sky130_ef_sc_hd__decap_12
XPHY_EDGE_ROW_11_1_Right_667 VGND VGND VPWR VPWR sky130_fd_sc_hd__decap_3
XFILLER_215_1021 VPWR VGND VPWR VGND sky130_ef_sc_hd__decap_12
XFILLER_65_1385 VGND VGND VPWR VPWR sky130_fd_sc_hd__fill_1
XFILLER_2_195 VGND VGND VPWR VPWR sky130_fd_sc_hd__fill_1
XFILLER_191_1393 VGND VGND VPWR VPWR sky130_fd_sc_hd__decap_6
XFILLER_215_1065 VPWR VGND VPWR VGND sky130_ef_sc_hd__decap_12
XFILLER_238_245 VGND VGND VPWR VPWR sky130_fd_sc_hd__decap_6
XFILLER_117_1497 VGND VGND VPWR VPWR sky130_fd_sc_hd__fill_1
XTAP_TAPCELL_ROW_166_1356 VGND VPWR sky130_fd_sc_hd__tapvpwrvgnd_1
XTAP_TAPCELL_ROW_166_1367 VGND VPWR sky130_fd_sc_hd__tapvpwrvgnd_1
XTAP_TAPCELL_ROW_166_1378 VGND VPWR sky130_fd_sc_hd__tapvpwrvgnd_1
XFILLER_238_289 VPWR VGND VPWR VGND sky130_ef_sc_hd__decap_12
XFILLER_254_749 VGND VGND VPWR VPWR sky130_fd_sc_hd__decap_6
XFILLER_171_81 VPWR VGND VPWR VGND sky130_ef_sc_hd__decap_12
XFILLER_253_237 VPWR VGND VPWR VGND sky130_ef_sc_hd__decap_12
XFILLER_0_65 VGND VGND VPWR VPWR sky130_fd_sc_hd__fill_1
XFILLER_207_665 VGND VGND VPWR VPWR sky130_fd_sc_hd__decap_6
XFILLER_206_153 VPWR VGND VPWR VGND sky130_ef_sc_hd__decap_12
XFILLER_222_613 VPWR VGND VPWR VGND sky130_ef_sc_hd__decap_12
XTAP_TAPCELL_ROW_179_1706 VGND VPWR sky130_fd_sc_hd__tapvpwrvgnd_1
XFILLER_179_517 VPWR VGND VPWR VGND sky130_ef_sc_hd__decap_12
XTAP_TAPCELL_ROW_179_1717 VGND VPWR sky130_fd_sc_hd__tapvpwrvgnd_1
XFILLER_185_1175 VGND VGND VPWR VPWR sky130_fd_sc_hd__fill_1
XFILLER_59_1189 VPWR VGND VPWR VGND sky130_ef_sc_hd__decap_12
XTAP_TAPCELL_ROW_179_1728 VGND VPWR sky130_fd_sc_hd__tapvpwrvgnd_1
XFILLER_206_197 VPWR VGND VPWR VGND sky130_ef_sc_hd__decap_12
XFILLER_72_1301 VGND VGND VPWR VPWR sky130_fd_sc_hd__fill_1
XFILLER_222_657 VPWR VGND VPWR VGND sky130_ef_sc_hd__decap_12
XFILLER_37_1443 VPWR VGND VPWR VGND sky130_ef_sc_hd__decap_12
XFILLER_226_1161 VPWR VGND VPWR VGND sky130_ef_sc_hd__decap_12
XFILLER_221_167 VGND VGND VPWR VPWR sky130_fd_sc_hd__fill_1
XFILLER_9_41 VPWR VGND VPWR VGND sky130_ef_sc_hd__decap_12
XFILLER_124_1413 VGND VGND VPWR VPWR sky130_fd_sc_hd__fill_1
XFILLER_187_561 VPWR VGND VPWR VGND sky130_ef_sc_hd__decap_12
XFILLER_33_1329 VGND VGND VPWR VPWR sky130_fd_sc_hd__fill_1
XFILLER_9_85 VPWR VGND VPWR VGND sky130_ef_sc_hd__decap_12
XTAP_TAPCELL_ROW_250_3630 VGND VPWR sky130_fd_sc_hd__tapvpwrvgnd_1
XTAP_TAPCELL_ROW_155_2_4685 VGND VPWR sky130_fd_sc_hd__tapvpwrvgnd_1
XTAP_TAPCELL_ROW_250_3641 VGND VPWR sky130_fd_sc_hd__tapvpwrvgnd_1
XFILLER_174_233 VPWR VGND VPWR VGND sky130_ef_sc_hd__decap_12
XFILLER_239_1511 VGND VGND VPWR VPWR sky130_fd_sc_hd__fill_1
XFILLER_174_277 VPWR VGND VPWR VGND sky130_ef_sc_hd__decap_12
Xmax_cap611 rd_addr\[3\] VGND VGND VPWR VPWR net611 sky130_fd_sc_hd__clkbuf_1
XFILLER_190_737 VPWR VGND VPWR VGND sky130_ef_sc_hd__decap_12
XFILLER_171_951 VGND VGND VPWR VPWR sky130_fd_sc_hd__fill_1
XFILLER_157_1255 VPWR VGND VPWR VGND sky130_ef_sc_hd__decap_12
XTAP_TAPCELL_ROW_248_3570 VGND VPWR sky130_fd_sc_hd__tapvpwrvgnd_1
XFILLER_83_1441 VGND VGND VPWR VPWR sky130_fd_sc_hd__fill_1
XFILLER_118_1239 VGND VGND VPWR VPWR sky130_fd_sc_hd__decap_6
XTAP_TAPCELL_ROW_248_3581 VGND VPWR sky130_fd_sc_hd__tapvpwrvgnd_1
XFILLER_157_1299 VPWR VGND VPWR VGND sky130_ef_sc_hd__decap_12
XFILLER_233_1121 VPWR VGND VPWR VGND sky130_ef_sc_hd__decap_12
XFILLER_9_1021 VPWR VGND VPWR VGND sky130_ef_sc_hd__decap_12
XTAP_TAPCELL_ROW_248_3592 VGND VPWR sky130_fd_sc_hd__tapvpwrvgnd_1
XFILLER_9_1065 VPWR VGND VPWR VGND sky130_ef_sc_hd__decap_12
XFILLER_229_223 VGND VGND VPWR VPWR sky130_fd_sc_hd__fill_1
XTAP_TAPCELL_ROW_244_3467 VGND VPWR sky130_fd_sc_hd__tapvpwrvgnd_1
XTAP_TAPCELL_ROW_244_3478 VGND VPWR sky130_fd_sc_hd__tapvpwrvgnd_1
XFILLER_44_1469 VGND VGND VPWR VPWR sky130_fd_sc_hd__fill_1
XFILLER_170_1477 VGND VGND VPWR VPWR sky130_fd_sc_hd__decap_6
XFILLER_245_727 VGND VGND VPWR VPWR sky130_fd_sc_hd__fill_1
XFILLER_217_429 VPWR VGND VPWR VGND sky130_ef_sc_hd__decap_12
XFILLER_77_1201 VPWR VGND VPWR VGND sky130_ef_sc_hd__decap_12
XFILLER_231_51 VGND VGND VPWR VPWR sky130_fd_sc_hd__decap_4
XFILLER_44_27 VGND VGND VPWR VPWR sky130_fd_sc_hd__fill_1
XFILLER_168_1373 VPWR VGND VPWR VGND sky130_ef_sc_hd__decap_12
XFILLER_225_473 VPWR VGND VPWR VGND sky130_ef_sc_hd__decap_12
XFILLER_241_933 VPWR VGND VPWR VGND sky130_ef_sc_hd__decap_12
XFILLER_77_1267 VGND VGND VPWR VPWR sky130_fd_sc_hd__decap_6
XFILLER_164_1215 VPWR VGND VPWR VGND sky130_ef_sc_hd__decap_12
XFILLER_44_49 VGND VGND VPWR VPWR sky130_fd_sc_hd__fill_2
XFILLER_198_837 VPWR VGND VPWR VGND sky130_ef_sc_hd__decap_12
XFILLER_240_421 VPWR VGND VPWR VGND sky130_ef_sc_hd__decap_12
XFILLER_241_977 VPWR VGND VPWR VGND sky130_ef_sc_hd__decap_12
XFILLER_129_1379 VGND VGND VPWR VPWR sky130_fd_sc_hd__decap_6
XFILLER_164_1259 VPWR VGND VPWR VGND sky130_ef_sc_hd__decap_12
XPHY_EDGE_ROW_112_2_Right_203 VGND VGND VPWR VPWR sky130_fd_sc_hd__decap_3
XFILLER_205_1201 VPWR VGND VPWR VGND sky130_ef_sc_hd__decap_12
XFILLER_244_1261 VPWR VGND VPWR VGND sky130_ef_sc_hd__decap_12
XFILLER_200_307 VGND VGND VPWR VPWR sky130_fd_sc_hd__fill_1
XFILLER_209_1381 VPWR VGND VPWR VGND sky130_ef_sc_hd__decap_12
XFILLER_166_701 VPWR VGND VPWR VGND sky130_ef_sc_hd__decap_12
XFILLER_212_189 VGND VGND VPWR VPWR sky130_fd_sc_hd__decap_6
XTAP_TAPCELL_ROW_75_2_4207 VGND VPWR sky130_fd_sc_hd__tapvpwrvgnd_1
XFILLER_205_1245 VPWR VGND VPWR VGND sky130_ef_sc_hd__decap_12
XFILLER_240_1147 VGND VGND VPWR VPWR sky130_fd_sc_hd__fill_1
XFILLER_60_26 VGND VGND VPWR VPWR sky130_fd_sc_hd__fill_2
XFILLER_176_15 VPWR VGND VPWR VGND sky130_ef_sc_hd__decap_12
XFILLER_205_1289 VPWR VGND VPWR VGND sky130_ef_sc_hd__decap_12
XFILLER_193_553 VGND VGND VPWR VPWR sky130_fd_sc_hd__decap_6
XFILLER_165_277 VGND VGND VPWR VPWR sky130_fd_sc_hd__decap_3
XFILLER_197_1057 VGND VGND VPWR VPWR sky130_fd_sc_hd__decap_6
XFILLER_193_597 VPWR VGND VPWR VGND sky130_ef_sc_hd__decap_12
XFILLER_14_1295 VGND VGND VPWR VPWR sky130_fd_sc_hd__decap_6
XFILLER_101_1243 VPWR VGND VPWR VGND sky130_ef_sc_hd__decap_12
XFILLER_84_1227 VPWR VGND VPWR VGND sky130_ef_sc_hd__decap_12
XFILLER_101_1287 VPWR VGND VPWR VGND sky130_ef_sc_hd__decap_12
XFILLER_69_57 VPWR VGND VPWR VGND sky130_ef_sc_hd__decap_12
XFILLER_0_600 VGND VGND VPWR VPWR sky130_fd_sc_hd__fill_2
XFILLER_136_1339 VPWR VGND VPWR VGND sky130_ef_sc_hd__decap_12
XFILLER_175_1399 VGND VGND VPWR VPWR sky130_fd_sc_hd__fill_1
XFILLER_216_1341 VPWR VGND VPWR VGND sky130_ef_sc_hd__decap_12
XFILLER_212_1205 VPWR VGND VPWR VGND sky130_ef_sc_hd__decap_12
XFILLER_0_666 VGND VGND VPWR VPWR sky130_fd_sc_hd__fill_2
XFILLER_216_1385 VPWR VGND VPWR VGND sky130_ef_sc_hd__decap_12
XFILLER_251_1287 VGND VGND VPWR VPWR sky130_fd_sc_hd__fill_1
XFILLER_0_699 VGND VGND VPWR VPWR sky130_fd_sc_hd__fill_1
XFILLER_248_587 VGND VGND VPWR VPWR sky130_fd_sc_hd__fill_1
XTAP_TAPCELL_ROW_4_961 VGND VPWR sky130_fd_sc_hd__tapvpwrvgnd_1
XFILLER_236_749 VGND VGND VPWR VPWR sky130_fd_sc_hd__decap_6
XFILLER_60_1271 VPWR VGND VPWR VGND sky130_ef_sc_hd__decap_12
XTAP_TAPCELL_ROW_4_972 VGND VPWR sky130_fd_sc_hd__tapvpwrvgnd_1
XTAP_TAPCELL_ROW_4_983 VGND VPWR sky130_fd_sc_hd__tapvpwrvgnd_1
XFILLER_235_237 VPWR VGND VPWR VGND sky130_ef_sc_hd__decap_12
XFILLER_18_61 VGND VGND VPWR VPWR sky130_fd_sc_hd__fill_2
XFILLER_21_1255 VPWR VGND VPWR VGND sky130_ef_sc_hd__decap_12
XFILLER_95_1323 VGND VGND VPWR VPWR sky130_fd_sc_hd__decap_6
XFILLER_112_1383 VPWR VGND VPWR VGND sky130_ef_sc_hd__decap_12
XFILLER_141_51 VGND VGND VPWR VPWR sky130_fd_sc_hd__decap_4
XPHY_EDGE_ROW_49_2_Left_551 VGND VGND VPWR VPWR sky130_fd_sc_hd__decap_3
XTAP_TAPCELL_ROW_54_1_1189 VGND VPWR sky130_fd_sc_hd__tapvpwrvgnd_1
XFILLER_21_1299 VPWR VGND VPWR VGND sky130_ef_sc_hd__decap_12
XFILLER_204_613 VPWR VGND VPWR VGND sky130_ef_sc_hd__decap_12
XFILLER_244_793 VPWR VGND VPWR VGND sky130_ef_sc_hd__decap_12
XFILLER_95_1367 VPWR VGND VPWR VGND sky130_ef_sc_hd__decap_12
XFILLER_147_1435 VGND VGND VPWR VPWR sky130_fd_sc_hd__decap_6
XFILLER_182_1315 VGND VGND VPWR VPWR sky130_fd_sc_hd__fill_1
XFILLER_243_281 VPWR VGND VPWR VGND sky130_ef_sc_hd__decap_12
XFILLER_204_657 VPWR VGND VPWR VGND sky130_ef_sc_hd__decap_12
XFILLER_147_1479 VPWR VGND VPWR VGND sky130_ef_sc_hd__decap_12
XFILLER_223_1301 VPWR VGND VPWR VGND sky130_ef_sc_hd__decap_12
XFILLER_203_167 VGND VGND VPWR VPWR sky130_fd_sc_hd__fill_1
XFILLER_227_1481 VPWR VGND VPWR VGND sky130_ef_sc_hd__decap_12
XFILLER_169_561 VPWR VGND VPWR VGND sky130_ef_sc_hd__decap_12
XFILLER_180_1061 VPWR VGND VPWR VGND sky130_ef_sc_hd__decap_12
XFILLER_223_1345 VPWR VGND VPWR VGND sky130_ef_sc_hd__decap_12
XFILLER_184_531 VGND VGND VPWR VPWR sky130_fd_sc_hd__fill_1
XFILLER_106_1165 VPWR VGND VPWR VGND sky130_ef_sc_hd__decap_12
XFILLER_8_755 VGND VGND VPWR VPWR sky130_fd_sc_hd__fill_1
XFILLER_32_1351 VGND VGND VPWR VPWR sky130_fd_sc_hd__decap_6
Xwire163 _150_ VGND VGND VPWR VPWR net163 sky130_fd_sc_hd__clkbuf_1
XFILLER_8_799 VPWR VGND VPWR VGND sky130_ef_sc_hd__decap_12
XFILLER_172_737 VPWR VGND VPWR VGND sky130_ef_sc_hd__decap_12
Xwire185 _262_ VGND VGND VPWR VPWR net185 sky130_fd_sc_hd__clkbuf_1
XTAP_TAPCELL_ROW_121_2_4480 VGND VPWR sky130_fd_sc_hd__tapvpwrvgnd_1
XFILLER_32_1395 VPWR VGND VPWR VGND sky130_ef_sc_hd__decap_12
XFILLER_7_287 VGND VGND VPWR VPWR sky130_fd_sc_hd__decap_6
XFILLER_171_225 VPWR VGND VPWR VGND sky130_ef_sc_hd__decap_12
XFILLER_236_29 VPWR VGND VPWR VGND sky130_ef_sc_hd__decap_12
XFILLER_4_961 VPWR VGND VPWR VGND sky130_ef_sc_hd__decap_12
XFILLER_193_1455 VGND VGND VPWR VPWR sky130_fd_sc_hd__fill_1
XFILLER_180_781 VPWR VGND VPWR VGND sky130_ef_sc_hd__decap_12
XFILLER_252_1029 VGND VGND VPWR VPWR sky130_fd_sc_hd__decap_6
XTAP_TAPCELL_ROW_88_2_4285 VGND VPWR sky130_fd_sc_hd__tapvpwrvgnd_1
XFILLER_154_1439 VPWR VGND VPWR VGND sky130_ef_sc_hd__decap_12
XTAP_TAPCELL_ROW_168_1418 VGND VPWR sky130_fd_sc_hd__tapvpwrvgnd_1
XFILLER_234_1441 VPWR VGND VPWR VGND sky130_ef_sc_hd__decap_12
XTAP_TAPCELL_ROW_168_1429 VGND VPWR sky130_fd_sc_hd__tapvpwrvgnd_1
XPHY_EDGE_ROW_12_1_Right_668 VGND VGND VPWR VPWR sky130_fd_sc_hd__decap_3
XFILLER_6_1205 VPWR VGND VPWR VGND sky130_ef_sc_hd__decap_12
XFILLER_234_1485 VPWR VGND VPWR VGND sky130_ef_sc_hd__decap_12
XFILLER_26_1177 VPWR VGND VPWR VGND sky130_ef_sc_hd__decap_12
XPHY_EDGE_ROW_115_1_Left_370 VGND VGND VPWR VPWR sky130_fd_sc_hd__decap_3
XTAP_TAPCELL_ROW_68_2_4161 VGND VPWR sky130_fd_sc_hd__tapvpwrvgnd_1
XTAP_TAPCELL_ROW_2_909 VGND VPWR sky130_fd_sc_hd__tapvpwrvgnd_1
XFILLER_254_513 VPWR VGND VPWR VGND sky130_ef_sc_hd__decap_12
XFILLER_15_3 VPWR VGND VPWR VGND sky130_ef_sc_hd__decap_12
XFILLER_227_727 VGND VGND VPWR VPWR sky130_fd_sc_hd__fill_1
XFILLER_43_1491 VGND VGND VPWR VPWR sky130_fd_sc_hd__decap_6
XFILLER_254_557 VPWR VGND VPWR VGND sky130_ef_sc_hd__decap_12
XTAP_TAPCELL_ROW_81_2_4239 VGND VPWR sky130_fd_sc_hd__tapvpwrvgnd_1
XFILLER_130_1483 VPWR VGND VPWR VGND sky130_ef_sc_hd__decap_12
XFILLER_165_1513 VGND VGND VPWR VPWR sky130_fd_sc_hd__fill_2
XFILLER_207_473 VPWR VGND VPWR VGND sky130_ef_sc_hd__decap_12
XFILLER_74_1407 VGND VGND VPWR VPWR sky130_fd_sc_hd__decap_6
XFILLER_223_933 VPWR VGND VPWR VGND sky130_ef_sc_hd__decap_12
XFILLER_222_421 VPWR VGND VPWR VGND sky130_ef_sc_hd__decap_12
XFILLER_223_977 VPWR VGND VPWR VGND sky130_ef_sc_hd__decap_12
XFILLER_241_1401 VPWR VGND VPWR VGND sky130_ef_sc_hd__decap_12
XTAP_TAPCELL_ROW_237_3271 VGND VPWR sky130_fd_sc_hd__tapvpwrvgnd_1
XTAP_TAPCELL_ROW_237_3282 VGND VPWR sky130_fd_sc_hd__tapvpwrvgnd_1
XFILLER_37_1273 VGND VGND VPWR VPWR sky130_fd_sc_hd__fill_1
XFILLER_188_881 VPWR VGND VPWR VGND sky130_ef_sc_hd__decap_12
XTAP_TAPCELL_ROW_237_3293 VGND VPWR sky130_fd_sc_hd__tapvpwrvgnd_1
XFILLER_187_391 VGND VGND VPWR VPWR sky130_fd_sc_hd__fill_1
XFILLER_202_1429 VPWR VGND VPWR VGND sky130_ef_sc_hd__decap_12
XTAP_TAPCELL_ROW_233_3168 VGND VPWR sky130_fd_sc_hd__tapvpwrvgnd_1
XFILLER_175_553 VGND VGND VPWR VPWR sky130_fd_sc_hd__decap_6
XTAP_TAPCELL_ROW_233_3179 VGND VPWR sky130_fd_sc_hd__tapvpwrvgnd_1
XFILLER_50_1451 VPWR VGND VPWR VGND sky130_ef_sc_hd__decap_12
XTAP_TAPCELL_ROW_41_2_4002 VGND VPWR sky130_fd_sc_hd__tapvpwrvgnd_1
XFILLER_190_501 VPWR VGND VPWR VGND sky130_ef_sc_hd__decap_12
XFILLER_30_29 VPWR VGND VPWR VGND sky130_ef_sc_hd__decap_12
XFILLER_11_1435 VGND VGND VPWR VPWR sky130_fd_sc_hd__decap_6
XFILLER_175_597 VPWR VGND VPWR VGND sky130_ef_sc_hd__decap_12
XFILLER_50_1495 VPWR VGND VPWR VGND sky130_ef_sc_hd__decap_12
XFILLER_190_545 VPWR VGND VPWR VGND sky130_ef_sc_hd__decap_12
XFILLER_146_29 VPWR VGND VPWR VGND sky130_ef_sc_hd__decap_12
XFILLER_11_1479 VPWR VGND VPWR VGND sky130_ef_sc_hd__decap_12
XFILLER_200_1197 VGND VGND VPWR VPWR sky130_fd_sc_hd__decap_6
XFILLER_190_589 VPWR VGND VPWR VGND sky130_ef_sc_hd__decap_12
XTAP_TAPCELL_ROW_246_3518 VGND VPWR sky130_fd_sc_hd__tapvpwrvgnd_1
XTAP_TAPCELL_ROW_246_3529 VGND VPWR sky130_fd_sc_hd__tapvpwrvgnd_1
Xmax_cap496 _121_ VGND VGND VPWR VPWR net496 sky130_fd_sc_hd__clkbuf_1
XFILLER_249_329 VGND VGND VPWR VPWR sky130_fd_sc_hd__decap_6
XFILLER_39_27 VPWR VGND VPWR VGND sky130_ef_sc_hd__decap_12
XFILLER_170_1241 VPWR VGND VPWR VGND sky130_ef_sc_hd__decap_12
XFILLER_170_1285 VPWR VGND VPWR VGND sky130_ef_sc_hd__decap_12
XFILLER_218_749 VGND VGND VPWR VPWR sky130_fd_sc_hd__decap_6
XFILLER_55_15 VPWR VGND VPWR VGND sky130_ef_sc_hd__decap_12
XFILLER_79_1329 VGND VGND VPWR VPWR sky130_fd_sc_hd__fill_1
XFILLER_217_237 VPWR VGND VPWR VGND sky130_ef_sc_hd__decap_12
XFILLER_242_83 VGND VGND VPWR VPWR sky130_fd_sc_hd__fill_1
XFILLER_229_1009 VPWR VGND VPWR VGND sky130_ef_sc_hd__decap_12
XFILLER_198_601 VPWR VGND VPWR VGND sky130_ef_sc_hd__decap_12
XTAP_TAPCELL_ROW_222_2872 VGND VPWR sky130_fd_sc_hd__tapvpwrvgnd_1
XFILLER_92_1507 VGND VGND VPWR VPWR sky130_fd_sc_hd__decap_8
XTAP_TAPCELL_ROW_222_2883 VGND VPWR sky130_fd_sc_hd__tapvpwrvgnd_1
XFILLER_226_793 VPWR VGND VPWR VGND sky130_ef_sc_hd__decap_12
XFILLER_225_281 VPWR VGND VPWR VGND sky130_ef_sc_hd__decap_12
XFILLER_241_741 VPWR VGND VPWR VGND sky130_ef_sc_hd__decap_12
XFILLER_197_111 VGND VGND VPWR VPWR sky130_fd_sc_hd__fill_1
XFILLER_198_645 VPWR VGND VPWR VGND sky130_ef_sc_hd__decap_12
XFILLER_129_1165 VPWR VGND VPWR VGND sky130_ef_sc_hd__decap_12
XFILLER_240_251 VGND VGND VPWR VPWR sky130_fd_sc_hd__fill_1
XFILLER_241_785 VPWR VGND VPWR VGND sky130_ef_sc_hd__decap_12
XFILLER_185_317 VPWR VGND VPWR VGND sky130_ef_sc_hd__decap_12
XPHY_EDGE_ROW_113_2_Right_204 VGND VGND VPWR VPWR sky130_fd_sc_hd__decap_3
XFILLER_244_1091 VGND VGND VPWR VPWR sky130_fd_sc_hd__fill_1
XFILLER_71_69 VGND VGND VPWR VPWR sky130_fd_sc_hd__fill_2
XFILLER_107_1441 VGND VGND VPWR VPWR sky130_fd_sc_hd__fill_1
XFILLER_181_1381 VPWR VGND VPWR VGND sky130_ef_sc_hd__decap_12
XFILLER_199_1119 VGND VGND VPWR VPWR sky130_fd_sc_hd__fill_1
XFILLER_16_1357 VGND VGND VPWR VPWR sky130_fd_sc_hd__fill_1
XFILLER_166_531 VGND VGND VPWR VPWR sky130_fd_sc_hd__fill_1
XFILLER_187_69 VPWR VGND VPWR VGND sky130_ef_sc_hd__decap_12
XFILLER_193_361 VPWR VGND VPWR VGND sky130_ef_sc_hd__decap_12
XTAP_TAPCELL_ROW_106_2_4393 VGND VPWR sky130_fd_sc_hd__tapvpwrvgnd_1
XFILLER_217_3 VPWR VGND VPWR VGND sky130_ef_sc_hd__decap_12
XFILLER_4_268 VGND VGND VPWR VPWR sky130_fd_sc_hd__fill_2
XFILLER_49_1177 VPWR VGND VPWR VGND sky130_ef_sc_hd__decap_12
XFILLER_1_953 VPWR VGND VPWR VGND sky130_ef_sc_hd__decap_12
XFILLER_0_441 VGND VGND VPWR VPWR sky130_fd_sc_hd__fill_1
XFILLER_249_841 VPWR VGND VPWR VGND sky130_ef_sc_hd__decap_12
XTAP_TAPCELL_ROW_54_2_4080 VGND VPWR sky130_fd_sc_hd__tapvpwrvgnd_1
XFILLER_27_1497 VGND VGND VPWR VPWR sky130_fd_sc_hd__fill_1
XFILLER_209_727 VGND VGND VPWR VPWR sky130_fd_sc_hd__fill_1
XFILLER_212_1035 VGND VGND VPWR VPWR sky130_fd_sc_hd__fill_1
XFILLER_236_513 VPWR VGND VPWR VGND sky130_ef_sc_hd__decap_12
XFILLER_236_557 VPWR VGND VPWR VGND sky130_ef_sc_hd__decap_12
XFILLER_1_1113 VGND VGND VPWR VPWR sky130_fd_sc_hd__decap_6
XFILLER_251_505 VPWR VGND VPWR VGND sky130_ef_sc_hd__decap_12
XFILLER_112_1191 VPWR VGND VPWR VGND sky130_ef_sc_hd__decap_12
XFILLER_1_1157 VPWR VGND VPWR VGND sky130_ef_sc_hd__decap_12
XFILLER_205_933 VPWR VGND VPWR VGND sky130_ef_sc_hd__decap_12
XFILLER_204_421 VPWR VGND VPWR VGND sky130_ef_sc_hd__decap_12
X_597_ clknet_3_2__leaf_clk _079_ _005_ VGND VGND VPWR VPWR rd_addr\[5\] sky130_fd_sc_hd__dfrtp_1
XFILLER_147_1243 VPWR VGND VPWR VGND sky130_ef_sc_hd__decap_12
XTAP_TAPCELL_ROW_46_2_4028 VGND VPWR sky130_fd_sc_hd__tapvpwrvgnd_1
XFILLER_205_977 VPWR VGND VPWR VGND sky130_ef_sc_hd__decap_12
XFILLER_188_133 VGND VGND VPWR VPWR sky130_fd_sc_hd__decap_6
XFILLER_108_1227 VPWR VGND VPWR VGND sky130_ef_sc_hd__decap_12
XFILLER_220_925 VPWR VGND VPWR VGND sky130_ef_sc_hd__decap_12
XFILLER_147_1287 VPWR VGND VPWR VGND sky130_ef_sc_hd__decap_12
XFILLER_231_273 VGND VGND VPWR VPWR sky130_fd_sc_hd__decap_6
XFILLER_34_1413 VGND VGND VPWR VPWR sky130_fd_sc_hd__fill_1
XFILLER_188_177 VPWR VGND VPWR VGND sky130_ef_sc_hd__decap_12
XFILLER_169_391 VGND VGND VPWR VPWR sky130_fd_sc_hd__fill_1
XFILLER_223_1175 VGND VGND VPWR VPWR sky130_fd_sc_hd__fill_1
XFILLER_172_501 VPWR VGND VPWR VGND sky130_ef_sc_hd__decap_12
XFILLER_247_39 VPWR VGND VPWR VGND sky130_ef_sc_hd__decap_12
XFILLER_185_895 VGND VGND VPWR VPWR sky130_fd_sc_hd__fill_1
XFILLER_200_693 VGND VGND VPWR VPWR sky130_fd_sc_hd__decap_6
XANTENNA_2 dout0\[2\] VGND VGND VPWR VPWR sky130_fd_sc_hd__diode_2
XFILLER_172_545 VPWR VGND VPWR VGND sky130_ef_sc_hd__decap_12
XFILLER_6_53 VPWR VGND VPWR VGND sky130_ef_sc_hd__decap_12
XFILLER_172_589 VPWR VGND VPWR VGND sky130_ef_sc_hd__decap_12
XFILLER_6_97 VPWR VGND VPWR VGND sky130_ef_sc_hd__decap_12
XFILLER_67_1255 VPWR VGND VPWR VGND sky130_ef_sc_hd__decap_12
XFILLER_119_1323 VGND VGND VPWR VPWR sky130_fd_sc_hd__decap_6
XFILLER_154_1203 VPWR VGND VPWR VGND sky130_ef_sc_hd__decap_12
XFILLER_158_1383 VPWR VGND VPWR VGND sky130_ef_sc_hd__decap_12
XFILLER_28_1239 VGND VGND VPWR VPWR sky130_fd_sc_hd__decap_6
XFILLER_67_1299 VPWR VGND VPWR VGND sky130_ef_sc_hd__decap_12
XFILLER_119_1367 VPWR VGND VPWR VGND sky130_ef_sc_hd__decap_12
XFILLER_154_1247 VPWR VGND VPWR VGND sky130_ef_sc_hd__decap_12
XTAP_TAPCELL_ROW_241_3404 VGND VPWR sky130_fd_sc_hd__tapvpwrvgnd_1
XPHY_EDGE_ROW_13_1_Right_669 VGND VGND VPWR VPWR sky130_fd_sc_hd__decap_3
XFILLER_6_1035 VGND VGND VPWR VPWR sky130_fd_sc_hd__fill_1
XFILLER_239_373 VPWR VGND VPWR VGND sky130_ef_sc_hd__decap_12
XFILLER_254_321 VPWR VGND VPWR VGND sky130_ef_sc_hd__decap_12
XTAP_TAPCELL_ROW_7_1041 VGND VPWR sky130_fd_sc_hd__tapvpwrvgnd_1
XFILLER_187_1001 VGND VGND VPWR VPWR sky130_fd_sc_hd__decap_6
XTAP_TAPCELL_ROW_7_1052 VGND VPWR sky130_fd_sc_hd__tapvpwrvgnd_1
XTAP_TAPCELL_ROW_7_1063 VGND VPWR sky130_fd_sc_hd__tapvpwrvgnd_1
XTAP_TAPCELL_ROW_143_2_4612 VGND VPWR sky130_fd_sc_hd__tapvpwrvgnd_1
XFILLER_187_1045 VPWR VGND VPWR VGND sky130_ef_sc_hd__decap_12
XFILLER_254_365 VPWR VGND VPWR VGND sky130_ef_sc_hd__decap_12
XFILLER_212_53 VPWR VGND VPWR VGND sky130_ef_sc_hd__decap_12
XFILLER_78_1351 VGND VGND VPWR VPWR sky130_fd_sc_hd__decap_6
XFILLER_187_1089 VPWR VGND VPWR VGND sky130_ef_sc_hd__decap_12
XFILLER_208_793 VPWR VGND VPWR VGND sky130_ef_sc_hd__decap_12
XTAP_TAPCELL_ROW_239_3333 VGND VPWR sky130_fd_sc_hd__tapvpwrvgnd_1
XFILLER_207_281 VPWR VGND VPWR VGND sky130_ef_sc_hd__decap_12
XFILLER_74_1215 VPWR VGND VPWR VGND sky130_ef_sc_hd__decap_12
XFILLER_223_741 VPWR VGND VPWR VGND sky130_ef_sc_hd__decap_12
XTAP_TAPCELL_ROW_239_3344 VGND VPWR sky130_fd_sc_hd__tapvpwrvgnd_1
XFILLER_179_111 VGND VGND VPWR VPWR sky130_fd_sc_hd__fill_1
XFILLER_212_97 VPWR VGND VPWR VGND sky130_ef_sc_hd__decap_12
XFILLER_78_1395 VPWR VGND VPWR VGND sky130_ef_sc_hd__decap_12
XFILLER_222_251 VGND VGND VPWR VPWR sky130_fd_sc_hd__fill_1
XTAP_TAPCELL_ROW_235_3219 VGND VPWR sky130_fd_sc_hd__tapvpwrvgnd_1
XFILLER_39_1379 VGND VGND VPWR VPWR sky130_fd_sc_hd__decap_6
XFILLER_74_1259 VPWR VGND VPWR VGND sky130_ef_sc_hd__decap_12
XFILLER_126_1327 VPWR VGND VPWR VGND sky130_ef_sc_hd__decap_12
XFILLER_223_785 VPWR VGND VPWR VGND sky130_ef_sc_hd__decap_12
XFILLER_195_615 VGND VGND VPWR VPWR sky130_fd_sc_hd__fill_1
XFILLER_210_413 VGND VGND VPWR VPWR sky130_fd_sc_hd__decap_6
XFILLER_167_317 VPWR VGND VPWR VGND sky130_ef_sc_hd__decap_12
XFILLER_241_1231 VGND VGND VPWR VPWR sky130_fd_sc_hd__fill_1
XFILLER_210_457 VPWR VGND VPWR VGND sky130_ef_sc_hd__decap_12
XFILLER_206_1373 VPWR VGND VPWR VGND sky130_ef_sc_hd__decap_12
XFILLER_41_39 VPWR VGND VPWR VGND sky130_ef_sc_hd__decap_12
XFILLER_182_309 VPWR VGND VPWR VGND sky130_ef_sc_hd__decap_12
XFILLER_157_39 VPWR VGND VPWR VGND sky130_ef_sc_hd__decap_12
XFILLER_175_361 VPWR VGND VPWR VGND sky130_ef_sc_hd__decap_12
XFILLER_198_1141 VGND VGND VPWR VPWR sky130_fd_sc_hd__decap_6
XFILLER_202_1259 VGND VGND VPWR VPWR sky130_fd_sc_hd__fill_1
XFILLER_191_821 VPWR VGND VPWR VGND sky130_ef_sc_hd__decap_12
XFILLER_194_1005 VPWR VGND VPWR VGND sky130_ef_sc_hd__decap_12
XFILLER_11_1243 VPWR VGND VPWR VGND sky130_ef_sc_hd__decap_12
XFILLER_191_865 VPWR VGND VPWR VGND sky130_ef_sc_hd__decap_12
XFILLER_198_1185 VPWR VGND VPWR VGND sky130_ef_sc_hd__decap_12
XFILLER_85_1311 VPWR VGND VPWR VGND sky130_ef_sc_hd__decap_12
XFILLER_102_1371 VPWR VGND VPWR VGND sky130_ef_sc_hd__decap_12
XFILLER_89_1491 VGND VGND VPWR VPWR sky130_fd_sc_hd__decap_6
XFILLER_194_1049 VPWR VGND VPWR VGND sky130_ef_sc_hd__decap_12
XFILLER_11_1287 VPWR VGND VPWR VGND sky130_ef_sc_hd__decap_12
XFILLER_2_739 VPWR VGND VPWR VGND sky130_ef_sc_hd__decap_12
XFILLER_85_1355 VPWR VGND VPWR VGND sky130_ef_sc_hd__decap_12
XFILLER_137_1423 VPWR VGND VPWR VGND sky130_ef_sc_hd__decap_12
XTAP_TAPCELL_ROW_211_2573 VGND VPWR sky130_fd_sc_hd__tapvpwrvgnd_1
XFILLER_173_27 VPWR VGND VPWR VGND sky130_ef_sc_hd__decap_12
XFILLER_176_1483 VGND VGND VPWR VPWR sky130_fd_sc_hd__fill_1
XTAP_TAPCELL_ROW_211_2584 VGND VPWR sky130_fd_sc_hd__tapvpwrvgnd_1
XFILLER_46_1339 VPWR VGND VPWR VGND sky130_ef_sc_hd__decap_12
XFILLER_81_1219 VPWR VGND VPWR VGND sky130_ef_sc_hd__decap_12
XTAP_TAPCELL_ROW_211_2595 VGND VPWR sky130_fd_sc_hd__tapvpwrvgnd_1
XFILLER_235_1057 VGND VGND VPWR VPWR sky130_fd_sc_hd__decap_6
XFILLER_85_1399 VPWR VGND VPWR VGND sky130_ef_sc_hd__decap_12
XFILLER_137_1467 VPWR VGND VPWR VGND sky130_ef_sc_hd__decap_12
XFILLER_249_137 VPWR VGND VPWR VGND sky130_ef_sc_hd__decap_12
XFILLER_252_1371 VGND VGND VPWR VPWR sky130_fd_sc_hd__fill_1
XFILLER_106_65 VGND VGND VPWR VPWR sky130_fd_sc_hd__decap_6
XFILLER_246_811 VGND VGND VPWR VPWR sky130_fd_sc_hd__fill_1
XFILLER_218_513 VPWR VGND VPWR VGND sky130_ef_sc_hd__decap_12
XFILLER_253_93 VPWR VGND VPWR VGND sky130_ef_sc_hd__decap_12
XTAP_TAPCELL_ROW_224_2923 VGND VPWR sky130_fd_sc_hd__tapvpwrvgnd_1
XTAP_TAPCELL_ROW_37_2_3976 VGND VPWR sky130_fd_sc_hd__tapvpwrvgnd_1
XFILLER_170_1093 VPWR VGND VPWR VGND sky130_ef_sc_hd__decap_12
XTAP_TAPCELL_ROW_224_2934 VGND VPWR sky130_fd_sc_hd__tapvpwrvgnd_1
XTAP_TAPCELL_ROW_224_2945 VGND VPWR sky130_fd_sc_hd__tapvpwrvgnd_1
XFILLER_213_1399 VGND VGND VPWR VPWR sky130_fd_sc_hd__fill_1
XFILLER_218_557 VPWR VGND VPWR VGND sky130_ef_sc_hd__decap_12
XFILLER_248_1429 VPWR VGND VPWR VGND sky130_ef_sc_hd__decap_12
XFILLER_233_505 VPWR VGND VPWR VGND sky130_ef_sc_hd__decap_12
X_520_ net664 VGND VGND VPWR VPWR _002_ sky130_fd_sc_hd__inv_2
XFILLER_22_1383 VPWR VGND VPWR VGND sky130_ef_sc_hd__decap_12
XFILLER_122_53 VPWR VGND VPWR VGND sky130_ef_sc_hd__decap_12
XFILLER_96_1451 VPWR VGND VPWR VGND sky130_ef_sc_hd__decap_12
XFILLER_166_1129 VPWR VGND VPWR VGND sky130_ef_sc_hd__decap_12
XFILLER_199_921 VPWR VGND VPWR VGND sky130_ef_sc_hd__decap_12
XFILLER_2_1477 VGND VGND VPWR VPWR sky130_fd_sc_hd__decap_6
XFILLER_167_3 VPWR VGND VPWR VGND sky130_ef_sc_hd__decap_12
X_451_ net180 net83 VGND VGND VPWR VPWR acc_core.adder.cla_blocks\[7\].block.sum\[0\]
+ sky130_fd_sc_hd__xnor2_1
XFILLER_57_1435 VGND VGND VPWR VPWR sky130_fd_sc_hd__decap_6
XFILLER_92_1315 VPWR VGND VPWR VGND sky130_ef_sc_hd__decap_12
XFILLER_96_1495 VPWR VGND VPWR VGND sky130_ef_sc_hd__decap_12
XFILLER_199_965 VPWR VGND VPWR VGND sky130_ef_sc_hd__decap_12
XFILLER_202_925 VPWR VGND VPWR VGND sky130_ef_sc_hd__decap_12
XFILLER_242_1017 VPWR VGND VPWR VGND sky130_ef_sc_hd__decap_12
XFILLER_57_1479 VPWR VGND VPWR VGND sky130_ef_sc_hd__decap_12
X_382_ net590 net581 net554 VGND VGND VPWR VPWR _171_ sky130_fd_sc_hd__and3_1
XFILLER_92_1359 VPWR VGND VPWR VGND sky130_ef_sc_hd__decap_12
XFILLER_144_1427 VPWR VGND VPWR VGND sky130_ef_sc_hd__decap_12
XFILLER_246_1197 VGND VGND VPWR VPWR sky130_fd_sc_hd__decap_6
XFILLER_198_475 VGND VGND VPWR VPWR sky130_fd_sc_hd__fill_1
XFILLER_213_273 VGND VGND VPWR VPWR sky130_fd_sc_hd__decap_6
XFILLER_186_637 VGND VGND VPWR VPWR sky130_fd_sc_hd__decap_6
XFILLER_185_125 VPWR VGND VPWR VGND sky130_ef_sc_hd__decap_12
XTAP_TAPCELL_ROW_156_2_4690 VGND VPWR sky130_fd_sc_hd__tapvpwrvgnd_1
XFILLER_9_349 VPWR VGND VPWR VGND sky130_ef_sc_hd__decap_12
XPHY_EDGE_ROW_114_2_Right_205 VGND VGND VPWR VPWR sky130_fd_sc_hd__decap_3
XFILLER_220_1315 VGND VGND VPWR VPWR sky130_fd_sc_hd__fill_1
XFILLER_16_1165 VPWR VGND VPWR VGND sky130_ef_sc_hd__decap_12
XFILLER_185_169 VPWR VGND VPWR VGND sky130_ef_sc_hd__decap_12
XTAP_TAPCELL_ROW_49_1_1184 VGND VPWR sky130_fd_sc_hd__tapvpwrvgnd_1
XFILLER_167_895 VGND VGND VPWR VPWR sky130_fd_sc_hd__fill_1
XFILLER_194_681 VPWR VGND VPWR VGND sky130_ef_sc_hd__decap_12
XTAP_TAPCELL_ROW_10_2_3817 VGND VPWR sky130_fd_sc_hd__tapvpwrvgnd_1
XFILLER_177_1225 VGND VGND VPWR VPWR sky130_fd_sc_hd__decap_6
XFILLER_120_1471 VPWR VGND VPWR VGND sky130_ef_sc_hd__decap_12
XPHY_EDGE_ROW_165_Left_420 VGND VGND VPWR VPWR sky130_fd_sc_hd__decap_3
XFILLER_177_1269 VPWR VGND VPWR VGND sky130_ef_sc_hd__decap_12
XFILLER_253_1113 VGND VGND VPWR VPWR sky130_fd_sc_hd__decap_6
Xoutput50 net50 VGND VGND VPWR VPWR acc_out[16] sky130_fd_sc_hd__buf_2
XFILLER_64_1439 VPWR VGND VPWR VGND sky130_ef_sc_hd__decap_12
Xoutput61 net529 VGND VGND VPWR VPWR acc_out[26] sky130_fd_sc_hd__buf_2
XFILLER_116_1507 VGND VGND VPWR VPWR sky130_fd_sc_hd__decap_8
XFILLER_253_1157 VPWR VGND VPWR VGND sky130_ef_sc_hd__decap_12
Xoutput72 net551 VGND VGND VPWR VPWR acc_out[7] sky130_fd_sc_hd__buf_2
XPHY_EDGE_ROW_140_1_Right_796 VGND VGND VPWR VPWR sky130_fd_sc_hd__decap_3
XFILLER_249_671 VGND VGND VPWR VPWR sky130_fd_sc_hd__fill_1
XFILLER_231_1455 VGND VGND VPWR VPWR sky130_fd_sc_hd__fill_1
XFILLER_237_833 VGND VGND VPWR VPWR sky130_fd_sc_hd__decap_6
XFILLER_0_293 VGND VGND VPWR VPWR sky130_fd_sc_hd__decap_3
XFILLER_236_321 VPWR VGND VPWR VGND sky130_ef_sc_hd__decap_12
XTAP_TAPCELL_ROW_128_2_4525 VGND VPWR sky130_fd_sc_hd__tapvpwrvgnd_1
XFILLER_7_1399 VGND VGND VPWR VPWR sky130_fd_sc_hd__fill_1
XFILLER_237_877 VPWR VGND VPWR VGND sky130_ef_sc_hd__decap_12
XFILLER_236_365 VPWR VGND VPWR VGND sky130_ef_sc_hd__decap_12
XFILLER_252_825 VPWR VGND VPWR VGND sky130_ef_sc_hd__decap_12
XFILLER_188_1365 VGND VGND VPWR VPWR sky130_fd_sc_hd__decap_6
XFILLER_40_1483 VPWR VGND VPWR VGND sky130_ef_sc_hd__decap_12
XFILLER_251_335 VGND VGND VPWR VPWR sky130_fd_sc_hd__fill_1
XFILLER_184_1229 VPWR VGND VPWR VGND sky130_ef_sc_hd__decap_12
XFILLER_252_869 VPWR VGND VPWR VGND sky130_ef_sc_hd__decap_12
X_649_ clknet_3_6__leaf_clk acc_core.adder.cla_blocks\[3\].block.sum\[3\] _057_ VGND
+ VGND VPWR VPWR net49 sky130_fd_sc_hd__dfrtp_1
XFILLER_205_741 VPWR VGND VPWR VGND sky130_ef_sc_hd__decap_12
XTAP_TAPCELL_ROW_108_2_4401 VGND VPWR sky130_fd_sc_hd__tapvpwrvgnd_1
XFILLER_204_251 VGND VGND VPWR VPWR sky130_fd_sc_hd__fill_1
XFILLER_205_785 VPWR VGND VPWR VGND sky130_ef_sc_hd__decap_12
XFILLER_177_615 VGND VGND VPWR VPWR sky130_fd_sc_hd__fill_1
XFILLER_189_497 VGND VGND VPWR VPWR sky130_fd_sc_hd__decap_6
XTAP_TAPCELL_ROW_76_2_4212 VGND VPWR sky130_fd_sc_hd__tapvpwrvgnd_1
XFILLER_220_755 VGND VGND VPWR VPWR sky130_fd_sc_hd__fill_1
XFILLER_82_3 VPWR VGND VPWR VGND sky130_ef_sc_hd__decap_12
XFILLER_203_1513 VGND VGND VPWR VPWR sky130_fd_sc_hd__fill_2
XTAP_TAPCELL_ROW_230_3105 VGND VPWR sky130_fd_sc_hd__tapvpwrvgnd_1
XFILLER_121_1213 VGND VGND VPWR VPWR sky130_fd_sc_hd__decap_4
XFILLER_173_821 VPWR VGND VPWR VGND sky130_ef_sc_hd__decap_12
XFILLER_160_1295 VGND VGND VPWR VPWR sky130_fd_sc_hd__decap_6
XFILLER_8_382 VPWR VGND VPWR VGND sky130_ef_sc_hd__decap_12
XFILLER_195_1325 VPWR VGND VPWR VGND sky130_ef_sc_hd__decap_12
XFILLER_173_865 VPWR VGND VPWR VGND sky130_ef_sc_hd__decap_12
XFILLER_201_1281 VGND VGND VPWR VPWR sky130_fd_sc_hd__decap_6
XFILLER_195_1369 VPWR VGND VPWR VGND sky130_ef_sc_hd__decap_12
XFILLER_158_1191 VPWR VGND VPWR VGND sky130_ef_sc_hd__decap_12
XTAP_TAPCELL_ROW_228_3034 VGND VPWR sky130_fd_sc_hd__tapvpwrvgnd_1
XTAP_TAPCELL_ROW_228_3045 VGND VPWR sky130_fd_sc_hd__tapvpwrvgnd_1
XTAP_TAPCELL_ROW_9_1103 VGND VPWR sky130_fd_sc_hd__tapvpwrvgnd_1
XTAP_TAPCELL_ROW_9_1114 VGND VPWR sky130_fd_sc_hd__tapvpwrvgnd_1
XTAP_TAPCELL_ROW_9_1125 VGND VPWR sky130_fd_sc_hd__tapvpwrvgnd_1
XTAP_TAPCELL_ROW_9_1136 VGND VPWR sky130_fd_sc_hd__tapvpwrvgnd_1
XFILLER_228_811 VGND VGND VPWR VPWR sky130_fd_sc_hd__fill_1
XTAP_TAPCELL_ROW_23_2_3895 VGND VPWR sky130_fd_sc_hd__tapvpwrvgnd_1
XFILLER_239_181 VPWR VGND VPWR VGND sky130_ef_sc_hd__decap_12
XFILLER_255_641 VGND VGND VPWR VPWR sky130_fd_sc_hd__decap_3
XFILLER_215_505 VPWR VGND VPWR VGND sky130_ef_sc_hd__decap_12
XFILLER_255_685 VPWR VGND VPWR VGND sky130_ef_sc_hd__decap_12
XFILLER_199_217 VGND VGND VPWR VPWR sky130_fd_sc_hd__decap_6
XFILLER_254_195 VGND VGND VPWR VPWR sky130_fd_sc_hd__fill_1
XFILLER_167_1449 VGND VGND VPWR VPWR sky130_fd_sc_hd__decap_6
XFILLER_242_357 VGND VGND VPWR VPWR sky130_fd_sc_hd__decap_6
XFILLER_243_1337 VGND VGND VPWR VPWR sky130_fd_sc_hd__decap_6
XFILLER_52_27 VGND VGND VPWR VPWR sky130_fd_sc_hd__fill_1
XFILLER_165_1173 VGND VGND VPWR VPWR sky130_fd_sc_hd__decap_3
XTAP_TAPCELL_ROW_200_2274 VGND VPWR sky130_fd_sc_hd__tapvpwrvgnd_1
XFILLER_168_637 VGND VGND VPWR VPWR sky130_fd_sc_hd__decap_6
XTAP_TAPCELL_ROW_200_2285 VGND VPWR sky130_fd_sc_hd__tapvpwrvgnd_1
XFILLER_210_221 VPWR VGND VPWR VGND sky130_ef_sc_hd__decap_12
XTAP_TAPCELL_ROW_200_2296 VGND VPWR sky130_fd_sc_hd__tapvpwrvgnd_1
XFILLER_168_27 VGND VGND VPWR VPWR sky130_fd_sc_hd__fill_1
XFILLER_167_125 VPWR VGND VPWR VGND sky130_ef_sc_hd__decap_12
XFILLER_17_1441 VGND VGND VPWR VPWR sky130_fd_sc_hd__fill_1
XFILLER_196_979 VGND VGND VPWR VPWR sky130_fd_sc_hd__fill_1
XFILLER_211_777 VGND VGND VPWR VPWR sky130_fd_sc_hd__decap_6
XFILLER_210_265 VPWR VGND VPWR VGND sky130_ef_sc_hd__decap_12
XTAP_TAPCELL_ROW_192_2064 VGND VPWR sky130_fd_sc_hd__tapvpwrvgnd_1
XFILLER_167_169 VPWR VGND VPWR VGND sky130_ef_sc_hd__decap_12
XFILLER_183_629 VPWR VGND VPWR VGND sky130_ef_sc_hd__decap_12
XTAP_TAPCELL_ROW_192_2075 VGND VPWR sky130_fd_sc_hd__tapvpwrvgnd_1
XFILLER_176_681 VPWR VGND VPWR VGND sky130_ef_sc_hd__decap_12
XFILLER_182_139 VGND VGND VPWR VPWR sky130_fd_sc_hd__fill_1
XTAP_TAPCELL_ROW_213_2624 VGND VPWR sky130_fd_sc_hd__tapvpwrvgnd_1
XTAP_TAPCELL_ROW_213_2635 VGND VPWR sky130_fd_sc_hd__tapvpwrvgnd_1
XFILLER_184_15 VPWR VGND VPWR VGND sky130_ef_sc_hd__decap_12
XTAP_TAPCELL_ROW_213_2646 VGND VPWR sky130_fd_sc_hd__tapvpwrvgnd_1
XFILLER_237_1119 VGND VGND VPWR VPWR sky130_fd_sc_hd__fill_1
XFILLER_174_1409 VPWR VGND VPWR VGND sky130_ef_sc_hd__decap_12
XFILLER_191_673 VPWR VGND VPWR VGND sky130_ef_sc_hd__decap_12
XPHY_EDGE_ROW_58_2_Left_560 VGND VGND VPWR VPWR sky130_fd_sc_hd__decap_3
Xsram0_676 VGND VGND VPWR VPWR sram0_676/HI net676 sky130_fd_sc_hd__conb_1
XTAP_TAPCELL_ROW_134_2_4557 VGND VPWR sky130_fd_sc_hd__tapvpwrvgnd_1
XTAP_TAPCELL_ROW_89_2_4290 VGND VPWR sky130_fd_sc_hd__tapvpwrvgnd_1
Xsram0_687 VGND VGND VPWR VPWR net687 sram0_687/LO sky130_fd_sc_hd__conb_1
XFILLER_137_1231 VPWR VGND VPWR VGND sky130_ef_sc_hd__decap_12
XFILLER_2_569 VGND VGND VPWR VPWR sky130_fd_sc_hd__fill_2
XFILLER_254_1477 VGND VGND VPWR VPWR sky130_fd_sc_hd__decap_6
XFILLER_137_1275 VPWR VGND VPWR VGND sky130_ef_sc_hd__decap_12
XFILLER_77_57 VPWR VGND VPWR VGND sky130_ef_sc_hd__decap_12
XFILLER_219_833 VGND VGND VPWR VPWR sky130_fd_sc_hd__decap_6
XFILLER_218_321 VPWR VGND VPWR VGND sky130_ef_sc_hd__decap_12
XFILLER_219_877 VPWR VGND VPWR VGND sky130_ef_sc_hd__decap_12
XTAP_TAPCELL_ROW_82_2_4244 VGND VPWR sky130_fd_sc_hd__tapvpwrvgnd_1
XFILLER_218_365 VPWR VGND VPWR VGND sky130_ef_sc_hd__decap_12
XFILLER_234_825 VPWR VGND VPWR VGND sky130_ef_sc_hd__decap_12
XFILLER_185_1505 VGND VGND VPWR VPWR sky130_fd_sc_hd__decap_6
XFILLER_2_1241 VPWR VGND VPWR VGND sky130_ef_sc_hd__decap_12
XFILLER_248_1259 VGND VGND VPWR VPWR sky130_fd_sc_hd__fill_1
XFILLER_22_1191 VPWR VGND VPWR VGND sky130_ef_sc_hd__decap_12
X_503_ _103_ _257_ VGND VGND VPWR VPWR acc_core.adder.cla_blocks\[6\].block.sum\[3\]
+ sky130_fd_sc_hd__xnor2_1
XFILLER_233_335 VGND VGND VPWR VPWR sky130_fd_sc_hd__fill_1
XFILLER_234_869 VPWR VGND VPWR VGND sky130_ef_sc_hd__decap_12
XFILLER_2_1285 VPWR VGND VPWR VGND sky130_ef_sc_hd__decap_12
XFILLER_57_1243 VPWR VGND VPWR VGND sky130_ef_sc_hd__decap_12
XFILLER_109_1311 VPWR VGND VPWR VGND sky130_ef_sc_hd__decap_12
X_434_ _221_ net190 VGND VGND VPWR VPWR _223_ sky130_fd_sc_hd__or2_1
XFILLER_148_1371 VPWR VGND VPWR VGND sky130_ef_sc_hd__decap_12
XFILLER_186_401 VPWR VGND VPWR VGND sky130_ef_sc_hd__decap_12
XFILLER_18_1227 VPWR VGND VPWR VGND sky130_ef_sc_hd__decap_12
XFILLER_57_1287 VPWR VGND VPWR VGND sky130_ef_sc_hd__decap_12
XFILLER_109_1355 VPWR VGND VPWR VGND sky130_ef_sc_hd__decap_12
XFILLER_202_755 VGND VGND VPWR VPWR sky130_fd_sc_hd__fill_1
X_365_ net592 net575 net547 VGND VGND VPWR VPWR _154_ sky130_fd_sc_hd__and3_1
XFILLER_92_1189 VGND VGND VPWR VPWR sky130_fd_sc_hd__fill_1
XFILLER_9_113 VPWR VGND VPWR VGND sky130_ef_sc_hd__decap_12
XFILLER_186_445 VPWR VGND VPWR VGND sky130_ef_sc_hd__decap_12
Xsram0 net662 net649 net636 net633 net632 net631 net630 net629 net626 net625 net661
+ net660 net659 net658 net657 net656 net655 net654 net653 net650 net648 net647 net646
+ net645 net644 net643 net642 net641 net638 net637 net635 net634 addr0\[0\] addr0\[1\]
+ addr0\[2\] addr0\[3\] addr0\[4\] addr0\[5\] addr0\[6\] addr0\[7\] net673 net674
+ net675 net676 net677 net678 net679 net680 net682 net683 net620 clknet_3_2__leaf_clk
+ net681 net684 net685 net686 net687 dout0\[0\] dout0\[1\] dout0\[2\] dout0\[3\] dout0\[4\]
+ dout0\[5\] dout0\[6\] dout0\[7\] dout0\[8\] dout0\[9\] dout0\[10\] dout0\[11\] dout0\[12\]
+ dout0\[13\] dout0\[14\] dout0\[15\] dout0\[16\] dout0\[17\] dout0\[18\] dout0\[19\]
+ dout0\[20\] dout0\[21\] dout0\[22\] dout0\[23\] dout0\[24\] dout0\[25\] dout0\[26\]
+ dout0\[27\] dout0\[28\] dout0\[29\] dout0\[30\] dout0\[31\] sram0/dout1[0] sram0/dout1[1]
+ sram0/dout1[2] sram0/dout1[3] sram0/dout1[4] sram0/dout1[5] sram0/dout1[6] sram0/dout1[7]
+ sram0/dout1[8] sram0/dout1[9] sram0/dout1[10] sram0/dout1[11] sram0/dout1[12] sram0/dout1[13]
+ sram0/dout1[14] sram0/dout1[15] sram0/dout1[16] sram0/dout1[17] sram0/dout1[18]
+ sram0/dout1[19] sram0/dout1[20] sram0/dout1[21] sram0/dout1[22] sram0/dout1[23]
+ sram0/dout1[24] sram0/dout1[25] sram0/dout1[26] sram0/dout1[27] sram0/dout1[28]
+ sram0/dout1[29] sram0/dout1[30] sram0/dout1[31] sram0/vccd1 sram0/vssd1 sky130_sram_1kbyte_1rw1r_32x256_8
XFILLER_105_1219 VPWR VGND VPWR VGND sky130_ef_sc_hd__decap_12
XFILLER_109_1399 VPWR VGND VPWR VGND sky130_ef_sc_hd__decap_12
X_296_ web0 net615 net618 net613 VGND VGND VPWR VPWR _088_ sky130_fd_sc_hd__a31o_1
XFILLER_186_489 VPWR VGND VPWR VGND sky130_ef_sc_hd__decap_12
XPHY_EDGE_ROW_115_2_Right_206 VGND VGND VPWR VPWR sky130_fd_sc_hd__decap_3
XFILLER_177_1033 VPWR VGND VPWR VGND sky130_ef_sc_hd__decap_12
XFILLER_170_813 VPWR VGND VPWR VGND sky130_ef_sc_hd__decap_12
XFILLER_192_1509 VGND VGND VPWR VPWR sky130_fd_sc_hd__decap_6
XFILLER_181_161 VGND VGND VPWR VPWR sky130_fd_sc_hd__decap_6
XFILLER_177_1077 VPWR VGND VPWR VGND sky130_ef_sc_hd__decap_12
XFILLER_64_1203 VPWR VGND VPWR VGND sky130_ef_sc_hd__decap_12
XFILLER_29_1323 VGND VGND VPWR VPWR sky130_fd_sc_hd__decap_6
XFILLER_68_1383 VPWR VGND VPWR VGND sky130_ef_sc_hd__decap_12
XFILLER_155_1331 VPWR VGND VPWR VGND sky130_ef_sc_hd__decap_12
XFILLER_244_29 VPWR VGND VPWR VGND sky130_ef_sc_hd__decap_12
XFILLER_64_1247 VPWR VGND VPWR VGND sky130_ef_sc_hd__decap_12
XFILLER_29_1367 VPWR VGND VPWR VGND sky130_ef_sc_hd__decap_12
XFILLER_116_1315 VPWR VGND VPWR VGND sky130_ef_sc_hd__decap_12
XTAP_TAPCELL_ROW_188_1955 VGND VPWR sky130_fd_sc_hd__tapvpwrvgnd_1
XTAP_TAPCELL_ROW_188_1966 VGND VPWR sky130_fd_sc_hd__tapvpwrvgnd_1
XFILLER_218_1085 VGND VGND VPWR VPWR sky130_fd_sc_hd__decap_6
XFILLER_151_1217 VGND VGND VPWR VPWR sky130_fd_sc_hd__fill_1
XFILLER_116_1359 VPWR VGND VPWR VGND sky130_ef_sc_hd__decap_12
XPHY_EDGE_ROW_141_1_Right_797 VGND VGND VPWR VPWR sky130_fd_sc_hd__decap_3
XFILLER_237_641 VPWR VGND VPWR VGND sky130_ef_sc_hd__decap_12
XFILLER_237_685 VPWR VGND VPWR VGND sky130_ef_sc_hd__decap_12
XFILLER_188_1173 VPWR VGND VPWR VGND sky130_ef_sc_hd__decap_12
XFILLER_236_195 VGND VGND VPWR VPWR sky130_fd_sc_hd__fill_1
XFILLER_184_1037 VPWR VGND VPWR VGND sky130_ef_sc_hd__decap_12
XFILLER_224_357 VGND VGND VPWR VPWR sky130_fd_sc_hd__decap_6
XFILLER_252_699 VGND VGND VPWR VPWR sky130_fd_sc_hd__fill_1
XFILLER_75_1343 VPWR VGND VPWR VGND sky130_ef_sc_hd__decap_12
XFILLER_127_1411 VPWR VGND VPWR VGND sky130_ef_sc_hd__decap_12
XFILLER_225_1001 VGND VGND VPWR VPWR sky130_fd_sc_hd__decap_6
XFILLER_196_209 VPWR VGND VPWR VGND sky130_ef_sc_hd__decap_12
XFILLER_189_261 VPWR VGND VPWR VGND sky130_ef_sc_hd__decap_12
XFILLER_36_1327 VPWR VGND VPWR VGND sky130_ef_sc_hd__decap_12
XFILLER_225_1045 VPWR VGND VPWR VGND sky130_ef_sc_hd__decap_12
XFILLER_75_1387 VPWR VGND VPWR VGND sky130_ef_sc_hd__decap_12
XFILLER_127_1455 VPWR VGND VPWR VGND sky130_ef_sc_hd__decap_12
XFILLER_162_1357 VGND VGND VPWR VPWR sky130_fd_sc_hd__fill_1
XFILLER_178_979 VGND VGND VPWR VPWR sky130_fd_sc_hd__fill_1
XFILLER_225_1089 VPWR VGND VPWR VGND sky130_ef_sc_hd__decap_12
XFILLER_127_1499 VPWR VGND VPWR VGND sky130_ef_sc_hd__decap_12
XFILLER_165_629 VPWR VGND VPWR VGND sky130_ef_sc_hd__decap_12
XFILLER_203_1343 VGND VGND VPWR VPWR sky130_fd_sc_hd__fill_1
XFILLER_195_1133 VPWR VGND VPWR VGND sky130_ef_sc_hd__decap_12
XFILLER_218_41 VPWR VGND VPWR VGND sky130_ef_sc_hd__decap_12
XTAP_TAPCELL_ROW_120_2_4476 VGND VPWR sky130_fd_sc_hd__tapvpwrvgnd_1
XFILLER_173_673 VPWR VGND VPWR VGND sky130_ef_sc_hd__decap_12
XFILLER_12_1371 VPWR VGND VPWR VGND sky130_ef_sc_hd__decap_12
XFILLER_195_1177 VPWR VGND VPWR VGND sky130_ef_sc_hd__decap_12
XFILLER_218_85 VPWR VGND VPWR VGND sky130_ef_sc_hd__decap_12
XFILLER_47_1423 VPWR VGND VPWR VGND sky130_ef_sc_hd__decap_12
XFILLER_82_1303 VPWR VGND VPWR VGND sky130_ef_sc_hd__decap_12
XFILLER_236_1141 VGND VGND VPWR VPWR sky130_fd_sc_hd__decap_6
XFILLER_86_1483 VPWR VGND VPWR VGND sky130_ef_sc_hd__decap_12
XFILLER_154_29 VPWR VGND VPWR VGND sky130_ef_sc_hd__decap_12
XFILLER_232_1005 VPWR VGND VPWR VGND sky130_ef_sc_hd__decap_12
XFILLER_47_1467 VPWR VGND VPWR VGND sky130_ef_sc_hd__decap_12
XFILLER_134_1415 VPWR VGND VPWR VGND sky130_ef_sc_hd__decap_12
XFILLER_248_917 VGND VGND VPWR VPWR sky130_fd_sc_hd__decap_6
XFILLER_236_1185 VPWR VGND VPWR VGND sky130_ef_sc_hd__decap_12
XTAP_TAPCELL_ROW_100_2_4352 VGND VPWR sky130_fd_sc_hd__tapvpwrvgnd_1
XFILLER_247_405 VPWR VGND VPWR VGND sky130_ef_sc_hd__decap_12
XFILLER_232_1049 VPWR VGND VPWR VGND sky130_ef_sc_hd__decap_12
XFILLER_47_27 VPWR VGND VPWR VGND sky130_ef_sc_hd__decap_12
XFILLER_247_449 VPWR VGND VPWR VGND sky130_ef_sc_hd__decap_12
XFILLER_45_1180 VPWR VGND VPWR VGND sky130_ef_sc_hd__decap_12
XFILLER_214_1483 VGND VGND VPWR VPWR sky130_fd_sc_hd__fill_1
XTAP_TAPCELL_ROW_67_2_4157 VGND VPWR sky130_fd_sc_hd__tapvpwrvgnd_1
XFILLER_249_1513 VGND VGND VPWR VPWR sky130_fd_sc_hd__fill_2
XTAP_TAPCELL_ROW_206_2450 VGND VPWR sky130_fd_sc_hd__tapvpwrvgnd_1
XFILLER_216_825 VPWR VGND VPWR VGND sky130_ef_sc_hd__decap_12
XFILLER_167_1213 VPWR VGND VPWR VGND sky130_ef_sc_hd__decap_12
XFILLER_242_121 VPWR VGND VPWR VGND sky130_ef_sc_hd__decap_12
XFILLER_103_55 VGND VGND VPWR VPWR sky130_fd_sc_hd__fill_1
XFILLER_215_335 VGND VGND VPWR VPWR sky130_fd_sc_hd__fill_1
XFILLER_63_15 VPWR VGND VPWR VGND sky130_ef_sc_hd__decap_12
XTAP_TAPCELL_ROW_202_2336 VGND VPWR sky130_fd_sc_hd__tapvpwrvgnd_1
XFILLER_216_869 VPWR VGND VPWR VGND sky130_ef_sc_hd__decap_12
XFILLER_250_83 VGND VGND VPWR VPWR sky130_fd_sc_hd__fill_1
XFILLER_167_1257 VPWR VGND VPWR VGND sky130_ef_sc_hd__decap_12
XTAP_TAPCELL_ROW_202_2347 VGND VPWR sky130_fd_sc_hd__tapvpwrvgnd_1
XTAP_TAPCELL_ROW_198_2240 VGND VPWR sky130_fd_sc_hd__tapvpwrvgnd_1
XFILLER_243_1101 VPWR VGND VPWR VGND sky130_ef_sc_hd__decap_12
XFILLER_242_165 VPWR VGND VPWR VGND sky130_ef_sc_hd__decap_12
XFILLER_179_15 VPWR VGND VPWR VGND sky130_ef_sc_hd__decap_12
XFILLER_93_1443 VPWR VGND VPWR VGND sky130_ef_sc_hd__decap_12
XFILLER_145_1511 VGND VGND VPWR VPWR sky130_fd_sc_hd__decap_4
XFILLER_231_839 VGND VGND VPWR VPWR sky130_fd_sc_hd__fill_1
XFILLER_247_1281 VGND VGND VPWR VPWR sky130_fd_sc_hd__decap_6
XTAP_TAPCELL_ROW_194_2115 VGND VPWR sky130_fd_sc_hd__tapvpwrvgnd_1
XFILLER_168_401 VPWR VGND VPWR VGND sky130_ef_sc_hd__decap_12
XTAP_TAPCELL_ROW_194_2126 VGND VPWR sky130_fd_sc_hd__tapvpwrvgnd_1
XTAP_TAPCELL_ROW_219_2800 VGND VPWR sky130_fd_sc_hd__tapvpwrvgnd_1
XFILLER_54_1427 VPWR VGND VPWR VGND sky130_ef_sc_hd__decap_12
XTAP_TAPCELL_ROW_219_2811 VGND VPWR sky130_fd_sc_hd__tapvpwrvgnd_1
XFILLER_243_1145 VPWR VGND VPWR VGND sky130_ef_sc_hd__decap_12
XFILLER_211_541 VPWR VGND VPWR VGND sky130_ef_sc_hd__decap_12
XFILLER_168_445 VPWR VGND VPWR VGND sky130_ef_sc_hd__decap_12
XFILLER_184_905 VPWR VGND VPWR VGND sky130_ef_sc_hd__decap_12
XFILLER_204_1129 VPWR VGND VPWR VGND sky130_ef_sc_hd__decap_12
XFILLER_243_1189 VPWR VGND VPWR VGND sky130_ef_sc_hd__decap_12
Xwire504 _112_ VGND VGND VPWR VPWR net504 sky130_fd_sc_hd__clkbuf_1
XFILLER_211_585 VPWR VGND VPWR VGND sky130_ef_sc_hd__decap_12
XFILLER_168_489 VPWR VGND VPWR VGND sky130_ef_sc_hd__decap_12
XFILLER_184_949 VPWR VGND VPWR VGND sky130_ef_sc_hd__decap_12
Xwire548 net44 VGND VGND VPWR VPWR net548 sky130_fd_sc_hd__clkbuf_1
XFILLER_12_41 VPWR VGND VPWR VGND sky130_ef_sc_hd__decap_12
XFILLER_195_69 VPWR VGND VPWR VGND sky130_ef_sc_hd__decap_12
XTAP_TAPCELL_ROW_25_2_3903 VGND VPWR sky130_fd_sc_hd__tapvpwrvgnd_1
XFILLER_128_41 VPWR VGND VPWR VGND sky130_ef_sc_hd__decap_12
XFILLER_170_109 VPWR VGND VPWR VGND sky130_ef_sc_hd__decap_12
XFILLER_178_1353 VPWR VGND VPWR VGND sky130_ef_sc_hd__decap_12
XFILLER_192_993 VPWR VGND VPWR VGND sky130_ef_sc_hd__decap_12
XFILLER_30_1471 VPWR VGND VPWR VGND sky130_ef_sc_hd__decap_12
XFILLER_174_1217 VPWR VGND VPWR VGND sky130_ef_sc_hd__decap_12
XFILLER_178_1397 VPWR VGND VPWR VGND sky130_ef_sc_hd__decap_12
XTAP_TAPCELL_ROW_170_1480 VGND VPWR sky130_fd_sc_hd__tapvpwrvgnd_1
XFILLER_254_1241 VPWR VGND VPWR VGND sky130_ef_sc_hd__decap_12
XFILLER_26_1507 VGND VGND VPWR VPWR sky130_fd_sc_hd__decap_8
XFILLER_250_1105 VPWR VGND VPWR VGND sky130_ef_sc_hd__decap_12
XFILLER_215_1225 VGND VGND VPWR VPWR sky130_fd_sc_hd__decap_6
XFILLER_254_1285 VPWR VGND VPWR VGND sky130_ef_sc_hd__decap_12
XTAP_TAPCELL_ROW_164_2_4741 VGND VPWR sky130_fd_sc_hd__tapvpwrvgnd_1
XFILLER_250_1149 VPWR VGND VPWR VGND sky130_ef_sc_hd__decap_12
XFILLER_215_1269 VPWR VGND VPWR VGND sky130_ef_sc_hd__decap_12
Xfanout670 net671 VGND VGND VPWR VPWR net670 sky130_fd_sc_hd__buf_4
XFILLER_8_1483 VGND VGND VPWR VPWR sky130_fd_sc_hd__fill_1
XTAP_TAPCELL_ROW_183_1830 VGND VPWR sky130_fd_sc_hd__tapvpwrvgnd_1
XFILLER_219_641 VPWR VGND VPWR VGND sky130_ef_sc_hd__decap_12
XFILLER_111_1201 VPWR VGND VPWR VGND sky130_ef_sc_hd__decap_12
XFILLER_150_1283 VPWR VGND VPWR VGND sky130_ef_sc_hd__decap_12
XFILLER_219_685 VPWR VGND VPWR VGND sky130_ef_sc_hd__decap_12
XFILLER_185_1313 VPWR VGND VPWR VGND sky130_ef_sc_hd__decap_12
XFILLER_111_1267 VGND VGND VPWR VPWR sky130_fd_sc_hd__decap_6
XFILLER_189_1493 VPWR VGND VPWR VGND sky130_ef_sc_hd__decap_12
XFILLER_218_195 VGND VGND VPWR VPWR sky130_fd_sc_hd__fill_1
XFILLER_206_357 VGND VGND VPWR VPWR sky130_fd_sc_hd__decap_6
XFILLER_209_1007 VGND VGND VPWR VPWR sky130_fd_sc_hd__fill_1
XFILLER_185_1357 VPWR VGND VPWR VGND sky130_ef_sc_hd__decap_12
XFILLER_221_305 VPWR VGND VPWR VGND sky130_ef_sc_hd__decap_12
XFILLER_234_699 VGND VGND VPWR VPWR sky130_fd_sc_hd__fill_1
XFILLER_2_1093 VPWR VGND VPWR VGND sky130_ef_sc_hd__decap_12
XFILLER_178_209 VPWR VGND VPWR VGND sky130_ef_sc_hd__decap_12
XFILLER_187_721 VGND VGND VPWR VPWR sky130_fd_sc_hd__decap_6
XFILLER_221_349 VPWR VGND VPWR VGND sky130_ef_sc_hd__decap_12
XPHY_EDGE_ROW_1_Left_257 VGND VGND VPWR VPWR sky130_fd_sc_hd__decap_3
X_417_ _160_ _204_ net114 VGND VGND VPWR VPWR _206_ sky130_fd_sc_hd__and3_1
XFILLER_226_1365 VGND VGND VPWR VPWR sky130_fd_sc_hd__decap_6
XFILLER_230_861 VGND VGND VPWR VPWR sky130_fd_sc_hd__decap_6
XFILLER_187_765 VPWR VGND VPWR VGND sky130_ef_sc_hd__decap_12
XTAP_TAPCELL_ROW_177_1656 VGND VPWR sky130_fd_sc_hd__tapvpwrvgnd_1
XFILLER_222_1229 VPWR VGND VPWR VGND sky130_ef_sc_hd__decap_12
XFILLER_186_253 VPWR VGND VPWR VGND sky130_ef_sc_hd__decap_12
X_348_ net593 dout0_q\[15\] net540 VGND VGND VPWR VPWR _137_ sky130_fd_sc_hd__a21oi_1
XFILLER_169_81 VPWR VGND VPWR VGND sky130_ef_sc_hd__decap_12
XTAP_TAPCELL_ROW_177_1667 VGND VPWR sky130_fd_sc_hd__tapvpwrvgnd_1
XFILLER_31_1213 VGND VGND VPWR VPWR sky130_fd_sc_hd__decap_4
XFILLER_70_1295 VGND VGND VPWR VPWR sky130_fd_sc_hd__decap_6
XPHY_EDGE_ROW_116_2_Right_207 VGND VGND VPWR VPWR sky130_fd_sc_hd__decap_3
XFILLER_255_1005 VGND VGND VPWR VPWR sky130_fd_sc_hd__decap_3
XFILLER_196_1453 VPWR VGND VPWR VGND sky130_ef_sc_hd__decap_12
XFILLER_192_1317 VPWR VGND VPWR VGND sky130_ef_sc_hd__decap_12
XFILLER_170_643 VGND VGND VPWR VPWR sky130_fd_sc_hd__fill_1
XFILLER_196_1497 VPWR VGND VPWR VGND sky130_ef_sc_hd__decap_12
XFILLER_255_1049 VPWR VGND VPWR VGND sky130_ef_sc_hd__decap_12
XFILLER_45_3 VPWR VGND VPWR VGND sky130_ef_sc_hd__decap_12
XFILLER_68_1191 VPWR VGND VPWR VGND sky130_ef_sc_hd__decap_12
XFILLER_233_1325 VPWR VGND VPWR VGND sky130_ef_sc_hd__decap_12
XFILLER_229_405 VPWR VGND VPWR VGND sky130_ef_sc_hd__decap_12
XFILLER_233_1369 VPWR VGND VPWR VGND sky130_ef_sc_hd__decap_12
XFILLER_190_1085 VGND VGND VPWR VPWR sky130_fd_sc_hd__decap_6
XFILLER_229_449 VPWR VGND VPWR VGND sky130_ef_sc_hd__decap_12
XFILLER_245_909 VPWR VGND VPWR VGND sky130_ef_sc_hd__decap_12
XTAP_TAPCELL_ROW_38_2_3981 VGND VPWR sky130_fd_sc_hd__tapvpwrvgnd_1
XFILLER_116_1189 VGND VGND VPWR VPWR sky130_fd_sc_hd__fill_1
XPHY_EDGE_ROW_142_1_Right_798 VGND VGND VPWR VPWR sky130_fd_sc_hd__decap_3
XFILLER_238_961 VPWR VGND VPWR VGND sky130_ef_sc_hd__decap_12
XFILLER_244_419 VGND VGND VPWR VPWR sky130_fd_sc_hd__fill_1
XFILLER_204_65 VPWR VGND VPWR VGND sky130_ef_sc_hd__decap_12
XTAP_TAPCELL_ROW_0_826 VGND VPWR sky130_fd_sc_hd__tapvpwrvgnd_1
XFILLER_253_953 VPWR VGND VPWR VGND sky130_ef_sc_hd__decap_12
XTAP_TAPCELL_ROW_0_837 VGND VPWR sky130_fd_sc_hd__tapvpwrvgnd_1
XFILLER_224_121 VPWR VGND VPWR VGND sky130_ef_sc_hd__decap_12
XTAP_TAPCELL_ROW_0_848 VGND VPWR sky130_fd_sc_hd__tapvpwrvgnd_1
XTAP_TAPCELL_ROW_0_859 VGND VPWR sky130_fd_sc_hd__tapvpwrvgnd_1
XFILLER_213_839 VGND VGND VPWR VPWR sky130_fd_sc_hd__fill_1
XFILLER_224_165 VPWR VGND VPWR VGND sky130_ef_sc_hd__decap_12
XFILLER_244_1421 VGND VGND VPWR VPWR sky130_fd_sc_hd__decap_6
XFILLER_240_625 VPWR VGND VPWR VGND sky130_ef_sc_hd__decap_12
XFILLER_197_529 VPWR VGND VPWR VGND sky130_ef_sc_hd__decap_12
XFILLER_220_53 VPWR VGND VPWR VGND sky130_ef_sc_hd__decap_12
XFILLER_240_669 VPWR VGND VPWR VGND sky130_ef_sc_hd__decap_12
XFILLER_244_1465 VPWR VGND VPWR VGND sky130_ef_sc_hd__decap_12
XTAP_TAPCELL_ROW_255_3767 VGND VPWR sky130_fd_sc_hd__tapvpwrvgnd_1
XFILLER_220_97 VPWR VGND VPWR VGND sky130_ef_sc_hd__decap_12
XTAP_TAPCELL_ROW_255_3778 VGND VPWR sky130_fd_sc_hd__tapvpwrvgnd_1
XTAP_TAPCELL_ROW_255_3789 VGND VPWR sky130_fd_sc_hd__tapvpwrvgnd_1
XFILLER_166_905 VPWR VGND VPWR VGND sky130_ef_sc_hd__decap_12
XFILLER_240_1329 VPWR VGND VPWR VGND sky130_ef_sc_hd__decap_12
XFILLER_162_1165 VPWR VGND VPWR VGND sky130_ef_sc_hd__decap_12
XFILLER_205_1449 VGND VGND VPWR VPWR sky130_fd_sc_hd__decap_6
XFILLER_166_949 VPWR VGND VPWR VGND sky130_ef_sc_hd__decap_12
XFILLER_229_51 VGND VGND VPWR VPWR sky130_fd_sc_hd__decap_4
XTAP_TAPCELL_ROW_11_2_3822 VGND VPWR sky130_fd_sc_hd__tapvpwrvgnd_1
XFILLER_140_1463 VGND VGND VPWR VPWR sky130_fd_sc_hd__decap_6
XFILLER_192_245 VGND VGND VPWR VPWR sky130_fd_sc_hd__decap_6
XFILLER_238_1203 VGND VGND VPWR VPWR sky130_fd_sc_hd__fill_1
XFILLER_174_993 VPWR VGND VPWR VGND sky130_ef_sc_hd__decap_12
XFILLER_192_289 VPWR VGND VPWR VGND sky130_ef_sc_hd__decap_12
XFILLER_47_1231 VPWR VGND VPWR VGND sky130_ef_sc_hd__decap_12
XFILLER_58_15 VPWR VGND VPWR VGND sky130_ef_sc_hd__decap_12
XFILLER_0_826 VPWR VGND VPWR VGND sky130_ef_sc_hd__decap_12
XFILLER_251_1425 VPWR VGND VPWR VGND sky130_ef_sc_hd__decap_12
XFILLER_47_1275 VPWR VGND VPWR VGND sky130_ef_sc_hd__decap_12
XFILLER_248_725 VPWR VGND VPWR VGND sky130_ef_sc_hd__decap_12
XFILLER_181_27 VPWR VGND VPWR VGND sky130_ef_sc_hd__decap_12
XTAP_TAPCELL_ROW_208_2501 VGND VPWR sky130_fd_sc_hd__tapvpwrvgnd_1
XFILLER_212_1409 VPWR VGND VPWR VGND sky130_ef_sc_hd__decap_12
XFILLER_82_1177 VPWR VGND VPWR VGND sky130_ef_sc_hd__decap_12
XFILLER_134_1245 VGND VGND VPWR VPWR sky130_fd_sc_hd__fill_1
XTAP_TAPCELL_ROW_208_2512 VGND VPWR sky130_fd_sc_hd__tapvpwrvgnd_1
XFILLER_251_1469 VPWR VGND VPWR VGND sky130_ef_sc_hd__decap_12
XFILLER_248_769 VPWR VGND VPWR VGND sky130_ef_sc_hd__decap_12
XTAP_TAPCELL_ROW_129_2_4530 VGND VPWR sky130_fd_sc_hd__tapvpwrvgnd_1
XFILLER_247_279 VGND VGND VPWR VPWR sky130_fd_sc_hd__fill_1
XFILLER_114_65 VGND VGND VPWR VPWR sky130_fd_sc_hd__decap_6
XFILLER_249_1343 VGND VGND VPWR VPWR sky130_fd_sc_hd__fill_1
XTAP_TAPCELL_ROW_142_2_4608 VGND VPWR sky130_fd_sc_hd__tapvpwrvgnd_1
XFILLER_167_1021 VPWR VGND VPWR VGND sky130_ef_sc_hd__decap_12
XFILLER_243_441 VGND VGND VPWR VPWR sky130_fd_sc_hd__decap_6
XFILLER_167_1065 VPWR VGND VPWR VGND sky130_ef_sc_hd__decap_12
XFILLER_203_305 VPWR VGND VPWR VGND sky130_ef_sc_hd__decap_12
XFILLER_243_485 VPWR VGND VPWR VGND sky130_ef_sc_hd__decap_12
XFILLER_216_699 VGND VGND VPWR VPWR sky130_fd_sc_hd__fill_1
XFILLER_19_1311 VPWR VGND VPWR VGND sky130_ef_sc_hd__decap_12
XFILLER_130_53 VPWR VGND VPWR VGND sky130_ef_sc_hd__decap_12
XFILLER_58_1371 VPWR VGND VPWR VGND sky130_ef_sc_hd__decap_12
XFILLER_169_721 VGND VGND VPWR VPWR sky130_fd_sc_hd__decap_6
XFILLER_247_3 VPWR VGND VPWR VGND sky130_ef_sc_hd__decap_12
XFILLER_203_349 VPWR VGND VPWR VGND sky130_ef_sc_hd__decap_12
XFILLER_93_1273 VGND VGND VPWR VPWR sky130_fd_sc_hd__fill_1
XFILLER_223_1505 VGND VGND VPWR VPWR sky130_fd_sc_hd__decap_6
XFILLER_19_1355 VPWR VGND VPWR VGND sky130_ef_sc_hd__decap_12
XFILLER_106_1303 VPWR VGND VPWR VGND sky130_ef_sc_hd__decap_12
XFILLER_208_1073 VPWR VGND VPWR VGND sky130_ef_sc_hd__decap_12
XFILLER_212_861 VGND VGND VPWR VPWR sky130_fd_sc_hd__decap_6
XPHY_EDGE_ROW_104_1_Right_760 VGND VGND VPWR VPWR sky130_fd_sc_hd__decap_3
XFILLER_169_765 VPWR VGND VPWR VGND sky130_ef_sc_hd__decap_12
XFILLER_15_1219 VPWR VGND VPWR VGND sky130_ef_sc_hd__decap_12
XFILLER_145_1385 VGND VGND VPWR VPWR sky130_fd_sc_hd__fill_1
XFILLER_168_253 VPWR VGND VPWR VGND sky130_ef_sc_hd__decap_12
XFILLER_19_1399 VPWR VGND VPWR VGND sky130_ef_sc_hd__decap_12
Xwire301 net302 VGND VGND VPWR VPWR net301 sky130_fd_sc_hd__clkbuf_1
XFILLER_184_713 VPWR VGND VPWR VGND sky130_ef_sc_hd__decap_12
XFILLER_8_937 VPWR VGND VPWR VGND sky130_ef_sc_hd__decap_12
Xwire312 net313 VGND VGND VPWR VPWR net312 sky130_fd_sc_hd__clkbuf_1
XFILLER_211_393 VPWR VGND VPWR VGND sky130_ef_sc_hd__decap_12
Xwire323 net324 VGND VGND VPWR VPWR net323 sky130_fd_sc_hd__clkbuf_1
XFILLER_183_223 VGND VGND VPWR VPWR sky130_fd_sc_hd__fill_1
Xwire345 net346 VGND VGND VPWR VPWR net345 sky130_fd_sc_hd__clkbuf_1
XFILLER_139_51 VGND VGND VPWR VPWR sky130_fd_sc_hd__decap_4
XFILLER_184_757 VPWR VGND VPWR VGND sky130_ef_sc_hd__decap_12
Xwire356 net357 VGND VGND VPWR VPWR net356 sky130_fd_sc_hd__clkbuf_1
XTAP_TAPCELL_ROW_172_1520 VGND VPWR sky130_fd_sc_hd__tapvpwrvgnd_1
XTAP_TAPCELL_ROW_172_1531 VGND VPWR sky130_fd_sc_hd__tapvpwrvgnd_1
Xwire367 net368 VGND VGND VPWR VPWR net367 sky130_fd_sc_hd__clkbuf_1
XTAP_TAPCELL_ROW_172_1542 VGND VPWR sky130_fd_sc_hd__tapvpwrvgnd_1
Xwire378 net379 VGND VGND VPWR VPWR net378 sky130_fd_sc_hd__clkbuf_1
Xwire389 net390 VGND VGND VPWR VPWR net389 sky130_fd_sc_hd__clkbuf_1
XFILLER_99_55 VGND VGND VPWR VPWR sky130_fd_sc_hd__fill_1
XFILLER_165_993 VPWR VGND VPWR VGND sky130_ef_sc_hd__decap_12
XFILLER_171_429 VPWR VGND VPWR VGND sky130_ef_sc_hd__decap_12
XFILLER_178_1161 VPWR VGND VPWR VGND sky130_ef_sc_hd__decap_12
XPHY_EDGE_ROW_40_2_Right_131 VGND VGND VPWR VPWR sky130_fd_sc_hd__decap_3
XFILLER_65_1331 VPWR VGND VPWR VGND sky130_ef_sc_hd__decap_12
XFILLER_2_141 VPWR VGND VPWR VGND sky130_ef_sc_hd__decap_12
XFILLER_139_1189 VPWR VGND VPWR VGND sky130_ef_sc_hd__decap_12
XFILLER_152_1301 VGND VGND VPWR VPWR sky130_fd_sc_hd__fill_1
XFILLER_26_1315 VPWR VGND VPWR VGND sky130_ef_sc_hd__decap_12
XFILLER_117_1443 VPWR VGND VPWR VGND sky130_ef_sc_hd__decap_12
XFILLER_215_1033 VPWR VGND VPWR VGND sky130_ef_sc_hd__decap_12
XFILLER_254_1093 VPWR VGND VPWR VGND sky130_ef_sc_hd__decap_12
XFILLER_61_1217 VGND VGND VPWR VPWR sky130_fd_sc_hd__fill_1
XFILLER_6_1409 VPWR VGND VPWR VGND sky130_ef_sc_hd__decap_12
XFILLER_230_1509 VGND VGND VPWR VPWR sky130_fd_sc_hd__decap_6
XFILLER_26_1359 VPWR VGND VPWR VGND sky130_ef_sc_hd__decap_12
XFILLER_215_1077 VPWR VGND VPWR VGND sky130_ef_sc_hd__decap_12
XFILLER_227_909 VPWR VGND VPWR VGND sky130_ef_sc_hd__decap_12
XFILLER_113_1329 VGND VGND VPWR VPWR sky130_fd_sc_hd__fill_1
XTAP_TAPCELL_ROW_166_1357 VGND VPWR sky130_fd_sc_hd__tapvpwrvgnd_1
XTAP_TAPCELL_ROW_166_1368 VGND VPWR sky130_fd_sc_hd__tapvpwrvgnd_1
XFILLER_226_419 VGND VGND VPWR VPWR sky130_fd_sc_hd__fill_1
XFILLER_253_205 VPWR VGND VPWR VGND sky130_ef_sc_hd__decap_12
XTAP_TAPCELL_ROW_166_1379 VGND VPWR sky130_fd_sc_hd__tapvpwrvgnd_1
XFILLER_171_93 VPWR VGND VPWR VGND sky130_ef_sc_hd__decap_12
XFILLER_253_249 VPWR VGND VPWR VGND sky130_ef_sc_hd__decap_12
XFILLER_235_953 VPWR VGND VPWR VGND sky130_ef_sc_hd__decap_12
XFILLER_206_121 VPWR VGND VPWR VGND sky130_ef_sc_hd__decap_12
XFILLER_185_1121 VPWR VGND VPWR VGND sky130_ef_sc_hd__decap_12
XFILLER_228_1427 VGND VGND VPWR VPWR sky130_fd_sc_hd__fill_1
XFILLER_250_923 VGND VGND VPWR VPWR sky130_fd_sc_hd__fill_1
XFILLER_206_165 VPWR VGND VPWR VGND sky130_ef_sc_hd__decap_12
XTAP_TAPCELL_ROW_179_1707 VGND VPWR sky130_fd_sc_hd__tapvpwrvgnd_1
XFILLER_222_625 VPWR VGND VPWR VGND sky130_ef_sc_hd__decap_12
XPHY_EDGE_ROW_10_2_Left_512 VGND VGND VPWR VPWR sky130_fd_sc_hd__decap_3
XTAP_TAPCELL_ROW_179_1718 VGND VPWR sky130_fd_sc_hd__tapvpwrvgnd_1
XFILLER_181_1007 VGND VGND VPWR VPWR sky130_fd_sc_hd__fill_1
XFILLER_37_1411 VPWR VGND VPWR VGND sky130_ef_sc_hd__decap_12
XTAP_TAPCELL_ROW_16_2_3848 VGND VPWR sky130_fd_sc_hd__tapvpwrvgnd_1
XFILLER_179_529 VPWR VGND VPWR VGND sky130_ef_sc_hd__decap_12
XFILLER_221_113 VPWR VGND VPWR VGND sky130_ef_sc_hd__decap_12
XTAP_TAPCELL_ROW_179_1729 VGND VPWR sky130_fd_sc_hd__tapvpwrvgnd_1
XFILLER_76_1471 VPWR VGND VPWR VGND sky130_ef_sc_hd__decap_12
XFILLER_222_669 VPWR VGND VPWR VGND sky130_ef_sc_hd__decap_12
XFILLER_163_1441 VGND VGND VPWR VPWR sky130_fd_sc_hd__fill_1
XFILLER_37_1455 VPWR VGND VPWR VGND sky130_ef_sc_hd__decap_12
XFILLER_226_1173 VPWR VGND VPWR VGND sky130_ef_sc_hd__decap_12
XFILLER_9_53 VGND VGND VPWR VPWR sky130_fd_sc_hd__decap_3
XFILLER_72_1357 VGND VGND VPWR VPWR sky130_fd_sc_hd__fill_1
XFILLER_187_573 VPWR VGND VPWR VGND sky130_ef_sc_hd__decap_12
XFILLER_37_1499 VPWR VGND VPWR VGND sky130_ef_sc_hd__decap_12
XFILLER_222_1037 VPWR VGND VPWR VGND sky130_ef_sc_hd__decap_12
XTAP_TAPCELL_ROW_250_3631 VGND VPWR sky130_fd_sc_hd__tapvpwrvgnd_1
XFILLER_9_97 VPWR VGND VPWR VGND sky130_ef_sc_hd__decap_12
XFILLER_124_1469 VGND VGND VPWR VPWR sky130_fd_sc_hd__fill_1
XTAP_TAPCELL_ROW_250_3642 VGND VPWR sky130_fd_sc_hd__tapvpwrvgnd_1
XTAP_TAPCELL_ROW_155_2_4686 VGND VPWR sky130_fd_sc_hd__tapvpwrvgnd_1
XFILLER_174_245 VGND VGND VPWR VPWR sky130_fd_sc_hd__decap_6
Xmax_cap612 rd_addr\[3\] VGND VGND VPWR VPWR net612 sky130_fd_sc_hd__clkbuf_1
XFILLER_174_289 VPWR VGND VPWR VGND sky130_ef_sc_hd__decap_12
XFILLER_157_1201 VPWR VGND VPWR VGND sky130_ef_sc_hd__decap_12
XFILLER_190_749 VGND VGND VPWR VPWR sky130_fd_sc_hd__decap_6
Xmax_cap623 net624 VGND VGND VPWR VPWR net623 sky130_fd_sc_hd__clkbuf_2
XPHY_EDGE_ROW_117_2_Right_208 VGND VGND VPWR VPWR sky130_fd_sc_hd__decap_3
XFILLER_196_1261 VPWR VGND VPWR VGND sky130_ef_sc_hd__decap_12
XTAP_TAPCELL_ROW_135_2_4562 VGND VPWR sky130_fd_sc_hd__tapvpwrvgnd_1
XFILLER_6_491 VGND VGND VPWR VPWR sky130_fd_sc_hd__fill_2
XFILLER_157_1267 VGND VGND VPWR VPWR sky130_fd_sc_hd__decap_6
XFILLER_192_1147 VGND VGND VPWR VPWR sky130_fd_sc_hd__fill_1
XTAP_TAPCELL_ROW_248_3571 VGND VPWR sky130_fd_sc_hd__tapvpwrvgnd_1
XTAP_TAPCELL_ROW_248_3582 VGND VPWR sky130_fd_sc_hd__tapvpwrvgnd_1
XTAP_TAPCELL_ROW_248_3593 VGND VPWR sky130_fd_sc_hd__tapvpwrvgnd_1
XFILLER_44_1415 VPWR VGND VPWR VGND sky130_ef_sc_hd__decap_12
XFILLER_9_1033 VGND VGND VPWR VPWR sky130_fd_sc_hd__decap_3
XFILLER_233_1133 VPWR VGND VPWR VGND sky130_ef_sc_hd__decap_12
XFILLER_83_1497 VGND VGND VPWR VPWR sky130_fd_sc_hd__fill_1
XTAP_TAPCELL_ROW_244_3468 VGND VPWR sky130_fd_sc_hd__tapvpwrvgnd_1
XFILLER_9_1077 VPWR VGND VPWR VGND sky130_ef_sc_hd__decap_12
XTAP_TAPCELL_ROW_244_3479 VGND VPWR sky130_fd_sc_hd__tapvpwrvgnd_1
XFILLER_233_1177 VPWR VGND VPWR VGND sky130_ef_sc_hd__decap_12
XFILLER_28_29 VPWR VGND VPWR VGND sky130_ef_sc_hd__decap_12
XFILLER_229_279 VGND VGND VPWR VPWR sky130_fd_sc_hd__fill_1
XPHY_EDGE_ROW_143_1_Right_799 VGND VGND VPWR VPWR sky130_fd_sc_hd__decap_3
XFILLER_77_1213 VGND VGND VPWR VPWR sky130_fd_sc_hd__decap_4
XFILLER_168_1341 VPWR VGND VPWR VGND sky130_ef_sc_hd__decap_12
XFILLER_225_441 VGND VGND VPWR VPWR sky130_fd_sc_hd__decap_6
XFILLER_198_805 VGND VGND VPWR VPWR sky130_fd_sc_hd__decap_6
XFILLER_253_783 VGND VGND VPWR VPWR sky130_fd_sc_hd__fill_1
XFILLER_168_1385 VPWR VGND VPWR VGND sky130_ef_sc_hd__decap_12
XFILLER_225_485 VPWR VGND VPWR VGND sky130_ef_sc_hd__decap_12
XFILLER_241_945 VGND VGND VPWR VPWR sky130_fd_sc_hd__decap_6
XFILLER_164_1227 VPWR VGND VPWR VGND sky130_ef_sc_hd__decap_12
XFILLER_240_433 VPWR VGND VPWR VGND sky130_ef_sc_hd__decap_12
XFILLER_55_1511 VGND VGND VPWR VPWR sky130_fd_sc_hd__decap_4
XTAP_TAPCELL_ROW_20_1_1155 VGND VPWR sky130_fd_sc_hd__tapvpwrvgnd_1
XFILLER_198_849 VPWR VGND VPWR VGND sky130_ef_sc_hd__decap_12
XFILLER_90_1413 VGND VGND VPWR VPWR sky130_fd_sc_hd__fill_1
XFILLER_197_337 VPWR VGND VPWR VGND sky130_ef_sc_hd__decap_12
XFILLER_201_809 VPWR VGND VPWR VGND sky130_ef_sc_hd__decap_12
XFILLER_241_989 VPWR VGND VPWR VGND sky130_ef_sc_hd__decap_12
XFILLER_240_477 VPWR VGND VPWR VGND sky130_ef_sc_hd__decap_12
XFILLER_205_1213 VPWR VGND VPWR VGND sky130_ef_sc_hd__decap_12
XFILLER_244_1273 VPWR VGND VPWR VGND sky130_ef_sc_hd__decap_12
XFILLER_209_1393 VGND VGND VPWR VPWR sky130_fd_sc_hd__decap_6
XFILLER_166_713 VPWR VGND VPWR VGND sky130_ef_sc_hd__decap_12
XFILLER_205_1257 VPWR VGND VPWR VGND sky130_ef_sc_hd__decap_12
XFILLER_166_757 VPWR VGND VPWR VGND sky130_ef_sc_hd__decap_12
XFILLER_176_27 VGND VGND VPWR VPWR sky130_fd_sc_hd__fill_1
Xclkbuf_3_0__f_clk clknet_0_clk VGND VGND VPWR VPWR clknet_3_0__leaf_clk sky130_fd_sc_hd__clkbuf_16
XFILLER_140_1271 VPWR VGND VPWR VGND sky130_ef_sc_hd__decap_12
XFILLER_181_727 VGND VGND VPWR VPWR sky130_fd_sc_hd__fill_1
XFILLER_175_1301 VPWR VGND VPWR VGND sky130_ef_sc_hd__decap_12
XPHY_EDGE_ROW_19_1_Left_274 VGND VGND VPWR VPWR sky130_fd_sc_hd__decap_3
XFILLER_101_1255 VPWR VGND VPWR VGND sky130_ef_sc_hd__decap_12
XFILLER_179_1481 VPWR VGND VPWR VGND sky130_ef_sc_hd__decap_12
XFILLER_175_1345 VPWR VGND VPWR VGND sky130_ef_sc_hd__decap_12
XFILLER_84_1239 VGND VGND VPWR VPWR sky130_fd_sc_hd__decap_6
XFILLER_101_1299 VPWR VGND VPWR VGND sky130_ef_sc_hd__decap_12
XFILLER_192_15 VPWR VGND VPWR VGND sky130_ef_sc_hd__decap_12
XFILLER_69_69 VGND VGND VPWR VPWR sky130_fd_sc_hd__fill_2
XFILLER_251_1233 VPWR VGND VPWR VGND sky130_ef_sc_hd__decap_12
XFILLER_216_1353 VPWR VGND VPWR VGND sky130_ef_sc_hd__decap_12
XFILLER_248_533 VPWR VGND VPWR VGND sky130_ef_sc_hd__decap_12
XFILLER_212_1217 VPWR VGND VPWR VGND sky130_ef_sc_hd__decap_12
XFILLER_0_678 VGND VGND VPWR VPWR sky130_fd_sc_hd__fill_2
XFILLER_197_3 VPWR VGND VPWR VGND sky130_ef_sc_hd__decap_12
XFILLER_209_909 VPWR VGND VPWR VGND sky130_ef_sc_hd__decap_12
XFILLER_216_1397 VPWR VGND VPWR VGND sky130_ef_sc_hd__decap_12
XFILLER_21_1201 VPWR VGND VPWR VGND sky130_ef_sc_hd__decap_12
XFILLER_85_57 VPWR VGND VPWR VGND sky130_ef_sc_hd__decap_12
XFILLER_208_419 VGND VGND VPWR VPWR sky130_fd_sc_hd__fill_1
XFILLER_235_205 VPWR VGND VPWR VGND sky130_ef_sc_hd__decap_12
XTAP_TAPCELL_ROW_4_962 VGND VPWR sky130_fd_sc_hd__tapvpwrvgnd_1
XTAP_TAPCELL_ROW_4_973 VGND VPWR sky130_fd_sc_hd__tapvpwrvgnd_1
XFILLER_60_1283 VPWR VGND VPWR VGND sky130_ef_sc_hd__decap_12
XFILLER_112_1351 VGND VGND VPWR VPWR sky130_fd_sc_hd__decap_6
XFILLER_235_249 VPWR VGND VPWR VGND sky130_ef_sc_hd__decap_12
XFILLER_251_709 VPWR VGND VPWR VGND sky130_ef_sc_hd__decap_12
XFILLER_217_953 VPWR VGND VPWR VGND sky130_ef_sc_hd__decap_12
XFILLER_21_1267 VGND VGND VPWR VPWR sky130_fd_sc_hd__decap_6
XFILLER_186_1441 VPWR VGND VPWR VGND sky130_ef_sc_hd__decap_12
XFILLER_112_1395 VPWR VGND VPWR VGND sky130_ef_sc_hd__decap_12
XFILLER_232_923 VGND VGND VPWR VPWR sky130_fd_sc_hd__fill_1
XFILLER_204_625 VPWR VGND VPWR VGND sky130_ef_sc_hd__decap_12
XFILLER_186_1485 VPWR VGND VPWR VGND sky130_ef_sc_hd__decap_12
XFILLER_203_113 VPWR VGND VPWR VGND sky130_ef_sc_hd__decap_12
XFILLER_95_1379 VGND VGND VPWR VPWR sky130_fd_sc_hd__decap_6
XFILLER_243_293 VPWR VGND VPWR VGND sky130_ef_sc_hd__decap_12
XFILLER_204_669 VPWR VGND VPWR VGND sky130_ef_sc_hd__decap_12
XFILLER_223_1313 VPWR VGND VPWR VGND sky130_ef_sc_hd__decap_12
XFILLER_227_1493 VPWR VGND VPWR VGND sky130_ef_sc_hd__decap_12
XFILLER_8_701 VPWR VGND VPWR VGND sky130_ef_sc_hd__decap_12
XFILLER_169_573 VPWR VGND VPWR VGND sky130_ef_sc_hd__decap_12
XFILLER_223_1357 VPWR VGND VPWR VGND sky130_ef_sc_hd__decap_12
XPHY_EDGE_ROW_105_1_Right_761 VGND VGND VPWR VPWR sky130_fd_sc_hd__decap_3
XFILLER_180_1073 VPWR VGND VPWR VGND sky130_ef_sc_hd__decap_12
Xwire120 _208_ VGND VGND VPWR VPWR net120 sky130_fd_sc_hd__clkbuf_1
XFILLER_106_1177 VPWR VGND VPWR VGND sky130_ef_sc_hd__decap_12
XPHY_EDGE_ROW_152_1_Left_407 VGND VGND VPWR VPWR sky130_fd_sc_hd__decap_3
Xwire142 net143 VGND VGND VPWR VPWR net142 sky130_fd_sc_hd__clkbuf_1
Xwire153 _174_ VGND VGND VPWR VPWR net153 sky130_fd_sc_hd__clkbuf_1
Xwire164 _143_ VGND VGND VPWR VPWR net164 sky130_fd_sc_hd__clkbuf_1
XFILLER_123_1491 VGND VGND VPWR VPWR sky130_fd_sc_hd__decap_6
XFILLER_184_587 VGND VGND VPWR VPWR sky130_fd_sc_hd__fill_1
XTAP_TAPCELL_ROW_121_2_4481 VGND VPWR sky130_fd_sc_hd__tapvpwrvgnd_1
XFILLER_172_749 VGND VGND VPWR VPWR sky130_fd_sc_hd__decap_6
XFILLER_193_1401 VPWR VGND VPWR VGND sky130_ef_sc_hd__decap_12
XFILLER_171_237 VPWR VGND VPWR VGND sky130_ef_sc_hd__decap_12
XFILLER_4_973 VGND VGND VPWR VPWR sky130_fd_sc_hd__decap_6
XFILLER_154_1407 VGND VGND VPWR VPWR sky130_fd_sc_hd__decap_6
XFILLER_180_793 VPWR VGND VPWR VGND sky130_ef_sc_hd__decap_12
XPHY_EDGE_ROW_41_2_Right_132 VGND VGND VPWR VPWR sky130_fd_sc_hd__decap_3
XTAP_TAPCELL_ROW_168_1408 VGND VPWR sky130_fd_sc_hd__tapvpwrvgnd_1
XTAP_TAPCELL_ROW_168_1419 VGND VPWR sky130_fd_sc_hd__tapvpwrvgnd_1
XFILLER_234_1453 VPWR VGND VPWR VGND sky130_ef_sc_hd__decap_12
XFILLER_252_29 VPWR VGND VPWR VGND sky130_ef_sc_hd__decap_12
XFILLER_6_1217 VPWR VGND VPWR VGND sky130_ef_sc_hd__decap_12
XFILLER_230_1317 VPWR VGND VPWR VGND sky130_ef_sc_hd__decap_12
XFILLER_234_1497 VPWR VGND VPWR VGND sky130_ef_sc_hd__decap_12
XFILLER_117_1273 VGND VGND VPWR VPWR sky130_fd_sc_hd__fill_1
XTAP_TAPCELL_ROW_68_2_4162 VGND VPWR sky130_fd_sc_hd__tapvpwrvgnd_1
XFILLER_26_1189 VGND VGND VPWR VPWR sky130_fd_sc_hd__fill_1
XFILLER_254_525 VGND VGND VPWR VPWR sky130_fd_sc_hd__decap_6
XFILLER_130_1451 VPWR VGND VPWR VGND sky130_ef_sc_hd__decap_12
XFILLER_254_569 VPWR VGND VPWR VGND sky130_ef_sc_hd__decap_12
XFILLER_207_441 VGND VGND VPWR VPWR sky130_fd_sc_hd__decap_6
XFILLER_130_1495 VPWR VGND VPWR VGND sky130_ef_sc_hd__decap_12
XFILLER_235_783 VGND VGND VPWR VPWR sky130_fd_sc_hd__fill_1
XFILLER_207_485 VPWR VGND VPWR VGND sky130_ef_sc_hd__decap_12
XFILLER_223_945 VGND VGND VPWR VPWR sky130_fd_sc_hd__decap_6
XFILLER_222_433 VPWR VGND VPWR VGND sky130_ef_sc_hd__decap_12
XFILLER_179_337 VPWR VGND VPWR VGND sky130_ef_sc_hd__decap_12
XFILLER_201_55 VGND VGND VPWR VPWR sky130_fd_sc_hd__fill_1
XFILLER_223_989 VPWR VGND VPWR VGND sky130_ef_sc_hd__decap_12
XFILLER_241_1413 VPWR VGND VPWR VGND sky130_ef_sc_hd__decap_12
XFILLER_222_477 VPWR VGND VPWR VGND sky130_ef_sc_hd__decap_12
XTAP_TAPCELL_ROW_237_3272 VGND VPWR sky130_fd_sc_hd__tapvpwrvgnd_1
XFILLER_194_307 VGND VGND VPWR VPWR sky130_fd_sc_hd__fill_1
XTAP_TAPCELL_ROW_237_3283 VGND VPWR sky130_fd_sc_hd__tapvpwrvgnd_1
XTAP_TAPCELL_ROW_237_3294 VGND VPWR sky130_fd_sc_hd__tapvpwrvgnd_1
XFILLER_72_1165 VPWR VGND VPWR VGND sky130_ef_sc_hd__decap_12
XFILLER_188_893 VPWR VGND VPWR VGND sky130_ef_sc_hd__decap_12
XFILLER_241_1457 VPWR VGND VPWR VGND sky130_ef_sc_hd__decap_12
XPHY_EDGE_ROW_84_1_Left_339 VGND VGND VPWR VPWR sky130_fd_sc_hd__decap_3
XTAP_TAPCELL_ROW_233_3169 VGND VPWR sky130_fd_sc_hd__tapvpwrvgnd_1
XTAP_TAPCELL_ROW_41_2_4003 VGND VPWR sky130_fd_sc_hd__tapvpwrvgnd_1
XPHY_EDGE_ROW_234_Left_489 VGND VGND VPWR VPWR sky130_fd_sc_hd__decap_3
XFILLER_50_1463 VGND VGND VPWR VPWR sky130_fd_sc_hd__decap_6
XFILLER_190_513 VPWR VGND VPWR VGND sky130_ef_sc_hd__decap_12
XFILLER_159_1329 VGND VGND VPWR VPWR sky130_fd_sc_hd__fill_1
XFILLER_190_557 VPWR VGND VPWR VGND sky130_ef_sc_hd__decap_12
XPHY_EDGE_ROW_118_2_Right_209 VGND VGND VPWR VPWR sky130_fd_sc_hd__decap_3
XFILLER_196_1091 VGND VGND VPWR VPWR sky130_fd_sc_hd__fill_1
XTAP_TAPCELL_ROW_246_3519 VGND VPWR sky130_fd_sc_hd__tapvpwrvgnd_1
XFILLER_226_41 VPWR VGND VPWR VGND sky130_ef_sc_hd__decap_12
Xmax_cap497 _119_ VGND VGND VPWR VPWR net497 sky130_fd_sc_hd__clkbuf_1
XFILLER_226_85 VPWR VGND VPWR VGND sky130_ef_sc_hd__decap_12
XFILLER_39_39 VPWR VGND VPWR VGND sky130_ef_sc_hd__decap_12
XFILLER_162_29 VPWR VGND VPWR VGND sky130_ef_sc_hd__decap_12
XFILLER_44_1245 VGND VGND VPWR VPWR sky130_fd_sc_hd__fill_1
XFILLER_170_1253 VGND VGND VPWR VPWR sky130_fd_sc_hd__decap_6
XFILLER_245_503 VGND VGND VPWR VPWR sky130_fd_sc_hd__fill_1
XPHY_EDGE_ROW_243_Left_498 VGND VGND VPWR VPWR sky130_fd_sc_hd__decap_3
XFILLER_217_205 VPWR VGND VPWR VGND sky130_ef_sc_hd__decap_12
XFILLER_170_1297 VPWR VGND VPWR VGND sky130_ef_sc_hd__decap_12
XPHY_EDGE_ROW_2_Right_2 VGND VGND VPWR VPWR sky130_fd_sc_hd__decap_3
XFILLER_55_27 VPWR VGND VPWR VGND sky130_ef_sc_hd__decap_12
XFILLER_217_249 VPWR VGND VPWR VGND sky130_ef_sc_hd__decap_12
XFILLER_233_709 VPWR VGND VPWR VGND sky130_ef_sc_hd__decap_12
XFILLER_214_923 VGND VGND VPWR VPWR sky130_fd_sc_hd__fill_1
XTAP_TAPCELL_ROW_222_2873 VGND VPWR sky130_fd_sc_hd__tapvpwrvgnd_1
XFILLER_198_613 VPWR VGND VPWR VGND sky130_ef_sc_hd__decap_12
XTAP_TAPCELL_ROW_222_2884 VGND VPWR sky130_fd_sc_hd__tapvpwrvgnd_1
XFILLER_225_293 VPWR VGND VPWR VGND sky130_ef_sc_hd__decap_12
XFILLER_241_753 VPWR VGND VPWR VGND sky130_ef_sc_hd__decap_12
XFILLER_111_55 VGND VGND VPWR VPWR sky130_fd_sc_hd__fill_1
XFILLER_71_15 VPWR VGND VPWR VGND sky130_ef_sc_hd__decap_12
XFILLER_198_657 VPWR VGND VPWR VGND sky130_ef_sc_hd__decap_12
XFILLER_129_1177 VPWR VGND VPWR VGND sky130_ef_sc_hd__decap_12
XFILLER_201_617 VPWR VGND VPWR VGND sky130_ef_sc_hd__decap_12
XFILLER_241_797 VPWR VGND VPWR VGND sky130_ef_sc_hd__decap_12
XFILLER_16_1303 VPWR VGND VPWR VGND sky130_ef_sc_hd__decap_12
XFILLER_187_15 VPWR VGND VPWR VGND sky130_ef_sc_hd__decap_12
XFILLER_197_167 VGND VGND VPWR VPWR sky130_fd_sc_hd__fill_1
XFILLER_205_1021 VPWR VGND VPWR VGND sky130_ef_sc_hd__decap_12
XFILLER_185_329 VGND VGND VPWR VPWR sky130_fd_sc_hd__decap_6
XFILLER_55_1385 VGND VGND VPWR VPWR sky130_fd_sc_hd__fill_1
XFILLER_181_1393 VGND VGND VPWR VPWR sky130_fd_sc_hd__decap_6
XFILLER_205_1065 VPWR VGND VPWR VGND sky130_ef_sc_hd__decap_12
XFILLER_107_1497 VGND VGND VPWR VPWR sky130_fd_sc_hd__fill_1
XFILLER_166_587 VGND VGND VPWR VPWR sky130_fd_sc_hd__fill_1
XFILLER_193_373 VPWR VGND VPWR VGND sky130_ef_sc_hd__decap_12
XFILLER_112_3 VPWR VGND VPWR VGND sky130_ef_sc_hd__decap_12
XFILLER_20_41 VPWR VGND VPWR VGND sky130_ef_sc_hd__decap_12
XFILLER_136_41 VPWR VGND VPWR VGND sky130_ef_sc_hd__decap_12
XFILLER_175_1175 VGND VGND VPWR VPWR sky130_fd_sc_hd__fill_1
XFILLER_49_1189 VPWR VGND VPWR VGND sky130_ef_sc_hd__decap_12
XFILLER_62_1301 VGND VGND VPWR VPWR sky130_fd_sc_hd__fill_1
XFILLER_1_965 VPWR VGND VPWR VGND sky130_ef_sc_hd__decap_12
XFILLER_27_1443 VPWR VGND VPWR VGND sky130_ef_sc_hd__decap_12
XFILLER_249_853 VPWR VGND VPWR VGND sky130_ef_sc_hd__decap_12
XFILLER_216_1161 VPWR VGND VPWR VGND sky130_ef_sc_hd__decap_12
XTAP_TAPCELL_ROW_54_2_4081 VGND VPWR sky130_fd_sc_hd__tapvpwrvgnd_1
XFILLER_114_1413 VGND VGND VPWR VPWR sky130_fd_sc_hd__fill_1
XFILLER_251_1063 VGND VGND VPWR VPWR sky130_fd_sc_hd__fill_1
XFILLER_248_363 VGND VGND VPWR VPWR sky130_fd_sc_hd__fill_1
XFILLER_23_1329 VGND VGND VPWR VPWR sky130_fd_sc_hd__fill_1
XFILLER_249_897 VPWR VGND VPWR VGND sky130_ef_sc_hd__decap_12
XFILLER_236_525 VGND VGND VPWR VPWR sky130_fd_sc_hd__decap_6
XFILLER_236_569 VPWR VGND VPWR VGND sky130_ef_sc_hd__decap_12
X_665_ clknet_3_5__leaf_clk acc_core.adder.cla_blocks\[7\].block.sum\[3\] _073_ VGND
+ VGND VPWR VPWR net67 sky130_fd_sc_hd__dfrtp_1
XFILLER_229_1511 VGND VGND VPWR VPWR sky130_fd_sc_hd__fill_1
XFILLER_251_517 VPWR VGND VPWR VGND sky130_ef_sc_hd__decap_12
XFILLER_217_783 VGND VGND VPWR VPWR sky130_fd_sc_hd__fill_1
XFILLER_45_60 VGND VGND VPWR VPWR sky130_fd_sc_hd__decap_8
XFILLER_1_1169 VGND VGND VPWR VPWR sky130_fd_sc_hd__decap_6
XFILLER_205_945 VGND VGND VPWR VPWR sky130_fd_sc_hd__decap_6
X_596_ clknet_3_2__leaf_clk _078_ _004_ VGND VGND VPWR VPWR rd_addr\[4\] sky130_fd_sc_hd__dfrtp_1
XFILLER_95_1165 VPWR VGND VPWR VGND sky130_ef_sc_hd__decap_12
XFILLER_204_433 VPWR VGND VPWR VGND sky130_ef_sc_hd__decap_12
XTAP_TAPCELL_ROW_46_2_4029 VGND VPWR sky130_fd_sc_hd__tapvpwrvgnd_1
XFILLER_147_1255 VPWR VGND VPWR VGND sky130_ef_sc_hd__decap_12
XFILLER_205_989 VPWR VGND VPWR VGND sky130_ef_sc_hd__decap_12
XFILLER_204_477 VPWR VGND VPWR VGND sky130_ef_sc_hd__decap_12
XFILLER_73_1441 VGND VGND VPWR VPWR sky130_fd_sc_hd__fill_1
XFILLER_108_1239 VGND VGND VPWR VPWR sky130_fd_sc_hd__decap_6
XFILLER_220_937 VPWR VGND VPWR VGND sky130_ef_sc_hd__decap_12
XFILLER_176_307 VGND VGND VPWR VPWR sky130_fd_sc_hd__fill_1
XFILLER_147_1299 VPWR VGND VPWR VGND sky130_ef_sc_hd__decap_12
XFILLER_223_1121 VPWR VGND VPWR VGND sky130_ef_sc_hd__decap_12
XFILLER_188_189 VGND VGND VPWR VPWR sky130_fd_sc_hd__decap_6
XFILLER_185_841 VPWR VGND VPWR VGND sky130_ef_sc_hd__decap_12
XFILLER_61_70 VGND VGND VPWR VPWR sky130_fd_sc_hd__fill_1
XFILLER_34_1469 VGND VGND VPWR VPWR sky130_fd_sc_hd__fill_1
XPHY_EDGE_ROW_106_1_Right_762 VGND VGND VPWR VPWR sky130_fd_sc_hd__decap_3
XFILLER_172_513 VPWR VGND VPWR VGND sky130_ef_sc_hd__decap_12
XFILLER_177_81 VPWR VGND VPWR VGND sky130_ef_sc_hd__decap_12
XANTENNA_3 dout0\[4\] VGND VGND VPWR VPWR sky130_fd_sc_hd__diode_2
XFILLER_67_1201 VPWR VGND VPWR VGND sky130_ef_sc_hd__decap_12
XFILLER_172_557 VPWR VGND VPWR VGND sky130_ef_sc_hd__decap_12
XFILLER_6_65 VPWR VGND VPWR VGND sky130_ef_sc_hd__decap_12
XFILLER_158_1351 VGND VGND VPWR VPWR sky130_fd_sc_hd__decap_6
XFILLER_193_1231 VGND VGND VPWR VPWR sky130_fd_sc_hd__fill_1
XFILLER_154_1215 VPWR VGND VPWR VGND sky130_ef_sc_hd__decap_12
XFILLER_67_1267 VGND VGND VPWR VPWR sky130_fd_sc_hd__decap_6
XFILLER_158_1395 VPWR VGND VPWR VGND sky130_ef_sc_hd__decap_12
XFILLER_154_1259 VPWR VGND VPWR VGND sky130_ef_sc_hd__decap_12
XPHY_EDGE_ROW_42_2_Right_133 VGND VGND VPWR VPWR sky130_fd_sc_hd__decap_3
XFILLER_119_1379 VGND VGND VPWR VPWR sky130_fd_sc_hd__decap_6
XFILLER_234_1261 VPWR VGND VPWR VGND sky130_ef_sc_hd__decap_12
XTAP_TAPCELL_ROW_241_3405 VGND VPWR sky130_fd_sc_hd__tapvpwrvgnd_1
XFILLER_227_503 VGND VGND VPWR VPWR sky130_fd_sc_hd__fill_1
XFILLER_230_1147 VGND VGND VPWR VPWR sky130_fd_sc_hd__fill_1
XFILLER_239_385 VGND VGND VPWR VPWR sky130_fd_sc_hd__decap_6
XTAP_TAPCELL_ROW_7_1042 VGND VPWR sky130_fd_sc_hd__tapvpwrvgnd_1
XFILLER_254_333 VPWR VGND VPWR VGND sky130_ef_sc_hd__decap_12
XTAP_TAPCELL_ROW_7_1053 VGND VPWR sky130_fd_sc_hd__tapvpwrvgnd_1
XTAP_TAPCELL_ROW_7_1064 VGND VPWR sky130_fd_sc_hd__tapvpwrvgnd_1
XTAP_TAPCELL_ROW_143_2_4613 VGND VPWR sky130_fd_sc_hd__tapvpwrvgnd_1
XFILLER_215_709 VPWR VGND VPWR VGND sky130_ef_sc_hd__decap_12
XFILLER_187_1057 VGND VGND VPWR VPWR sky130_fd_sc_hd__decap_6
XFILLER_254_377 VPWR VGND VPWR VGND sky130_ef_sc_hd__decap_12
XFILLER_212_65 VPWR VGND VPWR VGND sky130_ef_sc_hd__decap_12
XTAP_TAPCELL_ROW_239_3334 VGND VPWR sky130_fd_sc_hd__tapvpwrvgnd_1
XTAP_TAPCELL_ROW_239_3345 VGND VPWR sky130_fd_sc_hd__tapvpwrvgnd_1
XFILLER_207_293 VPWR VGND VPWR VGND sky130_ef_sc_hd__decap_12
XFILLER_74_1227 VPWR VGND VPWR VGND sky130_ef_sc_hd__decap_12
XFILLER_223_753 VPWR VGND VPWR VGND sky130_ef_sc_hd__decap_12
XFILLER_126_1339 VPWR VGND VPWR VGND sky130_ef_sc_hd__decap_12
XFILLER_161_1219 VPWR VGND VPWR VGND sky130_ef_sc_hd__decap_12
XFILLER_223_797 VPWR VGND VPWR VGND sky130_ef_sc_hd__decap_12
XFILLER_179_167 VGND VGND VPWR VPWR sky130_fd_sc_hd__fill_1
XFILLER_206_1341 VPWR VGND VPWR VGND sky130_ef_sc_hd__decap_12
XFILLER_167_329 VGND VGND VPWR VPWR sky130_fd_sc_hd__decap_6
XTAP_TAPCELL_ROW_91_2_4300 VGND VPWR sky130_fd_sc_hd__tapvpwrvgnd_1
XFILLER_202_1205 VPWR VGND VPWR VGND sky130_ef_sc_hd__decap_12
XFILLER_210_469 VGND VGND VPWR VPWR sky130_fd_sc_hd__decap_6
XFILLER_206_1385 VPWR VGND VPWR VGND sky130_ef_sc_hd__decap_12
XFILLER_241_1287 VGND VGND VPWR VPWR sky130_fd_sc_hd__fill_1
XFILLER_175_373 VPWR VGND VPWR VGND sky130_ef_sc_hd__decap_12
XTAP_TAPCELL_ROW_15_1_1150 VGND VPWR sky130_fd_sc_hd__tapvpwrvgnd_1
XFILLER_191_833 VGND VGND VPWR VPWR sky130_fd_sc_hd__decap_6
XFILLER_50_1271 VPWR VGND VPWR VGND sky130_ef_sc_hd__decap_12
XFILLER_190_321 VPWR VGND VPWR VGND sky130_ef_sc_hd__decap_12
XFILLER_194_1017 VPWR VGND VPWR VGND sky130_ef_sc_hd__decap_12
XFILLER_237_51 VGND VGND VPWR VPWR sky130_fd_sc_hd__decap_4
XFILLER_198_1197 VGND VGND VPWR VPWR sky130_fd_sc_hd__decap_6
XFILLER_11_1255 VPWR VGND VPWR VGND sky130_ef_sc_hd__decap_12
XFILLER_191_877 VPWR VGND VPWR VGND sky130_ef_sc_hd__decap_12
XFILLER_85_1323 VGND VGND VPWR VPWR sky130_fd_sc_hd__decap_6
XFILLER_102_1383 VPWR VGND VPWR VGND sky130_ef_sc_hd__decap_12
XFILLER_190_365 VPWR VGND VPWR VGND sky130_ef_sc_hd__decap_12
XFILLER_11_1299 VPWR VGND VPWR VGND sky130_ef_sc_hd__decap_12
XFILLER_85_1367 VPWR VGND VPWR VGND sky130_ef_sc_hd__decap_12
XFILLER_172_1315 VGND VGND VPWR VPWR sky130_fd_sc_hd__fill_1
XTAP_TAPCELL_ROW_211_2574 VGND VPWR sky130_fd_sc_hd__tapvpwrvgnd_1
XFILLER_137_1435 VGND VGND VPWR VPWR sky130_fd_sc_hd__decap_6
XFILLER_173_39 VPWR VGND VPWR VGND sky130_ef_sc_hd__decap_12
XTAP_TAPCELL_ROW_211_2585 VGND VPWR sky130_fd_sc_hd__tapvpwrvgnd_1
XFILLER_249_105 VGND VGND VPWR VPWR sky130_fd_sc_hd__decap_6
XFILLER_137_1479 VPWR VGND VPWR VGND sky130_ef_sc_hd__decap_12
XFILLER_213_1301 VPWR VGND VPWR VGND sky130_ef_sc_hd__decap_12
XPHY_EDGE_ROW_251_Left_506 VGND VGND VPWR VPWR sky130_fd_sc_hd__decap_3
XFILLER_249_149 VPWR VGND VPWR VGND sky130_ef_sc_hd__decap_12
XFILLER_217_1481 VPWR VGND VPWR VGND sky130_ef_sc_hd__decap_12
XFILLER_66_26 VGND VGND VPWR VPWR sky130_fd_sc_hd__fill_2
XFILLER_170_1061 VPWR VGND VPWR VGND sky130_ef_sc_hd__decap_12
XFILLER_213_1345 VPWR VGND VPWR VGND sky130_ef_sc_hd__decap_12
XFILLER_218_525 VGND VGND VPWR VPWR sky130_fd_sc_hd__decap_6
XTAP_TAPCELL_ROW_224_2924 VGND VPWR sky130_fd_sc_hd__tapvpwrvgnd_1
XTAP_TAPCELL_ROW_37_2_3977 VGND VPWR sky130_fd_sc_hd__tapvpwrvgnd_1
XTAP_TAPCELL_ROW_224_2935 VGND VPWR sky130_fd_sc_hd__tapvpwrvgnd_1
XTAP_TAPCELL_ROW_224_2946 VGND VPWR sky130_fd_sc_hd__tapvpwrvgnd_1
XFILLER_246_867 VGND VGND VPWR VPWR sky130_fd_sc_hd__fill_1
XFILLER_22_1351 VGND VGND VPWR VPWR sky130_fd_sc_hd__decap_6
XFILLER_218_569 VPWR VGND VPWR VGND sky130_ef_sc_hd__decap_12
XFILLER_233_517 VPWR VGND VPWR VGND sky130_ef_sc_hd__decap_12
XFILLER_22_1395 VPWR VGND VPWR VGND sky130_ef_sc_hd__decap_12
XFILLER_122_65 VGND VGND VPWR VPWR sky130_fd_sc_hd__decap_6
X_450_ _237_ _238_ VGND VGND VPWR VPWR acc_core.adder.cla_blocks\[7\].block.sum\[1\]
+ sky130_fd_sc_hd__nand2_1
XFILLER_96_1463 VGND VGND VPWR VPWR sky130_fd_sc_hd__decap_6
XFILLER_199_933 VPWR VGND VPWR VGND sky130_ef_sc_hd__decap_12
XFILLER_198_421 VPWR VGND VPWR VGND sky130_ef_sc_hd__decap_12
XFILLER_92_1327 VPWR VGND VPWR VGND sky130_ef_sc_hd__decap_12
XFILLER_183_1455 VGND VGND VPWR VPWR sky130_fd_sc_hd__fill_1
XFILLER_241_561 VPWR VGND VPWR VGND sky130_ef_sc_hd__decap_12
XFILLER_15_30 VPWR VGND VPWR VGND sky130_ef_sc_hd__decap_12
X_381_ _167_ _168_ VGND VGND VPWR VPWR _170_ sky130_fd_sc_hd__or2_1
XFILLER_199_977 VPWR VGND VPWR VGND sky130_ef_sc_hd__decap_12
XFILLER_202_937 VPWR VGND VPWR VGND sky130_ef_sc_hd__decap_12
XFILLER_242_1029 VGND VGND VPWR VPWR sky130_fd_sc_hd__decap_6
XFILLER_144_1439 VPWR VGND VPWR VGND sky130_ef_sc_hd__decap_12
XFILLER_9_306 VGND VGND VPWR VPWR sky130_fd_sc_hd__fill_2
XFILLER_224_1441 VPWR VGND VPWR VGND sky130_ef_sc_hd__decap_12
XFILLER_201_447 VGND VGND VPWR VPWR sky130_fd_sc_hd__fill_1
XFILLER_167_841 VPWR VGND VPWR VGND sky130_ef_sc_hd__decap_12
XFILLER_185_137 VPWR VGND VPWR VGND sky130_ef_sc_hd__decap_12
XTAP_TAPCELL_ROW_156_2_4691 VGND VPWR sky130_fd_sc_hd__tapvpwrvgnd_1
XFILLER_224_1485 VPWR VGND VPWR VGND sky130_ef_sc_hd__decap_12
XFILLER_210_981 VPWR VGND VPWR VGND sky130_ef_sc_hd__decap_12
XFILLER_16_1177 VPWR VGND VPWR VGND sky130_ef_sc_hd__decap_12
XFILLER_182_811 VGND VGND VPWR VPWR sky130_fd_sc_hd__fill_1
XFILLER_194_693 VGND VGND VPWR VPWR sky130_fd_sc_hd__decap_6
XFILLER_33_1491 VGND VGND VPWR VPWR sky130_fd_sc_hd__decap_6
XFILLER_193_181 VPWR VGND VPWR VGND sky130_ef_sc_hd__decap_12
XFILLER_147_51 VGND VGND VPWR VPWR sky130_fd_sc_hd__decap_4
XFILLER_120_1483 VPWR VGND VPWR VGND sky130_ef_sc_hd__decap_12
XFILLER_64_1407 VGND VGND VPWR VPWR sky130_fd_sc_hd__decap_6
Xoutput51 net538 VGND VGND VPWR VPWR acc_out[17] sky130_fd_sc_hd__buf_2
Xoutput62 net62 VGND VGND VPWR VPWR acc_out[27] sky130_fd_sc_hd__buf_2
Xoutput73 net73 VGND VGND VPWR VPWR acc_out[8] sky130_fd_sc_hd__buf_2
XFILLER_253_1169 VGND VGND VPWR VPWR sky130_fd_sc_hd__decap_6
XFILLER_7_1301 VPWR VGND VPWR VGND sky130_ef_sc_hd__decap_12
XFILLER_231_1401 VPWR VGND VPWR VGND sky130_ef_sc_hd__decap_12
XFILLER_27_1273 VGND VGND VPWR VPWR sky130_fd_sc_hd__fill_1
XFILLER_7_1345 VPWR VGND VPWR VGND sky130_ef_sc_hd__decap_12
XFILLER_209_503 VGND VGND VPWR VPWR sky130_fd_sc_hd__fill_1
XTAP_TAPCELL_ROW_186_1894 VGND VPWR sky130_fd_sc_hd__tapvpwrvgnd_1
XFILLER_236_333 VPWR VGND VPWR VGND sky130_ef_sc_hd__decap_12
XFILLER_40_1451 VPWR VGND VPWR VGND sky130_ef_sc_hd__decap_12
XFILLER_237_889 VGND VGND VPWR VPWR sky130_fd_sc_hd__decap_6
XFILLER_236_377 VPWR VGND VPWR VGND sky130_ef_sc_hd__decap_12
XFILLER_252_837 VPWR VGND VPWR VGND sky130_ef_sc_hd__decap_12
XFILLER_40_1495 VPWR VGND VPWR VGND sky130_ef_sc_hd__decap_12
X_648_ clknet_3_6__leaf_clk acc_core.adder.cla_blocks\[3\].block.sum\[2\] _056_ VGND
+ VGND VPWR VPWR net48 sky130_fd_sc_hd__dfrtp_1
XTAP_TAPCELL_ROW_108_2_4402 VGND VPWR sky130_fd_sc_hd__tapvpwrvgnd_1
XFILLER_205_753 VPWR VGND VPWR VGND sky130_ef_sc_hd__decap_12
XFILLER_220_701 VPWR VGND VPWR VGND sky130_ef_sc_hd__decap_12
X_579_ net668 VGND VGND VPWR VPWR _061_ sky130_fd_sc_hd__inv_2
XFILLER_205_797 VPWR VGND VPWR VGND sky130_ef_sc_hd__decap_12
XTAP_TAPCELL_ROW_76_2_4213 VGND VPWR sky130_fd_sc_hd__tapvpwrvgnd_1
XTAP_TAPCELL_ROW_230_3106 VGND VPWR sky130_fd_sc_hd__tapvpwrvgnd_1
XFILLER_75_3 VPWR VGND VPWR VGND sky130_ef_sc_hd__decap_12
XFILLER_8_350 VPWR VGND VPWR VGND sky130_ef_sc_hd__decap_12
XFILLER_185_671 VGND VGND VPWR VPWR sky130_fd_sc_hd__fill_1
XPHY_EDGE_ROW_107_1_Right_763 VGND VGND VPWR VPWR sky130_fd_sc_hd__decap_3
XFILLER_173_833 VGND VGND VPWR VPWR sky130_fd_sc_hd__decap_6
XFILLER_172_321 VPWR VGND VPWR VGND sky130_ef_sc_hd__decap_12
XFILLER_69_1329 VGND VGND VPWR VPWR sky130_fd_sc_hd__fill_1
XFILLER_195_1337 VGND VGND VPWR VPWR sky130_fd_sc_hd__decap_6
XFILLER_173_877 VPWR VGND VPWR VGND sky130_ef_sc_hd__decap_12
XFILLER_219_1009 VPWR VGND VPWR VGND sky130_ef_sc_hd__decap_12
XFILLER_172_365 VPWR VGND VPWR VGND sky130_ef_sc_hd__decap_12
XFILLER_82_1507 VGND VGND VPWR VPWR sky130_fd_sc_hd__decap_8
XTAP_TAPCELL_ROW_228_3035 VGND VPWR sky130_fd_sc_hd__tapvpwrvgnd_1
XTAP_TAPCELL_ROW_228_3046 VGND VPWR sky130_fd_sc_hd__tapvpwrvgnd_1
XFILLER_119_1165 VPWR VGND VPWR VGND sky130_ef_sc_hd__decap_12
XTAP_TAPCELL_ROW_9_1104 VGND VPWR sky130_fd_sc_hd__tapvpwrvgnd_1
XFILLER_247_609 VGND VGND VPWR VPWR sky130_fd_sc_hd__decap_6
XTAP_TAPCELL_ROW_9_1115 VGND VPWR sky130_fd_sc_hd__tapvpwrvgnd_1
XTAP_TAPCELL_ROW_9_1126 VGND VPWR sky130_fd_sc_hd__tapvpwrvgnd_1
XPHY_EDGE_ROW_43_2_Right_134 VGND VGND VPWR VPWR sky130_fd_sc_hd__decap_3
XTAP_TAPCELL_ROW_9_1137 VGND VPWR sky130_fd_sc_hd__tapvpwrvgnd_1
XFILLER_234_1091 VGND VGND VPWR VPWR sky130_fd_sc_hd__fill_1
XFILLER_171_1381 VPWR VGND VPWR VGND sky130_ef_sc_hd__decap_12
XFILLER_189_1119 VGND VGND VPWR VPWR sky130_fd_sc_hd__fill_1
XFILLER_239_193 VPWR VGND VPWR VGND sky130_ef_sc_hd__decap_12
XFILLER_228_867 VGND VGND VPWR VPWR sky130_fd_sc_hd__fill_1
XFILLER_254_141 VPWR VGND VPWR VGND sky130_ef_sc_hd__decap_12
XFILLER_36_29 VPWR VGND VPWR VGND sky130_ef_sc_hd__decap_12
XFILLER_215_517 VPWR VGND VPWR VGND sky130_ef_sc_hd__decap_12
XFILLER_255_697 VGND VGND VPWR VPWR sky130_fd_sc_hd__decap_3
XPHY_EDGE_ROW_28_1_Left_283 VGND VGND VPWR VPWR sky130_fd_sc_hd__decap_3
XFILLER_223_561 VPWR VGND VPWR VGND sky130_ef_sc_hd__decap_12
XFILLER_196_925 VPWR VGND VPWR VGND sky130_ef_sc_hd__decap_12
XTAP_TAPCELL_ROW_200_2275 VGND VPWR sky130_fd_sc_hd__tapvpwrvgnd_1
XTAP_TAPCELL_ROW_200_2286 VGND VPWR sky130_fd_sc_hd__tapvpwrvgnd_1
XTAP_TAPCELL_ROW_196_2190 VGND VPWR sky130_fd_sc_hd__tapvpwrvgnd_1
XTAP_TAPCELL_ROW_200_2297 VGND VPWR sky130_fd_sc_hd__tapvpwrvgnd_1
XFILLER_210_233 VPWR VGND VPWR VGND sky130_ef_sc_hd__decap_12
XFILLER_167_137 VPWR VGND VPWR VGND sky130_ef_sc_hd__decap_12
XTAP_TAPCELL_ROW_192_2065 VGND VPWR sky130_fd_sc_hd__tapvpwrvgnd_1
XFILLER_210_277 VPWR VGND VPWR VGND sky130_ef_sc_hd__decap_12
XTAP_TAPCELL_ROW_192_2076 VGND VPWR sky130_fd_sc_hd__tapvpwrvgnd_1
XTAP_TAPCELL_ROW_217_2750 VGND VPWR sky130_fd_sc_hd__tapvpwrvgnd_1
XFILLER_17_1497 VGND VGND VPWR VPWR sky130_fd_sc_hd__fill_1
XFILLER_6_309 VGND VGND VPWR VPWR sky130_fd_sc_hd__decap_6
XFILLER_202_1035 VGND VGND VPWR VPWR sky130_fd_sc_hd__fill_1
XFILLER_176_693 VGND VGND VPWR VPWR sky130_fd_sc_hd__decap_6
XFILLER_248_83 VGND VGND VPWR VPWR sky130_fd_sc_hd__fill_1
XFILLER_175_181 VPWR VGND VPWR VGND sky130_ef_sc_hd__decap_12
XTAP_TAPCELL_ROW_213_2625 VGND VPWR sky130_fd_sc_hd__tapvpwrvgnd_1
XFILLER_191_641 VPWR VGND VPWR VGND sky130_ef_sc_hd__decap_12
XTAP_TAPCELL_ROW_213_2636 VGND VPWR sky130_fd_sc_hd__tapvpwrvgnd_1
XTAP_TAPCELL_ROW_213_2647 VGND VPWR sky130_fd_sc_hd__tapvpwrvgnd_1
XFILLER_184_27 VGND VGND VPWR VPWR sky130_fd_sc_hd__fill_1
XFILLER_191_685 VPWR VGND VPWR VGND sky130_ef_sc_hd__decap_12
XFILLER_2_515 VGND VGND VPWR VPWR sky130_fd_sc_hd__fill_2
XFILLER_102_1191 VPWR VGND VPWR VGND sky130_ef_sc_hd__decap_12
XTAP_TAPCELL_ROW_123_1_1258 VGND VPWR sky130_fd_sc_hd__tapvpwrvgnd_1
Xsram0_677 VGND VGND VPWR VPWR sram0_677/HI net677 sky130_fd_sc_hd__conb_1
XTAP_TAPCELL_ROW_134_2_4558 VGND VPWR sky130_fd_sc_hd__tapvpwrvgnd_1
XFILLER_7_6 VPWR VGND VPWR VGND sky130_ef_sc_hd__decap_12
XTAP_TAPCELL_ROW_89_2_4291 VGND VPWR sky130_fd_sc_hd__tapvpwrvgnd_1
XFILLER_190_195 VGND VGND VPWR VPWR sky130_fd_sc_hd__fill_1
XFILLER_137_1243 VPWR VGND VPWR VGND sky130_ef_sc_hd__decap_12
XFILLER_250_1309 VGND VGND VPWR VPWR sky130_fd_sc_hd__decap_6
XFILLER_137_1287 VPWR VGND VPWR VGND sky130_ef_sc_hd__decap_12
XFILLER_24_1413 VGND VGND VPWR VPWR sky130_fd_sc_hd__fill_1
XFILLER_77_69 VGND VGND VPWR VPWR sky130_fd_sc_hd__fill_2
XFILLER_213_1175 VGND VGND VPWR VPWR sky130_fd_sc_hd__fill_1
XFILLER_218_333 VPWR VGND VPWR VGND sky130_ef_sc_hd__decap_12
XFILLER_248_1205 VPWR VGND VPWR VGND sky130_ef_sc_hd__decap_12
XFILLER_219_889 VGND VGND VPWR VPWR sky130_fd_sc_hd__decap_6
XTAP_TAPCELL_ROW_82_2_4245 VGND VPWR sky130_fd_sc_hd__tapvpwrvgnd_1
XPHY_EDGE_ROW_161_1_Left_416 VGND VGND VPWR VPWR sky130_fd_sc_hd__decap_3
XFILLER_218_377 VPWR VGND VPWR VGND sky130_ef_sc_hd__decap_12
XFILLER_234_837 VPWR VGND VPWR VGND sky130_ef_sc_hd__decap_12
XFILLER_93_57 VPWR VGND VPWR VGND sky130_ef_sc_hd__decap_12
XFILLER_2_1253 VGND VGND VPWR VPWR sky130_fd_sc_hd__decap_6
X_502_ net505 net138 _256_ VGND VGND VPWR VPWR _257_ sky130_fd_sc_hd__or3_1
XTAP_TAPCELL_ROW_181_1780 VGND VPWR sky130_fd_sc_hd__tapvpwrvgnd_1
XFILLER_96_1271 VPWR VGND VPWR VGND sky130_ef_sc_hd__decap_12
XFILLER_199_741 VPWR VGND VPWR VGND sky130_ef_sc_hd__decap_12
XFILLER_2_1297 VPWR VGND VPWR VGND sky130_ef_sc_hd__decap_12
X_433_ net597 net534 dout0_q\[21\] VGND VGND VPWR VPWR _222_ sky130_fd_sc_hd__and3_1
XFILLER_202_701 VPWR VGND VPWR VGND sky130_ef_sc_hd__decap_12
XFILLER_242_881 VPWR VGND VPWR VGND sky130_ef_sc_hd__decap_12
XFILLER_57_1255 VPWR VGND VPWR VGND sky130_ef_sc_hd__decap_12
XFILLER_109_1323 VGND VGND VPWR VPWR sky130_fd_sc_hd__decap_6
XFILLER_144_1203 VPWR VGND VPWR VGND sky130_ef_sc_hd__decap_12
XFILLER_148_1383 VPWR VGND VPWR VGND sky130_ef_sc_hd__decap_12
XFILLER_198_251 VGND VGND VPWR VPWR sky130_fd_sc_hd__fill_1
XFILLER_199_785 VPWR VGND VPWR VGND sky130_ef_sc_hd__decap_12
XFILLER_186_413 VGND VGND VPWR VPWR sky130_fd_sc_hd__decap_6
XFILLER_241_391 VGND VGND VPWR VPWR sky130_fd_sc_hd__fill_1
XFILLER_18_1239 VGND VGND VPWR VPWR sky130_fd_sc_hd__decap_6
X_364_ net248 _152_ VGND VGND VPWR VPWR _153_ sky130_fd_sc_hd__nand2b_1
XFILLER_57_1299 VPWR VGND VPWR VGND sky130_ef_sc_hd__decap_12
XFILLER_109_1367 VPWR VGND VPWR VGND sky130_ef_sc_hd__decap_12
XFILLER_144_1247 VPWR VGND VPWR VGND sky130_ef_sc_hd__decap_12
XFILLER_9_125 VPWR VGND VPWR VGND sky130_ef_sc_hd__decap_12
XFILLER_186_457 VPWR VGND VPWR VGND sky130_ef_sc_hd__decap_12
X_295_ net612 net521 VGND VGND VPWR VPWR _077_ sky130_fd_sc_hd__xor2_1
XFILLER_9_147 VGND VGND VPWR VPWR sky130_fd_sc_hd__fill_1
XFILLER_9_169 VPWR VGND VPWR VGND sky130_ef_sc_hd__decap_12
XFILLER_167_671 VGND VGND VPWR VPWR sky130_fd_sc_hd__fill_1
XFILLER_177_1001 VGND VGND VPWR VPWR sky130_fd_sc_hd__decap_6
XFILLER_5_320 VGND VGND VPWR VPWR sky130_fd_sc_hd__decap_8
XFILLER_5_331 VGND VGND VPWR VPWR sky130_fd_sc_hd__fill_2
XFILLER_177_1045 VPWR VGND VPWR VGND sky130_ef_sc_hd__decap_12
XFILLER_170_825 VPWR VGND VPWR VGND sky130_ef_sc_hd__decap_12
XFILLER_68_1351 VGND VGND VPWR VPWR sky130_fd_sc_hd__decap_6
XFILLER_177_1089 VPWR VGND VPWR VGND sky130_ef_sc_hd__decap_12
XFILLER_170_869 VPWR VGND VPWR VGND sky130_ef_sc_hd__decap_12
XFILLER_64_1215 VPWR VGND VPWR VGND sky130_ef_sc_hd__decap_12
XFILLER_68_1395 VPWR VGND VPWR VGND sky130_ef_sc_hd__decap_12
XFILLER_155_1343 VPWR VGND VPWR VGND sky130_ef_sc_hd__decap_12
XFILLER_9_1429 VPWR VGND VPWR VGND sky130_ef_sc_hd__decap_12
XTAP_TAPCELL_ROW_188_1956 VGND VPWR sky130_fd_sc_hd__tapvpwrvgnd_1
XFILLER_64_1259 VPWR VGND VPWR VGND sky130_ef_sc_hd__decap_12
XFILLER_29_1379 VGND VGND VPWR VPWR sky130_fd_sc_hd__decap_6
XFILLER_116_1327 VPWR VGND VPWR VGND sky130_ef_sc_hd__decap_12
XTAP_TAPCELL_ROW_188_1967 VGND VPWR sky130_fd_sc_hd__tapvpwrvgnd_1
XFILLER_229_609 VGND VGND VPWR VPWR sky130_fd_sc_hd__decap_6
XFILLER_155_1387 VPWR VGND VPWR VGND sky130_ef_sc_hd__decap_12
XFILLER_3_55 VGND VGND VPWR VPWR sky130_fd_sc_hd__fill_1
XFILLER_231_1231 VGND VGND VPWR VPWR sky130_fd_sc_hd__fill_1
XFILLER_7_1175 VGND VGND VPWR VPWR sky130_fd_sc_hd__fill_1
XPHY_EDGE_ROW_93_1_Left_348 VGND VGND VPWR VPWR sky130_fd_sc_hd__decap_3
XFILLER_237_653 VPWR VGND VPWR VGND sky130_ef_sc_hd__decap_12
XFILLER_236_141 VPWR VGND VPWR VGND sky130_ef_sc_hd__decap_12
XFILLER_252_601 VPWR VGND VPWR VGND sky130_ef_sc_hd__decap_12
XFILLER_188_1141 VGND VGND VPWR VPWR sky130_fd_sc_hd__decap_6
XFILLER_237_697 VPWR VGND VPWR VGND sky130_ef_sc_hd__decap_12
XFILLER_184_1005 VPWR VGND VPWR VGND sky130_ef_sc_hd__decap_12
XFILLER_251_111 VGND VGND VPWR VPWR sky130_fd_sc_hd__fill_1
XFILLER_252_645 VPWR VGND VPWR VGND sky130_ef_sc_hd__decap_12
XFILLER_188_1185 VPWR VGND VPWR VGND sky130_ef_sc_hd__decap_12
XFILLER_75_1311 VPWR VGND VPWR VGND sky130_ef_sc_hd__decap_12
XFILLER_79_1491 VGND VGND VPWR VPWR sky130_fd_sc_hd__decap_6
XFILLER_184_1049 VPWR VGND VPWR VGND sky130_ef_sc_hd__decap_12
XFILLER_205_561 VPWR VGND VPWR VGND sky130_ef_sc_hd__decap_12
XFILLER_75_1355 VPWR VGND VPWR VGND sky130_ef_sc_hd__decap_12
XFILLER_127_1423 VPWR VGND VPWR VGND sky130_ef_sc_hd__decap_12
XFILLER_162_1303 VPWR VGND VPWR VGND sky130_ef_sc_hd__decap_12
XFILLER_166_1483 VGND VGND VPWR VPWR sky130_fd_sc_hd__fill_1
XFILLER_178_925 VPWR VGND VPWR VGND sky130_ef_sc_hd__decap_12
XFILLER_36_1339 VPWR VGND VPWR VGND sky130_ef_sc_hd__decap_12
XFILLER_71_1219 VPWR VGND VPWR VGND sky130_ef_sc_hd__decap_12
XFILLER_189_273 VGND VGND VPWR VPWR sky130_fd_sc_hd__decap_6
XFILLER_220_531 VGND VGND VPWR VPWR sky130_fd_sc_hd__fill_1
XFILLER_225_1057 VGND VGND VPWR VPWR sky130_fd_sc_hd__decap_6
XFILLER_75_1399 VPWR VGND VPWR VGND sky130_ef_sc_hd__decap_12
XFILLER_127_1467 VPWR VGND VPWR VGND sky130_ef_sc_hd__decap_12
XFILLER_242_1371 VGND VGND VPWR VPWR sky130_fd_sc_hd__fill_1
XFILLER_195_1101 VPWR VGND VPWR VGND sky130_ef_sc_hd__decap_12
XFILLER_173_641 VPWR VGND VPWR VGND sky130_ef_sc_hd__decap_12
XFILLER_199_1281 VGND VGND VPWR VPWR sky130_fd_sc_hd__decap_6
XFILLER_203_1399 VGND VGND VPWR VPWR sky130_fd_sc_hd__fill_1
XPHY_EDGE_ROW_108_1_Right_764 VGND VGND VPWR VPWR sky130_fd_sc_hd__decap_3
XFILLER_238_1429 VPWR VGND VPWR VGND sky130_ef_sc_hd__decap_12
XTAP_TAPCELL_ROW_120_2_4477 VGND VPWR sky130_fd_sc_hd__tapvpwrvgnd_1
XFILLER_195_1145 VPWR VGND VPWR VGND sky130_ef_sc_hd__decap_12
XFILLER_218_53 VPWR VGND VPWR VGND sky130_ef_sc_hd__decap_12
XFILLER_173_685 VPWR VGND VPWR VGND sky130_ef_sc_hd__decap_12
XFILLER_12_1383 VPWR VGND VPWR VGND sky130_ef_sc_hd__decap_12
XFILLER_86_1451 VPWR VGND VPWR VGND sky130_ef_sc_hd__decap_12
XFILLER_191_1009 VPWR VGND VPWR VGND sky130_ef_sc_hd__decap_12
XFILLER_195_1189 VPWR VGND VPWR VGND sky130_ef_sc_hd__decap_12
XFILLER_172_195 VGND VGND VPWR VPWR sky130_fd_sc_hd__fill_1
XFILLER_218_97 VPWR VGND VPWR VGND sky130_ef_sc_hd__decap_12
XFILLER_47_1435 VGND VGND VPWR VPWR sky130_fd_sc_hd__decap_6
XFILLER_82_1315 VPWR VGND VPWR VGND sky130_ef_sc_hd__decap_12
XFILLER_86_1495 VPWR VGND VPWR VGND sky130_ef_sc_hd__decap_12
XFILLER_82_1359 VPWR VGND VPWR VGND sky130_ef_sc_hd__decap_12
XFILLER_232_1017 VPWR VGND VPWR VGND sky130_ef_sc_hd__decap_12
XFILLER_236_1197 VGND VGND VPWR VPWR sky130_fd_sc_hd__decap_6
XFILLER_47_1479 VPWR VGND VPWR VGND sky130_ef_sc_hd__decap_12
XTAP_TAPCELL_ROW_100_2_4353 VGND VPWR sky130_fd_sc_hd__tapvpwrvgnd_1
XFILLER_134_1427 VPWR VGND VPWR VGND sky130_ef_sc_hd__decap_12
XFILLER_234_41 VPWR VGND VPWR VGND sky130_ef_sc_hd__decap_12
XPHY_EDGE_ROW_184_Left_439 VGND VGND VPWR VPWR sky130_fd_sc_hd__decap_3
XFILLER_247_417 VPWR VGND VPWR VGND sky130_ef_sc_hd__decap_12
XFILLER_234_85 VPWR VGND VPWR VGND sky130_ef_sc_hd__decap_12
XFILLER_47_39 VPWR VGND VPWR VGND sky130_ef_sc_hd__decap_12
XFILLER_45_1192 VPWR VGND VPWR VGND sky130_ef_sc_hd__decap_12
XPHY_EDGE_ROW_44_2_Right_135 VGND VGND VPWR VPWR sky130_fd_sc_hd__decap_3
XFILLER_210_1315 VGND VGND VPWR VPWR sky130_fd_sc_hd__fill_1
XFILLER_170_29 VPWR VGND VPWR VGND sky130_ef_sc_hd__decap_12
XTAP_TAPCELL_ROW_67_2_4158 VGND VPWR sky130_fd_sc_hd__tapvpwrvgnd_1
XTAP_TAPCELL_ROW_206_2440 VGND VPWR sky130_fd_sc_hd__tapvpwrvgnd_1
XTAP_TAPCELL_ROW_206_2451 VGND VPWR sky130_fd_sc_hd__tapvpwrvgnd_1
XFILLER_255_461 VPWR VGND VPWR VGND sky130_ef_sc_hd__decap_12
XFILLER_216_837 VPWR VGND VPWR VGND sky130_ef_sc_hd__decap_12
XFILLER_167_1225 VGND VGND VPWR VPWR sky130_fd_sc_hd__decap_6
XTAP_TAPCELL_ROW_202_2326 VGND VPWR sky130_fd_sc_hd__tapvpwrvgnd_1
XTAP_TAPCELL_ROW_202_2337 VGND VPWR sky130_fd_sc_hd__tapvpwrvgnd_1
XFILLER_242_133 VGND VGND VPWR VPWR sky130_fd_sc_hd__decap_6
XTAP_TAPCELL_ROW_198_2230 VGND VPWR sky130_fd_sc_hd__tapvpwrvgnd_1
XTAP_TAPCELL_ROW_202_2348 VGND VPWR sky130_fd_sc_hd__tapvpwrvgnd_1
XFILLER_63_27 VPWR VGND VPWR VGND sky130_ef_sc_hd__decap_12
XFILLER_93_1411 VPWR VGND VPWR VGND sky130_ef_sc_hd__decap_12
XFILLER_110_1471 VPWR VGND VPWR VGND sky130_ef_sc_hd__decap_12
XTAP_TAPCELL_ROW_198_2241 VGND VPWR sky130_fd_sc_hd__tapvpwrvgnd_1
XFILLER_167_1269 VPWR VGND VPWR VGND sky130_ef_sc_hd__decap_12
XTAP_TAPCELL_ROW_47_2_4034 VGND VPWR sky130_fd_sc_hd__tapvpwrvgnd_1
XFILLER_243_1113 VGND VGND VPWR VPWR sky130_fd_sc_hd__decap_6
XFILLER_242_177 VPWR VGND VPWR VGND sky130_ef_sc_hd__decap_12
XFILLER_179_27 VPWR VGND VPWR VGND sky130_ef_sc_hd__decap_12
XFILLER_224_881 VPWR VGND VPWR VGND sky130_ef_sc_hd__decap_12
XFILLER_93_1455 VPWR VGND VPWR VGND sky130_ef_sc_hd__decap_12
XTAP_TAPCELL_ROW_194_2116 VGND VPWR sky130_fd_sc_hd__tapvpwrvgnd_1
XTAP_TAPCELL_ROW_194_2127 VGND VPWR sky130_fd_sc_hd__tapvpwrvgnd_1
XTAP_TAPCELL_ROW_219_2801 VGND VPWR sky130_fd_sc_hd__tapvpwrvgnd_1
XFILLER_168_413 VGND VGND VPWR VPWR sky130_fd_sc_hd__decap_6
XFILLER_54_1439 VPWR VGND VPWR VGND sky130_ef_sc_hd__decap_12
XFILLER_106_1507 VGND VGND VPWR VPWR sky130_fd_sc_hd__decap_8
XPHY_EDGE_ROW_193_Left_448 VGND VGND VPWR VPWR sky130_fd_sc_hd__decap_3
XFILLER_223_391 VGND VGND VPWR VPWR sky130_fd_sc_hd__fill_1
XFILLER_243_1157 VPWR VGND VPWR VGND sky130_ef_sc_hd__decap_12
XFILLER_93_1499 VPWR VGND VPWR VGND sky130_ef_sc_hd__decap_12
XFILLER_211_553 VGND VGND VPWR VPWR sky130_fd_sc_hd__decap_6
XFILLER_196_755 VGND VGND VPWR VPWR sky130_fd_sc_hd__fill_1
XFILLER_168_457 VPWR VGND VPWR VGND sky130_ef_sc_hd__decap_12
XFILLER_184_917 VGND VGND VPWR VPWR sky130_fd_sc_hd__decap_6
XFILLER_183_405 VPWR VGND VPWR VGND sky130_ef_sc_hd__decap_12
Xwire516 _091_ VGND VGND VPWR VPWR net516 sky130_fd_sc_hd__clkbuf_1
XFILLER_211_597 VPWR VGND VPWR VGND sky130_ef_sc_hd__decap_12
XFILLER_195_15 VPWR VGND VPWR VGND sky130_ef_sc_hd__decap_12
XFILLER_221_1455 VGND VGND VPWR VPWR sky130_fd_sc_hd__fill_1
XFILLER_183_449 VPWR VGND VPWR VGND sky130_ef_sc_hd__decap_12
XFILLER_12_53 VPWR VGND VPWR VGND sky130_ef_sc_hd__decap_12
XFILLER_6_139 VGND VGND VPWR VPWR sky130_fd_sc_hd__fill_1
XFILLER_192_961 VPWR VGND VPWR VGND sky130_ef_sc_hd__decap_12
XTAP_TAPCELL_ROW_25_2_3904 VGND VPWR sky130_fd_sc_hd__tapvpwrvgnd_1
XFILLER_128_53 VPWR VGND VPWR VGND sky130_ef_sc_hd__decap_12
XFILLER_178_1365 VGND VGND VPWR VPWR sky130_fd_sc_hd__decap_6
XFILLER_30_1483 VPWR VGND VPWR VGND sky130_ef_sc_hd__decap_12
XFILLER_174_1229 VPWR VGND VPWR VGND sky130_ef_sc_hd__decap_12
XTAP_TAPCELL_ROW_170_1470 VGND VPWR sky130_fd_sc_hd__tapvpwrvgnd_1
XTAP_TAPCELL_ROW_170_1481 VGND VPWR sky130_fd_sc_hd__tapvpwrvgnd_1
XFILLER_254_1253 VGND VGND VPWR VPWR sky130_fd_sc_hd__decap_6
XFILLER_250_1117 VPWR VGND VPWR VGND sky130_ef_sc_hd__decap_12
XFILLER_254_1297 VPWR VGND VPWR VGND sky130_ef_sc_hd__decap_12
XFILLER_144_41 VPWR VGND VPWR VGND sky130_ef_sc_hd__decap_12
Xfanout671 net672 VGND VGND VPWR VPWR net671 sky130_fd_sc_hd__buf_4
XTAP_TAPCELL_ROW_183_1820 VGND VPWR sky130_fd_sc_hd__tapvpwrvgnd_1
XFILLER_247_951 VGND VGND VPWR VPWR sky130_fd_sc_hd__fill_1
XFILLER_4_1315 VGND VGND VPWR VPWR sky130_fd_sc_hd__fill_1
XTAP_TAPCELL_ROW_183_1831 VGND VPWR sky130_fd_sc_hd__tapvpwrvgnd_1
XFILLER_219_653 VPWR VGND VPWR VGND sky130_ef_sc_hd__decap_12
XFILLER_111_1213 VGND VGND VPWR VPWR sky130_fd_sc_hd__decap_4
XFILLER_218_141 VPWR VGND VPWR VGND sky130_ef_sc_hd__decap_12
XFILLER_234_601 VPWR VGND VPWR VGND sky130_ef_sc_hd__decap_12
XFILLER_150_1295 VGND VGND VPWR VPWR sky130_fd_sc_hd__decap_6
XFILLER_219_697 VPWR VGND VPWR VGND sky130_ef_sc_hd__decap_12
XFILLER_248_1035 VGND VGND VPWR VPWR sky130_fd_sc_hd__fill_1
XFILLER_185_1325 VPWR VGND VPWR VGND sky130_ef_sc_hd__decap_12
XFILLER_233_111 VGND VGND VPWR VPWR sky130_fd_sc_hd__fill_1
XFILLER_234_645 VPWR VGND VPWR VGND sky130_ef_sc_hd__decap_12
XFILLER_2_1061 VPWR VGND VPWR VGND sky130_ef_sc_hd__decap_12
XFILLER_185_1369 VPWR VGND VPWR VGND sky130_ef_sc_hd__decap_12
XFILLER_221_317 VPWR VGND VPWR VGND sky130_ef_sc_hd__decap_12
X_416_ net124 net129 net122 net156 _163_ VGND VGND VPWR VPWR _205_ sky130_fd_sc_hd__a311o_1
XFILLER_148_1191 VPWR VGND VPWR VGND sky130_ef_sc_hd__decap_12
XFILLER_202_531 VGND VGND VPWR VPWR sky130_fd_sc_hd__fill_1
XFILLER_186_221 VPWR VGND VPWR VGND sky130_ef_sc_hd__decap_12
XTAP_TAPCELL_ROW_177_1657 VGND VPWR sky130_fd_sc_hd__tapvpwrvgnd_1
XFILLER_187_777 VGND VGND VPWR VPWR sky130_fd_sc_hd__decap_6
X_347_ net593 dout0_q\[15\] net540 VGND VGND VPWR VPWR _136_ sky130_fd_sc_hd__and3_1
XTAP_TAPCELL_ROW_177_1668 VGND VPWR sky130_fd_sc_hd__tapvpwrvgnd_1
XFILLER_186_265 VPWR VGND VPWR VGND sky130_ef_sc_hd__decap_12
XFILLER_169_93 VPWR VGND VPWR VGND sky130_ef_sc_hd__decap_12
XFILLER_196_1421 VGND VGND VPWR VPWR sky130_fd_sc_hd__decap_6
XFILLER_255_29 VPWR VGND VPWR VGND sky130_ef_sc_hd__decap_12
XFILLER_196_1465 VPWR VGND VPWR VGND sky130_ef_sc_hd__decap_12
XFILLER_5_161 VGND VGND VPWR VPWR sky130_fd_sc_hd__decap_3
XFILLER_185_81 VPWR VGND VPWR VGND sky130_ef_sc_hd__decap_12
XFILLER_5_172 VPWR VGND VPWR VGND sky130_ef_sc_hd__decap_12
XFILLER_192_1329 VPWR VGND VPWR VGND sky130_ef_sc_hd__decap_12
XFILLER_170_699 VGND VGND VPWR VPWR sky130_fd_sc_hd__fill_1
XFILLER_38_3 VPWR VGND VPWR VGND sky130_ef_sc_hd__decap_12
XFILLER_29_1165 VPWR VGND VPWR VGND sky130_ef_sc_hd__decap_12
XFILLER_233_1337 VGND VGND VPWR VPWR sky130_fd_sc_hd__decap_6
XFILLER_2_890 VPWR VGND VPWR VGND sky130_ef_sc_hd__decap_12
XFILLER_229_417 VPWR VGND VPWR VGND sky130_ef_sc_hd__decap_12
XTAP_TAPCELL_ROW_38_2_3982 VGND VPWR sky130_fd_sc_hd__tapvpwrvgnd_1
XFILLER_238_973 VGND VGND VPWR VPWR sky130_fd_sc_hd__decap_6
XFILLER_237_461 VPWR VGND VPWR VGND sky130_ef_sc_hd__decap_12
XFILLER_253_921 VPWR VGND VPWR VGND sky130_ef_sc_hd__decap_12
XFILLER_204_77 VGND VGND VPWR VPWR sky130_fd_sc_hd__decap_6
XTAP_TAPCELL_ROW_0_827 VGND VPWR sky130_fd_sc_hd__tapvpwrvgnd_1
XTAP_TAPCELL_ROW_0_838 VGND VPWR sky130_fd_sc_hd__tapvpwrvgnd_1
XFILLER_253_965 VPWR VGND VPWR VGND sky130_ef_sc_hd__decap_12
XTAP_TAPCELL_ROW_0_849 VGND VPWR sky130_fd_sc_hd__tapvpwrvgnd_1
XFILLER_224_133 VGND VGND VPWR VPWR sky130_fd_sc_hd__decap_6
XFILLER_227_1119 VGND VGND VPWR VPWR sky130_fd_sc_hd__fill_1
XFILLER_252_475 VGND VGND VPWR VPWR sky130_fd_sc_hd__fill_1
XFILLER_224_177 VPWR VGND VPWR VGND sky130_ef_sc_hd__decap_12
XFILLER_240_637 VGND VGND VPWR VPWR sky130_fd_sc_hd__decap_6
XFILLER_206_881 VPWR VGND VPWR VGND sky130_ef_sc_hd__decap_12
XFILLER_220_65 VPWR VGND VPWR VGND sky130_ef_sc_hd__decap_12
XFILLER_127_1231 VPWR VGND VPWR VGND sky130_ef_sc_hd__decap_12
XTAP_TAPCELL_ROW_255_3757 VGND VPWR sky130_fd_sc_hd__tapvpwrvgnd_1
XFILLER_205_391 VGND VGND VPWR VPWR sky130_fd_sc_hd__fill_1
XTAP_TAPCELL_ROW_255_3768 VGND VPWR sky130_fd_sc_hd__tapvpwrvgnd_1
XTAP_TAPCELL_ROW_255_3779 VGND VPWR sky130_fd_sc_hd__tapvpwrvgnd_1
XFILLER_244_1477 VGND VGND VPWR VPWR sky130_fd_sc_hd__decap_6
XFILLER_178_755 VGND VGND VPWR VPWR sky130_fd_sc_hd__fill_1
XFILLER_127_1275 VPWR VGND VPWR VGND sky130_ef_sc_hd__decap_12
XFILLER_166_917 VGND VGND VPWR VPWR sky130_fd_sc_hd__decap_6
XFILLER_162_1177 VPWR VGND VPWR VGND sky130_ef_sc_hd__decap_12
XFILLER_165_405 VPWR VGND VPWR VGND sky130_ef_sc_hd__decap_12
XFILLER_221_895 VGND VGND VPWR VPWR sky130_fd_sc_hd__fill_1
XFILLER_165_449 VPWR VGND VPWR VGND sky130_ef_sc_hd__decap_12
XTAP_TAPCELL_ROW_11_2_3823 VGND VPWR sky130_fd_sc_hd__tapvpwrvgnd_1
XFILLER_181_909 VPWR VGND VPWR VGND sky130_ef_sc_hd__decap_12
XFILLER_174_961 VPWR VGND VPWR VGND sky130_ef_sc_hd__decap_12
XFILLER_180_419 VGND VGND VPWR VPWR sky130_fd_sc_hd__fill_1
XFILLER_175_1505 VGND VGND VPWR VPWR sky130_fd_sc_hd__decap_6
XFILLER_165_29 VPWR VGND VPWR VGND sky130_ef_sc_hd__decap_12
XPHY_EDGE_ROW_109_1_Right_765 VGND VGND VPWR VPWR sky130_fd_sc_hd__decap_3
XFILLER_238_1259 VGND VGND VPWR VPWR sky130_fd_sc_hd__fill_1
XFILLER_12_1191 VPWR VGND VPWR VGND sky130_ef_sc_hd__decap_12
XFILLER_245_51 VGND VGND VPWR VPWR sky130_fd_sc_hd__decap_4
XFILLER_0_805 VGND VGND VPWR VPWR sky130_fd_sc_hd__decap_4
XFILLER_47_1243 VPWR VGND VPWR VGND sky130_ef_sc_hd__decap_12
XFILLER_58_27 VGND VGND VPWR VPWR sky130_fd_sc_hd__fill_1
XFILLER_138_1371 VPWR VGND VPWR VGND sky130_ef_sc_hd__decap_12
XFILLER_0_838 VGND VGND VPWR VPWR sky130_fd_sc_hd__fill_2
XFILLER_251_1437 VPWR VGND VPWR VGND sky130_ef_sc_hd__decap_12
XFILLER_0_849 VGND VGND VPWR VPWR sky130_fd_sc_hd__fill_2
XFILLER_47_1287 VPWR VGND VPWR VGND sky130_ef_sc_hd__decap_12
XTAP_TAPCELL_ROW_208_2502 VGND VPWR sky130_fd_sc_hd__tapvpwrvgnd_1
XFILLER_248_737 VPWR VGND VPWR VGND sky130_ef_sc_hd__decap_12
XTAP_TAPCELL_ROW_208_2513 VGND VPWR sky130_fd_sc_hd__tapvpwrvgnd_1
XFILLER_181_39 VPWR VGND VPWR VGND sky130_ef_sc_hd__decap_12
XFILLER_247_225 VPWR VGND VPWR VGND sky130_ef_sc_hd__decap_12
XFILLER_82_1189 VGND VGND VPWR VPWR sky130_fd_sc_hd__fill_1
XTAP_TAPCELL_ROW_129_2_4531 VGND VPWR sky130_fd_sc_hd__tapvpwrvgnd_1
XFILLER_229_951 VGND VGND VPWR VPWR sky130_fd_sc_hd__fill_1
XTAP_TAPCELL_ROW_118_1_1253 VGND VPWR sky130_fd_sc_hd__tapvpwrvgnd_1
XFILLER_216_601 VPWR VGND VPWR VGND sky130_ef_sc_hd__decap_12
XPHY_EDGE_ROW_45_2_Right_136 VGND VGND VPWR VPWR sky130_fd_sc_hd__decap_3
XFILLER_74_15 VPWR VGND VPWR VGND sky130_ef_sc_hd__decap_12
XPHY_EDGE_ROW_39_2_Left_541 VGND VGND VPWR VPWR sky130_fd_sc_hd__decap_3
XFILLER_215_111 VGND VGND VPWR VPWR sky130_fd_sc_hd__fill_1
XTAP_TAPCELL_ROW_142_2_4609 VGND VPWR sky130_fd_sc_hd__tapvpwrvgnd_1
XFILLER_216_645 VPWR VGND VPWR VGND sky130_ef_sc_hd__decap_12
XFILLER_167_1033 VPWR VGND VPWR VGND sky130_ef_sc_hd__decap_12
XFILLER_3_1381 VPWR VGND VPWR VGND sky130_ef_sc_hd__decap_12
XFILLER_182_1509 VGND VGND VPWR VPWR sky130_fd_sc_hd__decap_6
XFILLER_231_615 VGND VGND VPWR VPWR sky130_fd_sc_hd__fill_1
XFILLER_249_1399 VGND VGND VPWR VPWR sky130_fd_sc_hd__fill_1
XFILLER_167_1077 VPWR VGND VPWR VGND sky130_ef_sc_hd__decap_12
XFILLER_203_317 VPWR VGND VPWR VGND sky130_ef_sc_hd__decap_12
XFILLER_243_497 VGND VGND VPWR VPWR sky130_fd_sc_hd__decap_6
XFILLER_54_1203 VPWR VGND VPWR VGND sky130_ef_sc_hd__decap_12
XFILLER_19_1323 VGND VGND VPWR VPWR sky130_fd_sc_hd__decap_6
XFILLER_130_65 VGND VGND VPWR VPWR sky130_fd_sc_hd__decap_6
XFILLER_58_1383 VPWR VGND VPWR VGND sky130_ef_sc_hd__decap_12
XFILLER_145_1331 VPWR VGND VPWR VGND sky130_ef_sc_hd__decap_12
XFILLER_142_3 VPWR VGND VPWR VGND sky130_ef_sc_hd__decap_12
XFILLER_168_221 VPWR VGND VPWR VGND sky130_ef_sc_hd__decap_12
XFILLER_54_1247 VPWR VGND VPWR VGND sky130_ef_sc_hd__decap_12
XFILLER_19_1367 VPWR VGND VPWR VGND sky130_ef_sc_hd__decap_12
XFILLER_106_1315 VPWR VGND VPWR VGND sky130_ef_sc_hd__decap_12
XFILLER_208_1085 VGND VGND VPWR VPWR sky130_fd_sc_hd__decap_6
XFILLER_8_905 VPWR VGND VPWR VGND sky130_ef_sc_hd__decap_12
XFILLER_141_1217 VGND VGND VPWR VPWR sky130_fd_sc_hd__fill_1
XFILLER_169_777 VGND VGND VPWR VPWR sky130_fd_sc_hd__decap_6
XFILLER_211_361 VPWR VGND VPWR VGND sky130_ef_sc_hd__decap_12
Xwire302 net303 VGND VGND VPWR VPWR net302 sky130_fd_sc_hd__clkbuf_1
XFILLER_168_265 VPWR VGND VPWR VGND sky130_ef_sc_hd__decap_12
Xwire313 net314 VGND VGND VPWR VPWR net313 sky130_fd_sc_hd__clkbuf_1
XFILLER_106_1359 VPWR VGND VPWR VGND sky130_ef_sc_hd__decap_12
XFILLER_184_725 VPWR VGND VPWR VGND sky130_ef_sc_hd__decap_12
Xwire324 net325 VGND VGND VPWR VPWR net324 sky130_fd_sc_hd__clkbuf_1
XFILLER_8_949 VPWR VGND VPWR VGND sky130_ef_sc_hd__decap_12
Xwire346 net347 VGND VGND VPWR VPWR net346 sky130_fd_sc_hd__clkbuf_1
XFILLER_184_769 VPWR VGND VPWR VGND sky130_ef_sc_hd__decap_12
Xwire357 net358 VGND VGND VPWR VPWR net357 sky130_fd_sc_hd__clkbuf_1
XTAP_TAPCELL_ROW_172_1521 VGND VPWR sky130_fd_sc_hd__tapvpwrvgnd_1
Xwire368 net369 VGND VGND VPWR VPWR net368 sky130_fd_sc_hd__clkbuf_1
XTAP_TAPCELL_ROW_172_1532 VGND VPWR sky130_fd_sc_hd__tapvpwrvgnd_1
Xwire379 net380 VGND VGND VPWR VPWR net379 sky130_fd_sc_hd__clkbuf_1
XFILLER_183_279 VGND VGND VPWR VPWR sky130_fd_sc_hd__fill_1
XFILLER_178_1173 VPWR VGND VPWR VGND sky130_ef_sc_hd__decap_12
XFILLER_174_1037 VPWR VGND VPWR VGND sky130_ef_sc_hd__decap_12
XFILLER_155_51 VGND VGND VPWR VPWR sky130_fd_sc_hd__decap_4
XFILLER_65_1343 VPWR VGND VPWR VGND sky130_ef_sc_hd__decap_12
XFILLER_2_153 VPWR VGND VPWR VGND sky130_ef_sc_hd__decap_12
XFILLER_3_676 VGND VGND VPWR VPWR sky130_fd_sc_hd__fill_1
XFILLER_117_1411 VPWR VGND VPWR VGND sky130_ef_sc_hd__decap_12
XFILLER_215_1001 VGND VGND VPWR VPWR sky130_fd_sc_hd__decap_6
XFILLER_254_1061 VPWR VGND VPWR VGND sky130_ef_sc_hd__decap_12
XFILLER_156_1471 VPWR VGND VPWR VGND sky130_ef_sc_hd__decap_12
XFILLER_26_1327 VPWR VGND VPWR VGND sky130_ef_sc_hd__decap_12
XFILLER_65_1387 VPWR VGND VPWR VGND sky130_ef_sc_hd__decap_12
XFILLER_2_197 VPWR VGND VPWR VGND sky130_ef_sc_hd__decap_12
XPHY_EDGE_ROW_105_1_Left_360 VGND VGND VPWR VPWR sky130_fd_sc_hd__decap_3
XFILLER_117_1455 VPWR VGND VPWR VGND sky130_ef_sc_hd__decap_12
XFILLER_215_1045 VPWR VGND VPWR VGND sky130_ef_sc_hd__decap_12
XFILLER_152_1357 VGND VGND VPWR VPWR sky130_fd_sc_hd__fill_1
XFILLER_117_1499 VPWR VGND VPWR VGND sky130_ef_sc_hd__decap_12
XFILLER_215_1089 VPWR VGND VPWR VGND sky130_ef_sc_hd__decap_12
XTAP_TAPCELL_ROW_166_1358 VGND VPWR sky130_fd_sc_hd__tapvpwrvgnd_1
XTAP_TAPCELL_ROW_166_1369 VGND VPWR sky130_fd_sc_hd__tapvpwrvgnd_1
XFILLER_219_461 VPWR VGND VPWR VGND sky130_ef_sc_hd__decap_12
XFILLER_253_217 VGND VGND VPWR VPWR sky130_fd_sc_hd__decap_6
XFILLER_235_921 VPWR VGND VPWR VGND sky130_ef_sc_hd__decap_12
XFILLER_0_1009 VPWR VGND VPWR VGND sky130_ef_sc_hd__decap_12
XFILLER_235_965 VPWR VGND VPWR VGND sky130_ef_sc_hd__decap_12
XFILLER_206_133 VGND VGND VPWR VPWR sky130_fd_sc_hd__decap_6
XFILLER_185_1133 VPWR VGND VPWR VGND sky130_ef_sc_hd__decap_12
XFILLER_234_475 VGND VGND VPWR VPWR sky130_fd_sc_hd__fill_1
XTAP_TAPCELL_ROW_179_1708 VGND VPWR sky130_fd_sc_hd__tapvpwrvgnd_1
XFILLER_206_177 VPWR VGND VPWR VGND sky130_ef_sc_hd__decap_12
XTAP_TAPCELL_ROW_179_1719 VGND VPWR sky130_fd_sc_hd__tapvpwrvgnd_1
XFILLER_185_1177 VPWR VGND VPWR VGND sky130_ef_sc_hd__decap_12
XFILLER_222_637 VGND VGND VPWR VPWR sky130_fd_sc_hd__decap_6
XTAP_TAPCELL_ROW_16_2_3849 VGND VPWR sky130_fd_sc_hd__tapvpwrvgnd_1
XFILLER_37_1423 VPWR VGND VPWR VGND sky130_ef_sc_hd__decap_12
XFILLER_72_1303 VPWR VGND VPWR VGND sky130_ef_sc_hd__decap_12
XFILLER_221_125 VPWR VGND VPWR VGND sky130_ef_sc_hd__decap_12
XFILLER_76_1483 VPWR VGND VPWR VGND sky130_ef_sc_hd__decap_12
XFILLER_226_1141 VGND VGND VPWR VPWR sky130_fd_sc_hd__decap_6
XFILLER_250_979 VGND VGND VPWR VPWR sky130_fd_sc_hd__fill_1
XFILLER_187_541 VPWR VGND VPWR VGND sky130_ef_sc_hd__decap_12
XFILLER_221_169 VPWR VGND VPWR VGND sky130_ef_sc_hd__decap_12
XFILLER_222_1005 VPWR VGND VPWR VGND sky130_ef_sc_hd__decap_12
XFILLER_37_1467 VPWR VGND VPWR VGND sky130_ef_sc_hd__decap_12
XFILLER_124_1415 VPWR VGND VPWR VGND sky130_ef_sc_hd__decap_12
XFILLER_226_1185 VPWR VGND VPWR VGND sky130_ef_sc_hd__decap_12
XFILLER_203_895 VGND VGND VPWR VPWR sky130_fd_sc_hd__fill_1
XFILLER_230_681 VPWR VGND VPWR VGND sky130_ef_sc_hd__decap_12
XFILLER_163_1497 VGND VGND VPWR VPWR sky130_fd_sc_hd__fill_1
XFILLER_187_585 VPWR VGND VPWR VGND sky130_ef_sc_hd__decap_12
XFILLER_222_1049 VPWR VGND VPWR VGND sky130_ef_sc_hd__decap_12
XTAP_TAPCELL_ROW_250_3632 VGND VPWR sky130_fd_sc_hd__tapvpwrvgnd_1
XTAP_TAPCELL_ROW_155_2_4687 VGND VPWR sky130_fd_sc_hd__tapvpwrvgnd_1
XTAP_TAPCELL_ROW_250_3643 VGND VPWR sky130_fd_sc_hd__tapvpwrvgnd_1
XFILLER_204_1483 VGND VGND VPWR VPWR sky130_fd_sc_hd__fill_1
XFILLER_239_1513 VGND VGND VPWR VPWR sky130_fd_sc_hd__fill_2
Xmax_cap602 net603 VGND VGND VPWR VPWR net602 sky130_fd_sc_hd__clkbuf_1
Xmax_cap613 rd_addr\[2\] VGND VGND VPWR VPWR net613 sky130_fd_sc_hd__clkbuf_1
Xmax_cap624 net42 VGND VGND VPWR VPWR net624 sky130_fd_sc_hd__clkbuf_2
XFILLER_157_1213 VGND VGND VPWR VPWR sky130_fd_sc_hd__decap_4
XFILLER_196_1273 VPWR VGND VPWR VGND sky130_ef_sc_hd__decap_12
XTAP_TAPCELL_ROW_135_2_4563 VGND VPWR sky130_fd_sc_hd__tapvpwrvgnd_1
XFILLER_171_953 VPWR VGND VPWR VGND sky130_ef_sc_hd__decap_12
XTAP_TAPCELL_ROW_248_3572 VGND VPWR sky130_fd_sc_hd__tapvpwrvgnd_1
XFILLER_233_1101 VPWR VGND VPWR VGND sky130_ef_sc_hd__decap_12
XPHY_EDGE_ROW_37_1_Left_292 VGND VGND VPWR VPWR sky130_fd_sc_hd__decap_3
XFILLER_83_1443 VPWR VGND VPWR VGND sky130_ef_sc_hd__decap_12
XFILLER_135_1511 VGND VGND VPWR VPWR sky130_fd_sc_hd__decap_4
XFILLER_237_1281 VGND VGND VPWR VPWR sky130_fd_sc_hd__decap_6
XTAP_TAPCELL_ROW_248_3583 VGND VPWR sky130_fd_sc_hd__tapvpwrvgnd_1
XTAP_TAPCELL_ROW_248_3594 VGND VPWR sky130_fd_sc_hd__tapvpwrvgnd_1
XFILLER_44_1427 VPWR VGND VPWR VGND sky130_ef_sc_hd__decap_12
XFILLER_233_1145 VPWR VGND VPWR VGND sky130_ef_sc_hd__decap_12
XTAP_TAPCELL_ROW_244_3469 VGND VPWR sky130_fd_sc_hd__tapvpwrvgnd_1
XFILLER_229_225 VPWR VGND VPWR VGND sky130_ef_sc_hd__decap_12
XFILLER_233_1189 VPWR VGND VPWR VGND sky130_ef_sc_hd__decap_12
XFILLER_9_1089 VGND VGND VPWR VPWR sky130_fd_sc_hd__decap_3
XFILLER_245_729 VPWR VGND VPWR VGND sky130_ef_sc_hd__decap_12
XPHY_EDGE_ROW_206_Right_51 VGND VGND VPWR VPWR sky130_fd_sc_hd__decap_3
XFILLER_238_781 VPWR VGND VPWR VGND sky130_ef_sc_hd__decap_12
XTAP_TAPCELL_ROW_83_2_4250 VGND VPWR sky130_fd_sc_hd__tapvpwrvgnd_1
XFILLER_168_1353 VPWR VGND VPWR VGND sky130_ef_sc_hd__decap_12
XFILLER_240_401 VPWR VGND VPWR VGND sky130_ef_sc_hd__decap_12
XFILLER_44_29 VPWR VGND VPWR VGND sky130_ef_sc_hd__decap_12
XFILLER_20_1471 VPWR VGND VPWR VGND sky130_ef_sc_hd__decap_12
XFILLER_213_615 VGND VGND VPWR VPWR sky130_fd_sc_hd__fill_1
XFILLER_197_305 VPWR VGND VPWR VGND sky130_ef_sc_hd__decap_12
XFILLER_168_1397 VPWR VGND VPWR VGND sky130_ef_sc_hd__decap_12
XFILLER_225_497 VGND VGND VPWR VPWR sky130_fd_sc_hd__decap_6
XFILLER_164_1239 VGND VGND VPWR VPWR sky130_fd_sc_hd__decap_6
XFILLER_240_445 VPWR VGND VPWR VGND sky130_ef_sc_hd__decap_12
XFILLER_244_1241 VPWR VGND VPWR VGND sky130_ef_sc_hd__decap_12
XFILLER_197_349 VPWR VGND VPWR VGND sky130_ef_sc_hd__decap_12
XFILLER_240_1105 VPWR VGND VPWR VGND sky130_ef_sc_hd__decap_12
XFILLER_16_1507 VGND VGND VPWR VPWR sky130_fd_sc_hd__decap_8
XFILLER_200_309 VPWR VGND VPWR VGND sky130_ef_sc_hd__decap_12
XFILLER_205_1225 VGND VGND VPWR VPWR sky130_fd_sc_hd__decap_6
XFILLER_240_489 VPWR VGND VPWR VGND sky130_ef_sc_hd__decap_12
XFILLER_244_1285 VPWR VGND VPWR VGND sky130_ef_sc_hd__decap_12
XFILLER_90_1469 VGND VGND VPWR VPWR sky130_fd_sc_hd__fill_1
XFILLER_166_725 VPWR VGND VPWR VGND sky130_ef_sc_hd__decap_12
XFILLER_240_1149 VPWR VGND VPWR VGND sky130_ef_sc_hd__decap_12
XFILLER_205_1269 VPWR VGND VPWR VGND sky130_ef_sc_hd__decap_12
XPHY_EDGE_ROW_215_Right_60 VGND VGND VPWR VPWR sky130_fd_sc_hd__decap_3
XFILLER_166_769 VPWR VGND VPWR VGND sky130_ef_sc_hd__decap_12
XFILLER_101_1201 VPWR VGND VPWR VGND sky130_ef_sc_hd__decap_12
XFILLER_140_1283 VPWR VGND VPWR VGND sky130_ef_sc_hd__decap_12
XFILLER_109_55 VGND VGND VPWR VPWR sky130_fd_sc_hd__fill_1
XFILLER_175_1313 VPWR VGND VPWR VGND sky130_ef_sc_hd__decap_12
XFILLER_69_15 VPWR VGND VPWR VGND sky130_ef_sc_hd__decap_12
XFILLER_101_1267 VGND VGND VPWR VPWR sky130_fd_sc_hd__decap_6
XFILLER_179_1493 VPWR VGND VPWR VGND sky130_ef_sc_hd__decap_12
XFILLER_175_1357 VPWR VGND VPWR VGND sky130_ef_sc_hd__decap_12
XFILLER_192_27 VGND VGND VPWR VPWR sky130_fd_sc_hd__fill_1
XFILLER_251_1201 VPWR VGND VPWR VGND sky130_ef_sc_hd__decap_12
XFILLER_248_501 VPWR VGND VPWR VGND sky130_ef_sc_hd__decap_12
XFILLER_251_1245 VPWR VGND VPWR VGND sky130_ef_sc_hd__decap_12
XFILLER_216_1365 VGND VGND VPWR VPWR sky130_fd_sc_hd__decap_6
XFILLER_248_545 VPWR VGND VPWR VGND sky130_ef_sc_hd__decap_12
XFILLER_212_1229 VPWR VGND VPWR VGND sky130_ef_sc_hd__decap_12
XFILLER_251_1289 VPWR VGND VPWR VGND sky130_ef_sc_hd__decap_12
XFILLER_248_589 VPWR VGND VPWR VGND sky130_ef_sc_hd__decap_12
XFILLER_235_217 VGND VGND VPWR VPWR sky130_fd_sc_hd__decap_6
XFILLER_21_1213 VGND VGND VPWR VPWR sky130_fd_sc_hd__decap_4
XTAP_TAPCELL_ROW_4_963 VGND VPWR sky130_fd_sc_hd__tapvpwrvgnd_1
XFILLER_85_69 VGND VGND VPWR VPWR sky130_fd_sc_hd__fill_2
XFILLER_18_41 VPWR VGND VPWR VGND sky130_ef_sc_hd__decap_12
XTAP_TAPCELL_ROW_4_974 VGND VPWR sky130_fd_sc_hd__tapvpwrvgnd_1
XFILLER_217_921 VPWR VGND VPWR VGND sky130_ef_sc_hd__decap_12
XFILLER_60_1295 VGND VGND VPWR VPWR sky130_fd_sc_hd__decap_6
XPHY_EDGE_ROW_46_2_Right_137 VGND VGND VPWR VPWR sky130_fd_sc_hd__decap_3
XFILLER_217_965 VPWR VGND VPWR VGND sky130_ef_sc_hd__decap_12
XFILLER_250_209 VPWR VGND VPWR VGND sky130_ef_sc_hd__decap_12
XFILLER_186_1453 VPWR VGND VPWR VGND sky130_ef_sc_hd__decap_12
XFILLER_216_475 VGND VGND VPWR VPWR sky130_fd_sc_hd__fill_1
XFILLER_243_261 VPWR VGND VPWR VGND sky130_ef_sc_hd__decap_12
XFILLER_182_1317 VPWR VGND VPWR VGND sky130_ef_sc_hd__decap_12
XFILLER_189_839 VGND VGND VPWR VPWR sky130_fd_sc_hd__fill_1
XFILLER_204_637 VGND VGND VPWR VPWR sky130_fd_sc_hd__decap_6
XFILLER_186_1497 VPWR VGND VPWR VGND sky130_ef_sc_hd__decap_12
XFILLER_203_125 VPWR VGND VPWR VGND sky130_ef_sc_hd__decap_12
XFILLER_232_979 VGND VGND VPWR VPWR sky130_fd_sc_hd__fill_1
XFILLER_58_1191 VPWR VGND VPWR VGND sky130_ef_sc_hd__decap_12
XFILLER_169_541 VPWR VGND VPWR VGND sky130_ef_sc_hd__decap_12
XFILLER_203_169 VPWR VGND VPWR VGND sky130_ef_sc_hd__decap_12
XFILLER_223_1325 VPWR VGND VPWR VGND sky130_ef_sc_hd__decap_12
XFILLER_212_681 VPWR VGND VPWR VGND sky130_ef_sc_hd__decap_12
XFILLER_8_713 VGND VGND VPWR VPWR sky130_fd_sc_hd__decap_6
XFILLER_169_585 VPWR VGND VPWR VGND sky130_ef_sc_hd__decap_12
XFILLER_180_1085 VGND VGND VPWR VPWR sky130_fd_sc_hd__decap_6
XFILLER_223_1369 VPWR VGND VPWR VGND sky130_ef_sc_hd__decap_12
XFILLER_184_533 VPWR VGND VPWR VGND sky130_ef_sc_hd__decap_12
XFILLER_7_212 VGND VGND VPWR VPWR sky130_fd_sc_hd__fill_1
XFILLER_8_757 VPWR VGND VPWR VGND sky130_ef_sc_hd__decap_12
XFILLER_106_1189 VGND VGND VPWR VPWR sky130_fd_sc_hd__fill_1
XFILLER_7_245 VGND VGND VPWR VPWR sky130_fd_sc_hd__fill_2
Xwire154 _170_ VGND VGND VPWR VPWR net154 sky130_fd_sc_hd__clkbuf_1
XFILLER_171_205 VPWR VGND VPWR VGND sky130_ef_sc_hd__decap_12
XFILLER_7_278 VGND VGND VPWR VPWR sky130_fd_sc_hd__fill_2
Xwire187 _259_ VGND VGND VPWR VPWR net187 sky130_fd_sc_hd__clkbuf_1
XTAP_TAPCELL_ROW_121_2_4482 VGND VPWR sky130_fd_sc_hd__tapvpwrvgnd_1
Xwire198 _192_ VGND VGND VPWR VPWR net198 sky130_fd_sc_hd__clkbuf_1
XFILLER_171_249 VPWR VGND VPWR VGND sky130_ef_sc_hd__decap_12
XFILLER_193_1413 VPWR VGND VPWR VGND sky130_ef_sc_hd__decap_12
XFILLER_166_83 VGND VGND VPWR VPWR sky130_fd_sc_hd__fill_1
XFILLER_193_1457 VPWR VGND VPWR VGND sky130_ef_sc_hd__decap_12
XFILLER_234_1421 VGND VGND VPWR VPWR sky130_fd_sc_hd__decap_6
XTAP_TAPCELL_ROW_168_1409 VGND VPWR sky130_fd_sc_hd__tapvpwrvgnd_1
XFILLER_234_1465 VPWR VGND VPWR VGND sky130_ef_sc_hd__decap_12
XFILLER_6_1229 VPWR VGND VPWR VGND sky130_ef_sc_hd__decap_12
XFILLER_152_1165 VPWR VGND VPWR VGND sky130_ef_sc_hd__decap_12
XFILLER_230_1329 VPWR VGND VPWR VGND sky130_ef_sc_hd__decap_12
XTAP_TAPCELL_ROW_68_2_4163 VGND VPWR sky130_fd_sc_hd__tapvpwrvgnd_1
XFILLER_227_729 VPWR VGND VPWR VGND sky130_ef_sc_hd__decap_12
XFILLER_130_1463 VGND VGND VPWR VPWR sky130_fd_sc_hd__decap_6
XFILLER_228_1203 VGND VGND VPWR VPWR sky130_fd_sc_hd__fill_1
XFILLER_222_401 VPWR VGND VPWR VGND sky130_ef_sc_hd__decap_12
XFILLER_179_305 VPWR VGND VPWR VGND sky130_ef_sc_hd__decap_12
XFILLER_207_497 VGND VGND VPWR VPWR sky130_fd_sc_hd__decap_6
XFILLER_222_445 VPWR VGND VPWR VGND sky130_ef_sc_hd__decap_12
XFILLER_179_349 VPWR VGND VPWR VGND sky130_ef_sc_hd__decap_12
XFILLER_37_1231 VPWR VGND VPWR VGND sky130_ef_sc_hd__decap_12
XFILLER_195_809 VPWR VGND VPWR VGND sky130_ef_sc_hd__decap_12
XFILLER_188_861 VGND VGND VPWR VPWR sky130_fd_sc_hd__decap_6
XFILLER_241_1425 VPWR VGND VPWR VGND sky130_ef_sc_hd__decap_12
XFILLER_222_489 VPWR VGND VPWR VGND sky130_ef_sc_hd__decap_12
XTAP_TAPCELL_ROW_237_3273 VGND VPWR sky130_fd_sc_hd__tapvpwrvgnd_1
XTAP_TAPCELL_ROW_237_3284 VGND VPWR sky130_fd_sc_hd__tapvpwrvgnd_1
XFILLER_37_1275 VPWR VGND VPWR VGND sky130_ef_sc_hd__decap_12
XTAP_TAPCELL_ROW_237_3295 VGND VPWR sky130_fd_sc_hd__tapvpwrvgnd_1
XFILLER_72_1177 VPWR VGND VPWR VGND sky130_ef_sc_hd__decap_12
XTAP_TAPCELL_ROW_80_1_1215 VGND VPWR sky130_fd_sc_hd__tapvpwrvgnd_1
XFILLER_124_1245 VGND VGND VPWR VPWR sky130_fd_sc_hd__fill_1
XFILLER_202_1409 VPWR VGND VPWR VGND sky130_ef_sc_hd__decap_12
XFILLER_241_1469 VPWR VGND VPWR VGND sky130_ef_sc_hd__decap_12
XFILLER_187_393 VPWR VGND VPWR VGND sky130_ef_sc_hd__decap_12
XFILLER_190_525 VGND VGND VPWR VPWR sky130_fd_sc_hd__decap_6
XFILLER_239_1343 VGND VGND VPWR VPWR sky130_fd_sc_hd__fill_1
XFILLER_190_569 VPWR VGND VPWR VGND sky130_ef_sc_hd__decap_12
XFILLER_171_783 VGND VGND VPWR VPWR sky130_fd_sc_hd__fill_1
XFILLER_226_53 VPWR VGND VPWR VGND sky130_ef_sc_hd__decap_12
XFILLER_48_1371 VPWR VGND VPWR VGND sky130_ef_sc_hd__decap_12
XFILLER_83_1273 VGND VGND VPWR VPWR sky130_fd_sc_hd__fill_1
XFILLER_213_1505 VGND VGND VPWR VPWR sky130_fd_sc_hd__decap_6
XFILLER_226_97 VPWR VGND VPWR VGND sky130_ef_sc_hd__decap_12
XPHY_EDGE_ROW_34_1_Right_690 VGND VGND VPWR VPWR sky130_fd_sc_hd__decap_3
XFILLER_135_1385 VGND VGND VPWR VPWR sky130_fd_sc_hd__fill_1
XFILLER_242_41 VPWR VGND VPWR VGND sky130_ef_sc_hd__decap_12
XFILLER_217_217 VGND VGND VPWR VPWR sky130_fd_sc_hd__decap_6
XTAP_TAPCELL_ROW_1_900 VGND VPWR sky130_fd_sc_hd__tapvpwrvgnd_1
XFILLER_242_85 VPWR VGND VPWR VGND sky130_ef_sc_hd__decap_12
XFILLER_245_559 VGND VGND VPWR VPWR sky130_fd_sc_hd__fill_1
XFILLER_55_39 VGND VGND VPWR VPWR sky130_fd_sc_hd__decap_8
XFILLER_232_209 VPWR VGND VPWR VGND sky130_ef_sc_hd__decap_12
XTAP_TAPCELL_ROW_222_2874 VGND VPWR sky130_fd_sc_hd__tapvpwrvgnd_1
XFILLER_225_261 VPWR VGND VPWR VGND sky130_ef_sc_hd__decap_12
XFILLER_241_721 VGND VGND VPWR VPWR sky130_fd_sc_hd__decap_6
XFILLER_168_1161 VPWR VGND VPWR VGND sky130_ef_sc_hd__decap_12
XTAP_TAPCELL_ROW_222_2885 VGND VPWR sky130_fd_sc_hd__tapvpwrvgnd_1
XFILLER_198_625 VPWR VGND VPWR VGND sky130_ef_sc_hd__decap_12
XFILLER_0_1373 VPWR VGND VPWR VGND sky130_ef_sc_hd__decap_12
XFILLER_197_113 VPWR VGND VPWR VGND sky130_ef_sc_hd__decap_12
XFILLER_241_765 VPWR VGND VPWR VGND sky130_ef_sc_hd__decap_12
XFILLER_214_979 VGND VGND VPWR VPWR sky130_fd_sc_hd__fill_1
XFILLER_240_253 VPWR VGND VPWR VGND sky130_ef_sc_hd__decap_12
XFILLER_55_1331 VPWR VGND VPWR VGND sky130_ef_sc_hd__decap_12
XFILLER_71_27 VPWR VGND VPWR VGND sky130_ef_sc_hd__decap_12
XFILLER_198_669 VPWR VGND VPWR VGND sky130_ef_sc_hd__decap_12
XFILLER_129_1189 VPWR VGND VPWR VGND sky130_ef_sc_hd__decap_12
XFILLER_142_1301 VGND VGND VPWR VPWR sky130_fd_sc_hd__fill_1
XFILLER_201_629 VPWR VGND VPWR VGND sky130_ef_sc_hd__decap_12
XFILLER_16_1315 VPWR VGND VPWR VGND sky130_ef_sc_hd__decap_12
XFILLER_187_27 VPWR VGND VPWR VGND sky130_ef_sc_hd__decap_12
XFILLER_205_1033 VPWR VGND VPWR VGND sky130_ef_sc_hd__decap_12
XFILLER_244_1093 VPWR VGND VPWR VGND sky130_ef_sc_hd__decap_12
XFILLER_107_1443 VPWR VGND VPWR VGND sky130_ef_sc_hd__decap_12
XFILLER_51_1217 VGND VGND VPWR VPWR sky130_fd_sc_hd__fill_1
XFILLER_200_139 VGND VGND VPWR VPWR sky130_fd_sc_hd__fill_1
XFILLER_220_1509 VGND VGND VPWR VPWR sky130_fd_sc_hd__decap_6
XFILLER_16_1359 VPWR VGND VPWR VGND sky130_ef_sc_hd__decap_12
XFILLER_166_533 VPWR VGND VPWR VGND sky130_ef_sc_hd__decap_12
XFILLER_205_1077 VPWR VGND VPWR VGND sky130_ef_sc_hd__decap_12
XFILLER_103_1329 VGND VGND VPWR VPWR sky130_fd_sc_hd__fill_1
XFILLER_181_503 VGND VGND VPWR VPWR sky130_fd_sc_hd__fill_1
XFILLER_193_385 VGND VGND VPWR VPWR sky130_fd_sc_hd__decap_6
XFILLER_175_1121 VPWR VGND VPWR VGND sky130_ef_sc_hd__decap_12
XFILLER_105_3 VPWR VGND VPWR VGND sky130_ef_sc_hd__decap_12
XFILLER_20_53 VPWR VGND VPWR VGND sky130_ef_sc_hd__decap_12
XFILLER_218_1427 VGND VGND VPWR VPWR sky130_fd_sc_hd__fill_1
XFILLER_1_900 VPWR VGND VPWR VGND sky130_ef_sc_hd__decap_12
XFILLER_136_53 VPWR VGND VPWR VGND sky130_ef_sc_hd__decap_12
XFILLER_171_1007 VGND VGND VPWR VPWR sky130_fd_sc_hd__fill_1
XFILLER_27_1411 VPWR VGND VPWR VGND sky130_ef_sc_hd__decap_12
XFILLER_249_821 VPWR VGND VPWR VGND sky130_ef_sc_hd__decap_12
XFILLER_66_1471 VPWR VGND VPWR VGND sky130_ef_sc_hd__decap_12
XFILLER_0_421 VGND VGND VPWR VPWR sky130_fd_sc_hd__fill_1
XFILLER_7_1505 VGND VGND VPWR VPWR sky130_fd_sc_hd__decap_6
XFILLER_153_1441 VGND VGND VPWR VPWR sky130_fd_sc_hd__fill_1
XFILLER_27_1455 VPWR VGND VPWR VGND sky130_ef_sc_hd__decap_12
XFILLER_1_977 VPWR VGND VPWR VGND sky130_ef_sc_hd__decap_12
XFILLER_216_1173 VPWR VGND VPWR VGND sky130_ef_sc_hd__decap_12
XFILLER_249_865 VPWR VGND VPWR VGND sky130_ef_sc_hd__decap_12
XFILLER_62_1357 VGND VGND VPWR VPWR sky130_fd_sc_hd__fill_1
XFILLER_27_1499 VPWR VGND VPWR VGND sky130_ef_sc_hd__decap_12
XFILLER_212_1037 VPWR VGND VPWR VGND sky130_ef_sc_hd__decap_12
XFILLER_152_41 VPWR VGND VPWR VGND sky130_ef_sc_hd__decap_12
XFILLER_209_729 VPWR VGND VPWR VGND sky130_ef_sc_hd__decap_12
XFILLER_114_1469 VGND VGND VPWR VPWR sky130_fd_sc_hd__fill_1
X_664_ clknet_3_5__leaf_clk acc_core.adder.cla_blocks\[7\].block.sum\[2\] _072_ VGND
+ VGND VPWR VPWR net66 sky130_fd_sc_hd__dfrtp_1
XFILLER_251_529 VPWR VGND VPWR VGND sky130_ef_sc_hd__decap_12
XFILLER_147_1201 VPWR VGND VPWR VGND sky130_ef_sc_hd__decap_12
XPHY_EDGE_ROW_47_2_Right_138 VGND VGND VPWR VPWR sky130_fd_sc_hd__decap_3
XFILLER_204_401 VPWR VGND VPWR VGND sky130_ef_sc_hd__decap_12
XFILLER_244_581 VGND VGND VPWR VPWR sky130_fd_sc_hd__decap_6
XFILLER_186_1261 VPWR VGND VPWR VGND sky130_ef_sc_hd__decap_12
X_595_ clknet_3_2__leaf_clk _077_ _003_ VGND VGND VPWR VPWR rd_addr\[3\] sky130_fd_sc_hd__dfrtp_1
XFILLER_95_1177 VPWR VGND VPWR VGND sky130_ef_sc_hd__decap_12
XFILLER_204_445 VPWR VGND VPWR VGND sky130_ef_sc_hd__decap_12
XFILLER_220_905 VPWR VGND VPWR VGND sky130_ef_sc_hd__decap_12
XFILLER_182_1147 VGND VGND VPWR VPWR sky130_fd_sc_hd__fill_1
XFILLER_147_1267 VGND VGND VPWR VPWR sky130_fd_sc_hd__decap_6
XFILLER_177_809 VPWR VGND VPWR VGND sky130_ef_sc_hd__decap_12
XFILLER_204_489 VPWR VGND VPWR VGND sky130_ef_sc_hd__decap_12
XFILLER_220_949 VPWR VGND VPWR VGND sky130_ef_sc_hd__decap_12
XFILLER_34_1415 VPWR VGND VPWR VGND sky130_ef_sc_hd__decap_12
XFILLER_223_1133 VPWR VGND VPWR VGND sky130_ef_sc_hd__decap_12
XFILLER_8_510 VGND VGND VPWR VPWR sky130_fd_sc_hd__decap_4
XFILLER_73_1497 VGND VGND VPWR VPWR sky130_fd_sc_hd__fill_1
XFILLER_169_393 VPWR VGND VPWR VGND sky130_ef_sc_hd__decap_12
XFILLER_185_853 VPWR VGND VPWR VGND sky130_ef_sc_hd__decap_12
XFILLER_223_1177 VPWR VGND VPWR VGND sky130_ef_sc_hd__decap_12
XFILLER_184_363 VGND VGND VPWR VPWR sky130_fd_sc_hd__fill_1
XFILLER_185_897 VPWR VGND VPWR VGND sky130_ef_sc_hd__decap_12
XFILLER_8_587 VGND VGND VPWR VPWR sky130_fd_sc_hd__fill_1
XFILLER_172_525 VGND VGND VPWR VPWR sky130_fd_sc_hd__decap_6
XFILLER_177_93 VPWR VGND VPWR VGND sky130_ef_sc_hd__decap_12
XANTENNA_4 dout0\[5\] VGND VGND VPWR VPWR sky130_fd_sc_hd__diode_2
XTAP_TAPCELL_ROW_141_1_1276 VGND VPWR sky130_fd_sc_hd__tapvpwrvgnd_1
XFILLER_67_1213 VGND VGND VPWR VPWR sky130_fd_sc_hd__decap_4
XFILLER_172_569 VPWR VGND VPWR VGND sky130_ef_sc_hd__decap_12
XFILLER_6_77 VGND VGND VPWR VPWR sky130_fd_sc_hd__decap_6
XFILLER_154_1227 VPWR VGND VPWR VGND sky130_ef_sc_hd__decap_12
XFILLER_45_1511 VGND VGND VPWR VPWR sky130_fd_sc_hd__decap_4
XFILLER_193_81 VPWR VGND VPWR VGND sky130_ef_sc_hd__decap_12
XFILLER_193_1287 VGND VGND VPWR VPWR sky130_fd_sc_hd__fill_1
XFILLER_80_1413 VGND VGND VPWR VPWR sky130_fd_sc_hd__fill_1
XFILLER_234_1273 VPWR VGND VPWR VGND sky130_ef_sc_hd__decap_12
XFILLER_20_3 VPWR VGND VPWR VGND sky130_ef_sc_hd__decap_12
XFILLER_255_813 VPWR VGND VPWR VGND sky130_ef_sc_hd__decap_12
XFILLER_6_1037 VPWR VGND VPWR VGND sky130_ef_sc_hd__decap_12
XFILLER_254_301 VGND VGND VPWR VPWR sky130_fd_sc_hd__decap_6
XTAP_TAPCELL_ROW_7_1043 VGND VPWR sky130_fd_sc_hd__tapvpwrvgnd_1
XTAP_TAPCELL_ROW_7_1054 VGND VPWR sky130_fd_sc_hd__tapvpwrvgnd_1
XFILLER_227_559 VGND VGND VPWR VPWR sky130_fd_sc_hd__fill_1
XFILLER_254_345 VPWR VGND VPWR VGND sky130_ef_sc_hd__decap_12
XTAP_TAPCELL_ROW_143_2_4614 VGND VPWR sky130_fd_sc_hd__tapvpwrvgnd_1
XFILLER_130_1271 VPWR VGND VPWR VGND sky130_ef_sc_hd__decap_12
XFILLER_214_209 VPWR VGND VPWR VGND sky130_ef_sc_hd__decap_12
XFILLER_254_389 VPWR VGND VPWR VGND sky130_ef_sc_hd__decap_12
XFILLER_165_1301 VPWR VGND VPWR VGND sky130_ef_sc_hd__decap_12
XFILLER_207_261 VPWR VGND VPWR VGND sky130_ef_sc_hd__decap_12
XFILLER_223_721 VGND VGND VPWR VPWR sky130_fd_sc_hd__decap_6
XFILLER_169_1481 VPWR VGND VPWR VGND sky130_ef_sc_hd__decap_12
XFILLER_212_77 VGND VGND VPWR VPWR sky130_fd_sc_hd__decap_6
XTAP_TAPCELL_ROW_239_3335 VGND VPWR sky130_fd_sc_hd__tapvpwrvgnd_1
XTAP_TAPCELL_ROW_239_3346 VGND VPWR sky130_fd_sc_hd__tapvpwrvgnd_1
XFILLER_179_113 VPWR VGND VPWR VGND sky130_ef_sc_hd__decap_12
XFILLER_165_1345 VPWR VGND VPWR VGND sky130_ef_sc_hd__decap_12
XFILLER_74_1239 VGND VGND VPWR VPWR sky130_fd_sc_hd__decap_6
XFILLER_223_765 VPWR VGND VPWR VGND sky130_ef_sc_hd__decap_12
XFILLER_222_253 VPWR VGND VPWR VGND sky130_ef_sc_hd__decap_12
XFILLER_195_617 VPWR VGND VPWR VGND sky130_ef_sc_hd__decap_12
XFILLER_241_1233 VPWR VGND VPWR VGND sky130_ef_sc_hd__decap_12
XFILLER_206_1353 VPWR VGND VPWR VGND sky130_ef_sc_hd__decap_12
XTAP_TAPCELL_ROW_91_2_4301 VGND VPWR sky130_fd_sc_hd__tapvpwrvgnd_1
XFILLER_202_1217 VPWR VGND VPWR VGND sky130_ef_sc_hd__decap_12
XFILLER_206_1397 VPWR VGND VPWR VGND sky130_ef_sc_hd__decap_12
XFILLER_11_1201 VPWR VGND VPWR VGND sky130_ef_sc_hd__decap_12
XFILLER_175_385 VGND VGND VPWR VPWR sky130_fd_sc_hd__decap_6
XFILLER_50_1283 VPWR VGND VPWR VGND sky130_ef_sc_hd__decap_12
XFILLER_102_1351 VGND VGND VPWR VPWR sky130_fd_sc_hd__decap_6
XFILLER_190_333 VPWR VGND VPWR VGND sky130_ef_sc_hd__decap_12
XPHY_EDGE_ROW_48_2_Left_550 VGND VGND VPWR VPWR sky130_fd_sc_hd__decap_3
XFILLER_194_1029 VGND VGND VPWR VPWR sky130_fd_sc_hd__decap_6
XFILLER_11_1267 VGND VGND VPWR VPWR sky130_fd_sc_hd__decap_6
XFILLER_176_1441 VPWR VGND VPWR VGND sky130_ef_sc_hd__decap_12
XFILLER_191_889 VGND VGND VPWR VPWR sky130_fd_sc_hd__decap_6
XFILLER_102_1395 VPWR VGND VPWR VGND sky130_ef_sc_hd__decap_12
XFILLER_190_377 VPWR VGND VPWR VGND sky130_ef_sc_hd__decap_12
XFILLER_176_1485 VPWR VGND VPWR VGND sky130_ef_sc_hd__decap_12
XTAP_TAPCELL_ROW_211_2575 VGND VPWR sky130_fd_sc_hd__tapvpwrvgnd_1
XFILLER_85_1379 VGND VGND VPWR VPWR sky130_fd_sc_hd__decap_6
XTAP_TAPCELL_ROW_211_2586 VGND VPWR sky130_fd_sc_hd__tapvpwrvgnd_1
XFILLER_253_51 VGND VGND VPWR VPWR sky130_fd_sc_hd__decap_4
XFILLER_213_1313 VPWR VGND VPWR VGND sky130_ef_sc_hd__decap_12
XFILLER_252_1373 VPWR VGND VPWR VGND sky130_ef_sc_hd__decap_12
XFILLER_217_1493 VPWR VGND VPWR VGND sky130_ef_sc_hd__decap_12
XFILLER_246_813 VPWR VGND VPWR VGND sky130_ef_sc_hd__decap_12
XPHY_EDGE_ROW_35_1_Right_691 VGND VGND VPWR VPWR sky130_fd_sc_hd__decap_3
XFILLER_170_1073 VPWR VGND VPWR VGND sky130_ef_sc_hd__decap_12
XFILLER_213_1357 VPWR VGND VPWR VGND sky130_ef_sc_hd__decap_12
XTAP_TAPCELL_ROW_224_2925 VGND VPWR sky130_fd_sc_hd__tapvpwrvgnd_1
XTAP_TAPCELL_ROW_224_2936 VGND VPWR sky130_fd_sc_hd__tapvpwrvgnd_1
XTAP_TAPCELL_ROW_37_2_3978 VGND VPWR sky130_fd_sc_hd__tapvpwrvgnd_1
XFILLER_248_1409 VPWR VGND VPWR VGND sky130_ef_sc_hd__decap_12
XFILLER_113_1491 VGND VGND VPWR VPWR sky130_fd_sc_hd__decap_6
XFILLER_233_529 VPWR VGND VPWR VGND sky130_ef_sc_hd__decap_12
XFILLER_82_15 VPWR VGND VPWR VGND sky130_ef_sc_hd__decap_12
XFILLER_183_1401 VPWR VGND VPWR VGND sky130_ef_sc_hd__decap_12
XFILLER_226_581 VGND VGND VPWR VPWR sky130_fd_sc_hd__decap_6
XTAP_TAPCELL_ROW_17_2_3854 VGND VPWR sky130_fd_sc_hd__tapvpwrvgnd_1
XFILLER_199_945 VGND VGND VPWR VPWR sky130_fd_sc_hd__decap_6
XFILLER_198_15 VPWR VGND VPWR VGND sky130_ef_sc_hd__decap_12
XFILLER_198_433 VPWR VGND VPWR VGND sky130_ef_sc_hd__decap_12
XFILLER_202_905 VPWR VGND VPWR VGND sky130_ef_sc_hd__decap_12
X_380_ net591 net579 net552 VGND VGND VPWR VPWR _169_ sky130_fd_sc_hd__a21o_1
XFILLER_92_1339 VPWR VGND VPWR VGND sky130_ef_sc_hd__decap_12
XFILLER_144_1407 VGND VGND VPWR VPWR sky130_fd_sc_hd__decap_6
XFILLER_241_573 VPWR VGND VPWR VGND sky130_ef_sc_hd__decap_12
XFILLER_15_42 VPWR VGND VPWR VGND sky130_ef_sc_hd__decap_12
XFILLER_199_989 VPWR VGND VPWR VGND sky130_ef_sc_hd__decap_12
XFILLER_198_477 VPWR VGND VPWR VGND sky130_ef_sc_hd__decap_12
XFILLER_202_949 VPWR VGND VPWR VGND sky130_ef_sc_hd__decap_12
XFILLER_185_105 VGND VGND VPWR VPWR sky130_fd_sc_hd__decap_6
XFILLER_224_1453 VPWR VGND VPWR VGND sky130_ef_sc_hd__decap_12
XTAP_TAPCELL_ROW_156_2_4692 VGND VPWR sky130_fd_sc_hd__tapvpwrvgnd_1
XFILLER_167_853 VPWR VGND VPWR VGND sky130_ef_sc_hd__decap_12
XFILLER_185_149 VPWR VGND VPWR VGND sky130_ef_sc_hd__decap_12
XFILLER_220_1317 VPWR VGND VPWR VGND sky130_ef_sc_hd__decap_12
XFILLER_107_1273 VGND VGND VPWR VPWR sky130_fd_sc_hd__fill_1
XFILLER_222_3 VPWR VGND VPWR VGND sky130_ef_sc_hd__decap_12
XFILLER_224_1497 VPWR VGND VPWR VGND sky130_ef_sc_hd__decap_12
XFILLER_210_993 VPWR VGND VPWR VGND sky130_ef_sc_hd__decap_12
XFILLER_16_1189 VGND VGND VPWR VPWR sky130_fd_sc_hd__fill_1
XFILLER_166_363 VGND VGND VPWR VPWR sky130_fd_sc_hd__fill_1
XFILLER_167_897 VPWR VGND VPWR VGND sky130_ef_sc_hd__decap_12
XFILLER_120_1451 VPWR VGND VPWR VGND sky130_ef_sc_hd__decap_12
XFILLER_193_193 VPWR VGND VPWR VGND sky130_ef_sc_hd__decap_12
XFILLER_182_867 VGND VGND VPWR VPWR sky130_fd_sc_hd__fill_1
XFILLER_120_1495 VPWR VGND VPWR VGND sky130_ef_sc_hd__decap_12
Xoutput52 net537 VGND VGND VPWR VPWR acc_out[18] sky130_fd_sc_hd__buf_2
XFILLER_190_1427 VGND VGND VPWR VPWR sky130_fd_sc_hd__fill_1
Xoutput63 net63 VGND VGND VPWR VPWR acc_out[28] sky130_fd_sc_hd__buf_2
Xoutput74 net74 VGND VGND VPWR VPWR acc_out[9] sky130_fd_sc_hd__buf_2
XFILLER_7_1313 VPWR VGND VPWR VGND sky130_ef_sc_hd__decap_12
XFILLER_163_51 VGND VGND VPWR VPWR sky130_fd_sc_hd__decap_4
XFILLER_231_1413 VPWR VGND VPWR VGND sky130_ef_sc_hd__decap_12
XFILLER_255_109 VGND VGND VPWR VPWR sky130_fd_sc_hd__decap_3
XFILLER_249_673 VPWR VGND VPWR VGND sky130_ef_sc_hd__decap_12
XFILLER_62_1165 VPWR VGND VPWR VGND sky130_ef_sc_hd__decap_12
XFILLER_236_301 VGND VGND VPWR VPWR sky130_fd_sc_hd__decap_6
XFILLER_7_1357 VPWR VGND VPWR VGND sky130_ef_sc_hd__decap_12
XFILLER_231_1457 VPWR VGND VPWR VGND sky130_ef_sc_hd__decap_12
XTAP_TAPCELL_ROW_186_1895 VGND VPWR sky130_fd_sc_hd__tapvpwrvgnd_1
XFILLER_236_345 VPWR VGND VPWR VGND sky130_ef_sc_hd__decap_12
XFILLER_97_1217 VGND VGND VPWR VPWR sky130_fd_sc_hd__fill_1
XFILLER_209_559 VGND VGND VPWR VPWR sky130_fd_sc_hd__fill_1
XFILLER_252_805 VGND VGND VPWR VPWR sky130_fd_sc_hd__decap_6
XFILLER_40_1463 VGND VGND VPWR VPWR sky130_fd_sc_hd__decap_6
XFILLER_236_389 VPWR VGND VPWR VGND sky130_ef_sc_hd__decap_12
XFILLER_149_1329 VGND VGND VPWR VPWR sky130_fd_sc_hd__fill_1
XFILLER_252_849 VPWR VGND VPWR VGND sky130_ef_sc_hd__decap_12
X_647_ clknet_3_6__leaf_clk acc_core.adder.cla_blocks\[3\].block.sum\[1\] _055_ VGND
+ VGND VPWR VPWR net47 sky130_fd_sc_hd__dfrtp_1
XFILLER_205_721 VGND VGND VPWR VPWR sky130_fd_sc_hd__decap_6
XFILLER_251_337 VPWR VGND VPWR VGND sky130_ef_sc_hd__decap_12
XTAP_TAPCELL_ROW_108_2_4403 VGND VPWR sky130_fd_sc_hd__tapvpwrvgnd_1
XPHY_EDGE_ROW_48_2_Right_139 VGND VGND VPWR VPWR sky130_fd_sc_hd__decap_3
XFILLER_186_1091 VGND VGND VPWR VPWR sky130_fd_sc_hd__fill_1
XFILLER_205_765 VPWR VGND VPWR VGND sky130_ef_sc_hd__decap_12
X_578_ net667 VGND VGND VPWR VPWR _060_ sky130_fd_sc_hd__inv_2
XFILLER_162_1507 VGND VGND VPWR VPWR sky130_fd_sc_hd__decap_8
XFILLER_204_253 VPWR VGND VPWR VGND sky130_ef_sc_hd__decap_12
XFILLER_220_713 VPWR VGND VPWR VGND sky130_ef_sc_hd__decap_12
XFILLER_177_617 VPWR VGND VPWR VGND sky130_ef_sc_hd__decap_12
XTAP_TAPCELL_ROW_234_3210 VGND VPWR sky130_fd_sc_hd__tapvpwrvgnd_1
XFILLER_220_757 VPWR VGND VPWR VGND sky130_ef_sc_hd__decap_12
XFILLER_34_1245 VGND VGND VPWR VPWR sky130_fd_sc_hd__fill_1
XFILLER_9_841 VPWR VGND VPWR VGND sky130_ef_sc_hd__decap_12
XTAP_TAPCELL_ROW_230_3107 VGND VPWR sky130_fd_sc_hd__tapvpwrvgnd_1
XFILLER_8_362 VGND VGND VPWR VPWR sky130_fd_sc_hd__fill_2
XFILLER_68_3 VPWR VGND VPWR VGND sky130_ef_sc_hd__decap_12
XFILLER_172_333 VPWR VGND VPWR VGND sky130_ef_sc_hd__decap_12
XFILLER_173_889 VGND VGND VPWR VPWR sky130_fd_sc_hd__decap_6
XFILLER_172_377 VPWR VGND VPWR VGND sky130_ef_sc_hd__decap_12
XTAP_TAPCELL_ROW_75_1_1210 VGND VPWR sky130_fd_sc_hd__tapvpwrvgnd_1
XFILLER_207_55 VGND VGND VPWR VPWR sky130_fd_sc_hd__fill_1
XTAP_TAPCELL_ROW_228_3036 VGND VPWR sky130_fd_sc_hd__tapvpwrvgnd_1
XTAP_TAPCELL_ROW_228_3047 VGND VPWR sky130_fd_sc_hd__tapvpwrvgnd_1
XTAP_TAPCELL_ROW_9_1105 VGND VPWR sky130_fd_sc_hd__tapvpwrvgnd_1
XFILLER_119_1177 VPWR VGND VPWR VGND sky130_ef_sc_hd__decap_12
XTAP_TAPCELL_ROW_9_1116 VGND VPWR sky130_fd_sc_hd__tapvpwrvgnd_1
XTAP_TAPCELL_ROW_9_1127 VGND VPWR sky130_fd_sc_hd__tapvpwrvgnd_1
.ends
