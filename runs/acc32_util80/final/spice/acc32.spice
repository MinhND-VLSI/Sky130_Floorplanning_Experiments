* NGSPICE file created from acc32.ext - technology: sky130A

* Black-box entry subcircuit for sky130_fd_sc_hd__a21oi_1 abstract view
.subckt sky130_fd_sc_hd__a21oi_1 A1 A2 B1 VGND VNB VPB VPWR Y
.ends

* Black-box entry subcircuit for sky130_fd_sc_hd__nand2_1 abstract view
.subckt sky130_fd_sc_hd__nand2_1 A B VGND VNB VPB VPWR Y
.ends

* Black-box entry subcircuit for sky130_fd_sc_hd__dfrtp_1 abstract view
.subckt sky130_fd_sc_hd__dfrtp_1 CLK D RESET_B VGND VNB VPB VPWR Q
.ends

* Black-box entry subcircuit for sky130_fd_sc_hd__inv_2 abstract view
.subckt sky130_fd_sc_hd__inv_2 A VGND VNB VPB VPWR Y
.ends

* Black-box entry subcircuit for sky130_fd_sc_hd__fill_1 abstract view
.subckt sky130_fd_sc_hd__fill_1 VGND VNB VPB VPWR
.ends

* Black-box entry subcircuit for sky130_fd_sc_hd__fill_2 abstract view
.subckt sky130_fd_sc_hd__fill_2 VGND VNB VPB VPWR
.ends

* Black-box entry subcircuit for sky130_fd_sc_hd__tapvpwrvgnd_1 abstract view
.subckt sky130_fd_sc_hd__tapvpwrvgnd_1 VGND VPWR
.ends

* Black-box entry subcircuit for sky130_fd_sc_hd__decap_4 abstract view
.subckt sky130_fd_sc_hd__decap_4 VGND VNB VPB VPWR
.ends

* Black-box entry subcircuit for sky130_fd_sc_hd__decap_3 abstract view
.subckt sky130_fd_sc_hd__decap_3 VGND VNB VPB VPWR
.ends

* Black-box entry subcircuit for sky130_fd_sc_hd__buf_2 abstract view
.subckt sky130_fd_sc_hd__buf_2 A VGND VNB VPB VPWR X
.ends

* Black-box entry subcircuit for sky130_fd_sc_hd__a21o_1 abstract view
.subckt sky130_fd_sc_hd__a21o_1 A1 A2 B1 VGND VNB VPB VPWR X
.ends

* Black-box entry subcircuit for sky130_fd_sc_hd__or2_1 abstract view
.subckt sky130_fd_sc_hd__or2_1 A B VGND VNB VPB VPWR X
.ends

* Black-box entry subcircuit for sky130_fd_sc_hd__and4_1 abstract view
.subckt sky130_fd_sc_hd__and4_1 A B C D VGND VNB VPB VPWR X
.ends

* Black-box entry subcircuit for sky130_fd_sc_hd__or3_1 abstract view
.subckt sky130_fd_sc_hd__or3_1 A B C VGND VNB VPB VPWR X
.ends

* Black-box entry subcircuit for sky130_fd_sc_hd__nor2_1 abstract view
.subckt sky130_fd_sc_hd__nor2_1 A B VGND VNB VPB VPWR Y
.ends

* Black-box entry subcircuit for sky130_fd_sc_hd__o211a_1 abstract view
.subckt sky130_fd_sc_hd__o211a_1 A1 A2 B1 C1 VGND VNB VPB VPWR X
.ends

* Black-box entry subcircuit for sky130_fd_sc_hd__and3_1 abstract view
.subckt sky130_fd_sc_hd__and3_1 A B C VGND VNB VPB VPWR X
.ends

* Black-box entry subcircuit for sky130_fd_sc_hd__xnor2_1 abstract view
.subckt sky130_fd_sc_hd__xnor2_1 A B VGND VNB VPB VPWR Y
.ends

* Black-box entry subcircuit for sky130_fd_sc_hd__nand2b_1 abstract view
.subckt sky130_fd_sc_hd__nand2b_1 A_N B VGND VNB VPB VPWR Y
.ends

* Black-box entry subcircuit for sky130_fd_sc_hd__a31o_1 abstract view
.subckt sky130_fd_sc_hd__a31o_1 A1 A2 A3 B1 VGND VNB VPB VPWR X
.ends

* Black-box entry subcircuit for sky130_fd_sc_hd__o211ai_1 abstract view
.subckt sky130_fd_sc_hd__o211ai_1 A1 A2 B1 C1 VGND VNB VPB VPWR Y
.ends

* Black-box entry subcircuit for sky130_fd_sc_hd__and2_1 abstract view
.subckt sky130_fd_sc_hd__and2_1 A B VGND VNB VPB VPWR X
.ends

* Black-box entry subcircuit for sky130_fd_sc_hd__o21a_1 abstract view
.subckt sky130_fd_sc_hd__o21a_1 A1 A2 B1 VGND VNB VPB VPWR X
.ends

* Black-box entry subcircuit for sky130_fd_sc_hd__a211oi_1 abstract view
.subckt sky130_fd_sc_hd__a211oi_1 A1 A2 B1 C1 VGND VNB VPB VPWR Y
.ends

* Black-box entry subcircuit for sky130_fd_sc_hd__clkbuf_8 abstract view
.subckt sky130_fd_sc_hd__clkbuf_8 A VGND VNB VPB VPWR X
.ends

* Black-box entry subcircuit for sky130_fd_sc_hd__o221ai_1 abstract view
.subckt sky130_fd_sc_hd__o221ai_1 A1 A2 B1 B2 C1 VGND VNB VPB VPWR Y
.ends

* Black-box entry subcircuit for sky130_fd_sc_hd__nand3_1 abstract view
.subckt sky130_fd_sc_hd__nand3_1 A B C VGND VNB VPB VPWR Y
.ends

* Black-box entry subcircuit for sky130_fd_sc_hd__a211o_1 abstract view
.subckt sky130_fd_sc_hd__a211o_1 A1 A2 B1 C1 VGND VNB VPB VPWR X
.ends

* Black-box entry subcircuit for sky130_fd_sc_hd__decap_6 abstract view
.subckt sky130_fd_sc_hd__decap_6 VGND VNB VPB VPWR
.ends

* Black-box entry subcircuit for sky130_fd_sc_hd__clkbuf_4 abstract view
.subckt sky130_fd_sc_hd__clkbuf_4 A VGND VNB VPB VPWR X
.ends

* Black-box entry subcircuit for sky130_ef_sc_hd__decap_12 abstract view
.subckt sky130_ef_sc_hd__decap_12 VPWR VGND VPB VNB
.ends

* Black-box entry subcircuit for sky130_fd_sc_hd__o22ai_1 abstract view
.subckt sky130_fd_sc_hd__o22ai_1 A1 A2 B1 B2 VGND VNB VPB VPWR Y
.ends

* Black-box entry subcircuit for sky130_fd_sc_hd__xor2_1 abstract view
.subckt sky130_fd_sc_hd__xor2_1 A B VGND VNB VPB VPWR X
.ends

* Black-box entry subcircuit for sky130_fd_sc_hd__clkbuf_16 abstract view
.subckt sky130_fd_sc_hd__clkbuf_16 A VGND VNB VPB VPWR X
.ends

* Black-box entry subcircuit for sky130_fd_sc_hd__a21bo_1 abstract view
.subckt sky130_fd_sc_hd__a21bo_1 A1 A2 B1_N VGND VNB VPB VPWR X
.ends

* Black-box entry subcircuit for sky130_fd_sc_hd__buf_4 abstract view
.subckt sky130_fd_sc_hd__buf_4 A VGND VNB VPB VPWR X
.ends

* Black-box entry subcircuit for sky130_fd_sc_hd__clkbuf_1 abstract view
.subckt sky130_fd_sc_hd__clkbuf_1 A VGND VNB VPB VPWR X
.ends

* Black-box entry subcircuit for sky130_fd_sc_hd__and2b_1 abstract view
.subckt sky130_fd_sc_hd__and2b_1 A_N B VGND VNB VPB VPWR X
.ends

* Black-box entry subcircuit for sky130_fd_sc_hd__decap_8 abstract view
.subckt sky130_fd_sc_hd__decap_8 VGND VNB VPB VPWR
.ends

* Black-box entry subcircuit for sky130_fd_sc_hd__buf_1 abstract view
.subckt sky130_fd_sc_hd__buf_1 A VGND VNB VPB VPWR X
.ends

* Black-box entry subcircuit for sky130_fd_sc_hd__o31a_1 abstract view
.subckt sky130_fd_sc_hd__o31a_1 A1 A2 A3 B1 VGND VNB VPB VPWR X
.ends

* Black-box entry subcircuit for sky130_fd_sc_hd__o22a_1 abstract view
.subckt sky130_fd_sc_hd__o22a_1 A1 A2 B1 B2 VGND VNB VPB VPWR X
.ends

* Black-box entry subcircuit for sky130_fd_sc_hd__nor3_2 abstract view
.subckt sky130_fd_sc_hd__nor3_2 A B C VGND VNB VPB VPWR Y
.ends

* Black-box entry subcircuit for sky130_fd_sc_hd__o221ai_4 abstract view
.subckt sky130_fd_sc_hd__o221ai_4 A1 A2 B1 B2 C1 VGND VNB VPB VPWR Y
.ends

* Black-box entry subcircuit for sky130_fd_sc_hd__nor3_1 abstract view
.subckt sky130_fd_sc_hd__nor3_1 A B C VGND VNB VPB VPWR Y
.ends

* Black-box entry subcircuit for sky130_fd_sc_hd__dlymetal6s2s_1 abstract view
.subckt sky130_fd_sc_hd__dlymetal6s2s_1 A VGND VNB VPB VPWR X
.ends

* Black-box entry subcircuit for sky130_fd_sc_hd__clkbuf_2 abstract view
.subckt sky130_fd_sc_hd__clkbuf_2 A VGND VNB VPB VPWR X
.ends

* Black-box entry subcircuit for sky130_fd_sc_hd__dfrtp_4 abstract view
.subckt sky130_fd_sc_hd__dfrtp_4 CLK D RESET_B VGND VNB VPB VPWR Q
.ends

* Black-box entry subcircuit for sky130_fd_sc_hd__a311o_1 abstract view
.subckt sky130_fd_sc_hd__a311o_1 A1 A2 A3 B1 C1 VGND VNB VPB VPWR X
.ends

* Black-box entry subcircuit for sky130_fd_sc_hd__a31oi_1 abstract view
.subckt sky130_fd_sc_hd__a31oi_1 A1 A2 A3 B1 VGND VNB VPB VPWR Y
.ends

.subckt acc32 VGND VPWR acc[0] acc[10] acc[11] acc[12] acc[13] acc[14] acc[15] acc[16]
+ acc[17] acc[18] acc[19] acc[1] acc[20] acc[21] acc[22] acc[23] acc[24] acc[25] acc[26]
+ acc[27] acc[28] acc[29] acc[2] acc[30] acc[31] acc[3] acc[4] acc[5] acc[6] acc[7]
+ acc[8] acc[9] clk data_in[0] data_in[10] data_in[11] data_in[12] data_in[13] data_in[14]
+ data_in[15] data_in[16] data_in[17] data_in[18] data_in[19] data_in[1] data_in[20]
+ data_in[21] data_in[22] data_in[23] data_in[24] data_in[25] data_in[26] data_in[27]
+ data_in[28] data_in[29] data_in[2] data_in[30] data_in[31] data_in[3] data_in[4]
+ data_in[5] data_in[6] data_in[7] data_in[8] data_in[9] rst
X_363_ _157_ _166_ _167_ VGND VGND VPWR VPWR _168_ sky130_fd_sc_hd__a21oi_1
X_294_ _100_ _101_ VGND VGND VPWR VPWR _102_ sky130_fd_sc_hd__nand2_1
X_432_ clknet_2_3__leaf_clk adder.cla_blocks\[0\].block.p\[0\] _000_ VGND VGND VPWR
+ VPWR net34 sky130_fd_sc_hd__dfrtp_1
X_346_ _149_ _153_ _051_ VGND VGND VPWR VPWR _154_ sky130_fd_sc_hd__a21oi_1
X_415_ net29 net62 _194_ VGND VGND VPWR VPWR _196_ sky130_fd_sc_hd__a21oi_1
X_277_ net28 net61 VGND VGND VPWR VPWR _085_ sky130_fd_sc_hd__nand2_1
X_200_ net66 VGND VGND VPWR VPWR _009_ sky130_fd_sc_hd__inv_2
X_329_ _135_ _136_ VGND VGND VPWR VPWR _137_ sky130_fd_sc_hd__nand2_1
XFILLER_0_57 VGND VGND VPWR VPWR sky130_fd_sc_hd__fill_1
XFILLER_9_22 VGND VGND VPWR VPWR sky130_fd_sc_hd__fill_2
XTAP_TAPCELL_ROW_20_87 VGND VPWR sky130_fd_sc_hd__tapvpwrvgnd_1
XFILLER_20_32 VGND VGND VPWR VPWR sky130_fd_sc_hd__decap_4
XPHY_EDGE_ROW_16_Left_37 VGND VGND VPWR VPWR sky130_fd_sc_hd__decap_3
XFILLER_15_54 VGND VGND VPWR VPWR sky130_fd_sc_hd__fill_2
Xoutput53 net53 VGND VGND VPWR VPWR acc[27] sky130_fd_sc_hd__buf_2
Xoutput64 net64 VGND VGND VPWR VPWR acc[8] sky130_fd_sc_hd__buf_2
Xoutput42 net42 VGND VGND VPWR VPWR acc[17] sky130_fd_sc_hd__buf_2
X_362_ _158_ _163_ _162_ VGND VGND VPWR VPWR _167_ sky130_fd_sc_hd__a21o_1
XFILLER_3_24 VGND VGND VPWR VPWR sky130_fd_sc_hd__fill_1
X_293_ net5 net38 VGND VGND VPWR VPWR _101_ sky130_fd_sc_hd__or2_1
X_431_ net67 VGND VGND VPWR VPWR _008_ sky130_fd_sc_hd__inv_2
XPHY_EDGE_ROW_19_Left_40 VGND VGND VPWR VPWR sky130_fd_sc_hd__decap_3
X_345_ _141_ _150_ _151_ _152_ VGND VGND VPWR VPWR _153_ sky130_fd_sc_hd__and4_1
X_276_ _080_ _081_ _082_ VGND VGND VPWR VPWR _084_ sky130_fd_sc_hd__or3_1
X_414_ _194_ _195_ VGND VGND VPWR VPWR adder.cla_blocks\[1\].block.sum\[2\] sky130_fd_sc_hd__nor2_1
XPHY_EDGE_ROW_4_Left_25 VGND VGND VPWR VPWR sky130_fd_sc_hd__decap_3
XPHY_EDGE_ROW_12_Right_12 VGND VGND VPWR VPWR sky130_fd_sc_hd__decap_3
X_328_ net14 net47 VGND VGND VPWR VPWR _136_ sky130_fd_sc_hd__or2_1
X_259_ _065_ _066_ VGND VGND VPWR VPWR _067_ sky130_fd_sc_hd__nand2_1
XFILLER_20_22 VGND VGND VPWR VPWR sky130_fd_sc_hd__fill_1
XPHY_EDGE_ROW_6_Right_6 VGND VGND VPWR VPWR sky130_fd_sc_hd__decap_3
Xoutput54 net54 VGND VGND VPWR VPWR acc[28] sky130_fd_sc_hd__buf_2
Xoutput43 net43 VGND VGND VPWR VPWR acc[18] sky130_fd_sc_hd__buf_2
Xoutput65 net65 VGND VGND VPWR VPWR acc[9] sky130_fd_sc_hd__buf_2
X_361_ _159_ _162_ _163_ _032_ VGND VGND VPWR VPWR _166_ sky130_fd_sc_hd__o211a_1
X_292_ net5 net38 VGND VGND VPWR VPWR _100_ sky130_fd_sc_hd__nand2_1
X_430_ net67 VGND VGND VPWR VPWR _007_ sky130_fd_sc_hd__inv_2
XPHY_EDGE_ROW_20_Left_41 VGND VGND VPWR VPWR sky130_fd_sc_hd__decap_3
X_344_ _135_ _140_ _143_ VGND VGND VPWR VPWR _152_ sky130_fd_sc_hd__or3_1
X_413_ _080_ _085_ _192_ VGND VGND VPWR VPWR _195_ sky130_fd_sc_hd__and3_1
X_275_ _081_ _082_ VGND VGND VPWR VPWR _083_ sky130_fd_sc_hd__nor2_1
X_327_ net14 net47 VGND VGND VPWR VPWR _135_ sky130_fd_sc_hd__nand2_1
X_258_ net31 net64 VGND VGND VPWR VPWR _066_ sky130_fd_sc_hd__or2_1
XFILLER_9_68 VGND VGND VPWR VPWR sky130_fd_sc_hd__fill_1
Xoutput44 net44 VGND VGND VPWR VPWR acc[19] sky130_fd_sc_hd__buf_2
Xoutput55 net55 VGND VGND VPWR VPWR acc[29] sky130_fd_sc_hd__buf_2
XTAP_TAPCELL_ROW_2_48 VGND VPWR sky130_fd_sc_hd__tapvpwrvgnd_1
X_360_ _164_ _165_ VGND VGND VPWR VPWR adder.cla_blocks\[7\].block.sum\[2\] sky130_fd_sc_hd__xnor2_1
X_291_ _097_ _098_ VGND VGND VPWR VPWR _099_ sky130_fd_sc_hd__or2_1
XFILLER_12_24 VGND VGND VPWR VPWR sky130_fd_sc_hd__fill_1
XTAP_TAPCELL_ROW_12_68 VGND VPWR sky130_fd_sc_hd__tapvpwrvgnd_1
X_343_ _139_ _142_ VGND VGND VPWR VPWR _151_ sky130_fd_sc_hd__nand2b_1
X_274_ net30 net63 VGND VGND VPWR VPWR _082_ sky130_fd_sc_hd__nor2_1
X_412_ _085_ _192_ _080_ VGND VGND VPWR VPWR _194_ sky130_fd_sc_hd__a21oi_1
XFILLER_4_80 VGND VGND VPWR VPWR sky130_fd_sc_hd__fill_1
X_257_ net31 net64 VGND VGND VPWR VPWR _065_ sky130_fd_sc_hd__nand2_1
X_326_ _129_ _133_ VGND VGND VPWR VPWR _134_ sky130_fd_sc_hd__nand2_1
XFILLER_18_67 VGND VGND VPWR VPWR sky130_fd_sc_hd__fill_1
X_309_ net4 net37 _111_ _116_ VGND VGND VPWR VPWR _117_ sky130_fd_sc_hd__a31o_1
XFILLER_13_6 VGND VGND VPWR VPWR sky130_fd_sc_hd__fill_1
Xoutput34 net34 VGND VGND VPWR VPWR acc[0] sky130_fd_sc_hd__buf_2
XFILLER_15_13 VGND VGND VPWR VPWR sky130_fd_sc_hd__decap_3
Xoutput45 net45 VGND VGND VPWR VPWR acc[1] sky130_fd_sc_hd__buf_2
XTAP_TAPCELL_ROW_2_49 VGND VPWR sky130_fd_sc_hd__tapvpwrvgnd_1
Xoutput56 net56 VGND VGND VPWR VPWR acc[2] sky130_fd_sc_hd__buf_2
XFILLER_7_80 VGND VGND VPWR VPWR sky130_fd_sc_hd__fill_1
XFILLER_3_38 VGND VGND VPWR VPWR sky130_fd_sc_hd__fill_1
X_290_ _062_ _065_ _064_ _063_ VGND VGND VPWR VPWR _098_ sky130_fd_sc_hd__o211ai_1
XTAP_TAPCELL_ROW_12_69 VGND VPWR sky130_fd_sc_hd__tapvpwrvgnd_1
X_342_ _145_ _146_ VGND VGND VPWR VPWR _150_ sky130_fd_sc_hd__or2_1
X_273_ net30 net63 VGND VGND VPWR VPWR _081_ sky130_fd_sc_hd__and2_1
X_411_ _192_ _193_ VGND VGND VPWR VPWR adder.cla_blocks\[1\].block.sum\[1\] sky130_fd_sc_hd__and2_1
XFILLER_5_111 VGND VGND VPWR VPWR sky130_fd_sc_hd__fill_1
XFILLER_5_122 VGND VGND VPWR VPWR sky130_fd_sc_hd__fill_2
X_256_ _053_ _056_ _052_ VGND VGND VPWR VPWR _064_ sky130_fd_sc_hd__o21a_1
X_325_ net11 net44 _130_ _132_ VGND VGND VPWR VPWR _133_ sky130_fd_sc_hd__a211oi_1
XPHY_EDGE_ROW_8_Left_29 VGND VGND VPWR VPWR sky130_fd_sc_hd__decap_3
Xclkload0 clknet_2_0__leaf_clk VGND VGND VPWR VPWR clkload0/X sky130_fd_sc_hd__clkbuf_8
X_239_ _046_ VGND VGND VPWR VPWR _047_ sky130_fd_sc_hd__inv_2
X_308_ _104_ _107_ _110_ _100_ _106_ VGND VGND VPWR VPWR _116_ sky130_fd_sc_hd__o221ai_1
Xoutput57 net57 VGND VGND VPWR VPWR acc[30] sky130_fd_sc_hd__buf_2
Xoutput46 net46 VGND VGND VPWR VPWR acc[20] sky130_fd_sc_hd__buf_2
Xoutput35 net35 VGND VGND VPWR VPWR acc[10] sky130_fd_sc_hd__buf_2
XPHY_EDGE_ROW_19_Right_19 VGND VGND VPWR VPWR sky130_fd_sc_hd__decap_3
XFILLER_13_116 VGND VGND VPWR VPWR sky130_fd_sc_hd__fill_1
X_272_ net29 net62 VGND VGND VPWR VPWR _080_ sky130_fd_sc_hd__xnor2_1
X_410_ _087_ _088_ _190_ VGND VGND VPWR VPWR _193_ sky130_fd_sc_hd__nand3_1
X_341_ _129_ _133_ _145_ _148_ VGND VGND VPWR VPWR _149_ sky130_fd_sc_hd__a211o_1
X_255_ _055_ _058_ _059_ VGND VGND VPWR VPWR _063_ sky130_fd_sc_hd__or3_1
XFILLER_0_29 VGND VGND VPWR VPWR sky130_fd_sc_hd__fill_2
X_324_ net8 net41 _125_ _131_ VGND VGND VPWR VPWR _132_ sky130_fd_sc_hd__a31o_1
XFILLER_13_80 VGND VGND VPWR VPWR sky130_fd_sc_hd__decap_6
Xclkload1 clknet_2_1__leaf_clk VGND VGND VPWR VPWR clkload1/X sky130_fd_sc_hd__clkbuf_4
X_238_ net20 net53 _044_ _045_ VGND VGND VPWR VPWR _046_ sky130_fd_sc_hd__a211o_1
X_307_ _097_ _098_ _111_ _114_ VGND VGND VPWR VPWR _115_ sky130_fd_sc_hd__o211a_1
XFILLER_20_26 VGND VGND VPWR VPWR sky130_fd_sc_hd__fill_2
XFILLER_19_111 VGND VGND VPWR VPWR sky130_fd_sc_hd__fill_1
XFILLER_10_92 VGND VGND VPWR VPWR sky130_fd_sc_hd__decap_6
XPHY_EDGE_ROW_11_Left_32 VGND VGND VPWR VPWR sky130_fd_sc_hd__decap_3
Xoutput47 net47 VGND VGND VPWR VPWR acc[21] sky130_fd_sc_hd__buf_2
XFILLER_16_103 VGND VGND VPWR VPWR sky130_fd_sc_hd__fill_1
Xoutput36 net36 VGND VGND VPWR VPWR acc[11] sky130_fd_sc_hd__buf_2
Xoutput58 net58 VGND VGND VPWR VPWR acc[31] sky130_fd_sc_hd__buf_2
XTAP_TAPCELL_ROW_3_50 VGND VPWR sky130_fd_sc_hd__tapvpwrvgnd_1
XFILLER_12_49 VPWR VGND VPWR VGND sky130_ef_sc_hd__decap_12
X_271_ net26 net59 _076_ _077_ VGND VGND VPWR VPWR _079_ sky130_fd_sc_hd__o22ai_1
X_340_ _146_ _147_ VGND VGND VPWR VPWR _148_ sky130_fd_sc_hd__nand2_1
X_254_ _055_ _058_ _061_ VGND VGND VPWR VPWR _062_ sky130_fd_sc_hd__or3_1
X_323_ net9 net42 _124_ VGND VGND VPWR VPWR _131_ sky130_fd_sc_hd__and3_1
XTAP_TAPCELL_ROW_13_70 VGND VPWR sky130_fd_sc_hd__tapvpwrvgnd_1
Xclkload2 clknet_2_3__leaf_clk VGND VGND VPWR VPWR clkload2/X sky130_fd_sc_hd__clkbuf_8
X_237_ net20 net53 net19 net52 VGND VGND VPWR VPWR _045_ sky130_fd_sc_hd__o211a_1
X_306_ _112_ _113_ VGND VGND VPWR VPWR _114_ sky130_fd_sc_hd__and2_1
XFILLER_6_18 VGND VGND VPWR VPWR sky130_fd_sc_hd__fill_2
Xoutput48 net48 VGND VGND VPWR VPWR acc[22] sky130_fd_sc_hd__buf_2
XPHY_EDGE_ROW_1_Right_1 VGND VGND VPWR VPWR sky130_fd_sc_hd__decap_3
Xoutput37 net37 VGND VGND VPWR VPWR acc[12] sky130_fd_sc_hd__buf_2
Xoutput59 net59 VGND VGND VPWR VPWR acc[3] sky130_fd_sc_hd__buf_2
XTAP_TAPCELL_ROW_3_51 VGND VPWR sky130_fd_sc_hd__tapvpwrvgnd_1
XFILLER_8_122 VGND VGND VPWR VPWR sky130_fd_sc_hd__fill_2
X_270_ net26 net59 VGND VGND VPWR VPWR _078_ sky130_fd_sc_hd__xor2_1
X_399_ _096_ _186_ VGND VGND VPWR VPWR adder.cla_blocks\[2\].block.sum\[0\] sky130_fd_sc_hd__and2_1
X_322_ net11 net44 net10 net43 VGND VGND VPWR VPWR _130_ sky130_fd_sc_hd__o211a_1
XTAP_TAPCELL_ROW_13_71 VGND VPWR sky130_fd_sc_hd__tapvpwrvgnd_1
X_253_ _059_ _060_ VGND VGND VPWR VPWR _061_ sky130_fd_sc_hd__nand2_1
X_236_ _038_ _043_ VGND VGND VPWR VPWR _044_ sky130_fd_sc_hd__nor2_1
X_305_ net4 net37 VGND VGND VPWR VPWR _113_ sky130_fd_sc_hd__or2_1
XFILLER_10_83 VGND VGND VPWR VPWR sky130_fd_sc_hd__fill_1
X_219_ net69 VGND VGND VPWR VPWR _028_ sky130_fd_sc_hd__inv_2
Xoutput49 net49 VGND VGND VPWR VPWR acc[23] sky130_fd_sc_hd__buf_2
Xoutput38 net38 VGND VGND VPWR VPWR acc[13] sky130_fd_sc_hd__buf_2
Xclkbuf_0_clk clk VGND VGND VPWR VPWR clknet_0_clk sky130_fd_sc_hd__clkbuf_16
XPHY_EDGE_ROW_15_Right_15 VGND VGND VPWR VPWR sky130_fd_sc_hd__decap_3
XFILLER_16_60 VGND VGND VPWR VPWR sky130_fd_sc_hd__fill_1
XFILLER_12_18 VGND VGND VPWR VPWR sky130_fd_sc_hd__decap_6
XFILLER_4_85 VGND VGND VPWR VPWR sky130_fd_sc_hd__fill_1
X_398_ _067_ _092_ _095_ VGND VGND VPWR VPWR _186_ sky130_fd_sc_hd__nand3_1
XTAP_TAPCELL_ROW_0_42 VGND VPWR sky130_fd_sc_hd__tapvpwrvgnd_1
X_252_ net32 net65 VGND VGND VPWR VPWR _060_ sky130_fd_sc_hd__or2_1
X_321_ _115_ _117_ _125_ _128_ VGND VGND VPWR VPWR _129_ sky130_fd_sc_hd__o211ai_1
XTAP_TAPCELL_ROW_9_62 VGND VPWR sky130_fd_sc_hd__tapvpwrvgnd_1
X_235_ _035_ _041_ VGND VGND VPWR VPWR _043_ sky130_fd_sc_hd__or2_1
X_304_ net4 net37 VGND VGND VPWR VPWR _112_ sky130_fd_sc_hd__nand2_1
XTAP_TAPCELL_ROW_19_82 VGND VPWR sky130_fd_sc_hd__tapvpwrvgnd_1
X_218_ net68 VGND VGND VPWR VPWR _027_ sky130_fd_sc_hd__inv_2
XFILLER_15_29 VGND VGND VPWR VPWR sky130_fd_sc_hd__fill_1
Xoutput39 net39 VGND VGND VPWR VPWR acc[14] sky130_fd_sc_hd__buf_2
XPHY_EDGE_ROW_15_Left_36 VGND VGND VPWR VPWR sky130_fd_sc_hd__decap_3
XFILLER_16_83 VGND VGND VPWR VPWR sky130_fd_sc_hd__fill_1
X_397_ _109_ _185_ VGND VGND VPWR VPWR adder.cla_blocks\[3\].block.sum\[3\] sky130_fd_sc_hd__xnor2_1
Xclkbuf_2_0__f_clk clknet_0_clk VGND VGND VPWR VPWR clknet_2_0__leaf_clk sky130_fd_sc_hd__clkbuf_16
XFILLER_4_97 VGND VGND VPWR VPWR sky130_fd_sc_hd__fill_2
X_251_ net32 net65 VGND VGND VPWR VPWR _059_ sky130_fd_sc_hd__nand2_1
XTAP_TAPCELL_ROW_0_43 VGND VPWR sky130_fd_sc_hd__tapvpwrvgnd_1
X_320_ _126_ _127_ VGND VGND VPWR VPWR _128_ sky130_fd_sc_hd__and2_1
XFILLER_18_18 VGND VGND VPWR VPWR sky130_fd_sc_hd__fill_2
X_449_ clknet_2_0__leaf_clk adder.cla_blocks\[4\].block.sum\[1\] _017_ VGND VGND VPWR
+ VPWR net42 sky130_fd_sc_hd__dfrtp_1
XTAP_TAPCELL_ROW_9_63 VGND VPWR sky130_fd_sc_hd__tapvpwrvgnd_1
XPHY_EDGE_ROW_3_Left_24 VGND VGND VPWR VPWR sky130_fd_sc_hd__decap_3
X_234_ _037_ _041_ VGND VGND VPWR VPWR _042_ sky130_fd_sc_hd__or2_1
X_303_ _102_ _110_ VGND VGND VPWR VPWR _111_ sky130_fd_sc_hd__nor2_1
XTAP_TAPCELL_ROW_19_83 VGND VPWR sky130_fd_sc_hd__tapvpwrvgnd_1
X_217_ net68 VGND VGND VPWR VPWR _026_ sky130_fd_sc_hd__inv_2
XPHY_EDGE_ROW_5_Right_5 VGND VGND VPWR VPWR sky130_fd_sc_hd__decap_3
XFILLER_12_110 VGND VGND VPWR VPWR sky130_fd_sc_hd__fill_1
X_396_ _103_ _184_ _104_ VGND VGND VPWR VPWR _185_ sky130_fd_sc_hd__a21bo_1
X_250_ _056_ _057_ VGND VGND VPWR VPWR _058_ sky130_fd_sc_hd__nand2_1
XTAP_TAPCELL_ROW_0_44 VGND VPWR sky130_fd_sc_hd__tapvpwrvgnd_1
X_379_ _140_ _176_ VGND VGND VPWR VPWR adder.cla_blocks\[5\].block.sum\[2\] sky130_fd_sc_hd__xnor2_1
X_448_ clknet_2_0__leaf_clk adder.cla_blocks\[4\].block.sum\[0\] _016_ VGND VGND VPWR
+ VPWR net41 sky130_fd_sc_hd__dfrtp_1
X_233_ _039_ _040_ VGND VGND VPWR VPWR _041_ sky130_fd_sc_hd__nand2_1
X_302_ _105_ _109_ VGND VGND VPWR VPWR _110_ sky130_fd_sc_hd__or2_1
XFILLER_1_55 VGND VGND VPWR VPWR sky130_fd_sc_hd__fill_1
XTAP_TAPCELL_ROW_10_64 VGND VPWR sky130_fd_sc_hd__tapvpwrvgnd_1
X_216_ net68 VGND VGND VPWR VPWR _025_ sky130_fd_sc_hd__inv_2
XFILLER_18_3 VGND VGND VPWR VPWR sky130_fd_sc_hd__fill_2
XFILLER_7_54 VGND VGND VPWR VPWR sky130_fd_sc_hd__fill_2
XPHY_EDGE_ROW_20_Right_20 VGND VGND VPWR VPWR sky130_fd_sc_hd__decap_3
XFILLER_16_85 VGND VGND VPWR VPWR sky130_fd_sc_hd__fill_1
XPHY_EDGE_ROW_11_Right_11 VGND VGND VPWR VPWR sky130_fd_sc_hd__decap_3
X_395_ _105_ _184_ VGND VGND VPWR VPWR adder.cla_blocks\[3\].block.sum\[2\] sky130_fd_sc_hd__xnor2_1
XFILLER_13_86 VGND VGND VPWR VPWR sky130_fd_sc_hd__fill_1
X_378_ _136_ _175_ _135_ VGND VGND VPWR VPWR _176_ sky130_fd_sc_hd__a21bo_1
XTAP_TAPCELL_ROW_0_45 VGND VPWR sky130_fd_sc_hd__tapvpwrvgnd_1
X_447_ clknet_2_0__leaf_clk adder.cla_blocks\[3\].block.sum\[3\] _015_ VGND VGND VPWR
+ VPWR net40 sky130_fd_sc_hd__dfrtp_1
X_232_ net19 net52 VGND VGND VPWR VPWR _040_ sky130_fd_sc_hd__or2_1
X_301_ _106_ _108_ VGND VGND VPWR VPWR _109_ sky130_fd_sc_hd__nand2_1
XFILLER_1_67 VGND VGND VPWR VPWR sky130_fd_sc_hd__fill_2
XTAP_TAPCELL_ROW_10_65 VGND VPWR sky130_fd_sc_hd__tapvpwrvgnd_1
XFILLER_10_32 VGND VGND VPWR VPWR sky130_fd_sc_hd__fill_1
X_215_ net68 VGND VGND VPWR VPWR _024_ sky130_fd_sc_hd__inv_2
X_394_ _101_ _183_ _100_ VGND VGND VPWR VPWR _184_ sky130_fd_sc_hd__a21bo_1
X_463_ clknet_2_3__leaf_clk adder.cla_blocks\[7\].block.sum\[3\] _031_ VGND VGND VPWR
+ VPWR net58 sky130_fd_sc_hd__dfrtp_1
X_377_ _137_ _175_ VGND VGND VPWR VPWR adder.cla_blocks\[5\].block.sum\[1\] sky130_fd_sc_hd__xnor2_1
Xfanout66 net33 VGND VGND VPWR VPWR net66 sky130_fd_sc_hd__buf_4
XFILLER_1_122 VGND VGND VPWR VPWR sky130_fd_sc_hd__fill_2
X_446_ clknet_2_0__leaf_clk adder.cla_blocks\[3\].block.sum\[2\] _014_ VGND VGND VPWR
+ VPWR net39 sky130_fd_sc_hd__dfrtp_1
X_231_ net19 net52 VGND VGND VPWR VPWR _039_ sky130_fd_sc_hd__nand2_1
X_300_ net7 net40 VGND VGND VPWR VPWR _108_ sky130_fd_sc_hd__or2_1
X_429_ net67 VGND VGND VPWR VPWR _006_ sky130_fd_sc_hd__inv_2
XFILLER_1_57 VGND VGND VPWR VPWR sky130_fd_sc_hd__fill_1
XPHY_EDGE_ROW_7_Left_28 VGND VGND VPWR VPWR sky130_fd_sc_hd__decap_3
XFILLER_10_77 VGND VGND VPWR VPWR sky130_fd_sc_hd__decap_6
Xinput1 data_in[0] VGND VGND VPWR VPWR net1 sky130_fd_sc_hd__clkbuf_1
XFILLER_19_97 VGND VGND VPWR VPWR sky130_fd_sc_hd__fill_1
X_214_ net68 VGND VGND VPWR VPWR _023_ sky130_fd_sc_hd__inv_2
XTAP_TAPCELL_ROW_6_56 VGND VPWR sky130_fd_sc_hd__tapvpwrvgnd_1
XTAP_TAPCELL_ROW_16_76 VGND VPWR sky130_fd_sc_hd__tapvpwrvgnd_1
XPHY_EDGE_ROW_9_Right_9 VGND VGND VPWR VPWR sky130_fd_sc_hd__decap_3
X_462_ clknet_2_3__leaf_clk adder.cla_blocks\[7\].block.sum\[2\] _030_ VGND VGND VPWR
+ VPWR net57 sky130_fd_sc_hd__dfrtp_1
X_393_ _102_ _183_ VGND VGND VPWR VPWR adder.cla_blocks\[3\].block.sum\[1\] sky130_fd_sc_hd__xnor2_1
Xfanout67 net33 VGND VGND VPWR VPWR net67 sky130_fd_sc_hd__buf_2
X_376_ _134_ _147_ _146_ VGND VGND VPWR VPWR _175_ sky130_fd_sc_hd__a21bo_1
X_445_ clknet_2_0__leaf_clk adder.cla_blocks\[3\].block.sum\[1\] _013_ VGND VGND VPWR
+ VPWR net38 sky130_fd_sc_hd__dfrtp_1
X_230_ net20 net53 VGND VGND VPWR VPWR _038_ sky130_fd_sc_hd__xnor2_1
X_359_ _032_ _157_ _159_ _158_ VGND VGND VPWR VPWR _165_ sky130_fd_sc_hd__a31o_1
X_428_ net67 VGND VGND VPWR VPWR _005_ sky130_fd_sc_hd__inv_2
Xinput2 data_in[10] VGND VGND VPWR VPWR net2 sky130_fd_sc_hd__clkbuf_1
XFILLER_10_56 VGND VGND VPWR VPWR sky130_fd_sc_hd__fill_1
X_213_ net68 VGND VGND VPWR VPWR _022_ sky130_fd_sc_hd__inv_2
XTAP_TAPCELL_ROW_6_57 VGND VPWR sky130_fd_sc_hd__tapvpwrvgnd_1
XFILLER_7_57 VGND VGND VPWR VPWR sky130_fd_sc_hd__decap_3
XTAP_TAPCELL_ROW_16_77 VGND VPWR sky130_fd_sc_hd__tapvpwrvgnd_1
XPHY_EDGE_ROW_10_Left_31 VGND VGND VPWR VPWR sky130_fd_sc_hd__decap_3
X_461_ clknet_2_3__leaf_clk adder.cla_blocks\[7\].block.sum\[1\] _029_ VGND VGND VPWR
+ VPWR net55 sky130_fd_sc_hd__dfrtp_1
X_392_ _099_ _114_ _112_ VGND VGND VPWR VPWR _183_ sky130_fd_sc_hd__a21bo_1
Xfanout68 net33 VGND VGND VPWR VPWR net68 sky130_fd_sc_hd__buf_4
X_375_ _134_ _148_ VGND VGND VPWR VPWR adder.cla_blocks\[5\].block.sum\[0\] sky130_fd_sc_hd__xnor2_1
X_444_ clknet_2_0__leaf_clk adder.cla_blocks\[3\].block.sum\[0\] _012_ VGND VGND VPWR
+ VPWR net37 sky130_fd_sc_hd__dfrtp_1
X_358_ _162_ _163_ VGND VGND VPWR VPWR _164_ sky130_fd_sc_hd__and2b_1
X_427_ net67 VGND VGND VPWR VPWR _004_ sky130_fd_sc_hd__inv_2
XPHY_EDGE_ROW_18_Right_18 VGND VGND VPWR VPWR sky130_fd_sc_hd__decap_3
Xinput3 data_in[11] VGND VGND VPWR VPWR net3 sky130_fd_sc_hd__clkbuf_1
X_289_ _092_ _095_ _062_ _067_ VGND VGND VPWR VPWR _097_ sky130_fd_sc_hd__a211oi_1
X_212_ net68 VGND VGND VPWR VPWR _021_ sky130_fd_sc_hd__inv_2
XFILLER_16_23 VGND VGND VPWR VPWR sky130_fd_sc_hd__fill_2
XFILLER_16_67 VGND VGND VPWR VPWR sky130_fd_sc_hd__fill_2
XPHY_EDGE_ROW_0_Right_0 VGND VGND VPWR VPWR sky130_fd_sc_hd__decap_3
X_391_ _099_ _114_ VGND VGND VPWR VPWR adder.cla_blocks\[3\].block.sum\[0\] sky130_fd_sc_hd__xor2_1
X_460_ clknet_2_3__leaf_clk adder.cla_blocks\[7\].block.sum\[0\] _028_ VGND VGND VPWR
+ VPWR net54 sky130_fd_sc_hd__dfrtp_1
Xfanout69 net33 VGND VGND VPWR VPWR net69 sky130_fd_sc_hd__buf_2
XFILLER_13_13 VPWR VGND VPWR VGND sky130_ef_sc_hd__decap_12
XFILLER_13_57 VGND VGND VPWR VPWR sky130_fd_sc_hd__decap_8
XFILLER_13_68 VPWR VGND VPWR VGND sky130_ef_sc_hd__decap_12
X_374_ _038_ _174_ VGND VGND VPWR VPWR adder.cla_blocks\[6\].block.sum\[3\] sky130_fd_sc_hd__xor2_1
X_443_ clknet_2_1__leaf_clk adder.cla_blocks\[2\].block.sum\[3\] _011_ VGND VGND VPWR
+ VPWR net36 sky130_fd_sc_hd__dfrtp_1
X_357_ net24 net57 VGND VGND VPWR VPWR _163_ sky130_fd_sc_hd__nand2_1
Xinput4 data_in[12] VGND VGND VPWR VPWR net4 sky130_fd_sc_hd__buf_1
Xclkbuf_2_1__f_clk clknet_0_clk VGND VGND VPWR VPWR clknet_2_1__leaf_clk sky130_fd_sc_hd__clkbuf_16
X_288_ _092_ _095_ _067_ VGND VGND VPWR VPWR _096_ sky130_fd_sc_hd__a21o_1
X_426_ net67 VGND VGND VPWR VPWR _003_ sky130_fd_sc_hd__inv_2
XFILLER_10_36 VPWR VGND VPWR VGND sky130_ef_sc_hd__decap_12
X_211_ net68 VGND VGND VPWR VPWR _020_ sky130_fd_sc_hd__inv_2
X_409_ _088_ _190_ _087_ VGND VGND VPWR VPWR _192_ sky130_fd_sc_hd__a21o_1
X_390_ _123_ _182_ VGND VGND VPWR VPWR adder.cla_blocks\[4\].block.sum\[3\] sky130_fd_sc_hd__xnor2_1
XFILLER_13_25 VGND VGND VPWR VPWR sky130_fd_sc_hd__decap_6
X_373_ _039_ _043_ _173_ VGND VGND VPWR VPWR _174_ sky130_fd_sc_hd__and3_1
X_442_ clknet_2_0__leaf_clk adder.cla_blocks\[2\].block.sum\[2\] _010_ VGND VGND VPWR
+ VPWR net35 sky130_fd_sc_hd__dfrtp_1
X_356_ net24 net57 VGND VGND VPWR VPWR _162_ sky130_fd_sc_hd__nor2_1
Xinput5 data_in[13] VGND VGND VPWR VPWR net5 sky130_fd_sc_hd__clkbuf_1
X_287_ _084_ _087_ _088_ _094_ VGND VGND VPWR VPWR _095_ sky130_fd_sc_hd__o31a_1
X_425_ net66 VGND VGND VPWR VPWR _002_ sky130_fd_sc_hd__inv_2
XFILLER_19_57 VGND VGND VPWR VPWR sky130_fd_sc_hd__fill_2
XFILLER_10_48 VGND VGND VPWR VPWR sky130_fd_sc_hd__decap_8
X_408_ _190_ _191_ VGND VGND VPWR VPWR adder.cla_blocks\[1\].block.sum\[0\] sky130_fd_sc_hd__and2_1
X_210_ net68 VGND VGND VPWR VPWR _019_ sky130_fd_sc_hd__inv_2
X_339_ net13 net46 VGND VGND VPWR VPWR _147_ sky130_fd_sc_hd__or2_1
XFILLER_7_27 VGND VGND VPWR VPWR sky130_fd_sc_hd__fill_2
Xinput30 data_in[7] VGND VGND VPWR VPWR net30 sky130_fd_sc_hd__clkbuf_1
XFILLER_11_91 VGND VGND VPWR VPWR sky130_fd_sc_hd__decap_4
XFILLER_8_92 VGND VGND VPWR VPWR sky130_fd_sc_hd__fill_1
XPHY_EDGE_ROW_14_Left_35 VGND VGND VPWR VPWR sky130_fd_sc_hd__decap_3
X_372_ _041_ _172_ VGND VGND VPWR VPWR adder.cla_blocks\[6\].block.sum\[2\] sky130_fd_sc_hd__xnor2_1
X_441_ clknet_2_1__leaf_clk adder.cla_blocks\[2\].block.sum\[1\] _009_ VGND VGND VPWR
+ VPWR net65 sky130_fd_sc_hd__dfrtp_1
X_355_ _160_ _161_ VGND VGND VPWR VPWR adder.cla_blocks\[7\].block.sum\[1\] sky130_fd_sc_hd__xnor2_1
X_286_ _084_ _085_ _093_ _082_ VGND VGND VPWR VPWR _094_ sky130_fd_sc_hd__o22a_1
X_424_ net69 VGND VGND VPWR VPWR _001_ sky130_fd_sc_hd__inv_2
Xinput6 data_in[14] VGND VGND VPWR VPWR net6 sky130_fd_sc_hd__clkbuf_1
XFILLER_10_27 VGND VGND VPWR VPWR sky130_fd_sc_hd__fill_1
XPHY_EDGE_ROW_14_Right_14 VGND VGND VPWR VPWR sky130_fd_sc_hd__decap_3
XPHY_EDGE_ROW_2_Left_23 VGND VGND VPWR VPWR sky130_fd_sc_hd__decap_3
X_269_ net26 net59 _068_ VGND VGND VPWR VPWR _077_ sky130_fd_sc_hd__a21o_1
X_407_ _079_ _090_ VGND VGND VPWR VPWR _191_ sky130_fd_sc_hd__nand2_1
X_338_ net13 net46 VGND VGND VPWR VPWR _146_ sky130_fd_sc_hd__nand2_1
Xinput20 data_in[27] VGND VGND VPWR VPWR net20 sky130_fd_sc_hd__buf_1
Xinput31 data_in[8] VGND VGND VPWR VPWR net31 sky130_fd_sc_hd__clkbuf_1
XFILLER_11_81 VGND VGND VPWR VPWR sky130_fd_sc_hd__decap_6
XFILLER_7_122 VGND VGND VPWR VPWR sky130_fd_sc_hd__fill_2
XPHY_EDGE_ROW_4_Right_4 VGND VGND VPWR VPWR sky130_fd_sc_hd__decap_3
XFILLER_8_82 VGND VGND VPWR VPWR sky130_fd_sc_hd__fill_2
X_371_ _049_ _155_ _042_ VGND VGND VPWR VPWR _173_ sky130_fd_sc_hd__a21o_1
X_440_ clknet_2_1__leaf_clk adder.cla_blocks\[2\].block.sum\[0\] _008_ VGND VGND VPWR
+ VPWR net64 sky130_fd_sc_hd__dfrtp_1
XFILLER_13_38 VGND VGND VPWR VPWR sky130_fd_sc_hd__decap_8
XFILLER_13_49 VGND VGND VPWR VPWR sky130_fd_sc_hd__decap_4
X_354_ _032_ _157_ VGND VGND VPWR VPWR _161_ sky130_fd_sc_hd__nand2_1
X_285_ net29 net62 _081_ VGND VGND VPWR VPWR _093_ sky130_fd_sc_hd__a21oi_1
X_423_ _074_ _199_ VGND VGND VPWR VPWR adder.cla_blocks\[0\].block.p\[0\] sky130_fd_sc_hd__and2_1
Xinput7 data_in[15] VGND VGND VPWR VPWR net7 sky130_fd_sc_hd__buf_1
XFILLER_4_3 VGND VGND VPWR VPWR sky130_fd_sc_hd__fill_2
X_337_ _144_ VGND VGND VPWR VPWR _145_ sky130_fd_sc_hd__inv_2
X_406_ _079_ _090_ VGND VGND VPWR VPWR _190_ sky130_fd_sc_hd__or2_1
X_268_ _068_ _069_ _075_ VGND VGND VPWR VPWR _076_ sky130_fd_sc_hd__nor3_2
Xinput32 data_in[9] VGND VGND VPWR VPWR net32 sky130_fd_sc_hd__clkbuf_1
Xinput21 data_in[28] VGND VGND VPWR VPWR net21 sky130_fd_sc_hd__clkbuf_1
Xinput10 data_in[18] VGND VGND VPWR VPWR net10 sky130_fd_sc_hd__buf_1
X_370_ _036_ _171_ _035_ VGND VGND VPWR VPWR _172_ sky130_fd_sc_hd__a21bo_1
X_353_ _158_ _159_ VGND VGND VPWR VPWR _160_ sky130_fd_sc_hd__nand2b_1
X_284_ net26 net59 _076_ _077_ _091_ VGND VGND VPWR VPWR _092_ sky130_fd_sc_hd__o221ai_4
X_422_ net1 net34 VGND VGND VPWR VPWR _199_ sky130_fd_sc_hd__or2_1
Xinput8 data_in[16] VGND VGND VPWR VPWR net8 sky130_fd_sc_hd__buf_1
XFILLER_14_82 VGND VGND VPWR VPWR sky130_fd_sc_hd__fill_2
X_336_ _137_ _140_ _143_ VGND VGND VPWR VPWR _144_ sky130_fd_sc_hd__nor3_1
X_405_ _055_ _189_ VGND VGND VPWR VPWR adder.cla_blocks\[2\].block.sum\[3\] sky130_fd_sc_hd__xnor2_1
X_267_ _072_ _074_ _070_ VGND VGND VPWR VPWR _075_ sky130_fd_sc_hd__o21a_1
XFILLER_2_52 VGND VGND VPWR VPWR sky130_fd_sc_hd__fill_1
Xinput22 data_in[29] VGND VGND VPWR VPWR net22 sky130_fd_sc_hd__clkbuf_1
Xinput33 rst VGND VGND VPWR VPWR net33 sky130_fd_sc_hd__dlymetal6s2s_1
X_319_ net8 net41 VGND VGND VPWR VPWR _127_ sky130_fd_sc_hd__or2_1
Xinput11 data_in[19] VGND VGND VPWR VPWR net11 sky130_fd_sc_hd__buf_1
XFILLER_11_120 VGND VGND VPWR VPWR sky130_fd_sc_hd__fill_1
XFILLER_8_73 VGND VGND VPWR VPWR sky130_fd_sc_hd__decap_6
XPHY_EDGE_ROW_18_Left_39 VGND VGND VPWR VPWR sky130_fd_sc_hd__decap_3
XTAP_TAPCELL_ROW_4_52 VGND VPWR sky130_fd_sc_hd__tapvpwrvgnd_1
X_421_ _078_ _198_ VGND VGND VPWR VPWR adder.cla_blocks\[0\].block.sum\[3\] sky130_fd_sc_hd__xnor2_1
XTAP_TAPCELL_ROW_14_72 VGND VPWR sky130_fd_sc_hd__tapvpwrvgnd_1
X_352_ net22 net55 VGND VGND VPWR VPWR _159_ sky130_fd_sc_hd__nand2_1
X_283_ _084_ _087_ _090_ VGND VGND VPWR VPWR _091_ sky130_fd_sc_hd__nor3_1
Xinput9 data_in[17] VGND VGND VPWR VPWR net9 sky130_fd_sc_hd__buf_1
XFILLER_19_28 VGND VGND VPWR VPWR sky130_fd_sc_hd__fill_1
XFILLER_10_19 VGND VGND VPWR VPWR sky130_fd_sc_hd__fill_2
X_335_ _141_ _142_ VGND VGND VPWR VPWR _143_ sky130_fd_sc_hd__nand2_1
X_404_ _057_ _188_ _056_ VGND VGND VPWR VPWR _189_ sky130_fd_sc_hd__a21bo_1
X_266_ net1 net34 VGND VGND VPWR VPWR _074_ sky130_fd_sc_hd__nand2_1
XPHY_EDGE_ROW_10_Right_10 VGND VGND VPWR VPWR sky130_fd_sc_hd__decap_3
XPHY_EDGE_ROW_6_Left_27 VGND VGND VPWR VPWR sky130_fd_sc_hd__decap_3
X_249_ net2 net35 VGND VGND VPWR VPWR _057_ sky130_fd_sc_hd__or2_1
Xinput23 data_in[2] VGND VGND VPWR VPWR net23 sky130_fd_sc_hd__clkbuf_1
X_318_ net8 net41 VGND VGND VPWR VPWR _126_ sky130_fd_sc_hd__nand2_1
Xinput12 data_in[1] VGND VGND VPWR VPWR net12 sky130_fd_sc_hd__clkbuf_1
XFILLER_17_72 VGND VGND VPWR VPWR sky130_fd_sc_hd__fill_2
XTAP_TAPCELL_ROW_4_53 VGND VPWR sky130_fd_sc_hd__tapvpwrvgnd_1
XPHY_EDGE_ROW_9_Left_30 VGND VGND VPWR VPWR sky130_fd_sc_hd__decap_3
XPHY_EDGE_ROW_8_Right_8 VGND VGND VPWR VPWR sky130_fd_sc_hd__decap_3
XTAP_TAPCELL_ROW_14_73 VGND VPWR sky130_fd_sc_hd__tapvpwrvgnd_1
X_282_ _088_ _089_ VGND VGND VPWR VPWR _090_ sky130_fd_sc_hd__nand2_1
X_420_ _068_ _076_ VGND VGND VPWR VPWR _198_ sky130_fd_sc_hd__nor2_1
X_351_ net22 net55 VGND VGND VPWR VPWR _158_ sky130_fd_sc_hd__nor2_1
X_334_ net16 net49 VGND VGND VPWR VPWR _142_ sky130_fd_sc_hd__or2_1
X_403_ _058_ _188_ VGND VGND VPWR VPWR adder.cla_blocks\[2\].block.sum\[2\] sky130_fd_sc_hd__xnor2_1
X_265_ _071_ _072_ VGND VGND VPWR VPWR _073_ sky130_fd_sc_hd__nor2_1
Xinput24 data_in[30] VGND VGND VPWR VPWR net24 sky130_fd_sc_hd__clkbuf_1
Xinput13 data_in[20] VGND VGND VPWR VPWR net13 sky130_fd_sc_hd__clkbuf_1
X_248_ net2 net35 VGND VGND VPWR VPWR _056_ sky130_fd_sc_hd__nand2_1
X_317_ _119_ _124_ VGND VGND VPWR VPWR _125_ sky130_fd_sc_hd__and2b_1
Xclkbuf_2_2__f_clk clknet_0_clk VGND VGND VPWR VPWR clknet_2_2__leaf_clk sky130_fd_sc_hd__clkbuf_16
XFILLER_7_104 VGND VGND VPWR VPWR sky130_fd_sc_hd__fill_2
XFILLER_11_111 VGND VGND VPWR VPWR sky130_fd_sc_hd__fill_1
X_281_ net27 net60 VGND VGND VPWR VPWR _089_ sky130_fd_sc_hd__or2_1
XFILLER_14_74 VGND VGND VPWR VPWR sky130_fd_sc_hd__fill_1
X_350_ _034_ _156_ VGND VGND VPWR VPWR adder.cla_blocks\[7\].block.sum\[0\] sky130_fd_sc_hd__xnor2_1
X_333_ net16 net49 VGND VGND VPWR VPWR _141_ sky130_fd_sc_hd__nand2_1
X_402_ _060_ _187_ _059_ VGND VGND VPWR VPWR _188_ sky130_fd_sc_hd__a21bo_1
X_264_ net12 net45 VGND VGND VPWR VPWR _072_ sky130_fd_sc_hd__nor2_1
Xinput25 data_in[31] VGND VGND VPWR VPWR net25 sky130_fd_sc_hd__clkbuf_1
Xinput14 data_in[21] VGND VGND VPWR VPWR net14 sky130_fd_sc_hd__clkbuf_1
X_247_ _052_ _054_ VGND VGND VPWR VPWR _055_ sky130_fd_sc_hd__nand2_1
X_316_ _122_ _123_ VGND VGND VPWR VPWR _124_ sky130_fd_sc_hd__nor2_1
XFILLER_8_10 VGND VGND VPWR VPWR sky130_fd_sc_hd__fill_1
XFILLER_12_6 VGND VGND VPWR VPWR sky130_fd_sc_hd__fill_2
XFILLER_0_122 VGND VGND VPWR VPWR sky130_fd_sc_hd__fill_2
XFILLER_0_111 VGND VGND VPWR VPWR sky130_fd_sc_hd__fill_1
XFILLER_5_55 VGND VGND VPWR VPWR sky130_fd_sc_hd__fill_1
XFILLER_10_3 VGND VGND VPWR VPWR sky130_fd_sc_hd__fill_1
X_280_ net27 net60 VGND VGND VPWR VPWR _088_ sky130_fd_sc_hd__nand2_1
X_332_ _138_ _139_ VGND VGND VPWR VPWR _140_ sky130_fd_sc_hd__nand2_1
XFILLER_2_89 VGND VGND VPWR VPWR sky130_fd_sc_hd__fill_2
X_401_ _061_ _187_ VGND VGND VPWR VPWR adder.cla_blocks\[2\].block.sum\[1\] sky130_fd_sc_hd__xnor2_1
X_263_ _070_ VGND VGND VPWR VPWR _071_ sky130_fd_sc_hd__inv_2
Xinput15 data_in[22] VGND VGND VPWR VPWR net15 sky130_fd_sc_hd__clkbuf_1
X_246_ net3 net36 VGND VGND VPWR VPWR _054_ sky130_fd_sc_hd__or2_1
Xinput26 data_in[3] VGND VGND VPWR VPWR net26 sky130_fd_sc_hd__clkbuf_2
X_315_ net11 net44 VGND VGND VPWR VPWR _123_ sky130_fd_sc_hd__xnor2_1
XFILLER_11_113 VGND VGND VPWR VPWR sky130_fd_sc_hd__fill_1
X_229_ _035_ _036_ VGND VGND VPWR VPWR _037_ sky130_fd_sc_hd__nand2_1
XPHY_EDGE_ROW_17_Right_17 VGND VGND VPWR VPWR sky130_fd_sc_hd__decap_3
XFILLER_5_23 VGND VGND VPWR VPWR sky130_fd_sc_hd__fill_1
XTAP_TAPCELL_ROW_1_46 VGND VPWR sky130_fd_sc_hd__tapvpwrvgnd_1
X_331_ net15 net48 VGND VGND VPWR VPWR _139_ sky130_fd_sc_hd__nand2_1
X_400_ _065_ _096_ VGND VGND VPWR VPWR _187_ sky130_fd_sc_hd__nand2_1
X_262_ net12 net45 VGND VGND VPWR VPWR _070_ sky130_fd_sc_hd__nand2_1
XFILLER_2_13 VGND VGND VPWR VPWR sky130_fd_sc_hd__fill_2
XTAP_TAPCELL_ROW_11_66 VGND VPWR sky130_fd_sc_hd__tapvpwrvgnd_1
Xinput16 data_in[23] VGND VGND VPWR VPWR net16 sky130_fd_sc_hd__clkbuf_1
X_245_ net3 net36 VGND VGND VPWR VPWR _053_ sky130_fd_sc_hd__nor2_1
Xinput27 data_in[4] VGND VGND VPWR VPWR net27 sky130_fd_sc_hd__clkbuf_1
X_314_ _120_ _121_ VGND VGND VPWR VPWR _122_ sky130_fd_sc_hd__nand2_1
XFILLER_8_45 VPWR VGND VPWR VGND sky130_ef_sc_hd__decap_12
X_228_ net18 net51 VGND VGND VPWR VPWR _036_ sky130_fd_sc_hd__or2_1
XPHY_EDGE_ROW_13_Left_34 VGND VGND VPWR VPWR sky130_fd_sc_hd__decap_3
XTAP_TAPCELL_ROW_1_47 VGND VPWR sky130_fd_sc_hd__tapvpwrvgnd_1
X_330_ net15 net48 VGND VGND VPWR VPWR _138_ sky130_fd_sc_hd__or2_1
X_261_ net23 net56 VGND VGND VPWR VPWR _069_ sky130_fd_sc_hd__nor2_1
X_459_ clknet_2_3__leaf_clk adder.cla_blocks\[6\].block.sum\[3\] _027_ VGND VGND VPWR
+ VPWR net53 sky130_fd_sc_hd__dfrtp_1
XTAP_TAPCELL_ROW_11_67 VGND VPWR sky130_fd_sc_hd__tapvpwrvgnd_1
Xinput17 data_in[24] VGND VGND VPWR VPWR net17 sky130_fd_sc_hd__clkbuf_1
X_244_ net3 net36 VGND VGND VPWR VPWR _052_ sky130_fd_sc_hd__nand2_1
XPHY_EDGE_ROW_1_Left_22 VGND VGND VPWR VPWR sky130_fd_sc_hd__decap_3
Xinput28 data_in[5] VGND VGND VPWR VPWR net28 sky130_fd_sc_hd__clkbuf_1
X_313_ net10 net43 VGND VGND VPWR VPWR _121_ sky130_fd_sc_hd__nand2_1
XFILLER_14_112 VGND VGND VPWR VPWR sky130_fd_sc_hd__fill_2
X_227_ net18 net51 VGND VGND VPWR VPWR _035_ sky130_fd_sc_hd__nand2_1
XFILLER_8_57 VPWR VGND VPWR VGND sky130_ef_sc_hd__decap_12
XPHY_EDGE_ROW_3_Right_3 VGND VGND VPWR VPWR sky130_fd_sc_hd__decap_3
XFILLER_5_69 VGND VGND VPWR VPWR sky130_fd_sc_hd__fill_1
XFILLER_14_23 VGND VGND VPWR VPWR sky130_fd_sc_hd__fill_2
X_260_ net23 net56 VGND VGND VPWR VPWR _068_ sky130_fd_sc_hd__and2_1
X_458_ clknet_2_2__leaf_clk adder.cla_blocks\[6\].block.sum\[2\] _026_ VGND VGND VPWR
+ VPWR net52 sky130_fd_sc_hd__dfrtp_1
X_389_ _120_ _181_ _121_ VGND VGND VPWR VPWR _182_ sky130_fd_sc_hd__a21bo_1
XFILLER_11_57 VPWR VGND VPWR VGND sky130_ef_sc_hd__decap_12
Xinput18 data_in[25] VGND VGND VPWR VPWR net18 sky130_fd_sc_hd__clkbuf_1
X_243_ _049_ _050_ VGND VGND VPWR VPWR _051_ sky130_fd_sc_hd__nand2_1
Xinput29 data_in[6] VGND VGND VPWR VPWR net29 sky130_fd_sc_hd__buf_1
XTAP_TAPCELL_ROW_7_58 VGND VPWR sky130_fd_sc_hd__tapvpwrvgnd_1
X_312_ net10 net43 VGND VGND VPWR VPWR _120_ sky130_fd_sc_hd__or2_1
X_226_ _032_ _033_ VGND VGND VPWR VPWR _034_ sky130_fd_sc_hd__nand2_1
XFILLER_8_69 VGND VGND VPWR VPWR sky130_fd_sc_hd__fill_1
XTAP_TAPCELL_ROW_17_78 VGND VPWR sky130_fd_sc_hd__tapvpwrvgnd_1
XFILLER_17_34 VGND VGND VPWR VPWR sky130_fd_sc_hd__fill_2
XFILLER_3_123 VGND VGND VPWR VPWR sky130_fd_sc_hd__fill_1
X_209_ net68 VGND VGND VPWR VPWR _018_ sky130_fd_sc_hd__inv_2
XPHY_EDGE_ROW_13_Right_13 VGND VGND VPWR VPWR sky130_fd_sc_hd__decap_3
X_457_ clknet_2_2__leaf_clk adder.cla_blocks\[6\].block.sum\[1\] _025_ VGND VGND VPWR
+ VPWR net51 sky130_fd_sc_hd__dfrtp_1
X_388_ _122_ _181_ VGND VGND VPWR VPWR adder.cla_blocks\[4\].block.sum\[2\] sky130_fd_sc_hd__xnor2_1
Xinput19 data_in[26] VGND VGND VPWR VPWR net19 sky130_fd_sc_hd__buf_1
X_242_ net17 net50 VGND VGND VPWR VPWR _050_ sky130_fd_sc_hd__or2_1
XTAP_TAPCELL_ROW_7_59 VGND VPWR sky130_fd_sc_hd__tapvpwrvgnd_1
X_311_ net9 net42 VGND VGND VPWR VPWR _119_ sky130_fd_sc_hd__xnor2_1
XFILLER_11_69 VPWR VGND VPWR VGND sky130_ef_sc_hd__decap_12
X_225_ net21 net54 VGND VGND VPWR VPWR _033_ sky130_fd_sc_hd__or2_1
XTAP_TAPCELL_ROW_17_79 VGND VPWR sky130_fd_sc_hd__tapvpwrvgnd_1
X_208_ net66 VGND VGND VPWR VPWR _017_ sky130_fd_sc_hd__inv_2
XPHY_EDGE_ROW_17_Left_38 VGND VGND VPWR VPWR sky130_fd_sc_hd__decap_3
Xclkbuf_2_3__f_clk clknet_0_clk VGND VGND VPWR VPWR clknet_2_3__leaf_clk sky130_fd_sc_hd__clkbuf_16
X_387_ net9 net42 _179_ VGND VGND VPWR VPWR _181_ sky130_fd_sc_hd__a21o_1
X_456_ clknet_2_2__leaf_clk adder.cla_blocks\[6\].block.sum\[0\] _024_ VGND VGND VPWR
+ VPWR net50 sky130_fd_sc_hd__dfrtp_1
X_310_ _115_ _117_ VGND VGND VPWR VPWR _118_ sky130_fd_sc_hd__or2_1
XFILLER_11_48 VGND VGND VPWR VPWR sky130_fd_sc_hd__decap_8
X_241_ net17 net50 VGND VGND VPWR VPWR _049_ sky130_fd_sc_hd__nand2_1
X_439_ clknet_2_1__leaf_clk adder.cla_blocks\[1\].block.sum\[3\] _007_ VGND VGND VPWR
+ VPWR net63 sky130_fd_sc_hd__dfrtp_1
XPHY_EDGE_ROW_5_Left_26 VGND VGND VPWR VPWR sky130_fd_sc_hd__decap_3
X_224_ net21 net54 VGND VGND VPWR VPWR _032_ sky130_fd_sc_hd__nand2_1
X_207_ net66 VGND VGND VPWR VPWR _016_ sky130_fd_sc_hd__inv_2
XFILLER_0_117 VGND VGND VPWR VPWR sky130_fd_sc_hd__fill_1
XFILLER_0_83 VGND VGND VPWR VPWR sky130_fd_sc_hd__fill_1
XFILLER_10_9 VGND VGND VPWR VPWR sky130_fd_sc_hd__fill_2
XPHY_EDGE_ROW_7_Right_7 VGND VGND VPWR VPWR sky130_fd_sc_hd__decap_3
X_455_ clknet_2_2__leaf_clk adder.cla_blocks\[5\].block.sum\[3\] _023_ VGND VGND VPWR
+ VPWR net49 sky130_fd_sc_hd__dfrtp_1
X_386_ _179_ _180_ VGND VGND VPWR VPWR adder.cla_blocks\[4\].block.sum\[1\] sky130_fd_sc_hd__nor2_1
X_240_ _038_ _042_ _047_ VGND VGND VPWR VPWR _048_ sky130_fd_sc_hd__o21a_1
X_369_ _037_ _171_ VGND VGND VPWR VPWR adder.cla_blocks\[6\].block.sum\[1\] sky130_fd_sc_hd__xnor2_1
X_438_ clknet_2_1__leaf_clk adder.cla_blocks\[1\].block.sum\[2\] _006_ VGND VGND VPWR
+ VPWR net62 sky130_fd_sc_hd__dfrtp_1
XFILLER_8_17 VGND VGND VPWR VPWR sky130_fd_sc_hd__fill_1
X_223_ net69 VGND VGND VPWR VPWR _000_ sky130_fd_sc_hd__inv_2
XTAP_TAPCELL_ROW_8_60 VGND VPWR sky130_fd_sc_hd__tapvpwrvgnd_1
X_206_ net66 VGND VGND VPWR VPWR _015_ sky130_fd_sc_hd__inv_2
XFILLER_9_60 VGND VGND VPWR VPWR sky130_fd_sc_hd__decap_8
XTAP_TAPCELL_ROW_18_80 VGND VPWR sky130_fd_sc_hd__tapvpwrvgnd_1
X_454_ clknet_2_2__leaf_clk adder.cla_blocks\[5\].block.sum\[2\] _022_ VGND VGND VPWR
+ VPWR net48 sky130_fd_sc_hd__dfrtp_1
X_385_ _119_ _126_ _178_ VGND VGND VPWR VPWR _180_ sky130_fd_sc_hd__and3_1
X_368_ _049_ _155_ VGND VGND VPWR VPWR _171_ sky130_fd_sc_hd__nand2_1
XFILLER_3_51 VGND VGND VPWR VPWR sky130_fd_sc_hd__fill_1
X_299_ net7 net40 VGND VGND VPWR VPWR _107_ sky130_fd_sc_hd__nor2_1
X_437_ clknet_2_1__leaf_clk adder.cla_blocks\[1\].block.sum\[1\] _005_ VGND VGND VPWR
+ VPWR net61 sky130_fd_sc_hd__dfrtp_1
XFILLER_8_29 VGND VGND VPWR VPWR sky130_fd_sc_hd__fill_2
XTAP_TAPCELL_ROW_8_61 VGND VPWR sky130_fd_sc_hd__tapvpwrvgnd_1
X_222_ net69 VGND VGND VPWR VPWR _031_ sky130_fd_sc_hd__inv_2
X_205_ net66 VGND VGND VPWR VPWR _014_ sky130_fd_sc_hd__inv_2
XFILLER_0_85 VGND VGND VPWR VPWR sky130_fd_sc_hd__fill_2
XTAP_TAPCELL_ROW_18_81 VGND VPWR sky130_fd_sc_hd__tapvpwrvgnd_1
XFILLER_18_92 VGND VGND VPWR VPWR sky130_fd_sc_hd__fill_2
XFILLER_20_82 VGND VGND VPWR VPWR sky130_fd_sc_hd__fill_2
XFILLER_6_62 VGND VGND VPWR VPWR sky130_fd_sc_hd__fill_1
X_453_ clknet_2_2__leaf_clk adder.cla_blocks\[5\].block.sum\[1\] _021_ VGND VGND VPWR
+ VPWR net47 sky130_fd_sc_hd__dfrtp_1
X_384_ _126_ _178_ _119_ VGND VGND VPWR VPWR _179_ sky130_fd_sc_hd__a21oi_1
X_298_ net7 net40 VGND VGND VPWR VPWR _106_ sky130_fd_sc_hd__nand2_1
X_436_ clknet_2_1__leaf_clk adder.cla_blocks\[1\].block.sum\[0\] _004_ VGND VGND VPWR
+ VPWR net60 sky130_fd_sc_hd__dfrtp_1
X_367_ _154_ _170_ VGND VGND VPWR VPWR adder.cla_blocks\[6\].block.sum\[0\] sky130_fd_sc_hd__nor2_1
X_221_ net69 VGND VGND VPWR VPWR _030_ sky130_fd_sc_hd__inv_2
XFILLER_12_61 VPWR VGND VPWR VGND sky130_ef_sc_hd__decap_12
X_419_ _076_ _197_ VGND VGND VPWR VPWR adder.cla_blocks\[0\].block.sum\[2\] sky130_fd_sc_hd__nor2_1
XFILLER_3_117 VGND VGND VPWR VPWR sky130_fd_sc_hd__fill_1
X_204_ net66 VGND VGND VPWR VPWR _013_ sky130_fd_sc_hd__inv_2
XFILLER_14_18 VGND VGND VPWR VPWR sky130_fd_sc_hd__fill_2
XFILLER_14_29 VGND VGND VPWR VPWR sky130_fd_sc_hd__fill_2
XFILLER_6_85 VGND VGND VPWR VPWR sky130_fd_sc_hd__fill_1
X_383_ _118_ _128_ VGND VGND VPWR VPWR adder.cla_blocks\[4\].block.sum\[0\] sky130_fd_sc_hd__xor2_1
X_452_ clknet_2_2__leaf_clk adder.cla_blocks\[5\].block.sum\[0\] _020_ VGND VGND VPWR
+ VPWR net46 sky130_fd_sc_hd__dfrtp_1
XFILLER_15_72 VGND VGND VPWR VPWR sky130_fd_sc_hd__fill_1
Xoutput60 net60 VGND VGND VPWR VPWR acc[4] sky130_fd_sc_hd__buf_2
X_366_ _051_ _149_ _153_ VGND VGND VPWR VPWR _170_ sky130_fd_sc_hd__and3_1
X_297_ _103_ _104_ VGND VGND VPWR VPWR _105_ sky130_fd_sc_hd__nand2_1
X_435_ clknet_2_1__leaf_clk adder.cla_blocks\[0\].block.sum\[3\] _003_ VGND VGND VPWR
+ VPWR net59 sky130_fd_sc_hd__dfrtp_4
X_220_ net69 VGND VGND VPWR VPWR _029_ sky130_fd_sc_hd__inv_2
XFILLER_12_73 VGND VGND VPWR VPWR sky130_fd_sc_hd__decap_8
X_349_ _047_ _049_ _155_ _048_ _034_ VGND VGND VPWR VPWR _157_ sky130_fd_sc_hd__a311o_1
X_418_ _068_ _069_ _075_ VGND VGND VPWR VPWR _197_ sky130_fd_sc_hd__o21a_1
XFILLER_0_98 VGND VGND VPWR VPWR sky130_fd_sc_hd__fill_2
X_203_ net66 VGND VGND VPWR VPWR _012_ sky130_fd_sc_hd__inv_2
XPHY_EDGE_ROW_12_Left_33 VGND VGND VPWR VPWR sky130_fd_sc_hd__decap_3
XTAP_TAPCELL_ROW_20_84 VGND VPWR sky130_fd_sc_hd__tapvpwrvgnd_1
Xoutput50 net50 VGND VGND VPWR VPWR acc[24] sky130_fd_sc_hd__buf_2
XFILLER_15_62 VGND VGND VPWR VPWR sky130_fd_sc_hd__fill_2
Xoutput61 net61 VGND VGND VPWR VPWR acc[5] sky130_fd_sc_hd__buf_2
X_382_ _118_ _128_ VGND VGND VPWR VPWR _178_ sky130_fd_sc_hd__nand2_1
X_451_ clknet_2_2__leaf_clk adder.cla_blocks\[4\].block.sum\[3\] _019_ VGND VGND VPWR
+ VPWR net44 sky130_fd_sc_hd__dfrtp_1
X_365_ _168_ _169_ VGND VGND VPWR VPWR adder.cla_blocks\[7\].block.sum\[3\] sky130_fd_sc_hd__xnor2_1
X_296_ net6 net39 VGND VGND VPWR VPWR _104_ sky130_fd_sc_hd__nand2_1
X_434_ clknet_2_1__leaf_clk adder.cla_blocks\[0\].block.sum\[2\] _002_ VGND VGND VPWR
+ VPWR net56 sky130_fd_sc_hd__dfrtp_1
XPHY_EDGE_ROW_0_Left_21 VGND VGND VPWR VPWR sky130_fd_sc_hd__decap_3
XFILLER_10_101 VGND VGND VPWR VPWR sky130_fd_sc_hd__fill_2
XFILLER_10_123 VGND VGND VPWR VPWR sky130_fd_sc_hd__fill_1
XPHY_EDGE_ROW_16_Right_16 VGND VGND VPWR VPWR sky130_fd_sc_hd__decap_3
X_348_ _047_ _049_ _155_ _048_ VGND VGND VPWR VPWR _156_ sky130_fd_sc_hd__a31oi_1
X_279_ _085_ _086_ VGND VGND VPWR VPWR _087_ sky130_fd_sc_hd__nand2_1
X_417_ _073_ _074_ VGND VGND VPWR VPWR adder.cla_blocks\[0\].block.sum\[1\] sky130_fd_sc_hd__xnor2_1
X_202_ net66 VGND VGND VPWR VPWR _011_ sky130_fd_sc_hd__inv_2
XTAP_TAPCELL_ROW_5_54 VGND VPWR sky130_fd_sc_hd__tapvpwrvgnd_1
XTAP_TAPCELL_ROW_20_85 VGND VPWR sky130_fd_sc_hd__tapvpwrvgnd_1
XPHY_EDGE_ROW_2_Right_2 VGND VGND VPWR VPWR sky130_fd_sc_hd__decap_3
XFILLER_20_52 VGND VGND VPWR VPWR sky130_fd_sc_hd__fill_1
XTAP_TAPCELL_ROW_15_74 VGND VPWR sky130_fd_sc_hd__tapvpwrvgnd_1
Xoutput51 net51 VGND VGND VPWR VPWR acc[25] sky130_fd_sc_hd__buf_2
X_381_ _143_ _177_ VGND VGND VPWR VPWR adder.cla_blocks\[5\].block.sum\[3\] sky130_fd_sc_hd__xnor2_1
Xoutput40 net40 VGND VGND VPWR VPWR acc[15] sky130_fd_sc_hd__buf_2
Xoutput62 net62 VGND VGND VPWR VPWR acc[6] sky130_fd_sc_hd__buf_2
X_450_ clknet_2_2__leaf_clk adder.cla_blocks\[4\].block.sum\[2\] _018_ VGND VGND VPWR
+ VPWR net43 sky130_fd_sc_hd__dfrtp_1
X_433_ clknet_2_3__leaf_clk adder.cla_blocks\[0\].block.sum\[1\] _001_ VGND VGND VPWR
+ VPWR net45 sky130_fd_sc_hd__dfrtp_1
X_364_ net25 net58 VGND VGND VPWR VPWR _169_ sky130_fd_sc_hd__xnor2_1
XFILLER_3_55 VGND VGND VPWR VPWR sky130_fd_sc_hd__fill_1
X_295_ net6 net39 VGND VGND VPWR VPWR _103_ sky130_fd_sc_hd__or2_1
XFILLER_3_88 VGND VGND VPWR VPWR sky130_fd_sc_hd__fill_2
X_347_ _149_ _153_ _051_ VGND VGND VPWR VPWR _155_ sky130_fd_sc_hd__a21o_1
X_416_ _083_ _196_ VGND VGND VPWR VPWR adder.cla_blocks\[1\].block.sum\[3\] sky130_fd_sc_hd__xnor2_1
X_278_ net28 net61 VGND VGND VPWR VPWR _086_ sky130_fd_sc_hd__or2_1
X_201_ net66 VGND VGND VPWR VPWR _010_ sky130_fd_sc_hd__inv_2
XFILLER_18_41 VGND VGND VPWR VPWR sky130_fd_sc_hd__fill_2
XTAP_TAPCELL_ROW_5_55 VGND VPWR sky130_fd_sc_hd__tapvpwrvgnd_1
XTAP_TAPCELL_ROW_20_86 VGND VPWR sky130_fd_sc_hd__tapvpwrvgnd_1
XFILLER_6_11 VGND VGND VPWR VPWR sky130_fd_sc_hd__fill_1
Xoutput52 net52 VGND VGND VPWR VPWR acc[26] sky130_fd_sc_hd__buf_2
X_380_ _138_ _176_ _139_ VGND VGND VPWR VPWR _177_ sky130_fd_sc_hd__a21bo_1
XFILLER_17_119 VGND VGND VPWR VPWR sky130_fd_sc_hd__fill_1
XTAP_TAPCELL_ROW_15_75 VGND VPWR sky130_fd_sc_hd__tapvpwrvgnd_1
XFILLER_15_42 VGND VGND VPWR VPWR sky130_fd_sc_hd__fill_2
Xoutput41 net41 VGND VGND VPWR VPWR acc[16] sky130_fd_sc_hd__buf_2
Xoutput63 net63 VGND VGND VPWR VPWR acc[7] sky130_fd_sc_hd__buf_2
.ends
