* NGSPICE file created from acc8.ext - technology: sky130A

* Black-box entry subcircuit for sky130_fd_sc_hd__or2_1 abstract view
.subckt sky130_fd_sc_hd__or2_1 A B VGND VNB VPB VPWR X
.ends

* Black-box entry subcircuit for sky130_fd_sc_hd__xnor2_1 abstract view
.subckt sky130_fd_sc_hd__xnor2_1 A B VGND VNB VPB VPWR Y
.ends

* Black-box entry subcircuit for sky130_fd_sc_hd__nor2_1 abstract view
.subckt sky130_fd_sc_hd__nor2_1 A B VGND VNB VPB VPWR Y
.ends

* Black-box entry subcircuit for sky130_fd_sc_hd__fill_1 abstract view
.subckt sky130_fd_sc_hd__fill_1 VGND VNB VPB VPWR
.ends

* Black-box entry subcircuit for sky130_fd_sc_hd__nand2_1 abstract view
.subckt sky130_fd_sc_hd__nand2_1 A B VGND VNB VPB VPWR Y
.ends

* Black-box entry subcircuit for sky130_fd_sc_hd__decap_3 abstract view
.subckt sky130_fd_sc_hd__decap_3 VGND VNB VPB VPWR
.ends

* Black-box entry subcircuit for sky130_fd_sc_hd__buf_2 abstract view
.subckt sky130_fd_sc_hd__buf_2 A VGND VNB VPB VPWR X
.ends

* Black-box entry subcircuit for sky130_fd_sc_hd__tapvpwrvgnd_1 abstract view
.subckt sky130_fd_sc_hd__tapvpwrvgnd_1 VGND VPWR
.ends

* Black-box entry subcircuit for sky130_fd_sc_hd__decap_4 abstract view
.subckt sky130_fd_sc_hd__decap_4 VGND VNB VPB VPWR
.ends

* Black-box entry subcircuit for sky130_fd_sc_hd__nand2b_1 abstract view
.subckt sky130_fd_sc_hd__nand2b_1 A_N B VGND VNB VPB VPWR Y
.ends

* Black-box entry subcircuit for sky130_fd_sc_hd__and2_1 abstract view
.subckt sky130_fd_sc_hd__and2_1 A B VGND VNB VPB VPWR X
.ends

* Black-box entry subcircuit for sky130_fd_sc_hd__a311o_1 abstract view
.subckt sky130_fd_sc_hd__a311o_1 A1 A2 A3 B1 C1 VGND VNB VPB VPWR X
.ends

* Black-box entry subcircuit for sky130_fd_sc_hd__inv_2 abstract view
.subckt sky130_fd_sc_hd__inv_2 A VGND VNB VPB VPWR Y
.ends

* Black-box entry subcircuit for sky130_fd_sc_hd__clkbuf_16 abstract view
.subckt sky130_fd_sc_hd__clkbuf_16 A VGND VNB VPB VPWR X
.ends

* Black-box entry subcircuit for sky130_fd_sc_hd__fill_2 abstract view
.subckt sky130_fd_sc_hd__fill_2 VGND VNB VPB VPWR
.ends

* Black-box entry subcircuit for sky130_fd_sc_hd__dfrtp_1 abstract view
.subckt sky130_fd_sc_hd__dfrtp_1 CLK D RESET_B VGND VNB VPB VPWR Q
.ends

* Black-box entry subcircuit for sky130_fd_sc_hd__decap_8 abstract view
.subckt sky130_fd_sc_hd__decap_8 VGND VNB VPB VPWR
.ends

* Black-box entry subcircuit for sky130_fd_sc_hd__clkbuf_1 abstract view
.subckt sky130_fd_sc_hd__clkbuf_1 A VGND VNB VPB VPWR X
.ends

* Black-box entry subcircuit for sky130_fd_sc_hd__o211ai_1 abstract view
.subckt sky130_fd_sc_hd__o211ai_1 A1 A2 B1 C1 VGND VNB VPB VPWR Y
.ends

* Black-box entry subcircuit for sky130_fd_sc_hd__buf_1 abstract view
.subckt sky130_fd_sc_hd__buf_1 A VGND VNB VPB VPWR X
.ends

* Black-box entry subcircuit for sky130_fd_sc_hd__o21ai_1 abstract view
.subckt sky130_fd_sc_hd__o21ai_1 A1 A2 B1 VGND VNB VPB VPWR Y
.ends

* Black-box entry subcircuit for sky130_fd_sc_hd__decap_6 abstract view
.subckt sky130_fd_sc_hd__decap_6 VGND VNB VPB VPWR
.ends

* Black-box entry subcircuit for sky130_fd_sc_hd__a31o_1 abstract view
.subckt sky130_fd_sc_hd__a31o_1 A1 A2 A3 B1 VGND VNB VPB VPWR X
.ends

* Black-box entry subcircuit for sky130_fd_sc_hd__a21oi_1 abstract view
.subckt sky130_fd_sc_hd__a21oi_1 A1 A2 B1 VGND VNB VPB VPWR Y
.ends

* Black-box entry subcircuit for sky130_ef_sc_hd__decap_12 abstract view
.subckt sky130_ef_sc_hd__decap_12 VPWR VGND VPB VNB
.ends

* Black-box entry subcircuit for sky130_fd_sc_hd__a21o_1 abstract view
.subckt sky130_fd_sc_hd__a21o_1 A1 A2 B1 VGND VNB VPB VPWR X
.ends

* Black-box entry subcircuit for sky130_fd_sc_hd__o211a_1 abstract view
.subckt sky130_fd_sc_hd__o211a_1 A1 A2 B1 C1 VGND VNB VPB VPWR X
.ends

* Black-box entry subcircuit for sky130_fd_sc_hd__clkbuf_4 abstract view
.subckt sky130_fd_sc_hd__clkbuf_4 A VGND VNB VPB VPWR X
.ends

* Black-box entry subcircuit for sky130_fd_sc_hd__a211o_1 abstract view
.subckt sky130_fd_sc_hd__a211o_1 A1 A2 B1 C1 VGND VNB VPB VPWR X
.ends

* Black-box entry subcircuit for sky130_fd_sc_hd__or3b_1 abstract view
.subckt sky130_fd_sc_hd__or3b_1 A B C_N VGND VNB VPB VPWR X
.ends

* Black-box entry subcircuit for sky130_fd_sc_hd__and2b_1 abstract view
.subckt sky130_fd_sc_hd__and2b_1 A_N B VGND VNB VPB VPWR X
.ends

.subckt acc8 VGND VPWR acc[0] acc[1] acc[2] acc[3] acc[4] acc[5] acc[6] acc[7] clk
+ data_in[0] data_in[1] data_in[2] data_in[3] data_in[4] data_in[5] data_in[6] data_in[7]
+ rst
X_83_ net1 net10 VGND VGND VPWR VPWR _41_ sky130_fd_sc_hd__or2_1
X_66_ _28_ _29_ VGND VGND VPWR VPWR adder.high.sum\[1\] sky130_fd_sc_hd__xnor2_1
X_49_ net3 net12 VGND VGND VPWR VPWR _14_ sky130_fd_sc_hd__nor2_1
XFILLER_0_46 VGND VGND VPWR VPWR sky130_fd_sc_hd__fill_1
X_65_ _08_ _25_ VGND VGND VPWR VPWR _29_ sky130_fd_sc_hd__nand2_1
X_82_ _22_ _40_ VGND VGND VPWR VPWR adder.low.sum\[3\] sky130_fd_sc_hd__xnor2_1
X_48_ net3 net12 VGND VGND VPWR VPWR _13_ sky130_fd_sc_hd__nand2_1
XPHY_EDGE_ROW_6_Right_6 VGND VGND VPWR VPWR sky130_fd_sc_hd__decap_3
Xoutput10 net10 VGND VGND VPWR VPWR acc[0] sky130_fd_sc_hd__buf_2
XTAP_TAPCELL_ROW_2_25 VGND VPWR sky130_fd_sc_hd__tapvpwrvgnd_1
X_81_ _13_ _20_ VGND VGND VPWR VPWR _40_ sky130_fd_sc_hd__nand2_1
XFILLER_5_6 VGND VGND VPWR VPWR sky130_fd_sc_hd__decap_4
XFILLER_9_57 VGND VGND VPWR VPWR sky130_fd_sc_hd__fill_1
X_64_ _26_ _27_ VGND VGND VPWR VPWR _28_ sky130_fd_sc_hd__nand2b_1
X_47_ net3 net12 VGND VGND VPWR VPWR _12_ sky130_fd_sc_hd__and2_1
XFILLER_3_3 VGND VGND VPWR VPWR sky130_fd_sc_hd__decap_4
XPHY_EDGE_ROW_4_Left_15 VGND VGND VPWR VPWR sky130_fd_sc_hd__decap_3
Xoutput11 net11 VGND VGND VPWR VPWR acc[1] sky130_fd_sc_hd__buf_2
X_63_ net6 net15 VGND VGND VPWR VPWR _27_ sky130_fd_sc_hd__nand2_1
X_80_ _20_ _39_ VGND VGND VPWR VPWR adder.low.sum\[2\] sky130_fd_sc_hd__and2_1
XFILLER_9_36 VGND VGND VPWR VPWR sky130_fd_sc_hd__decap_3
X_46_ net4 net13 VGND VGND VPWR VPWR _11_ sky130_fd_sc_hd__nor2_1
XFILLER_6_15 VGND VGND VPWR VPWR sky130_fd_sc_hd__decap_4
Xoutput12 net12 VGND VGND VPWR VPWR acc[2] sky130_fd_sc_hd__buf_2
XFILLER_9_15 VGND VGND VPWR VPWR sky130_fd_sc_hd__fill_1
X_62_ net6 net15 VGND VGND VPWR VPWR _26_ sky130_fd_sc_hd__nor2_1
X_45_ _08_ _09_ VGND VGND VPWR VPWR _10_ sky130_fd_sc_hd__nand2_1
Xoutput13 net13 VGND VGND VPWR VPWR acc[3] sky130_fd_sc_hd__buf_2
X_61_ _24_ _25_ VGND VGND VPWR VPWR adder.high.sum\[0\] sky130_fd_sc_hd__and2_1
XPHY_EDGE_ROW_8_Left_19 VGND VGND VPWR VPWR sky130_fd_sc_hd__decap_3
XFILLER_0_29 VGND VGND VPWR VPWR sky130_fd_sc_hd__fill_1
XTAP_TAPCELL_ROW_5_28 VGND VPWR sky130_fd_sc_hd__tapvpwrvgnd_1
X_44_ net5 net14 VGND VGND VPWR VPWR _09_ sky130_fd_sc_hd__or2_1
Xoutput14 net14 VGND VGND VPWR VPWR acc[4] sky130_fd_sc_hd__buf_2
XFILLER_3_7 VGND VGND VPWR VPWR sky130_fd_sc_hd__fill_1
X_60_ _13_ _20_ _21_ _11_ _10_ VGND VGND VPWR VPWR _25_ sky130_fd_sc_hd__a311o_1
X_43_ net5 net14 VGND VGND VPWR VPWR _08_ sky130_fd_sc_hd__nand2_1
Xoutput15 net15 VGND VGND VPWR VPWR acc[5] sky130_fd_sc_hd__buf_2
XFILLER_6_29 VGND VGND VPWR VPWR sky130_fd_sc_hd__decap_3
XPHY_EDGE_ROW_1_Right_1 VGND VGND VPWR VPWR sky130_fd_sc_hd__decap_3
X_42_ net9 VGND VGND VPWR VPWR _00_ sky130_fd_sc_hd__inv_2
XFILLER_1_52 VGND VGND VPWR VPWR sky130_fd_sc_hd__fill_1
Xoutput16 net16 VGND VGND VPWR VPWR acc[6] sky130_fd_sc_hd__buf_2
Xclkbuf_0_clk clk VGND VGND VPWR VPWR clknet_0_clk sky130_fd_sc_hd__clkbuf_16
Xoutput17 net17 VGND VGND VPWR VPWR acc[7] sky130_fd_sc_hd__buf_2
XFILLER_7_41 VGND VGND VPWR VPWR sky130_fd_sc_hd__fill_2
XFILLER_10_41 VGND VGND VPWR VPWR sky130_fd_sc_hd__fill_1
XPHY_EDGE_ROW_5_Right_5 VGND VGND VPWR VPWR sky130_fd_sc_hd__decap_3
XTAP_TAPCELL_ROW_0_22 VGND VPWR sky130_fd_sc_hd__tapvpwrvgnd_1
XPHY_EDGE_ROW_3_Left_14 VGND VGND VPWR VPWR sky130_fd_sc_hd__decap_3
X_99_ clknet_1_1__leaf_clk adder.high.sum\[3\] _07_ VGND VGND VPWR VPWR net17 sky130_fd_sc_hd__dfrtp_1
XFILLER_7_54 VGND VGND VPWR VPWR sky130_fd_sc_hd__fill_2
XTAP_TAPCELL_ROW_9_32 VGND VPWR sky130_fd_sc_hd__tapvpwrvgnd_1
XTAP_TAPCELL_ROW_0_23 VGND VPWR sky130_fd_sc_hd__tapvpwrvgnd_1
XFILLER_4_44 VGND VGND VPWR VPWR sky130_fd_sc_hd__fill_1
X_98_ clknet_1_1__leaf_clk adder.high.sum\[2\] _06_ VGND VGND VPWR VPWR net16 sky130_fd_sc_hd__dfrtp_1
XFILLER_1_23 VGND VGND VPWR VPWR sky130_fd_sc_hd__fill_1
XFILLER_7_33 VGND VGND VPWR VPWR sky130_fd_sc_hd__decap_8
XFILLER_4_23 VGND VGND VPWR VPWR sky130_fd_sc_hd__fill_2
XFILLER_8_3 VGND VGND VPWR VPWR sky130_fd_sc_hd__fill_1
X_97_ clknet_1_0__leaf_clk adder.high.sum\[1\] _05_ VGND VGND VPWR VPWR net15 sky130_fd_sc_hd__dfrtp_1
XTAP_TAPCELL_ROW_10_33 VGND VPWR sky130_fd_sc_hd__tapvpwrvgnd_1
Xinput1 data_in[0] VGND VGND VPWR VPWR net1 sky130_fd_sc_hd__clkbuf_1
XFILLER_1_57 VGND VGND VPWR VPWR sky130_fd_sc_hd__fill_2
XPHY_EDGE_ROW_9_Right_9 VGND VGND VPWR VPWR sky130_fd_sc_hd__decap_3
XTAP_TAPCELL_ROW_10_34 VGND VPWR sky130_fd_sc_hd__tapvpwrvgnd_1
X_79_ _12_ _14_ _15_ _19_ VGND VGND VPWR VPWR _39_ sky130_fd_sc_hd__o211ai_1
Xinput2 data_in[1] VGND VGND VPWR VPWR net2 sky130_fd_sc_hd__clkbuf_1
X_96_ clknet_1_0__leaf_clk adder.high.sum\[0\] _04_ VGND VGND VPWR VPWR net14 sky130_fd_sc_hd__dfrtp_1
XPHY_EDGE_ROW_7_Left_18 VGND VGND VPWR VPWR sky130_fd_sc_hd__decap_3
X_95_ clknet_1_0__leaf_clk adder.low.sum\[3\] _03_ VGND VGND VPWR VPWR net13 sky130_fd_sc_hd__dfrtp_1
XFILLER_10_57 VGND VGND VPWR VPWR sky130_fd_sc_hd__decap_8
X_78_ _19_ _38_ VGND VGND VPWR VPWR adder.low.sum\[1\] sky130_fd_sc_hd__and2_1
Xinput3 data_in[2] VGND VGND VPWR VPWR net3 sky130_fd_sc_hd__buf_1
XPHY_EDGE_ROW_10_Left_21 VGND VGND VPWR VPWR sky130_fd_sc_hd__decap_3
XPHY_EDGE_ROW_0_Right_0 VGND VGND VPWR VPWR sky130_fd_sc_hd__decap_3
XTAP_TAPCELL_ROW_3_26 VGND VPWR sky130_fd_sc_hd__tapvpwrvgnd_1
Xinput4 data_in[3] VGND VGND VPWR VPWR net4 sky130_fd_sc_hd__clkbuf_1
X_77_ _16_ _17_ _18_ VGND VGND VPWR VPWR _38_ sky130_fd_sc_hd__o21ai_1
X_94_ clknet_1_0__leaf_clk adder.low.sum\[2\] _02_ VGND VGND VPWR VPWR net12 sky130_fd_sc_hd__dfrtp_1
XFILLER_6_3 VGND VGND VPWR VPWR sky130_fd_sc_hd__fill_1
X_93_ clknet_1_1__leaf_clk adder.low.sum\[1\] _01_ VGND VGND VPWR VPWR net11 sky130_fd_sc_hd__dfrtp_1
XFILLER_10_48 VGND VGND VPWR VPWR sky130_fd_sc_hd__decap_8
XFILLER_10_15 VGND VGND VPWR VPWR sky130_fd_sc_hd__decap_6
X_76_ _36_ _37_ VGND VGND VPWR VPWR adder.high.sum\[3\] sky130_fd_sc_hd__xnor2_1
Xinput5 data_in[4] VGND VGND VPWR VPWR net5 sky130_fd_sc_hd__clkbuf_1
XFILLER_7_27 VGND VGND VPWR VPWR sky130_fd_sc_hd__fill_2
X_59_ _10_ _23_ VGND VGND VPWR VPWR _24_ sky130_fd_sc_hd__nand2_1
X_92_ clknet_1_1__leaf_clk adder.low.p\[0\] _00_ VGND VGND VPWR VPWR net10 sky130_fd_sc_hd__dfrtp_1
Xinput6 data_in[5] VGND VGND VPWR VPWR net6 sky130_fd_sc_hd__clkbuf_1
XFILLER_10_27 VGND VGND VPWR VPWR sky130_fd_sc_hd__fill_1
X_58_ _13_ _20_ _21_ _11_ VGND VGND VPWR VPWR _23_ sky130_fd_sc_hd__a31o_1
X_75_ net8 net17 VGND VGND VPWR VPWR _37_ sky130_fd_sc_hd__xnor2_1
XPHY_EDGE_ROW_4_Right_4 VGND VGND VPWR VPWR sky130_fd_sc_hd__decap_3
X_91_ net9 VGND VGND VPWR VPWR _07_ sky130_fd_sc_hd__inv_2
Xinput7 data_in[6] VGND VGND VPWR VPWR net7 sky130_fd_sc_hd__clkbuf_1
X_74_ _25_ _34_ _35_ VGND VGND VPWR VPWR _36_ sky130_fd_sc_hd__a21oi_1
XTAP_TAPCELL_ROW_6_29 VGND VPWR sky130_fd_sc_hd__tapvpwrvgnd_1
XPHY_EDGE_ROW_2_Left_13 VGND VGND VPWR VPWR sky130_fd_sc_hd__decap_3
X_57_ _11_ _21_ VGND VGND VPWR VPWR _22_ sky130_fd_sc_hd__nand2b_1
X_90_ net9 VGND VGND VPWR VPWR _06_ sky130_fd_sc_hd__inv_2
XFILLER_10_29 VPWR VGND VPWR VGND sky130_ef_sc_hd__decap_12
X_73_ _26_ _31_ _30_ VGND VGND VPWR VPWR _35_ sky130_fd_sc_hd__a21o_1
Xinput8 data_in[7] VGND VGND VPWR VPWR net8 sky130_fd_sc_hd__clkbuf_1
X_56_ net4 net13 VGND VGND VPWR VPWR _21_ sky130_fd_sc_hd__nand2_1
Xclkbuf_1_0__f_clk clknet_0_clk VGND VGND VPWR VPWR clknet_1_0__leaf_clk sky130_fd_sc_hd__clkbuf_16
X_72_ _27_ _30_ _31_ _08_ VGND VGND VPWR VPWR _34_ sky130_fd_sc_hd__o211a_1
Xinput9 rst VGND VGND VPWR VPWR net9 sky130_fd_sc_hd__clkbuf_4
XPHY_EDGE_ROW_10_Right_10 VGND VGND VPWR VPWR sky130_fd_sc_hd__decap_3
XTAP_TAPCELL_ROW_7_30 VGND VPWR sky130_fd_sc_hd__tapvpwrvgnd_1
X_55_ _15_ _19_ _12_ _14_ VGND VGND VPWR VPWR _20_ sky130_fd_sc_hd__a211o_1
XFILLER_2_64 VGND VGND VPWR VPWR sky130_fd_sc_hd__fill_1
XFILLER_8_41 VGND VGND VPWR VPWR sky130_fd_sc_hd__fill_1
XPHY_EDGE_ROW_8_Right_8 VGND VGND VPWR VPWR sky130_fd_sc_hd__decap_3
XFILLER_5_64 VGND VGND VPWR VPWR sky130_fd_sc_hd__fill_1
X_71_ _32_ _33_ VGND VGND VPWR VPWR adder.high.sum\[2\] sky130_fd_sc_hd__xnor2_1
X_54_ _18_ _17_ _15_ VGND VGND VPWR VPWR _19_ sky130_fd_sc_hd__or3b_1
XFILLER_2_32 VGND VGND VPWR VPWR sky130_fd_sc_hd__decap_3
XPHY_EDGE_ROW_6_Left_17 VGND VGND VPWR VPWR sky130_fd_sc_hd__decap_3
XPHY_EDGE_ROW_9_Left_20 VGND VGND VPWR VPWR sky130_fd_sc_hd__decap_3
XFILLER_8_20 VGND VGND VPWR VPWR sky130_fd_sc_hd__fill_1
X_70_ _08_ _25_ _27_ _26_ VGND VGND VPWR VPWR _33_ sky130_fd_sc_hd__a31o_1
X_53_ net1 net10 VGND VGND VPWR VPWR _18_ sky130_fd_sc_hd__nand2_1
XFILLER_10_3 VPWR VGND VPWR VGND sky130_ef_sc_hd__decap_12
X_52_ net2 net11 VGND VGND VPWR VPWR _17_ sky130_fd_sc_hd__nor2_1
XTAP_TAPCELL_ROW_1_24 VGND VPWR sky130_fd_sc_hd__tapvpwrvgnd_1
X_51_ _15_ VGND VGND VPWR VPWR _16_ sky130_fd_sc_hd__inv_2
XFILLER_0_3 VGND VGND VPWR VPWR sky130_fd_sc_hd__decap_8
X_50_ net2 net11 VGND VGND VPWR VPWR _15_ sky130_fd_sc_hd__nand2_1
XFILLER_2_25 VGND VGND VPWR VPWR sky130_fd_sc_hd__decap_3
XFILLER_8_24 VGND VGND VPWR VPWR sky130_fd_sc_hd__decap_4
Xclkbuf_1_1__f_clk clknet_0_clk VGND VGND VPWR VPWR clknet_1_1__leaf_clk sky130_fd_sc_hd__clkbuf_16
XPHY_EDGE_ROW_3_Right_3 VGND VGND VPWR VPWR sky130_fd_sc_hd__decap_3
XFILLER_8_14 VGND VGND VPWR VPWR sky130_fd_sc_hd__decap_6
XPHY_EDGE_ROW_1_Left_12 VGND VGND VPWR VPWR sky130_fd_sc_hd__decap_3
XFILLER_5_15 VGND VGND VPWR VPWR sky130_fd_sc_hd__fill_1
XFILLER_2_38 VGND VGND VPWR VPWR sky130_fd_sc_hd__decap_3
XFILLER_8_37 VGND VGND VPWR VPWR sky130_fd_sc_hd__decap_4
XTAP_TAPCELL_ROW_4_27 VGND VPWR sky130_fd_sc_hd__tapvpwrvgnd_1
XFILLER_0_60 VGND VGND VPWR VPWR sky130_fd_sc_hd__fill_1
XFILLER_0_50 VGND VGND VPWR VPWR sky130_fd_sc_hd__fill_2
XPHY_EDGE_ROW_7_Right_7 VGND VGND VPWR VPWR sky130_fd_sc_hd__decap_3
XFILLER_2_18 VGND VGND VPWR VPWR sky130_fd_sc_hd__fill_2
XPHY_EDGE_ROW_5_Left_16 VGND VGND VPWR VPWR sky130_fd_sc_hd__decap_3
X_89_ net9 VGND VGND VPWR VPWR _05_ sky130_fd_sc_hd__inv_2
X_88_ net9 VGND VGND VPWR VPWR _04_ sky130_fd_sc_hd__inv_2
XFILLER_8_29 VGND VGND VPWR VPWR sky130_fd_sc_hd__fill_2
X_87_ net9 VGND VGND VPWR VPWR _03_ sky130_fd_sc_hd__inv_2
XFILLER_9_7 VGND VGND VPWR VPWR sky130_fd_sc_hd__decap_8
X_86_ net9 VGND VGND VPWR VPWR _02_ sky130_fd_sc_hd__inv_2
X_69_ _30_ _31_ VGND VGND VPWR VPWR _32_ sky130_fd_sc_hd__and2b_1
XFILLER_9_52 VGND VGND VPWR VPWR sky130_fd_sc_hd__decap_4
XTAP_TAPCELL_ROW_8_31 VGND VPWR sky130_fd_sc_hd__tapvpwrvgnd_1
X_85_ net9 VGND VGND VPWR VPWR _01_ sky130_fd_sc_hd__inv_2
X_68_ net7 net16 VGND VGND VPWR VPWR _31_ sky130_fd_sc_hd__nand2_1
XFILLER_0_11 VGND VGND VPWR VPWR sky130_fd_sc_hd__decap_3
XFILLER_0_55 VGND VGND VPWR VPWR sky130_fd_sc_hd__fill_1
XPHY_EDGE_ROW_2_Right_2 VGND VGND VPWR VPWR sky130_fd_sc_hd__decap_3
XFILLER_3_11 VGND VGND VPWR VPWR sky130_fd_sc_hd__fill_1
XFILLER_3_55 VGND VGND VPWR VPWR sky130_fd_sc_hd__fill_1
X_84_ _18_ _41_ VGND VGND VPWR VPWR adder.low.p\[0\] sky130_fd_sc_hd__and2_1
X_67_ net7 net16 VGND VGND VPWR VPWR _30_ sky130_fd_sc_hd__nor2_1
XPHY_EDGE_ROW_0_Left_11 VGND VGND VPWR VPWR sky130_fd_sc_hd__decap_3
XFILLER_0_23 VGND VGND VPWR VPWR sky130_fd_sc_hd__fill_1
XFILLER_6_22 VGND VGND VPWR VPWR sky130_fd_sc_hd__decap_6
.ends
