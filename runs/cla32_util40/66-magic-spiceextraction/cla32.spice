* NGSPICE file created from cla32.ext - technology: sky130A

* Black-box entry subcircuit for sky130_fd_sc_hd__decap_8 abstract view
.subckt sky130_fd_sc_hd__decap_8 VGND VNB VPB VPWR
.ends

* Black-box entry subcircuit for sky130_ef_sc_hd__decap_12 abstract view
.subckt sky130_ef_sc_hd__decap_12 VPWR VGND VPB VNB
.ends

* Black-box entry subcircuit for sky130_fd_sc_hd__and3_1 abstract view
.subckt sky130_fd_sc_hd__and3_1 A B C VGND VNB VPB VPWR X
.ends

* Black-box entry subcircuit for sky130_fd_sc_hd__or4_1 abstract view
.subckt sky130_fd_sc_hd__or4_1 A B C D VGND VNB VPB VPWR X
.ends

* Black-box entry subcircuit for sky130_fd_sc_hd__xnor2_1 abstract view
.subckt sky130_fd_sc_hd__xnor2_1 A B VGND VNB VPB VPWR Y
.ends

* Black-box entry subcircuit for sky130_fd_sc_hd__decap_4 abstract view
.subckt sky130_fd_sc_hd__decap_4 VGND VNB VPB VPWR
.ends

* Black-box entry subcircuit for sky130_fd_sc_hd__decap_6 abstract view
.subckt sky130_fd_sc_hd__decap_6 VGND VNB VPB VPWR
.ends

* Black-box entry subcircuit for sky130_fd_sc_hd__or2_1 abstract view
.subckt sky130_fd_sc_hd__or2_1 A B VGND VNB VPB VPWR X
.ends

* Black-box entry subcircuit for sky130_fd_sc_hd__decap_3 abstract view
.subckt sky130_fd_sc_hd__decap_3 VGND VNB VPB VPWR
.ends

* Black-box entry subcircuit for sky130_fd_sc_hd__nor2_1 abstract view
.subckt sky130_fd_sc_hd__nor2_1 A B VGND VNB VPB VPWR Y
.ends

* Black-box entry subcircuit for sky130_fd_sc_hd__fill_2 abstract view
.subckt sky130_fd_sc_hd__fill_2 VGND VNB VPB VPWR
.ends

* Black-box entry subcircuit for sky130_fd_sc_hd__nand2_1 abstract view
.subckt sky130_fd_sc_hd__nand2_1 A B VGND VNB VPB VPWR Y
.ends

* Black-box entry subcircuit for sky130_fd_sc_hd__tapvpwrvgnd_1 abstract view
.subckt sky130_fd_sc_hd__tapvpwrvgnd_1 VGND VPWR
.ends

* Black-box entry subcircuit for sky130_fd_sc_hd__fill_1 abstract view
.subckt sky130_fd_sc_hd__fill_1 VGND VNB VPB VPWR
.ends

* Black-box entry subcircuit for sky130_fd_sc_hd__buf_2 abstract view
.subckt sky130_fd_sc_hd__buf_2 A VGND VNB VPB VPWR X
.ends

* Black-box entry subcircuit for sky130_fd_sc_hd__xor2_1 abstract view
.subckt sky130_fd_sc_hd__xor2_1 A B VGND VNB VPB VPWR X
.ends

* Black-box entry subcircuit for sky130_fd_sc_hd__o21bai_2 abstract view
.subckt sky130_fd_sc_hd__o21bai_2 A1 A2 B1_N VGND VNB VPB VPWR Y
.ends

* Black-box entry subcircuit for sky130_fd_sc_hd__a31o_1 abstract view
.subckt sky130_fd_sc_hd__a31o_1 A1 A2 A3 B1 VGND VNB VPB VPWR X
.ends

* Black-box entry subcircuit for sky130_fd_sc_hd__o221ai_4 abstract view
.subckt sky130_fd_sc_hd__o221ai_4 A1 A2 B1 B2 C1 VGND VNB VPB VPWR Y
.ends

* Black-box entry subcircuit for sky130_fd_sc_hd__and2_1 abstract view
.subckt sky130_fd_sc_hd__and2_1 A B VGND VNB VPB VPWR X
.ends

* Black-box entry subcircuit for sky130_fd_sc_hd__nand2b_1 abstract view
.subckt sky130_fd_sc_hd__nand2b_1 A_N B VGND VNB VPB VPWR Y
.ends

* Black-box entry subcircuit for sky130_fd_sc_hd__a21bo_1 abstract view
.subckt sky130_fd_sc_hd__a21bo_1 A1 A2 B1_N VGND VNB VPB VPWR X
.ends

* Black-box entry subcircuit for sky130_fd_sc_hd__inv_2 abstract view
.subckt sky130_fd_sc_hd__inv_2 A VGND VNB VPB VPWR Y
.ends

* Black-box entry subcircuit for sky130_fd_sc_hd__a21o_1 abstract view
.subckt sky130_fd_sc_hd__a21o_1 A1 A2 B1 VGND VNB VPB VPWR X
.ends

* Black-box entry subcircuit for sky130_fd_sc_hd__nand3_1 abstract view
.subckt sky130_fd_sc_hd__nand3_1 A B C VGND VNB VPB VPWR Y
.ends

* Black-box entry subcircuit for sky130_fd_sc_hd__a211oi_4 abstract view
.subckt sky130_fd_sc_hd__a211oi_4 A1 A2 B1 C1 VGND VNB VPB VPWR Y
.ends

* Black-box entry subcircuit for sky130_fd_sc_hd__o2111a_1 abstract view
.subckt sky130_fd_sc_hd__o2111a_1 A1 A2 B1 C1 D1 VGND VNB VPB VPWR X
.ends

* Black-box entry subcircuit for sky130_fd_sc_hd__o21a_1 abstract view
.subckt sky130_fd_sc_hd__o21a_1 A1 A2 B1 VGND VNB VPB VPWR X
.ends

* Black-box entry subcircuit for sky130_fd_sc_hd__and2b_1 abstract view
.subckt sky130_fd_sc_hd__and2b_1 A_N B VGND VNB VPB VPWR X
.ends

* Black-box entry subcircuit for sky130_fd_sc_hd__a22o_1 abstract view
.subckt sky130_fd_sc_hd__a22o_1 A1 A2 B1 B2 VGND VNB VPB VPWR X
.ends

* Black-box entry subcircuit for sky130_fd_sc_hd__clkbuf_1 abstract view
.subckt sky130_fd_sc_hd__clkbuf_1 A VGND VNB VPB VPWR X
.ends

* Black-box entry subcircuit for sky130_fd_sc_hd__or3_1 abstract view
.subckt sky130_fd_sc_hd__or3_1 A B C VGND VNB VPB VPWR X
.ends

* Black-box entry subcircuit for sky130_fd_sc_hd__nand4_1 abstract view
.subckt sky130_fd_sc_hd__nand4_1 A B C D VGND VNB VPB VPWR Y
.ends

* Black-box entry subcircuit for sky130_fd_sc_hd__o21ai_1 abstract view
.subckt sky130_fd_sc_hd__o21ai_1 A1 A2 B1 VGND VNB VPB VPWR Y
.ends

* Black-box entry subcircuit for sky130_fd_sc_hd__a21oi_1 abstract view
.subckt sky130_fd_sc_hd__a21oi_1 A1 A2 B1 VGND VNB VPB VPWR Y
.ends

* Black-box entry subcircuit for sky130_fd_sc_hd__buf_1 abstract view
.subckt sky130_fd_sc_hd__buf_1 A VGND VNB VPB VPWR X
.ends

* Black-box entry subcircuit for sky130_fd_sc_hd__and4_1 abstract view
.subckt sky130_fd_sc_hd__and4_1 A B C D VGND VNB VPB VPWR X
.ends

* Black-box entry subcircuit for sky130_fd_sc_hd__a311o_1 abstract view
.subckt sky130_fd_sc_hd__a311o_1 A1 A2 A3 B1 C1 VGND VNB VPB VPWR X
.ends

* Black-box entry subcircuit for sky130_fd_sc_hd__o21ba_1 abstract view
.subckt sky130_fd_sc_hd__o21ba_1 A1 A2 B1_N VGND VNB VPB VPWR X
.ends

* Black-box entry subcircuit for sky130_fd_sc_hd__o221ai_1 abstract view
.subckt sky130_fd_sc_hd__o221ai_1 A1 A2 B1 B2 C1 VGND VNB VPB VPWR Y
.ends

* Black-box entry subcircuit for sky130_fd_sc_hd__a211o_1 abstract view
.subckt sky130_fd_sc_hd__a211o_1 A1 A2 B1 C1 VGND VNB VPB VPWR X
.ends

* Black-box entry subcircuit for sky130_fd_sc_hd__nor3_1 abstract view
.subckt sky130_fd_sc_hd__nor3_1 A B C VGND VNB VPB VPWR Y
.ends

* Black-box entry subcircuit for sky130_fd_sc_hd__o311ai_4 abstract view
.subckt sky130_fd_sc_hd__o311ai_4 A1 A2 A3 B1 C1 VGND VNB VPB VPWR Y
.ends

* Black-box entry subcircuit for sky130_fd_sc_hd__o31a_1 abstract view
.subckt sky130_fd_sc_hd__o31a_1 A1 A2 A3 B1 VGND VNB VPB VPWR X
.ends

* Black-box entry subcircuit for sky130_fd_sc_hd__o31a_2 abstract view
.subckt sky130_fd_sc_hd__o31a_2 A1 A2 A3 B1 VGND VNB VPB VPWR X
.ends

* Black-box entry subcircuit for sky130_fd_sc_hd__o221a_1 abstract view
.subckt sky130_fd_sc_hd__o221a_1 A1 A2 B1 B2 C1 VGND VNB VPB VPWR X
.ends

* Black-box entry subcircuit for sky130_fd_sc_hd__a2111o_1 abstract view
.subckt sky130_fd_sc_hd__a2111o_1 A1 A2 B1 C1 D1 VGND VNB VPB VPWR X
.ends

* Black-box entry subcircuit for sky130_fd_sc_hd__a311oi_1 abstract view
.subckt sky130_fd_sc_hd__a311oi_1 A1 A2 A3 B1 C1 VGND VNB VPB VPWR Y
.ends

* Black-box entry subcircuit for sky130_fd_sc_hd__a211oi_1 abstract view
.subckt sky130_fd_sc_hd__a211oi_1 A1 A2 B1 C1 VGND VNB VPB VPWR Y
.ends

* Black-box entry subcircuit for sky130_fd_sc_hd__o211a_1 abstract view
.subckt sky130_fd_sc_hd__o211a_1 A1 A2 B1 C1 VGND VNB VPB VPWR X
.ends

.subckt cla32 VGND VPWR a[0] a[10] a[11] a[12] a[13] a[14] a[15] a[16] a[17] a[18]
+ a[19] a[1] a[20] a[21] a[22] a[23] a[24] a[25] a[26] a[27] a[28] a[29] a[2] a[30]
+ a[31] a[3] a[4] a[5] a[6] a[7] a[8] a[9] b[0] b[10] b[11] b[12] b[13] b[14] b[15]
+ b[16] b[17] b[18] b[19] b[1] b[20] b[21] b[22] b[23] b[24] b[25] b[26] b[27] b[28]
+ b[29] b[2] b[30] b[31] b[3] b[4] b[5] b[6] b[7] b[8] b[9] cin cout sum[0] sum[10]
+ sum[11] sum[12] sum[13] sum[14] sum[15] sum[16] sum[17] sum[18] sum[19] sum[1] sum[20]
+ sum[21] sum[22] sum[23] sum[24] sum[25] sum[26] sum[27] sum[28] sum[29] sum[2] sum[30]
+ sum[31] sum[3] sum[4] sum[5] sum[6] sum[7] sum[8] sum[9]
XFILLER_13_133 VGND VGND VPWR VPWR sky130_fd_sc_hd__decap_8
XFILLER_3_12 VPWR VGND VPWR VGND sky130_ef_sc_hd__decap_12
X_294_ _085_ _086_ _094_ VGND VGND VPWR VPWR _099_ sky130_fd_sc_hd__and3_1
X_363_ _123_ _128_ _138_ _142_ VGND VGND VPWR VPWR _158_ sky130_fd_sc_hd__or4_1
X_346_ _141_ _142_ VGND VGND VPWR VPWR net85 sky130_fd_sc_hd__xnor2_1
XFILLER_12_65 VPWR VGND VPWR VGND sky130_ef_sc_hd__decap_12
XFILLER_6_129 VGND VGND VPWR VPWR sky130_fd_sc_hd__decap_4
XFILLER_12_21 VGND VGND VPWR VPWR sky130_fd_sc_hd__decap_6
X_277_ net41 net9 VGND VGND VPWR VPWR _084_ sky130_fd_sc_hd__or2_1
XFILLER_23_97 VGND VGND VPWR VPWR sky130_fd_sc_hd__decap_4
XFILLER_23_42 VGND VGND VPWR VPWR sky130_fd_sc_hd__decap_3
X_200_ net60 net28 VGND VGND VPWR VPWR _019_ sky130_fd_sc_hd__nor2_1
XFILLER_0_57 VGND VGND VPWR VPWR sky130_fd_sc_hd__fill_2
XFILLER_0_35 VGND VGND VPWR VPWR sky130_fd_sc_hd__decap_3
X_329_ _126_ _127_ VGND VGND VPWR VPWR _128_ sky130_fd_sc_hd__nand2_1
XTAP_TAPCELL_ROW_18_97 VGND VPWR sky130_fd_sc_hd__tapvpwrvgnd_1
XFILLER_18_97 VGND VGND VPWR VPWR sky130_fd_sc_hd__fill_1
XFILLER_18_75 VGND VGND VPWR VPWR sky130_fd_sc_hd__decap_4
XFILLER_18_53 VGND VGND VPWR VPWR sky130_fd_sc_hd__decap_3
XPHY_EDGE_ROW_12_Left_36 VGND VGND VPWR VPWR sky130_fd_sc_hd__decap_3
XFILLER_20_76 VGND VGND VPWR VPWR sky130_fd_sc_hd__decap_3
XFILLER_13_3 VGND VGND VPWR VPWR sky130_fd_sc_hd__decap_6
XFILLER_6_12 VPWR VGND VPWR VGND sky130_ef_sc_hd__decap_12
Xoutput97 net97 VGND VGND VPWR VPWR sum[8] sky130_fd_sc_hd__buf_2
XFILLER_16_131 VGND VGND VPWR VPWR sky130_fd_sc_hd__decap_8
Xoutput86 net86 VGND VGND VPWR VPWR sum[27] sky130_fd_sc_hd__buf_2
Xoutput75 net75 VGND VGND VPWR VPWR sum[17] sky130_fd_sc_hd__buf_2
XTAP_TAPCELL_ROW_2_57 VGND VPWR sky130_fd_sc_hd__tapvpwrvgnd_1
XFILLER_22_134 VGND VGND VPWR VPWR sky130_fd_sc_hd__fill_2
X_362_ net53 net21 VGND VGND VPWR VPWR _157_ sky130_fd_sc_hd__nor2_1
XFILLER_13_101 VGND VGND VPWR VPWR sky130_fd_sc_hd__decap_3
X_293_ _096_ _098_ VGND VGND VPWR VPWR net76 sky130_fd_sc_hd__xnor2_1
XFILLER_3_24 VPWR VGND VPWR VGND sky130_ef_sc_hd__decap_12
XFILLER_3_57 VGND VGND VPWR VPWR sky130_fd_sc_hd__decap_6
XFILLER_12_77 VGND VGND VPWR VPWR sky130_fd_sc_hd__decap_6
XPHY_EDGE_ROW_0_Left_24 VGND VGND VPWR VPWR sky130_fd_sc_hd__decap_3
X_345_ _123_ _143_ VGND VGND VPWR VPWR net86 sky130_fd_sc_hd__xor2_1
X_276_ net41 net9 VGND VGND VPWR VPWR _083_ sky130_fd_sc_hd__nand2_1
XPHY_EDGE_ROW_21_Right_21 VGND VGND VPWR VPWR sky130_fd_sc_hd__decap_3
XPHY_EDGE_ROW_12_Right_12 VGND VGND VPWR VPWR sky130_fd_sc_hd__decap_3
XFILLER_23_76 VGND VGND VPWR VPWR sky130_fd_sc_hd__decap_4
X_259_ _041_ _068_ _069_ VGND VGND VPWR VPWR _070_ sky130_fd_sc_hd__o21bai_2
XFILLER_2_111 VGND VGND VPWR VPWR sky130_fd_sc_hd__fill_1
X_328_ net50 net18 VGND VGND VPWR VPWR _127_ sky130_fd_sc_hd__or2_1
XFILLER_6_24 VGND VGND VPWR VPWR sky130_fd_sc_hd__decap_4
XTAP_TAPCELL_ROW_15_88 VGND VPWR sky130_fd_sc_hd__tapvpwrvgnd_1
XPHY_EDGE_ROW_6_Right_6 VGND VGND VPWR VPWR sky130_fd_sc_hd__decap_3
Xoutput98 net98 VGND VGND VPWR VPWR sum[9] sky130_fd_sc_hd__buf_2
Xoutput87 net87 VGND VGND VPWR VPWR sum[28] sky130_fd_sc_hd__buf_2
Xoutput76 net76 VGND VGND VPWR VPWR sum[18] sky130_fd_sc_hd__buf_2
X_361_ net53 net21 VGND VGND VPWR VPWR _156_ sky130_fd_sc_hd__nand2_1
XFILLER_13_113 VPWR VGND VPWR VGND sky130_ef_sc_hd__decap_12
X_292_ _081_ _082_ VGND VGND VPWR VPWR _098_ sky130_fd_sc_hd__nand2_1
XFILLER_9_106 VGND VGND VPWR VPWR sky130_fd_sc_hd__decap_6
XFILLER_9_117 VGND VGND VPWR VPWR sky130_fd_sc_hd__decap_8
XFILLER_3_36 VGND VGND VPWR VPWR sky130_fd_sc_hd__decap_3
XTAP_TAPCELL_ROW_20_100 VGND VPWR sky130_fd_sc_hd__tapvpwrvgnd_1
X_344_ _125_ _126_ _140_ _124_ VGND VGND VPWR VPWR _143_ sky130_fd_sc_hd__a31o_1
X_275_ net42 net10 VGND VGND VPWR VPWR _082_ sky130_fd_sc_hd__nand2_1
XFILLER_23_55 VGND VGND VPWR VPWR sky130_fd_sc_hd__fill_1
XFILLER_23_22 VGND VGND VPWR VPWR sky130_fd_sc_hd__fill_2
XFILLER_3_3 VGND VGND VPWR VPWR sky130_fd_sc_hd__fill_1
X_189_ _006_ _011_ VGND VGND VPWR VPWR _012_ sky130_fd_sc_hd__nor2_1
XFILLER_9_57 VPWR VGND VPWR VGND sky130_ef_sc_hd__decap_12
X_258_ _033_ _036_ _039_ _068_ _034_ VGND VGND VPWR VPWR _069_ sky130_fd_sc_hd__o221ai_4
X_327_ net50 net18 VGND VGND VPWR VPWR _126_ sky130_fd_sc_hd__nand2_1
XFILLER_18_33 VPWR VGND VPWR VGND sky130_ef_sc_hd__decap_12
XFILLER_6_36 VGND VGND VPWR VPWR sky130_fd_sc_hd__decap_4
XFILLER_19_130 VGND VGND VPWR VPWR sky130_fd_sc_hd__fill_1
XTAP_TAPCELL_ROW_15_89 VGND VPWR sky130_fd_sc_hd__tapvpwrvgnd_1
Xoutput88 net88 VGND VGND VPWR VPWR sum[29] sky130_fd_sc_hd__buf_2
Xoutput66 net66 VGND VGND VPWR VPWR cout sky130_fd_sc_hd__buf_2
XFILLER_16_111 VPWR VGND VPWR VGND sky130_ef_sc_hd__decap_12
Xoutput77 net77 VGND VGND VPWR VPWR sum[19] sky130_fd_sc_hd__buf_2
X_360_ net53 net21 VGND VGND VPWR VPWR _155_ sky130_fd_sc_hd__and2_1
XFILLER_13_125 VGND VGND VPWR VPWR sky130_fd_sc_hd__decap_4
X_291_ _080_ _097_ VGND VGND VPWR VPWR net77 sky130_fd_sc_hd__xnor2_1
XFILLER_3_48 VGND VGND VPWR VPWR sky130_fd_sc_hd__decap_8
XTAP_TAPCELL_ROW_20_101 VGND VPWR sky130_fd_sc_hd__tapvpwrvgnd_1
X_343_ _124_ _125_ VGND VGND VPWR VPWR _142_ sky130_fd_sc_hd__nand2b_1
X_274_ net42 net10 VGND VGND VPWR VPWR _081_ sky130_fd_sc_hd__or2_1
XFILLER_5_110 VGND VGND VPWR VPWR sky130_fd_sc_hd__fill_2
XFILLER_5_143 VGND VGND VPWR VPWR sky130_fd_sc_hd__fill_1
XFILLER_0_49 VGND VGND VPWR VPWR sky130_fd_sc_hd__decap_3
XFILLER_0_27 VGND VGND VPWR VPWR sky130_fd_sc_hd__fill_1
X_188_ net44 net12 VGND VGND VPWR VPWR _011_ sky130_fd_sc_hd__nor2_1
X_326_ net51 net19 VGND VGND VPWR VPWR _125_ sky130_fd_sc_hd__nand2_1
XFILLER_9_69 VPWR VGND VPWR VGND sky130_ef_sc_hd__decap_12
X_257_ _035_ _038_ VGND VGND VPWR VPWR _068_ sky130_fd_sc_hd__or2_1
XFILLER_18_45 VGND VGND VPWR VPWR sky130_fd_sc_hd__decap_8
X_309_ _085_ _111_ VGND VGND VPWR VPWR _112_ sky130_fd_sc_hd__or2_1
XFILLER_6_48 VPWR VGND VPWR VGND sky130_ef_sc_hd__decap_12
Xoutput67 net67 VGND VGND VPWR VPWR sum[0] sky130_fd_sc_hd__buf_2
Xoutput78 net78 VGND VGND VPWR VPWR sum[1] sky130_fd_sc_hd__buf_2
Xoutput89 net89 VGND VGND VPWR VPWR sum[2] sky130_fd_sc_hd__buf_2
XFILLER_15_57 VGND VGND VPWR VPWR sky130_fd_sc_hd__decap_6
XFILLER_15_35 VPWR VGND VPWR VGND sky130_ef_sc_hd__decap_12
XFILLER_15_13 VPWR VGND VPWR VGND sky130_ef_sc_hd__decap_12
XFILLER_11_3 VGND VGND VPWR VPWR sky130_fd_sc_hd__fill_1
XFILLER_22_126 VGND VGND VPWR VPWR sky130_fd_sc_hd__fill_1
XTAP_TAPCELL_ROW_23_110 VGND VPWR sky130_fd_sc_hd__tapvpwrvgnd_1
X_290_ _081_ _096_ _082_ VGND VGND VPWR VPWR _097_ sky130_fd_sc_hd__a21bo_1
XTAP_TAPCELL_ROW_20_102 VGND VPWR sky130_fd_sc_hd__tapvpwrvgnd_1
XPHY_EDGE_ROW_19_Left_43 VGND VGND VPWR VPWR sky130_fd_sc_hd__decap_3
XFILLER_8_130 VGND VGND VPWR VPWR sky130_fd_sc_hd__decap_6
X_342_ _126_ _140_ VGND VGND VPWR VPWR _141_ sky130_fd_sc_hd__nand2_1
X_273_ _078_ _079_ VGND VGND VPWR VPWR _080_ sky130_fd_sc_hd__nand2b_1
XFILLER_23_57 VGND VGND VPWR VPWR sky130_fd_sc_hd__fill_2
XFILLER_2_103 VGND VGND VPWR VPWR sky130_fd_sc_hd__decap_8
XPHY_EDGE_ROW_4_Left_28 VGND VGND VPWR VPWR sky130_fd_sc_hd__decap_3
X_187_ net65 _008_ _007_ VGND VGND VPWR VPWR _010_ sky130_fd_sc_hd__a21bo_1
X_325_ net51 net19 VGND VGND VPWR VPWR _124_ sky130_fd_sc_hd__nor2_1
X_256_ _066_ VGND VGND VPWR VPWR _067_ sky130_fd_sc_hd__inv_2
X_239_ _037_ _053_ _036_ VGND VGND VPWR VPWR _054_ sky130_fd_sc_hd__a21bo_1
X_308_ _080_ _098_ VGND VGND VPWR VPWR _111_ sky130_fd_sc_hd__or2_1
XPHY_EDGE_ROW_7_Left_31 VGND VGND VPWR VPWR sky130_fd_sc_hd__decap_3
XFILLER_15_47 VGND VGND VPWR VPWR sky130_fd_sc_hd__fill_2
XFILLER_15_25 VGND VGND VPWR VPWR sky130_fd_sc_hd__decap_3
XPHY_EDGE_ROW_19_Right_19 VGND VGND VPWR VPWR sky130_fd_sc_hd__decap_3
Xoutput68 net68 VGND VGND VPWR VPWR sum[10] sky130_fd_sc_hd__buf_2
Xoutput79 net79 VGND VGND VPWR VPWR sum[20] sky130_fd_sc_hd__buf_2
XFILLER_7_81 VPWR VGND VPWR VGND sky130_ef_sc_hd__decap_12
XTAP_TAPCELL_ROW_23_111 VGND VPWR sky130_fd_sc_hd__tapvpwrvgnd_1
XTAP_TAPCELL_ROW_16_90 VGND VPWR sky130_fd_sc_hd__tapvpwrvgnd_1
X_272_ net43 net11 VGND VGND VPWR VPWR _079_ sky130_fd_sc_hd__nand2_1
X_341_ _129_ _139_ _128_ VGND VGND VPWR VPWR _140_ sky130_fd_sc_hd__a21o_1
XPHY_EDGE_ROW_20_Left_44 VGND VGND VPWR VPWR sky130_fd_sc_hd__decap_3
XFILLER_5_134 VGND VGND VPWR VPWR sky130_fd_sc_hd__fill_1
XFILLER_23_14 VGND VGND VPWR VPWR sky130_fd_sc_hd__fill_2
X_186_ _007_ _008_ VGND VGND VPWR VPWR _009_ sky130_fd_sc_hd__nand2_1
X_324_ net52 net20 VGND VGND VPWR VPWR _123_ sky130_fd_sc_hd__xnor2_1
XFILLER_0_29 VGND VGND VPWR VPWR sky130_fd_sc_hd__fill_2
X_255_ _064_ _065_ VGND VGND VPWR VPWR _066_ sky130_fd_sc_hd__nand2_1
XFILLER_9_38 VPWR VGND VPWR VGND sky130_ef_sc_hd__decap_12
XTAP_TAPCELL_ROW_0_50 VGND VPWR sky130_fd_sc_hd__tapvpwrvgnd_1
XFILLER_1_3 VGND VGND VPWR VPWR sky130_fd_sc_hd__fill_1
X_238_ _040_ _052_ _039_ VGND VGND VPWR VPWR _053_ sky130_fd_sc_hd__a21bo_1
XFILLER_1_50 VGND VGND VPWR VPWR sky130_fd_sc_hd__decap_6
X_307_ _108_ _109_ VGND VGND VPWR VPWR _110_ sky130_fd_sc_hd__nand2_1
XFILLER_20_15 VPWR VGND VPWR VGND sky130_ef_sc_hd__decap_12
XFILLER_19_100 VPWR VGND VPWR VGND sky130_ef_sc_hd__decap_12
Xoutput69 net69 VGND VGND VPWR VPWR sum[11] sky130_fd_sc_hd__buf_2
XFILLER_7_93 VPWR VGND VPWR VGND sky130_ef_sc_hd__decap_12
XTAP_TAPCELL_ROW_23_112 VGND VPWR sky130_fd_sc_hd__tapvpwrvgnd_1
XTAP_TAPCELL_ROW_16_91 VGND VPWR sky130_fd_sc_hd__tapvpwrvgnd_1
XFILLER_16_91 VGND VGND VPWR VPWR sky130_fd_sc_hd__fill_1
XFILLER_12_27 VGND VGND VPWR VPWR sky130_fd_sc_hd__fill_1
X_271_ net43 net11 VGND VGND VPWR VPWR _078_ sky130_fd_sc_hd__nor2_1
XFILLER_5_124 VGND VGND VPWR VPWR sky130_fd_sc_hd__fill_1
X_340_ _132_ _136_ _138_ VGND VGND VPWR VPWR _139_ sky130_fd_sc_hd__a21o_1
XFILLER_23_48 VGND VGND VPWR VPWR sky130_fd_sc_hd__decap_4
XFILLER_4_50 VGND VGND VPWR VPWR sky130_fd_sc_hd__fill_1
XFILLER_4_83 VGND VGND VPWR VPWR sky130_fd_sc_hd__fill_1
X_185_ net33 net1 VGND VGND VPWR VPWR _008_ sky130_fd_sc_hd__or2_1
XFILLER_13_81 VPWR VGND VPWR VGND sky130_ef_sc_hd__decap_12
X_323_ _116_ _122_ VGND VGND VPWR VPWR net79 sky130_fd_sc_hd__and2_1
X_254_ net36 net4 VGND VGND VPWR VPWR _065_ sky130_fd_sc_hd__or2_1
XTAP_TAPCELL_ROW_0_51 VGND VPWR sky130_fd_sc_hd__tapvpwrvgnd_1
XFILLER_18_26 VGND VGND VPWR VPWR sky130_fd_sc_hd__fill_2
X_237_ _042_ _051_ VGND VGND VPWR VPWR _052_ sky130_fd_sc_hd__or2_1
X_306_ net45 net13 VGND VGND VPWR VPWR _109_ sky130_fd_sc_hd__or2_1
XFILLER_20_38 VPWR VGND VPWR VGND sky130_ef_sc_hd__decap_12
XFILLER_20_27 VGND VGND VPWR VPWR sky130_fd_sc_hd__fill_1
XFILLER_1_84 VGND VGND VPWR VPWR sky130_fd_sc_hd__decap_8
XFILLER_19_80 VGND VGND VPWR VPWR sky130_fd_sc_hd__fill_2
XPHY_EDGE_ROW_1_Right_1 VGND VGND VPWR VPWR sky130_fd_sc_hd__decap_3
XFILLER_22_107 VGND VGND VPWR VPWR sky130_fd_sc_hd__decap_6
XFILLER_21_140 VGND VGND VPWR VPWR sky130_fd_sc_hd__fill_1
XTAP_TAPCELL_ROW_16_92 VGND VPWR sky130_fd_sc_hd__tapvpwrvgnd_1
XFILLER_13_129 VGND VGND VPWR VPWR sky130_fd_sc_hd__fill_1
XFILLER_5_103 VGND VGND VPWR VPWR sky130_fd_sc_hd__fill_1
X_270_ _066_ _071_ VGND VGND VPWR VPWR net70 sky130_fd_sc_hd__xnor2_1
XFILLER_4_73 VGND VGND VPWR VPWR sky130_fd_sc_hd__fill_1
X_322_ _110_ _113_ _115_ VGND VGND VPWR VPWR _122_ sky130_fd_sc_hd__nand3_1
XFILLER_9_18 VPWR VGND VPWR VGND sky130_ef_sc_hd__decap_12
X_184_ net33 net1 VGND VGND VPWR VPWR _007_ sky130_fd_sc_hd__nand2_1
XFILLER_13_93 VGND VGND VPWR VPWR sky130_fd_sc_hd__decap_8
XTAP_TAPCELL_ROW_0_52 VGND VPWR sky130_fd_sc_hd__tapvpwrvgnd_1
X_253_ net36 net4 VGND VGND VPWR VPWR _064_ sky130_fd_sc_hd__nand2_1
X_236_ _028_ _047_ _050_ _046_ VGND VGND VPWR VPWR _051_ sky130_fd_sc_hd__a211oi_4
X_305_ net45 net13 VGND VGND VPWR VPWR _108_ sky130_fd_sc_hd__nand2_1
XFILLER_1_41 VGND VGND VPWR VPWR sky130_fd_sc_hd__fill_2
XFILLER_10_83 VGND VGND VPWR VPWR sky130_fd_sc_hd__fill_1
X_219_ net35 net3 VGND VGND VPWR VPWR _034_ sky130_fd_sc_hd__nand2_1
XPHY_EDGE_ROW_15_Right_15 VGND VGND VPWR VPWR sky130_fd_sc_hd__decap_3
XFILLER_12_29 VPWR VGND VPWR VGND sky130_ef_sc_hd__decap_12
XFILLER_4_85 VPWR VGND VPWR VGND sky130_ef_sc_hd__decap_12
XTAP_TAPCELL_ROW_13_83 VGND VPWR sky130_fd_sc_hd__tapvpwrvgnd_1
X_183_ net44 net12 VGND VGND VPWR VPWR _006_ sky130_fd_sc_hd__and2_1
X_321_ _117_ _121_ VGND VGND VPWR VPWR net80 sky130_fd_sc_hd__nor2_1
X_252_ _061_ _062_ VGND VGND VPWR VPWR _063_ sky130_fd_sc_hd__nand2_1
XTAP_TAPCELL_ROW_9_73 VGND VPWR sky130_fd_sc_hd__tapvpwrvgnd_1
X_304_ _105_ _106_ VGND VGND VPWR VPWR _107_ sky130_fd_sc_hd__nand2_1
X_235_ _042_ _049_ VGND VGND VPWR VPWR _050_ sky130_fd_sc_hd__or2_1
XFILLER_20_29 VGND VGND VPWR VPWR sky130_fd_sc_hd__decap_4
X_218_ net35 net3 VGND VGND VPWR VPWR _033_ sky130_fd_sc_hd__nor2_1
XPHY_EDGE_ROW_11_Left_35 VGND VGND VPWR VPWR sky130_fd_sc_hd__decap_3
XFILLER_16_139 VGND VGND VPWR VPWR sky130_fd_sc_hd__fill_1
XFILLER_13_109 VGND VGND VPWR VPWR sky130_fd_sc_hd__decap_3
XFILLER_21_120 VGND VGND VPWR VPWR sky130_fd_sc_hd__decap_8
XFILLER_23_29 VGND VGND VPWR VPWR sky130_fd_sc_hd__fill_2
XTAP_TAPCELL_ROW_13_84 VGND VPWR sky130_fd_sc_hd__tapvpwrvgnd_1
XFILLER_4_64 VGND VGND VPWR VPWR sky130_fd_sc_hd__fill_1
XFILLER_4_97 VPWR VGND VPWR VGND sky130_ef_sc_hd__decap_12
X_182_ _003_ _004_ VGND VGND VPWR VPWR _005_ sky130_fd_sc_hd__nor2_1
X_320_ _107_ _108_ _116_ VGND VGND VPWR VPWR _121_ sky130_fd_sc_hd__and3_1
X_251_ net37 net5 VGND VGND VPWR VPWR _062_ sky130_fd_sc_hd__or2_1
XFILLER_18_29 VGND VGND VPWR VPWR sky130_fd_sc_hd__fill_1
XFILLER_18_18 VGND VGND VPWR VPWR sky130_fd_sc_hd__decap_8
XTAP_TAPCELL_ROW_9_74 VGND VPWR sky130_fd_sc_hd__tapvpwrvgnd_1
XFILLER_1_76 VGND VGND VPWR VPWR sky130_fd_sc_hd__fill_1
X_303_ net46 net14 VGND VGND VPWR VPWR _106_ sky130_fd_sc_hd__or2_1
X_234_ net63 net31 VGND VGND VPWR VPWR _049_ sky130_fd_sc_hd__nor2_1
XFILLER_19_137 VGND VGND VPWR VPWR sky130_fd_sc_hd__decap_4
XFILLER_19_126 VGND VGND VPWR VPWR sky130_fd_sc_hd__decap_4
XFILLER_19_72 VGND VGND VPWR VPWR sky130_fd_sc_hd__decap_8
X_217_ _023_ _027_ VGND VGND VPWR VPWR net93 sky130_fd_sc_hd__xnor2_1
XFILLER_10_41 VPWR VGND VPWR VGND sky130_ef_sc_hd__decap_12
XFILLER_10_85 VPWR VGND VPWR VGND sky130_ef_sc_hd__decap_12
XFILLER_21_110 VGND VGND VPWR VPWR sky130_fd_sc_hd__fill_2
XPHY_EDGE_ROW_5_Right_5 VGND VGND VPWR VPWR sky130_fd_sc_hd__decap_3
XFILLER_8_136 VGND VGND VPWR VPWR sky130_fd_sc_hd__fill_1
X_181_ net55 net23 VGND VGND VPWR VPWR _004_ sky130_fd_sc_hd__nor2_1
X_250_ net37 net5 VGND VGND VPWR VPWR _061_ sky130_fd_sc_hd__nand2_1
X_379_ _155_ _157_ _159_ _161_ _163_ VGND VGND VPWR VPWR _171_ sky130_fd_sc_hd__o2111a_1
X_233_ _028_ _047_ _046_ VGND VGND VPWR VPWR _048_ sky130_fd_sc_hd__a21o_1
X_302_ net46 net14 VGND VGND VPWR VPWR _105_ sky130_fd_sc_hd__nand2_1
XTAP_TAPCELL_ROW_10_75 VGND VPWR sky130_fd_sc_hd__tapvpwrvgnd_1
XTAP_TAPCELL_ROW_6_65 VGND VPWR sky130_fd_sc_hd__tapvpwrvgnd_1
XFILLER_10_53 VPWR VGND VPWR VGND sky130_ef_sc_hd__decap_12
XFILLER_10_97 VGND VGND VPWR VPWR sky130_fd_sc_hd__decap_4
X_216_ _020_ _028_ VGND VGND VPWR VPWR net94 sky130_fd_sc_hd__xnor2_1
XFILLER_7_10 VPWR VGND VPWR VGND sky130_ef_sc_hd__decap_12
XFILLER_7_54 VGND VGND VPWR VPWR sky130_fd_sc_hd__fill_2
XPHY_EDGE_ROW_20_Right_20 VGND VGND VPWR VPWR sky130_fd_sc_hd__decap_3
XFILLER_16_85 VGND VGND VPWR VPWR sky130_fd_sc_hd__decap_6
XFILLER_16_41 VGND VGND VPWR VPWR sky130_fd_sc_hd__decap_8
XPHY_EDGE_ROW_11_Right_11 VGND VGND VPWR VPWR sky130_fd_sc_hd__decap_3
XFILLER_4_77 VGND VGND VPWR VPWR sky130_fd_sc_hd__decap_6
X_180_ _002_ VGND VGND VPWR VPWR _003_ sky130_fd_sc_hd__inv_2
XFILLER_13_31 VPWR VGND VPWR VGND sky130_ef_sc_hd__decap_12
X_378_ _169_ _170_ VGND VGND VPWR VPWR net88 sky130_fd_sc_hd__nand2_1
X_232_ _018_ _043_ _045_ VGND VGND VPWR VPWR _047_ sky130_fd_sc_hd__o21a_1
XFILLER_1_12 VGND VGND VPWR VPWR sky130_fd_sc_hd__fill_2
X_301_ net47 net15 VGND VGND VPWR VPWR _104_ sky130_fd_sc_hd__nand2_1
XTAP_TAPCELL_ROW_10_76 VGND VPWR sky130_fd_sc_hd__tapvpwrvgnd_1
XFILLER_10_21 VGND VGND VPWR VPWR sky130_fd_sc_hd__fill_1
XFILLER_10_65 VPWR VGND VPWR VGND sky130_ef_sc_hd__decap_12
X_215_ _030_ _032_ VGND VGND VPWR VPWR net95 sky130_fd_sc_hd__and2b_1
XTAP_TAPCELL_ROW_6_66 VGND VPWR sky130_fd_sc_hd__tapvpwrvgnd_1
XFILLER_21_31 VPWR VGND VPWR VGND sky130_ef_sc_hd__decap_12
XFILLER_21_20 VGND VGND VPWR VPWR sky130_fd_sc_hd__decap_6
XPHY_EDGE_ROW_15_Left_39 VGND VGND VPWR VPWR sky130_fd_sc_hd__decap_3
XFILLER_7_22 VPWR VGND VPWR VGND sky130_ef_sc_hd__decap_12
XFILLER_4_56 VGND VGND VPWR VPWR sky130_fd_sc_hd__decap_8
XPHY_EDGE_ROW_18_Left_42 VGND VGND VPWR VPWR sky130_fd_sc_hd__decap_3
X_377_ _149_ _153_ _156_ _165_ VGND VGND VPWR VPWR _170_ sky130_fd_sc_hd__a22o_1
XFILLER_13_43 VPWR VGND VPWR VGND sky130_ef_sc_hd__decap_12
XFILLER_8_3 VGND VGND VPWR VPWR sky130_fd_sc_hd__fill_1
X_231_ _019_ _043_ _045_ VGND VGND VPWR VPWR _046_ sky130_fd_sc_hd__o21a_1
X_300_ net47 net15 VGND VGND VPWR VPWR _103_ sky130_fd_sc_hd__or2_1
XPHY_EDGE_ROW_3_Left_27 VGND VGND VPWR VPWR sky130_fd_sc_hd__decap_3
XFILLER_1_57 VGND VGND VPWR VPWR sky130_fd_sc_hd__decap_3
Xinput1 a[0] VGND VGND VPWR VPWR net1 sky130_fd_sc_hd__clkbuf_1
XFILLER_10_77 VGND VGND VPWR VPWR sky130_fd_sc_hd__decap_6
XTAP_TAPCELL_ROW_10_77 VGND VPWR sky130_fd_sc_hd__tapvpwrvgnd_1
X_214_ _016_ _017_ _029_ VGND VGND VPWR VPWR _032_ sky130_fd_sc_hd__or3_1
XTAP_TAPCELL_ROW_6_67 VGND VPWR sky130_fd_sc_hd__tapvpwrvgnd_1
XFILLER_21_98 VPWR VGND VPWR VGND sky130_ef_sc_hd__decap_12
XFILLER_21_65 VPWR VGND VPWR VGND sky130_ef_sc_hd__decap_12
XFILLER_21_43 VGND VGND VPWR VPWR sky130_fd_sc_hd__decap_4
XPHY_EDGE_ROW_6_Left_30 VGND VGND VPWR VPWR sky130_fd_sc_hd__decap_3
XTAP_TAPCELL_ROW_23_108 VGND VPWR sky130_fd_sc_hd__tapvpwrvgnd_1
XFILLER_21_113 VGND VGND VPWR VPWR sky130_fd_sc_hd__decap_4
XFILLER_7_34 VPWR VGND VPWR VGND sky130_ef_sc_hd__decap_12
XFILLER_16_54 VPWR VGND VPWR VGND sky130_ef_sc_hd__decap_12
XPHY_EDGE_ROW_9_Right_9 VGND VGND VPWR VPWR sky130_fd_sc_hd__decap_3
XFILLER_13_55 VGND VGND VPWR VPWR sky130_fd_sc_hd__fill_1
X_376_ _149_ _153_ _156_ _165_ VGND VGND VPWR VPWR _169_ sky130_fd_sc_hd__nand4_1
X_230_ net62 net30 _044_ VGND VGND VPWR VPWR _045_ sky130_fd_sc_hd__o21ai_1
X_359_ _149_ _151_ _153_ VGND VGND VPWR VPWR _154_ sky130_fd_sc_hd__and3_1
XTAP_TAPCELL_ROW_19_98 VGND VPWR sky130_fd_sc_hd__tapvpwrvgnd_1
Xinput2 a[10] VGND VGND VPWR VPWR net2 sky130_fd_sc_hd__clkbuf_1
XFILLER_19_65 VGND VGND VPWR VPWR sky130_fd_sc_hd__fill_1
XFILLER_19_21 VGND VGND VPWR VPWR sky130_fd_sc_hd__decap_3
XFILLER_19_10 VGND VGND VPWR VPWR sky130_fd_sc_hd__decap_4
X_213_ _015_ _031_ VGND VGND VPWR VPWR net96 sky130_fd_sc_hd__xnor2_1
XFILLER_18_141 VGND VGND VPWR VPWR sky130_fd_sc_hd__decap_3
XFILLER_18_6 VPWR VGND VPWR VGND sky130_ef_sc_hd__decap_12
XFILLER_21_77 VPWR VGND VPWR VGND sky130_ef_sc_hd__decap_12
XFILLER_21_55 VGND VGND VPWR VPWR sky130_fd_sc_hd__fill_1
XFILLER_15_100 VPWR VGND VPWR VGND sky130_ef_sc_hd__decap_12
XTAP_TAPCELL_ROW_23_109 VGND VPWR sky130_fd_sc_hd__tapvpwrvgnd_1
XFILLER_7_46 VGND VGND VPWR VPWR sky130_fd_sc_hd__decap_8
XFILLER_7_57 VPWR VGND VPWR VGND sky130_ef_sc_hd__decap_12
Xinput60 b[5] VGND VGND VPWR VPWR net60 sky130_fd_sc_hd__clkbuf_1
XFILLER_16_66 VPWR VGND VPWR VGND sky130_ef_sc_hd__decap_12
XFILLER_8_118 VPWR VGND VPWR VGND sky130_ef_sc_hd__decap_12
XTAP_TAPCELL_ROW_3_58 VGND VPWR sky130_fd_sc_hd__tapvpwrvgnd_1
XFILLER_4_121 VGND VGND VPWR VPWR sky130_fd_sc_hd__decap_4
XTAP_TAPCELL_ROW_0_48 VGND VPWR sky130_fd_sc_hd__tapvpwrvgnd_1
X_375_ _151_ _168_ VGND VGND VPWR VPWR net90 sky130_fd_sc_hd__xnor2_1
X_358_ net54 net22 VGND VGND VPWR VPWR _153_ sky130_fd_sc_hd__or2_1
XTAP_TAPCELL_ROW_19_99 VGND VPWR sky130_fd_sc_hd__tapvpwrvgnd_1
XPHY_EDGE_ROW_18_Right_18 VGND VGND VPWR VPWR sky130_fd_sc_hd__decap_3
X_289_ net41 net9 _095_ VGND VGND VPWR VPWR _096_ sky130_fd_sc_hd__a21o_1
Xinput3 a[11] VGND VGND VPWR VPWR net3 sky130_fd_sc_hd__clkbuf_1
XFILLER_19_88 VPWR VGND VPWR VGND sky130_ef_sc_hd__decap_12
XFILLER_19_55 VGND VGND VPWR VPWR sky130_fd_sc_hd__fill_1
X_212_ net61 net29 _030_ VGND VGND VPWR VPWR _031_ sky130_fd_sc_hd__a21oi_1
XFILLER_21_89 VGND VGND VPWR VPWR sky130_fd_sc_hd__decap_6
XFILLER_7_69 VPWR VGND VPWR VGND sky130_ef_sc_hd__decap_12
Xinput61 b[6] VGND VGND VPWR VPWR net61 sky130_fd_sc_hd__buf_1
Xinput50 b[25] VGND VGND VPWR VPWR net50 sky130_fd_sc_hd__clkbuf_1
XFILLER_16_78 VGND VGND VPWR VPWR sky130_fd_sc_hd__decap_6
XPHY_EDGE_ROW_0_Right_0 VGND VGND VPWR VPWR sky130_fd_sc_hd__decap_3
XTAP_TAPCELL_ROW_3_59 VGND VPWR sky130_fd_sc_hd__tapvpwrvgnd_1
XFILLER_13_57 VPWR VGND VPWR VGND sky130_ef_sc_hd__decap_12
XFILLER_1_136 VGND VGND VPWR VPWR sky130_fd_sc_hd__fill_1
XTAP_TAPCELL_ROW_0_49 VGND VPWR sky130_fd_sc_hd__tapvpwrvgnd_1
X_374_ _149_ _156_ _165_ _152_ VGND VGND VPWR VPWR _168_ sky130_fd_sc_hd__a31o_1
XFILLER_6_3 VGND VGND VPWR VPWR sky130_fd_sc_hd__fill_1
X_357_ net54 net22 VGND VGND VPWR VPWR _152_ sky130_fd_sc_hd__nor2_1
Xinput4 a[12] VGND VGND VPWR VPWR net4 sky130_fd_sc_hd__clkbuf_1
X_288_ _086_ _094_ _085_ VGND VGND VPWR VPWR _095_ sky130_fd_sc_hd__a21oi_1
X_211_ _017_ _029_ _016_ VGND VGND VPWR VPWR _030_ sky130_fd_sc_hd__o21a_1
XFILLER_18_121 VGND VGND VPWR VPWR sky130_fd_sc_hd__decap_8
XFILLER_2_81 VGND VGND VPWR VPWR sky130_fd_sc_hd__decap_3
XFILLER_15_113 VPWR VGND VPWR VGND sky130_ef_sc_hd__decap_12
Xinput51 b[26] VGND VGND VPWR VPWR net51 sky130_fd_sc_hd__buf_1
Xinput40 b[16] VGND VGND VPWR VPWR net40 sky130_fd_sc_hd__clkbuf_1
Xinput62 b[7] VGND VGND VPWR VPWR net62 sky130_fd_sc_hd__buf_1
XFILLER_12_127 VGND VGND VPWR VPWR sky130_fd_sc_hd__fill_2
XFILLER_8_109 VGND VGND VPWR VPWR sky130_fd_sc_hd__fill_2
XFILLER_21_3 VGND VGND VPWR VPWR sky130_fd_sc_hd__fill_1
XFILLER_4_16 VPWR VGND VPWR VGND sky130_ef_sc_hd__decap_12
XFILLER_4_38 VPWR VGND VPWR VGND sky130_ef_sc_hd__decap_12
XFILLER_13_69 VPWR VGND VPWR VGND sky130_ef_sc_hd__decap_12
X_373_ _146_ _167_ VGND VGND VPWR VPWR net91 sky130_fd_sc_hd__xor2_1
XPHY_EDGE_ROW_23_Left_47 VGND VGND VPWR VPWR sky130_fd_sc_hd__decap_3
X_356_ _147_ _148_ VGND VGND VPWR VPWR _151_ sky130_fd_sc_hd__and2b_1
Xinput5 a[13] VGND VGND VPWR VPWR net5 sky130_fd_sc_hd__buf_1
X_287_ _088_ _093_ VGND VGND VPWR VPWR _094_ sky130_fd_sc_hd__or2_1
XFILLER_19_57 VGND VGND VPWR VPWR sky130_fd_sc_hd__decap_8
XFILLER_10_15 VGND VGND VPWR VPWR sky130_fd_sc_hd__decap_6
X_210_ _028_ _020_ VGND VGND VPWR VPWR _029_ sky130_fd_sc_hd__and2b_1
X_339_ _129_ _137_ VGND VGND VPWR VPWR _138_ sky130_fd_sc_hd__nand2_1
XFILLER_21_47 VGND VGND VPWR VPWR sky130_fd_sc_hd__fill_1
XFILLER_15_125 VPWR VGND VPWR VGND sky130_ef_sc_hd__decap_12
Xinput52 b[27] VGND VGND VPWR VPWR net52 sky130_fd_sc_hd__buf_1
Xinput41 b[17] VGND VGND VPWR VPWR net41 sky130_fd_sc_hd__clkbuf_1
Xinput63 b[8] VGND VGND VPWR VPWR net63 sky130_fd_sc_hd__buf_1
XPHY_EDGE_ROW_10_Left_34 VGND VGND VPWR VPWR sky130_fd_sc_hd__decap_3
Xinput30 a[7] VGND VGND VPWR VPWR net30 sky130_fd_sc_hd__buf_1
XFILLER_16_25 VGND VGND VPWR VPWR sky130_fd_sc_hd__decap_3
XFILLER_8_70 VPWR VGND VPWR VGND sky130_ef_sc_hd__decap_12
XTAP_TAPCELL_ROW_4_60 VGND VPWR sky130_fd_sc_hd__tapvpwrvgnd_1
X_372_ _154_ _164_ _166_ VGND VGND VPWR VPWR _167_ sky130_fd_sc_hd__a21o_1
X_355_ _148_ _149_ _147_ VGND VGND VPWR VPWR _150_ sky130_fd_sc_hd__a21oi_1
X_286_ _072_ _092_ _091_ VGND VGND VPWR VPWR _093_ sky130_fd_sc_hd__a21o_1
XFILLER_19_36 VGND VGND VPWR VPWR sky130_fd_sc_hd__decap_8
Xinput6 a[14] VGND VGND VPWR VPWR net6 sky130_fd_sc_hd__clkbuf_1
XPHY_EDGE_ROW_23_Right_23 VGND VGND VPWR VPWR sky130_fd_sc_hd__decap_3
XPHY_EDGE_ROW_14_Right_14 VGND VGND VPWR VPWR sky130_fd_sc_hd__decap_3
X_269_ _073_ _077_ VGND VGND VPWR VPWR net71 sky130_fd_sc_hd__nor2_1
X_338_ net49 net17 VGND VGND VPWR VPWR _137_ sky130_fd_sc_hd__or2_1
XFILLER_21_26 VGND VGND VPWR VPWR sky130_fd_sc_hd__fill_1
XFILLER_15_137 VGND VGND VPWR VPWR sky130_fd_sc_hd__decap_3
Xinput20 a[27] VGND VGND VPWR VPWR net20 sky130_fd_sc_hd__buf_1
XFILLER_16_7 VGND VGND VPWR VPWR sky130_fd_sc_hd__decap_3
Xinput31 a[8] VGND VGND VPWR VPWR net31 sky130_fd_sc_hd__buf_1
XFILLER_11_81 VPWR VGND VPWR VGND sky130_ef_sc_hd__decap_12
Xinput53 b[28] VGND VGND VPWR VPWR net53 sky130_fd_sc_hd__buf_1
Xinput64 b[9] VGND VGND VPWR VPWR net64 sky130_fd_sc_hd__clkbuf_1
Xinput42 b[18] VGND VGND VPWR VPWR net42 sky130_fd_sc_hd__clkbuf_1
XFILLER_22_91 VGND VGND VPWR VPWR sky130_fd_sc_hd__fill_1
XFILLER_7_111 VGND VGND VPWR VPWR sky130_fd_sc_hd__fill_1
XPHY_EDGE_ROW_4_Right_4 VGND VGND VPWR VPWR sky130_fd_sc_hd__decap_3
XFILLER_8_82 VGND VGND VPWR VPWR sky130_fd_sc_hd__fill_2
XFILLER_4_136 VGND VGND VPWR VPWR sky130_fd_sc_hd__fill_1
XTAP_TAPCELL_ROW_4_61 VGND VPWR sky130_fd_sc_hd__tapvpwrvgnd_1
X_371_ _154_ _155_ _150_ VGND VGND VPWR VPWR _166_ sky130_fd_sc_hd__a21o_1
XFILLER_1_106 VGND VGND VPWR VPWR sky130_fd_sc_hd__decap_6
X_354_ net54 net22 VGND VGND VPWR VPWR _149_ sky130_fd_sc_hd__nand2_1
X_285_ _090_ _064_ VGND VGND VPWR VPWR _092_ sky130_fd_sc_hd__and2b_1
Xinput7 a[15] VGND VGND VPWR VPWR net7 sky130_fd_sc_hd__clkbuf_1
XFILLER_18_135 VGND VGND VPWR VPWR sky130_fd_sc_hd__decap_4
X_199_ _017_ VGND VGND VPWR VPWR _018_ sky130_fd_sc_hd__inv_2
XFILLER_2_62 VPWR VGND VPWR VGND sky130_ef_sc_hd__decap_12
X_337_ _101_ _133_ _134_ _135_ VGND VGND VPWR VPWR _136_ sky130_fd_sc_hd__and4_1
X_268_ _063_ _064_ _072_ VGND VGND VPWR VPWR _077_ sky130_fd_sc_hd__and3_1
XFILLER_23_9 VGND VGND VPWR VPWR sky130_fd_sc_hd__fill_1
XFILLER_11_93 VGND VGND VPWR VPWR sky130_fd_sc_hd__decap_8
Xinput65 cin VGND VGND VPWR VPWR net65 sky130_fd_sc_hd__buf_1
Xinput21 a[28] VGND VGND VPWR VPWR net21 sky130_fd_sc_hd__buf_1
Xinput54 b[29] VGND VGND VPWR VPWR net54 sky130_fd_sc_hd__buf_1
Xinput32 a[9] VGND VGND VPWR VPWR net32 sky130_fd_sc_hd__clkbuf_1
XFILLER_16_49 VGND VGND VPWR VPWR sky130_fd_sc_hd__fill_1
XFILLER_12_119 VGND VGND VPWR VPWR sky130_fd_sc_hd__decap_8
Xinput43 b[19] VGND VGND VPWR VPWR net43 sky130_fd_sc_hd__clkbuf_1
Xinput10 a[18] VGND VGND VPWR VPWR net10 sky130_fd_sc_hd__clkbuf_1
XFILLER_22_70 VGND VGND VPWR VPWR sky130_fd_sc_hd__decap_6
XTAP_TAPCELL_ROW_4_62 VGND VPWR sky130_fd_sc_hd__tapvpwrvgnd_1
X_370_ _159_ _161_ _163_ _157_ _155_ VGND VGND VPWR VPWR _165_ sky130_fd_sc_hd__a311o_1
X_353_ net56 net24 VGND VGND VPWR VPWR _148_ sky130_fd_sc_hd__nand2_1
X_284_ _063_ _089_ _090_ VGND VGND VPWR VPWR _091_ sky130_fd_sc_hd__o21ba_1
Xinput8 a[16] VGND VGND VPWR VPWR net8 sky130_fd_sc_hd__buf_1
XFILLER_10_29 VPWR VGND VPWR VGND sky130_ef_sc_hd__decap_12
X_198_ net60 net28 VGND VGND VPWR VPWR _017_ sky130_fd_sc_hd__and2_1
X_267_ _074_ _076_ VGND VGND VPWR VPWR net72 sky130_fd_sc_hd__xor2_1
X_336_ _104_ _100_ VGND VGND VPWR VPWR _135_ sky130_fd_sc_hd__nand2b_1
XFILLER_2_74 VGND VGND VPWR VPWR sky130_fd_sc_hd__fill_2
XFILLER_2_85 VPWR VGND VPWR VGND sky130_ef_sc_hd__decap_12
Xinput33 b[0] VGND VGND VPWR VPWR net33 sky130_fd_sc_hd__clkbuf_1
Xinput44 b[1] VGND VGND VPWR VPWR net44 sky130_fd_sc_hd__clkbuf_1
Xinput22 a[29] VGND VGND VPWR VPWR net22 sky130_fd_sc_hd__buf_1
Xinput55 b[2] VGND VGND VPWR VPWR net55 sky130_fd_sc_hd__clkbuf_1
XFILLER_16_17 VGND VGND VPWR VPWR sky130_fd_sc_hd__decap_8
X_319_ _118_ _120_ VGND VGND VPWR VPWR net81 sky130_fd_sc_hd__xnor2_1
Xinput11 a[19] VGND VGND VPWR VPWR net11 sky130_fd_sc_hd__buf_1
XFILLER_12_109 VGND VGND VPWR VPWR sky130_fd_sc_hd__fill_1
XFILLER_14_6 VGND VGND VPWR VPWR sky130_fd_sc_hd__decap_8
XPHY_EDGE_ROW_14_Left_38 VGND VGND VPWR VPWR sky130_fd_sc_hd__decap_3
XFILLER_7_113 VPWR VGND VPWR VGND sky130_ef_sc_hd__decap_12
XTAP_TAPCELL_ROW_17_93 VGND VPWR sky130_fd_sc_hd__tapvpwrvgnd_1
XFILLER_1_119 VGND VGND VPWR VPWR sky130_fd_sc_hd__decap_4
XFILLER_5_41 VGND VGND VPWR VPWR sky130_fd_sc_hd__decap_3
XPHY_EDGE_ROW_17_Left_41 VGND VGND VPWR VPWR sky130_fd_sc_hd__decap_3
X_352_ net56 net24 VGND VGND VPWR VPWR _147_ sky130_fd_sc_hd__nor2_1
XFILLER_14_83 VGND VGND VPWR VPWR sky130_fd_sc_hd__fill_1
Xinput9 a[17] VGND VGND VPWR VPWR net9 sky130_fd_sc_hd__buf_1
XTAP_TAPCELL_ROW_1_53 VGND VPWR sky130_fd_sc_hd__tapvpwrvgnd_1
X_283_ _056_ _060_ _061_ _089_ _057_ VGND VGND VPWR VPWR _090_ sky130_fd_sc_hd__o221ai_1
XPHY_EDGE_ROW_2_Left_26 VGND VGND VPWR VPWR sky130_fd_sc_hd__decap_3
X_197_ net61 net29 VGND VGND VPWR VPWR _016_ sky130_fd_sc_hd__xor2_1
X_266_ _059_ _060_ VGND VGND VPWR VPWR _076_ sky130_fd_sc_hd__nand2b_1
X_335_ _102_ _105_ _120_ VGND VGND VPWR VPWR _134_ sky130_fd_sc_hd__or3_1
XPHY_EDGE_ROW_10_Right_10 VGND VGND VPWR VPWR sky130_fd_sc_hd__decap_3
Xinput23 a[2] VGND VGND VPWR VPWR net23 sky130_fd_sc_hd__clkbuf_1
Xinput12 a[1] VGND VGND VPWR VPWR net12 sky130_fd_sc_hd__clkbuf_1
Xinput56 b[30] VGND VGND VPWR VPWR net56 sky130_fd_sc_hd__buf_1
X_318_ _103_ _104_ VGND VGND VPWR VPWR _120_ sky130_fd_sc_hd__nand2_1
X_249_ net38 net6 VGND VGND VPWR VPWR _060_ sky130_fd_sc_hd__nand2_1
Xinput45 b[20] VGND VGND VPWR VPWR net45 sky130_fd_sc_hd__clkbuf_1
Xinput34 b[10] VGND VGND VPWR VPWR net34 sky130_fd_sc_hd__clkbuf_1
XTAP_TAPCELL_ROW_22_105 VGND VPWR sky130_fd_sc_hd__tapvpwrvgnd_1
XFILLER_16_29 VGND VGND VPWR VPWR sky130_fd_sc_hd__decap_3
XFILLER_7_125 VPWR VGND VPWR VGND sky130_ef_sc_hd__decap_12
XFILLER_11_110 VGND VGND VPWR VPWR sky130_fd_sc_hd__fill_2
XFILLER_11_143 VGND VGND VPWR VPWR sky130_fd_sc_hd__fill_1
XFILLER_8_85 VPWR VGND VPWR VGND sky130_ef_sc_hd__decap_12
XTAP_TAPCELL_ROW_17_94 VGND VPWR sky130_fd_sc_hd__tapvpwrvgnd_1
XFILLER_17_94 VGND VGND VPWR VPWR sky130_fd_sc_hd__decap_8
XFILLER_17_72 VGND VGND VPWR VPWR sky130_fd_sc_hd__decap_3
XFILLER_4_128 VGND VGND VPWR VPWR sky130_fd_sc_hd__decap_8
XPHY_EDGE_ROW_8_Right_8 VGND VGND VPWR VPWR sky130_fd_sc_hd__decap_3
X_351_ net57 net25 VGND VGND VPWR VPWR _146_ sky130_fd_sc_hd__xor2_1
XTAP_TAPCELL_ROW_1_54 VGND VPWR sky130_fd_sc_hd__tapvpwrvgnd_1
X_282_ _058_ _076_ VGND VGND VPWR VPWR _089_ sky130_fd_sc_hd__or2_1
XFILLER_4_6 VGND VGND VPWR VPWR sky130_fd_sc_hd__decap_3
X_334_ _108_ _131_ VGND VGND VPWR VPWR _133_ sky130_fd_sc_hd__or2_1
X_196_ net62 net30 VGND VGND VPWR VPWR _015_ sky130_fd_sc_hd__xor2_1
X_265_ _058_ _075_ VGND VGND VPWR VPWR net73 sky130_fd_sc_hd__xnor2_1
XFILLER_2_43 VGND VGND VPWR VPWR sky130_fd_sc_hd__decap_8
Xinput24 a[30] VGND VGND VPWR VPWR net24 sky130_fd_sc_hd__buf_1
X_179_ net55 net23 VGND VGND VPWR VPWR _002_ sky130_fd_sc_hd__nand2_1
Xinput57 b[31] VGND VGND VPWR VPWR net57 sky130_fd_sc_hd__buf_1
X_248_ net38 net6 VGND VGND VPWR VPWR _059_ sky130_fd_sc_hd__nor2_1
Xinput46 b[21] VGND VGND VPWR VPWR net46 sky130_fd_sc_hd__buf_1
Xinput35 b[11] VGND VGND VPWR VPWR net35 sky130_fd_sc_hd__clkbuf_1
X_317_ _102_ _119_ VGND VGND VPWR VPWR net82 sky130_fd_sc_hd__xnor2_1
Xinput13 a[20] VGND VGND VPWR VPWR net13 sky130_fd_sc_hd__clkbuf_1
XTAP_TAPCELL_ROW_22_106 VGND VPWR sky130_fd_sc_hd__tapvpwrvgnd_1
XFILLER_7_137 VGND VGND VPWR VPWR sky130_fd_sc_hd__decap_3
XFILLER_8_97 VGND VGND VPWR VPWR sky130_fd_sc_hd__decap_4
XFILLER_3_140 VGND VGND VPWR VPWR sky130_fd_sc_hd__fill_1
XFILLER_0_132 VGND VGND VPWR VPWR sky130_fd_sc_hd__fill_1
XFILLER_5_10 VGND VGND VPWR VPWR sky130_fd_sc_hd__decap_3
XFILLER_5_21 VGND VGND VPWR VPWR sky130_fd_sc_hd__decap_8
XTAP_TAPCELL_ROW_14_85 VGND VPWR sky130_fd_sc_hd__tapvpwrvgnd_1
XFILLER_5_54 VGND VGND VPWR VPWR sky130_fd_sc_hd__fill_2
XFILLER_14_85 VPWR VGND VPWR VGND sky130_ef_sc_hd__decap_12
XFILLER_14_41 VPWR VGND VPWR VGND sky130_ef_sc_hd__decap_12
X_281_ _086_ _087_ VGND VGND VPWR VPWR _088_ sky130_fd_sc_hd__nand2_1
X_350_ _139_ _145_ VGND VGND VPWR VPWR net83 sky130_fd_sc_hd__and2_1
XFILLER_18_139 VGND VGND VPWR VPWR sky130_fd_sc_hd__fill_1
X_195_ net65 _009_ VGND VGND VPWR VPWR net67 sky130_fd_sc_hd__xnor2_1
XFILLER_2_22 VGND VGND VPWR VPWR sky130_fd_sc_hd__decap_6
X_264_ _059_ _074_ _060_ VGND VGND VPWR VPWR _075_ sky130_fd_sc_hd__o21ai_1
X_333_ _113_ _115_ _131_ _110_ VGND VGND VPWR VPWR _132_ sky130_fd_sc_hd__a211o_1
Xinput25 a[31] VGND VGND VPWR VPWR net25 sky130_fd_sc_hd__buf_1
X_316_ _103_ _118_ _104_ VGND VGND VPWR VPWR _119_ sky130_fd_sc_hd__a21bo_1
Xinput14 a[21] VGND VGND VPWR VPWR net14 sky130_fd_sc_hd__buf_1
X_247_ _056_ _057_ VGND VGND VPWR VPWR _058_ sky130_fd_sc_hd__nand2b_1
Xinput36 b[12] VGND VGND VPWR VPWR net36 sky130_fd_sc_hd__clkbuf_1
XTAP_TAPCELL_ROW_22_107 VGND VPWR sky130_fd_sc_hd__tapvpwrvgnd_1
Xinput58 b[3] VGND VGND VPWR VPWR net58 sky130_fd_sc_hd__clkbuf_1
X_178_ _175_ _000_ VGND VGND VPWR VPWR _001_ sky130_fd_sc_hd__and2b_1
Xinput47 b[22] VGND VGND VPWR VPWR net47 sky130_fd_sc_hd__clkbuf_1
XFILLER_22_85 VGND VGND VPWR VPWR sky130_fd_sc_hd__decap_6
XFILLER_7_105 VGND VGND VPWR VPWR sky130_fd_sc_hd__decap_6
XFILLER_11_101 VGND VGND VPWR VPWR sky130_fd_sc_hd__fill_2
XFILLER_17_63 VGND VGND VPWR VPWR sky130_fd_sc_hd__decap_6
XFILLER_5_77 VGND VGND VPWR VPWR sky130_fd_sc_hd__fill_1
XFILLER_5_99 VGND VGND VPWR VPWR sky130_fd_sc_hd__decap_4
XFILLER_14_97 VGND VGND VPWR VPWR sky130_fd_sc_hd__decap_8
XTAP_TAPCELL_ROW_14_86 VGND VPWR sky130_fd_sc_hd__tapvpwrvgnd_1
XFILLER_14_53 VPWR VGND VPWR VGND sky130_ef_sc_hd__decap_12
X_280_ net40 net8 VGND VGND VPWR VPWR _087_ sky130_fd_sc_hd__or2_1
X_194_ _010_ _012_ VGND VGND VPWR VPWR net78 sky130_fd_sc_hd__xor2_1
XFILLER_2_34 VGND VGND VPWR VPWR sky130_fd_sc_hd__decap_6
X_332_ _130_ VGND VGND VPWR VPWR _131_ sky130_fd_sc_hd__inv_2
X_263_ net37 net5 _073_ VGND VGND VPWR VPWR _074_ sky130_fd_sc_hd__a21oi_1
Xinput26 a[3] VGND VGND VPWR VPWR net26 sky130_fd_sc_hd__clkbuf_1
Xinput59 b[4] VGND VGND VPWR VPWR net59 sky130_fd_sc_hd__clkbuf_1
X_177_ net58 net26 VGND VGND VPWR VPWR _000_ sky130_fd_sc_hd__nand2_1
Xinput15 a[22] VGND VGND VPWR VPWR net15 sky130_fd_sc_hd__clkbuf_1
X_246_ net39 net7 VGND VGND VPWR VPWR _057_ sky130_fd_sc_hd__nand2_1
X_315_ net46 net14 _117_ VGND VGND VPWR VPWR _118_ sky130_fd_sc_hd__a21o_1
Xinput37 b[13] VGND VGND VPWR VPWR net37 sky130_fd_sc_hd__buf_1
Xinput48 b[23] VGND VGND VPWR VPWR net48 sky130_fd_sc_hd__clkbuf_1
XFILLER_22_20 VGND VGND VPWR VPWR sky130_fd_sc_hd__fill_1
XFILLER_11_113 VGND VGND VPWR VPWR sky130_fd_sc_hd__decap_6
X_229_ net62 net30 net61 net29 VGND VGND VPWR VPWR _044_ sky130_fd_sc_hd__a22o_1
XFILLER_4_109 VPWR VGND VPWR VGND sky130_ef_sc_hd__decap_12
XFILLER_3_120 VPWR VGND VPWR VGND sky130_ef_sc_hd__decap_12
XPHY_EDGE_ROW_9_Left_33 VGND VGND VPWR VPWR sky130_fd_sc_hd__decap_3
XPHY_EDGE_ROW_17_Right_17 VGND VGND VPWR VPWR sky130_fd_sc_hd__decap_3
XTAP_TAPCELL_ROW_14_87 VGND VPWR sky130_fd_sc_hd__tapvpwrvgnd_1
XFILLER_14_65 VPWR VGND VPWR VGND sky130_ef_sc_hd__decap_12
XPHY_EDGE_ROW_22_Left_46 VGND VGND VPWR VPWR sky130_fd_sc_hd__decap_3
X_193_ _005_ _013_ VGND VGND VPWR VPWR net89 sky130_fd_sc_hd__xnor2_1
X_331_ _102_ _107_ _120_ VGND VGND VPWR VPWR _130_ sky130_fd_sc_hd__nor3_1
X_262_ _064_ _072_ _063_ VGND VGND VPWR VPWR _073_ sky130_fd_sc_hd__a21oi_1
X_176_ net58 net26 VGND VGND VPWR VPWR _175_ sky130_fd_sc_hd__nor2_1
Xinput27 a[4] VGND VGND VPWR VPWR net27 sky130_fd_sc_hd__clkbuf_1
Xinput38 b[14] VGND VGND VPWR VPWR net38 sky130_fd_sc_hd__clkbuf_1
X_245_ net39 net7 VGND VGND VPWR VPWR _056_ sky130_fd_sc_hd__nor2_1
Xinput16 a[23] VGND VGND VPWR VPWR net16 sky130_fd_sc_hd__clkbuf_1
X_314_ _108_ _116_ _107_ VGND VGND VPWR VPWR _117_ sky130_fd_sc_hd__a21oi_1
Xinput49 b[24] VGND VGND VPWR VPWR net49 sky130_fd_sc_hd__clkbuf_1
X_228_ _015_ _016_ VGND VGND VPWR VPWR _043_ sky130_fd_sc_hd__nand2_1
XFILLER_17_87 VGND VGND VPWR VPWR sky130_fd_sc_hd__fill_1
XFILLER_17_43 VGND VGND VPWR VPWR sky130_fd_sc_hd__decap_4
XFILLER_3_132 VGND VGND VPWR VPWR sky130_fd_sc_hd__decap_8
XFILLER_0_113 VGND VGND VPWR VPWR sky130_fd_sc_hd__fill_2
XFILLER_5_57 VPWR VGND VPWR VGND sky130_ef_sc_hd__decap_12
XFILLER_14_77 VGND VGND VPWR VPWR sky130_fd_sc_hd__decap_6
XFILLER_18_109 VPWR VGND VPWR VGND sky130_ef_sc_hd__decap_12
X_192_ _001_ _014_ VGND VGND VPWR VPWR net92 sky130_fd_sc_hd__xnor2_1
X_330_ net49 net17 VGND VGND VPWR VPWR _129_ sky130_fd_sc_hd__nand2_1
X_261_ _042_ _051_ _069_ _070_ _067_ VGND VGND VPWR VPWR _072_ sky130_fd_sc_hd__o311ai_4
XFILLER_17_120 VGND VGND VPWR VPWR sky130_fd_sc_hd__decap_8
XFILLER_11_12 VGND VGND VPWR VPWR sky130_fd_sc_hd__fill_2
XTAP_TAPCELL_ROW_11_78 VGND VPWR sky130_fd_sc_hd__tapvpwrvgnd_1
Xinput28 a[5] VGND VGND VPWR VPWR net28 sky130_fd_sc_hd__clkbuf_1
X_244_ _051_ _055_ VGND VGND VPWR VPWR net97 sky130_fd_sc_hd__nor2_1
Xinput39 b[15] VGND VGND VPWR VPWR net39 sky130_fd_sc_hd__clkbuf_1
X_313_ _113_ _115_ _110_ VGND VGND VPWR VPWR _116_ sky130_fd_sc_hd__a21o_1
Xinput17 a[24] VGND VGND VPWR VPWR net17 sky130_fd_sc_hd__clkbuf_1
XTAP_TAPCELL_ROW_7_68 VGND VPWR sky130_fd_sc_hd__tapvpwrvgnd_1
XFILLER_20_115 VGND VGND VPWR VPWR sky130_fd_sc_hd__fill_2
XFILLER_6_141 VGND VGND VPWR VPWR sky130_fd_sc_hd__decap_3
XFILLER_8_46 VPWR VGND VPWR VGND sky130_ef_sc_hd__decap_12
X_227_ net63 net31 VGND VGND VPWR VPWR _042_ sky130_fd_sc_hd__and2_1
XFILLER_17_55 VGND VGND VPWR VPWR sky130_fd_sc_hd__fill_1
XFILLER_3_100 VPWR VGND VPWR VGND sky130_ef_sc_hd__decap_12
XFILLER_12_9 VPWR VGND VPWR VGND sky130_ef_sc_hd__decap_12
XFILLER_0_91 VGND VGND VPWR VPWR sky130_fd_sc_hd__decap_3
XPHY_EDGE_ROW_3_Right_3 VGND VGND VPWR VPWR sky130_fd_sc_hd__decap_3
XFILLER_0_125 VGND VGND VPWR VPWR sky130_fd_sc_hd__fill_1
XFILLER_5_69 VGND VGND VPWR VPWR sky130_fd_sc_hd__decap_8
XFILLER_10_6 VGND VGND VPWR VPWR sky130_fd_sc_hd__decap_4
X_260_ _042_ _051_ _069_ _070_ VGND VGND VPWR VPWR _071_ sky130_fd_sc_hd__o31a_1
X_191_ _004_ _013_ _002_ VGND VGND VPWR VPWR _014_ sky130_fd_sc_hd__o21a_1
XFILLER_23_113 VGND VGND VPWR VPWR sky130_fd_sc_hd__fill_2
XFILLER_11_24 VPWR VGND VPWR VGND sky130_ef_sc_hd__decap_12
XFILLER_11_57 VPWR VGND VPWR VGND sky130_ef_sc_hd__decap_12
XTAP_TAPCELL_ROW_11_79 VGND VPWR sky130_fd_sc_hd__tapvpwrvgnd_1
Xinput29 a[6] VGND VGND VPWR VPWR net29 sky130_fd_sc_hd__buf_1
X_243_ _048_ _050_ VGND VGND VPWR VPWR _055_ sky130_fd_sc_hd__and2_1
Xinput18 a[25] VGND VGND VPWR VPWR net18 sky130_fd_sc_hd__clkbuf_1
X_312_ _083_ _111_ _114_ VGND VGND VPWR VPWR _115_ sky130_fd_sc_hd__o21a_1
XTAP_TAPCELL_ROW_7_69 VGND VPWR sky130_fd_sc_hd__tapvpwrvgnd_1
XFILLER_20_127 VGND VGND VPWR VPWR sky130_fd_sc_hd__decap_6
X_226_ _039_ _040_ VGND VGND VPWR VPWR _041_ sky130_fd_sc_hd__nand2_1
XFILLER_8_58 VPWR VGND VPWR VGND sky130_ef_sc_hd__decap_12
XFILLER_17_34 VGND VGND VPWR VPWR sky130_fd_sc_hd__fill_1
X_209_ _023_ _025_ _026_ _021_ VGND VGND VPWR VPWR _028_ sky130_fd_sc_hd__o31a_2
XFILLER_0_104 VGND VGND VPWR VPWR sky130_fd_sc_hd__decap_4
XPHY_EDGE_ROW_22_Right_22 VGND VGND VPWR VPWR sky130_fd_sc_hd__decap_3
XPHY_EDGE_ROW_13_Right_13 VGND VGND VPWR VPWR sky130_fd_sc_hd__decap_3
XFILLER_14_24 VGND VGND VPWR VPWR sky130_fd_sc_hd__decap_4
X_190_ _010_ _012_ _006_ VGND VGND VPWR VPWR _013_ sky130_fd_sc_hd__a21oi_1
XFILLER_23_125 VGND VGND VPWR VPWR sky130_fd_sc_hd__fill_1
Xinput19 a[26] VGND VGND VPWR VPWR net19 sky130_fd_sc_hd__buf_1
X_242_ _041_ _052_ VGND VGND VPWR VPWR net98 sky130_fd_sc_hd__xnor2_1
XFILLER_2_9 VGND VGND VPWR VPWR sky130_fd_sc_hd__fill_2
X_311_ _078_ _082_ _086_ _112_ _079_ VGND VGND VPWR VPWR _114_ sky130_fd_sc_hd__o221a_1
XFILLER_11_36 VPWR VGND VPWR VGND sky130_ef_sc_hd__decap_12
XFILLER_11_69 VPWR VGND VPWR VGND sky130_ef_sc_hd__decap_12
XFILLER_3_81 VGND VGND VPWR VPWR sky130_fd_sc_hd__fill_2
X_225_ net64 net32 VGND VGND VPWR VPWR _040_ sky130_fd_sc_hd__or2_1
XFILLER_17_57 VGND VGND VPWR VPWR sky130_fd_sc_hd__fill_2
X_208_ _025_ _026_ VGND VGND VPWR VPWR _027_ sky130_fd_sc_hd__nor2_1
XPHY_EDGE_ROW_13_Left_37 VGND VGND VPWR VPWR sky130_fd_sc_hd__decap_3
XFILLER_14_14 VGND VGND VPWR VPWR sky130_fd_sc_hd__decap_3
XPHY_EDGE_ROW_16_Left_40 VGND VGND VPWR VPWR sky130_fd_sc_hd__decap_3
XFILLER_23_104 VGND VGND VPWR VPWR sky130_fd_sc_hd__decap_4
XFILLER_14_126 VGND VGND VPWR VPWR sky130_fd_sc_hd__fill_1
XPHY_EDGE_ROW_1_Left_25 VGND VGND VPWR VPWR sky130_fd_sc_hd__decap_3
X_310_ _072_ _092_ _112_ _088_ _091_ VGND VGND VPWR VPWR _113_ sky130_fd_sc_hd__a2111o_1
XFILLER_11_48 VGND VGND VPWR VPWR sky130_fd_sc_hd__decap_8
XFILLER_20_107 VGND VGND VPWR VPWR sky130_fd_sc_hd__decap_8
X_241_ _038_ _053_ VGND VGND VPWR VPWR net68 sky130_fd_sc_hd__xnor2_1
XFILLER_22_58 VPWR VGND VPWR VGND sky130_ef_sc_hd__decap_12
XFILLER_22_36 VGND VGND VPWR VPWR sky130_fd_sc_hd__decap_3
X_224_ net64 net32 VGND VGND VPWR VPWR _039_ sky130_fd_sc_hd__nand2_1
XTAP_TAPCELL_ROW_12_80 VGND VPWR sky130_fd_sc_hd__tapvpwrvgnd_1
XFILLER_6_122 VGND VGND VPWR VPWR sky130_fd_sc_hd__decap_4
XFILLER_8_27 VGND VGND VPWR VPWR sky130_fd_sc_hd__fill_1
XTAP_TAPCELL_ROW_8_70 VGND VPWR sky130_fd_sc_hd__tapvpwrvgnd_1
XFILLER_17_47 VGND VGND VPWR VPWR sky130_fd_sc_hd__fill_1
XFILLER_17_14 VPWR VGND VPWR VGND sky130_ef_sc_hd__decap_12
X_207_ _000_ _004_ _175_ VGND VGND VPWR VPWR _026_ sky130_fd_sc_hd__a21o_1
XFILLER_0_72 VGND VGND VPWR VPWR sky130_fd_sc_hd__fill_1
XFILLER_9_81 VPWR VGND VPWR VGND sky130_ef_sc_hd__decap_12
XPHY_EDGE_ROW_7_Right_7 VGND VGND VPWR VPWR sky130_fd_sc_hd__decap_3
XFILLER_6_60 VPWR VGND VPWR VGND sky130_ef_sc_hd__decap_12
XFILLER_6_93 VGND VGND VPWR VPWR sky130_fd_sc_hd__fill_2
Xoutput90 net90 VGND VGND VPWR VPWR sum[30] sky130_fd_sc_hd__buf_2
XFILLER_17_113 VGND VGND VPWR VPWR sky130_fd_sc_hd__decap_4
XFILLER_17_102 VGND VGND VPWR VPWR sky130_fd_sc_hd__decap_3
XFILLER_2_29 VGND VGND VPWR VPWR sky130_fd_sc_hd__fill_2
XFILLER_14_105 VGND VGND VPWR VPWR sky130_fd_sc_hd__decap_3
X_240_ _035_ _054_ VGND VGND VPWR VPWR net69 sky130_fd_sc_hd__xnor2_1
X_369_ _159_ _161_ _163_ _157_ _155_ VGND VGND VPWR VPWR _164_ sky130_fd_sc_hd__a311oi_1
XFILLER_22_15 VGND VGND VPWR VPWR sky130_fd_sc_hd__fill_2
XTAP_TAPCELL_ROW_21_103 VGND VPWR sky130_fd_sc_hd__tapvpwrvgnd_1
X_223_ _036_ _037_ VGND VGND VPWR VPWR _038_ sky130_fd_sc_hd__nand2_1
XTAP_TAPCELL_ROW_12_81 VGND VPWR sky130_fd_sc_hd__tapvpwrvgnd_1
XFILLER_6_101 VPWR VGND VPWR VGND sky130_ef_sc_hd__decap_12
XTAP_TAPCELL_ROW_8_71 VGND VPWR sky130_fd_sc_hd__tapvpwrvgnd_1
XFILLER_17_26 VGND VGND VPWR VPWR sky130_fd_sc_hd__decap_8
XFILLER_23_91 VGND VGND VPWR VPWR sky130_fd_sc_hd__decap_3
X_206_ _010_ _012_ _024_ _006_ VGND VGND VPWR VPWR _025_ sky130_fd_sc_hd__a211oi_1
XFILLER_0_118 VGND VGND VPWR VPWR sky130_fd_sc_hd__fill_1
XFILLER_9_93 VGND VGND VPWR VPWR sky130_fd_sc_hd__decap_8
XFILLER_5_29 VGND VGND VPWR VPWR sky130_fd_sc_hd__fill_1
XFILLER_20_92 VGND VGND VPWR VPWR sky130_fd_sc_hd__decap_4
XFILLER_6_72 VPWR VGND VPWR VGND sky130_ef_sc_hd__decap_12
XFILLER_15_70 VPWR VGND VPWR VGND sky130_ef_sc_hd__decap_12
Xoutput91 net91 VGND VGND VPWR VPWR sum[31] sky130_fd_sc_hd__buf_2
Xoutput80 net80 VGND VGND VPWR VPWR sum[21] sky130_fd_sc_hd__buf_2
XFILLER_14_139 VGND VGND VPWR VPWR sky130_fd_sc_hd__fill_1
X_368_ net52 net20 _162_ VGND VGND VPWR VPWR _163_ sky130_fd_sc_hd__o21ai_1
XFILLER_3_73 VGND VGND VPWR VPWR sky130_fd_sc_hd__fill_2
X_299_ _100_ _101_ VGND VGND VPWR VPWR _102_ sky130_fd_sc_hd__nand2_1
XFILLER_22_49 VGND VGND VPWR VPWR sky130_fd_sc_hd__fill_1
XFILLER_22_27 VGND VGND VPWR VPWR sky130_fd_sc_hd__fill_1
XTAP_TAPCELL_ROW_21_104 VGND VPWR sky130_fd_sc_hd__tapvpwrvgnd_1
XTAP_TAPCELL_ROW_12_82 VGND VPWR sky130_fd_sc_hd__tapvpwrvgnd_1
XFILLER_8_29 VGND VGND VPWR VPWR sky130_fd_sc_hd__fill_2
XTAP_TAPCELL_ROW_8_72 VGND VPWR sky130_fd_sc_hd__tapvpwrvgnd_1
XFILLER_10_131 VGND VGND VPWR VPWR sky130_fd_sc_hd__decap_4
X_222_ net34 net2 VGND VGND VPWR VPWR _037_ sky130_fd_sc_hd__or2_1
XFILLER_23_70 VGND VGND VPWR VPWR sky130_fd_sc_hd__decap_3
X_205_ _175_ _002_ _000_ VGND VGND VPWR VPWR _024_ sky130_fd_sc_hd__o21ai_1
XFILLER_0_85 VGND VGND VPWR VPWR sky130_fd_sc_hd__fill_2
XFILLER_0_63 VGND VGND VPWR VPWR sky130_fd_sc_hd__decap_3
XFILLER_0_41 VGND VGND VPWR VPWR sky130_fd_sc_hd__decap_4
XFILLER_9_50 VGND VGND VPWR VPWR sky130_fd_sc_hd__decap_6
XFILLER_20_82 VGND VGND VPWR VPWR sky130_fd_sc_hd__fill_2
XFILLER_6_40 VGND VGND VPWR VPWR sky130_fd_sc_hd__fill_1
X_384_ _168_ _174_ _173_ VGND VGND VPWR VPWR net66 sky130_fd_sc_hd__o21ai_1
XFILLER_15_82 VPWR VGND VPWR VGND sky130_ef_sc_hd__decap_12
XFILLER_9_6 VPWR VGND VPWR VGND sky130_ef_sc_hd__decap_12
Xoutput92 net92 VGND VGND VPWR VPWR sum[3] sky130_fd_sc_hd__buf_2
Xoutput81 net81 VGND VGND VPWR VPWR sum[22] sky130_fd_sc_hd__buf_2
Xoutput70 net70 VGND VGND VPWR VPWR sum[12] sky130_fd_sc_hd__buf_2
XFILLER_7_3 VGND VGND VPWR VPWR sky130_fd_sc_hd__fill_1
X_367_ net52 net20 net51 net19 VGND VGND VPWR VPWR _162_ sky130_fd_sc_hd__a22o_1
XFILLER_3_63 VGND VGND VPWR VPWR sky130_fd_sc_hd__fill_1
X_298_ net48 net16 VGND VGND VPWR VPWR _101_ sky130_fd_sc_hd__nand2_1
XPHY_EDGE_ROW_5_Left_29 VGND VGND VPWR VPWR sky130_fd_sc_hd__decap_3
XFILLER_12_83 VGND VGND VPWR VPWR sky130_fd_sc_hd__fill_1
X_221_ net34 net2 VGND VGND VPWR VPWR _036_ sky130_fd_sc_hd__nand2_1
X_204_ _021_ _022_ VGND VGND VPWR VPWR _023_ sky130_fd_sc_hd__nand2_1
XFILLER_18_82 VGND VGND VPWR VPWR sky130_fd_sc_hd__fill_2
XTAP_TAPCELL_ROW_5_63 VGND VPWR sky130_fd_sc_hd__tapvpwrvgnd_1
XPHY_EDGE_ROW_8_Left_32 VGND VGND VPWR VPWR sky130_fd_sc_hd__decap_3
XFILLER_14_29 VPWR VGND VPWR VGND sky130_ef_sc_hd__decap_12
XFILLER_20_50 VPWR VGND VPWR VGND sky130_ef_sc_hd__decap_12
XFILLER_6_85 VGND VGND VPWR VPWR sky130_fd_sc_hd__decap_8
X_383_ _146_ _151_ VGND VGND VPWR VPWR _174_ sky130_fd_sc_hd__nand2_1
XFILLER_17_138 VGND VGND VPWR VPWR sky130_fd_sc_hd__fill_2
Xoutput93 net93 VGND VGND VPWR VPWR sum[4] sky130_fd_sc_hd__buf_2
XFILLER_15_94 VGND VGND VPWR VPWR sky130_fd_sc_hd__fill_1
Xoutput82 net82 VGND VGND VPWR VPWR sum[23] sky130_fd_sc_hd__buf_2
Xoutput71 net71 VGND VGND VPWR VPWR sum[13] sky130_fd_sc_hd__buf_2
XPHY_EDGE_ROW_21_Left_45 VGND VGND VPWR VPWR sky130_fd_sc_hd__decap_3
XFILLER_13_141 VGND VGND VPWR VPWR sky130_fd_sc_hd__decap_3
X_297_ net48 net16 VGND VGND VPWR VPWR _100_ sky130_fd_sc_hd__or2_1
X_366_ _126_ _160_ _142_ _123_ VGND VGND VPWR VPWR _161_ sky130_fd_sc_hd__a211o_1
X_220_ _033_ _034_ VGND VGND VPWR VPWR _035_ sky130_fd_sc_hd__nand2b_1
X_349_ _132_ _136_ _138_ VGND VGND VPWR VPWR _145_ sky130_fd_sc_hd__nand3_1
XFILLER_23_83 VGND VGND VPWR VPWR sky130_fd_sc_hd__fill_1
X_203_ net59 net27 VGND VGND VPWR VPWR _022_ sky130_fd_sc_hd__or2_1
XFILLER_0_98 VGND VGND VPWR VPWR sky130_fd_sc_hd__decap_3
XFILLER_0_76 VGND VGND VPWR VPWR sky130_fd_sc_hd__decap_4
XFILLER_9_30 VGND VGND VPWR VPWR sky130_fd_sc_hd__fill_2
XTAP_TAPCELL_ROW_5_64 VGND VPWR sky130_fd_sc_hd__tapvpwrvgnd_1
XFILLER_20_62 VGND VGND VPWR VPWR sky130_fd_sc_hd__decap_3
Xoutput94 net94 VGND VGND VPWR VPWR sum[5] sky130_fd_sc_hd__buf_2
X_382_ net57 net25 _172_ VGND VGND VPWR VPWR _173_ sky130_fd_sc_hd__a21oi_1
XFILLER_17_128 VGND VGND VPWR VPWR sky130_fd_sc_hd__decap_3
Xoutput72 net72 VGND VGND VPWR VPWR sum[14] sky130_fd_sc_hd__buf_2
Xoutput83 net83 VGND VGND VPWR VPWR sum[24] sky130_fd_sc_hd__buf_2
X_296_ _088_ _093_ VGND VGND VPWR VPWR net74 sky130_fd_sc_hd__xor2_1
XFILLER_9_113 VGND VGND VPWR VPWR sky130_fd_sc_hd__fill_1
X_365_ _129_ _127_ VGND VGND VPWR VPWR _160_ sky130_fd_sc_hd__nand2b_1
XFILLER_12_85 VPWR VGND VPWR VGND sky130_ef_sc_hd__decap_12
XFILLER_12_41 VPWR VGND VPWR VGND sky130_ef_sc_hd__decap_12
XFILLER_10_101 VGND VGND VPWR VPWR sky130_fd_sc_hd__fill_1
XFILLER_10_123 VGND VGND VPWR VPWR sky130_fd_sc_hd__decap_3
XPHY_EDGE_ROW_16_Right_16 VGND VGND VPWR VPWR sky130_fd_sc_hd__decap_3
X_279_ net40 net8 VGND VGND VPWR VPWR _086_ sky130_fd_sc_hd__nand2_1
X_348_ _140_ _144_ VGND VGND VPWR VPWR net84 sky130_fd_sc_hd__and2_1
X_202_ net59 net27 VGND VGND VPWR VPWR _021_ sky130_fd_sc_hd__nand2_1
XFILLER_0_55 VGND VGND VPWR VPWR sky130_fd_sc_hd__fill_1
XTAP_TAPCELL_ROW_18_95 VGND VPWR sky130_fd_sc_hd__tapvpwrvgnd_1
XPHY_EDGE_ROW_2_Right_2 VGND VGND VPWR VPWR sky130_fd_sc_hd__decap_3
XFILLER_20_96 VGND VGND VPWR VPWR sky130_fd_sc_hd__fill_1
Xoutput95 net95 VGND VGND VPWR VPWR sum[6] sky130_fd_sc_hd__buf_2
X_381_ net57 net25 net56 net24 VGND VGND VPWR VPWR _172_ sky130_fd_sc_hd__o211a_1
Xoutput73 net73 VGND VGND VPWR VPWR sum[15] sky130_fd_sc_hd__buf_2
Xoutput84 net84 VGND VGND VPWR VPWR sum[25] sky130_fd_sc_hd__buf_2
XTAP_TAPCELL_ROW_2_55 VGND VPWR sky130_fd_sc_hd__tapvpwrvgnd_1
X_295_ _095_ _099_ VGND VGND VPWR VPWR net75 sky130_fd_sc_hd__nor2_1
XFILLER_3_88 VGND VGND VPWR VPWR sky130_fd_sc_hd__decap_3
X_364_ _132_ _136_ _158_ VGND VGND VPWR VPWR _159_ sky130_fd_sc_hd__a21o_1
XFILLER_12_97 VPWR VGND VPWR VGND sky130_ef_sc_hd__decap_12
XFILLER_12_53 VPWR VGND VPWR VGND sky130_ef_sc_hd__decap_12
X_278_ _083_ _084_ VGND VGND VPWR VPWR _085_ sky130_fd_sc_hd__nand2_1
X_347_ _128_ _129_ _139_ VGND VGND VPWR VPWR _144_ sky130_fd_sc_hd__nand3_1
XFILLER_23_85 VGND VGND VPWR VPWR sky130_fd_sc_hd__fill_2
XFILLER_23_63 VGND VGND VPWR VPWR sky130_fd_sc_hd__decap_3
X_201_ _017_ _019_ VGND VGND VPWR VPWR _020_ sky130_fd_sc_hd__nor2_1
XFILLER_2_131 VGND VGND VPWR VPWR sky130_fd_sc_hd__fill_2
XTAP_TAPCELL_ROW_18_96 VGND VPWR sky130_fd_sc_hd__tapvpwrvgnd_1
XFILLER_18_85 VPWR VGND VPWR VGND sky130_ef_sc_hd__decap_12
XFILLER_18_63 VPWR VGND VPWR VGND sky130_ef_sc_hd__decap_12
X_380_ _164_ _171_ VGND VGND VPWR VPWR net87 sky130_fd_sc_hd__nor2_1
XTAP_TAPCELL_ROW_2_56 VGND VPWR sky130_fd_sc_hd__tapvpwrvgnd_1
Xoutput85 net85 VGND VGND VPWR VPWR sum[26] sky130_fd_sc_hd__buf_2
Xoutput74 net74 VGND VGND VPWR VPWR sum[16] sky130_fd_sc_hd__buf_2
Xoutput96 net96 VGND VGND VPWR VPWR sum[7] sky130_fd_sc_hd__buf_2
.ends
