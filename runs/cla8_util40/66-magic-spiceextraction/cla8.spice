* NGSPICE file created from cla8.ext - technology: sky130A

* Black-box entry subcircuit for sky130_fd_sc_hd__xnor2_1 abstract view
.subckt sky130_fd_sc_hd__xnor2_1 A B VGND VNB VPB VPWR Y
.ends

* Black-box entry subcircuit for sky130_fd_sc_hd__tapvpwrvgnd_1 abstract view
.subckt sky130_fd_sc_hd__tapvpwrvgnd_1 VGND VPWR
.ends

* Black-box entry subcircuit for sky130_fd_sc_hd__decap_3 abstract view
.subckt sky130_fd_sc_hd__decap_3 VGND VNB VPB VPWR
.ends

* Black-box entry subcircuit for sky130_fd_sc_hd__fill_2 abstract view
.subckt sky130_fd_sc_hd__fill_2 VGND VNB VPB VPWR
.ends

* Black-box entry subcircuit for sky130_fd_sc_hd__nand2b_1 abstract view
.subckt sky130_fd_sc_hd__nand2b_1 A_N B VGND VNB VPB VPWR Y
.ends

* Black-box entry subcircuit for sky130_fd_sc_hd__decap_8 abstract view
.subckt sky130_fd_sc_hd__decap_8 VGND VNB VPB VPWR
.ends

* Black-box entry subcircuit for sky130_fd_sc_hd__nand2_1 abstract view
.subckt sky130_fd_sc_hd__nand2_1 A B VGND VNB VPB VPWR Y
.ends

* Black-box entry subcircuit for sky130_fd_sc_hd__buf_2 abstract view
.subckt sky130_fd_sc_hd__buf_2 A VGND VNB VPB VPWR X
.ends

* Black-box entry subcircuit for sky130_fd_sc_hd__or2_1 abstract view
.subckt sky130_fd_sc_hd__or2_1 A B VGND VNB VPB VPWR X
.ends

* Black-box entry subcircuit for sky130_fd_sc_hd__a21bo_1 abstract view
.subckt sky130_fd_sc_hd__a21bo_1 A1 A2 B1_N VGND VNB VPB VPWR X
.ends

* Black-box entry subcircuit for sky130_ef_sc_hd__decap_12 abstract view
.subckt sky130_ef_sc_hd__decap_12 VPWR VGND VPB VNB
.ends

* Black-box entry subcircuit for sky130_fd_sc_hd__fill_1 abstract view
.subckt sky130_fd_sc_hd__fill_1 VGND VNB VPB VPWR
.ends

* Black-box entry subcircuit for sky130_fd_sc_hd__and2_1 abstract view
.subckt sky130_fd_sc_hd__and2_1 A B VGND VNB VPB VPWR X
.ends

* Black-box entry subcircuit for sky130_fd_sc_hd__nor2_1 abstract view
.subckt sky130_fd_sc_hd__nor2_1 A B VGND VNB VPB VPWR Y
.ends

* Black-box entry subcircuit for sky130_fd_sc_hd__decap_6 abstract view
.subckt sky130_fd_sc_hd__decap_6 VGND VNB VPB VPWR
.ends

* Black-box entry subcircuit for sky130_fd_sc_hd__clkbuf_1 abstract view
.subckt sky130_fd_sc_hd__clkbuf_1 A VGND VNB VPB VPWR X
.ends

* Black-box entry subcircuit for sky130_fd_sc_hd__buf_1 abstract view
.subckt sky130_fd_sc_hd__buf_1 A VGND VNB VPB VPWR X
.ends

* Black-box entry subcircuit for sky130_fd_sc_hd__o211a_1 abstract view
.subckt sky130_fd_sc_hd__o211a_1 A1 A2 B1 C1 VGND VNB VPB VPWR X
.ends

* Black-box entry subcircuit for sky130_fd_sc_hd__decap_4 abstract view
.subckt sky130_fd_sc_hd__decap_4 VGND VNB VPB VPWR
.ends

* Black-box entry subcircuit for sky130_fd_sc_hd__o31ai_2 abstract view
.subckt sky130_fd_sc_hd__o31ai_2 A1 A2 A3 B1 VGND VNB VPB VPWR Y
.ends

* Black-box entry subcircuit for sky130_fd_sc_hd__xor2_1 abstract view
.subckt sky130_fd_sc_hd__xor2_1 A B VGND VNB VPB VPWR X
.ends

* Black-box entry subcircuit for sky130_fd_sc_hd__o21ba_1 abstract view
.subckt sky130_fd_sc_hd__o21ba_1 A1 A2 B1_N VGND VNB VPB VPWR X
.ends

* Black-box entry subcircuit for sky130_fd_sc_hd__a21oi_1 abstract view
.subckt sky130_fd_sc_hd__a21oi_1 A1 A2 B1 VGND VNB VPB VPWR Y
.ends

* Black-box entry subcircuit for sky130_fd_sc_hd__a211o_1 abstract view
.subckt sky130_fd_sc_hd__a211o_1 A1 A2 B1 C1 VGND VNB VPB VPWR X
.ends

* Black-box entry subcircuit for sky130_fd_sc_hd__o221a_1 abstract view
.subckt sky130_fd_sc_hd__o221a_1 A1 A2 B1 B2 C1 VGND VNB VPB VPWR X
.ends

.subckt cla8 VGND VPWR a[0] a[1] a[2] a[3] a[4] a[5] a[6] a[7] b[0] b[1] b[2] b[3]
+ b[4] b[5] b[6] b[7] cin cout sum[0] sum[1] sum[2] sum[3] sum[4] sum[5] sum[6] sum[7]
X_83_ _31_ _36_ VGND VGND VPWR VPWR net24 sky130_fd_sc_hd__xnor2_1
XTAP_TAPCELL_ROW_8_33 VGND VPWR sky130_fd_sc_hd__tapvpwrvgnd_1
XPHY_EDGE_ROW_0_Left_12 VGND VGND VPWR VPWR sky130_fd_sc_hd__decap_3
XFILLER_9_66 VGND VGND VPWR VPWR sky130_fd_sc_hd__fill_2
X_66_ _22_ _21_ VGND VGND VPWR VPWR _23_ sky130_fd_sc_hd__nand2b_1
XFILLER_0_35 VGND VGND VPWR VPWR sky130_fd_sc_hd__decap_3
XFILLER_0_57 VGND VGND VPWR VPWR sky130_fd_sc_hd__decap_8
X_49_ _08_ _09_ VGND VGND VPWR VPWR _10_ sky130_fd_sc_hd__nand2_1
Xoutput20 net20 VGND VGND VPWR VPWR sum[1] sky130_fd_sc_hd__buf_2
XFILLER_3_46 VGND VGND VPWR VPWR sky130_fd_sc_hd__decap_3
X_82_ _35_ _37_ VGND VGND VPWR VPWR net25 sky130_fd_sc_hd__xnor2_1
X_65_ net14 net6 VGND VGND VPWR VPWR _22_ sky130_fd_sc_hd__or2_1
X_48_ net9 net1 VGND VGND VPWR VPWR _09_ sky130_fd_sc_hd__or2_1
XPHY_EDGE_ROW_6_Right_6 VGND VGND VPWR VPWR sky130_fd_sc_hd__decap_3
Xoutput21 net21 VGND VGND VPWR VPWR sum[2] sky130_fd_sc_hd__buf_2
X_81_ _22_ _31_ _32_ VGND VGND VPWR VPWR _37_ sky130_fd_sc_hd__a21bo_1
XFILLER_5_6 VPWR VGND VPWR VGND sky130_ef_sc_hd__decap_12
XFILLER_9_24 VGND VGND VPWR VPWR sky130_fd_sc_hd__fill_1
X_64_ net15 net7 VGND VGND VPWR VPWR _21_ sky130_fd_sc_hd__nand2_1
XFILLER_0_15 VGND VGND VPWR VPWR sky130_fd_sc_hd__decap_8
XFILLER_0_48 VGND VGND VPWR VPWR sky130_fd_sc_hd__decap_8
X_47_ net9 net1 VGND VGND VPWR VPWR _08_ sky130_fd_sc_hd__nand2_1
XFILLER_3_3 VGND VGND VPWR VPWR sky130_fd_sc_hd__fill_2
Xoutput22 net22 VGND VGND VPWR VPWR sum[3] sky130_fd_sc_hd__buf_2
X_80_ _22_ _32_ VGND VGND VPWR VPWR _36_ sky130_fd_sc_hd__nand2_1
X_63_ net15 net7 VGND VGND VPWR VPWR _20_ sky130_fd_sc_hd__or2_1
XFILLER_3_15 VGND VGND VPWR VPWR sky130_fd_sc_hd__fill_1
X_46_ net10 net2 VGND VGND VPWR VPWR _07_ sky130_fd_sc_hd__and2_1
XPHY_EDGE_ROW_4_Left_16 VGND VGND VPWR VPWR sky130_fd_sc_hd__decap_3
Xoutput23 net23 VGND VGND VPWR VPWR sum[4] sky130_fd_sc_hd__buf_2
XFILLER_6_26 VGND VGND VPWR VPWR sky130_fd_sc_hd__fill_2
XTAP_TAPCELL_ROW_2_27 VGND VPWR sky130_fd_sc_hd__tapvpwrvgnd_1
XFILLER_11_3 VPWR VGND VPWR VGND sky130_ef_sc_hd__decap_12
XFILLER_3_38 VGND VGND VPWR VPWR sky130_fd_sc_hd__decap_8
X_62_ _17_ _18_ VGND VGND VPWR VPWR _19_ sky130_fd_sc_hd__nand2_1
X_45_ _04_ _05_ VGND VGND VPWR VPWR _06_ sky130_fd_sc_hd__nor2_1
Xoutput24 net24 VGND VGND VPWR VPWR sum[5] sky130_fd_sc_hd__buf_2
X_61_ net16 net8 VGND VGND VPWR VPWR _18_ sky130_fd_sc_hd__or2_1
XFILLER_1_3 VPWR VGND VPWR VGND sky130_ef_sc_hd__decap_12
XFILLER_0_29 VGND VGND VPWR VPWR sky130_fd_sc_hd__fill_2
X_44_ net11 net3 VGND VGND VPWR VPWR _05_ sky130_fd_sc_hd__nor2_1
Xoutput25 net25 VGND VGND VPWR VPWR sum[6] sky130_fd_sc_hd__buf_2
XFILLER_7_60 VGND VGND VPWR VPWR sky130_fd_sc_hd__fill_2
X_60_ net16 net8 VGND VGND VPWR VPWR _17_ sky130_fd_sc_hd__nand2_1
X_43_ net11 net3 VGND VGND VPWR VPWR _04_ sky130_fd_sc_hd__and2_1
Xoutput26 net26 VGND VGND VPWR VPWR sum[7] sky130_fd_sc_hd__buf_2
XFILLER_7_50 VGND VGND VPWR VPWR sky130_fd_sc_hd__decap_6
XFILLER_6_29 VPWR VGND VPWR VGND sky130_ef_sc_hd__decap_12
XFILLER_6_18 VGND VGND VPWR VPWR sky130_fd_sc_hd__decap_8
XPHY_EDGE_ROW_1_Right_1 VGND VGND VPWR VPWR sky130_fd_sc_hd__decap_3
XFILLER_9_18 VGND VGND VPWR VPWR sky130_fd_sc_hd__decap_6
X_42_ _00_ _02_ VGND VGND VPWR VPWR _03_ sky130_fd_sc_hd__nor2_1
XPHY_EDGE_ROW_11_Left_23 VGND VGND VPWR VPWR sky130_fd_sc_hd__decap_3
XFILLER_4_41 VPWR VGND VPWR VGND sky130_ef_sc_hd__decap_12
XFILLER_1_53 VGND VGND VPWR VPWR sky130_fd_sc_hd__decap_3
X_41_ net12 net4 VGND VGND VPWR VPWR _02_ sky130_fd_sc_hd__and2_1
XFILLER_10_62 VGND VGND VPWR VPWR sky130_fd_sc_hd__fill_2
X_40_ net12 net4 VGND VGND VPWR VPWR _01_ sky130_fd_sc_hd__or2_1
XFILLER_4_53 VGND VGND VPWR VPWR sky130_fd_sc_hd__fill_2
XFILLER_4_64 VGND VGND VPWR VPWR sky130_fd_sc_hd__fill_1
XFILLER_10_41 VGND VGND VPWR VPWR sky130_fd_sc_hd__fill_1
XTAP_TAPCELL_ROW_6_31 VGND VPWR sky130_fd_sc_hd__tapvpwrvgnd_1
XFILLER_1_21 VPWR VGND VPWR VGND sky130_ef_sc_hd__decap_12
Xoutput18 net18 VGND VGND VPWR VPWR cout sky130_fd_sc_hd__buf_2
XPHY_EDGE_ROW_5_Right_5 VGND VGND VPWR VPWR sky130_fd_sc_hd__decap_3
XFILLER_1_33 VPWR VGND VPWR VGND sky130_ef_sc_hd__decap_12
Xoutput19 net19 VGND VGND VPWR VPWR sum[0] sky130_fd_sc_hd__buf_2
XPHY_EDGE_ROW_11_Right_11 VGND VGND VPWR VPWR sky130_fd_sc_hd__decap_3
XFILLER_4_33 VGND VGND VPWR VPWR sky130_fd_sc_hd__fill_1
XFILLER_1_45 VGND VGND VPWR VPWR sky130_fd_sc_hd__decap_8
XPHY_EDGE_ROW_3_Left_15 VGND VGND VPWR VPWR sky130_fd_sc_hd__decap_3
XFILLER_8_3 VGND VGND VPWR VPWR sky130_fd_sc_hd__decap_3
XTAP_TAPCELL_ROW_0_24 VGND VPWR sky130_fd_sc_hd__tapvpwrvgnd_1
XFILLER_10_33 VGND VGND VPWR VPWR sky130_fd_sc_hd__fill_1
XFILLER_1_57 VGND VGND VPWR VPWR sky130_fd_sc_hd__decap_8
Xinput1 a[0] VGND VGND VPWR VPWR net1 sky130_fd_sc_hd__clkbuf_1
XPHY_EDGE_ROW_9_Right_9 VGND VGND VPWR VPWR sky130_fd_sc_hd__decap_3
XFILLER_7_12 VGND VGND VPWR VPWR sky130_fd_sc_hd__fill_1
XTAP_TAPCELL_ROW_9_34 VGND VPWR sky130_fd_sc_hd__tapvpwrvgnd_1
XTAP_TAPCELL_ROW_0_25 VGND VPWR sky130_fd_sc_hd__tapvpwrvgnd_1
X_79_ _20_ _21_ VGND VGND VPWR VPWR _35_ sky130_fd_sc_hd__nand2_1
XFILLER_10_45 VGND VGND VPWR VPWR sky130_fd_sc_hd__fill_1
Xinput2 a[1] VGND VGND VPWR VPWR net2 sky130_fd_sc_hd__clkbuf_1
XFILLER_4_58 VGND VGND VPWR VPWR sky130_fd_sc_hd__decap_6
X_78_ _19_ _34_ VGND VGND VPWR VPWR net26 sky130_fd_sc_hd__xnor2_1
XTAP_TAPCELL_ROW_10_35 VGND VPWR sky130_fd_sc_hd__tapvpwrvgnd_1
Xinput3 a[2] VGND VGND VPWR VPWR net3 sky130_fd_sc_hd__buf_1
XPHY_EDGE_ROW_7_Left_19 VGND VGND VPWR VPWR sky130_fd_sc_hd__decap_3
XFILLER_1_15 VGND VGND VPWR VPWR sky130_fd_sc_hd__decap_3
XPHY_EDGE_ROW_0_Right_0 VGND VGND VPWR VPWR sky130_fd_sc_hd__decap_3
X_77_ _31_ _33_ _20_ _23_ VGND VGND VPWR VPWR _34_ sky130_fd_sc_hd__o211a_1
Xinput4 a[3] VGND VGND VPWR VPWR net4 sky130_fd_sc_hd__clkbuf_1
XFILLER_7_26 VPWR VGND VPWR VGND sky130_ef_sc_hd__decap_12
XPHY_EDGE_ROW_10_Left_22 VGND VGND VPWR VPWR sky130_fd_sc_hd__decap_3
X_76_ _21_ _32_ VGND VGND VPWR VPWR _33_ sky130_fd_sc_hd__nand2_1
XFILLER_10_37 VGND VGND VPWR VPWR sky130_fd_sc_hd__decap_4
Xinput5 a[4] VGND VGND VPWR VPWR net5 sky130_fd_sc_hd__clkbuf_1
X_59_ net16 net8 VGND VGND VPWR VPWR _16_ sky130_fd_sc_hd__and2_1
XFILLER_7_38 VPWR VGND VPWR VGND sky130_ef_sc_hd__decap_12
XTAP_TAPCELL_ROW_3_28 VGND VPWR sky130_fd_sc_hd__tapvpwrvgnd_1
Xinput6 a[5] VGND VGND VPWR VPWR net6 sky130_fd_sc_hd__clkbuf_1
XFILLER_10_27 VGND VGND VPWR VPWR sky130_fd_sc_hd__fill_1
X_75_ net14 net6 VGND VGND VPWR VPWR _32_ sky130_fd_sc_hd__nand2_1
X_58_ net17 _10_ VGND VGND VPWR VPWR net19 sky130_fd_sc_hd__xnor2_1
XPHY_EDGE_ROW_4_Right_4 VGND VGND VPWR VPWR sky130_fd_sc_hd__decap_3
XFILLER_4_29 VGND VGND VPWR VPWR sky130_fd_sc_hd__decap_4
Xinput7 a[6] VGND VGND VPWR VPWR net7 sky130_fd_sc_hd__clkbuf_1
X_74_ _26_ _28_ _29_ _24_ VGND VGND VPWR VPWR _31_ sky130_fd_sc_hd__o31ai_2
XFILLER_6_6 VPWR VGND VPWR VGND sky130_ef_sc_hd__decap_12
Xinput10 b[1] VGND VGND VPWR VPWR net10 sky130_fd_sc_hd__clkbuf_1
XFILLER_2_40 VPWR VGND VPWR VGND sky130_ef_sc_hd__decap_12
X_57_ _11_ _13_ VGND VGND VPWR VPWR net20 sky130_fd_sc_hd__xor2_1
XFILLER_10_29 VGND VGND VPWR VPWR sky130_fd_sc_hd__decap_4
Xinput8 a[7] VGND VGND VPWR VPWR net8 sky130_fd_sc_hd__clkbuf_1
X_73_ _28_ _29_ VGND VGND VPWR VPWR _30_ sky130_fd_sc_hd__nor2_1
XPHY_EDGE_ROW_2_Left_14 VGND VGND VPWR VPWR sky130_fd_sc_hd__decap_3
X_56_ _06_ _14_ VGND VGND VPWR VPWR net21 sky130_fd_sc_hd__xnor2_1
XFILLER_2_52 VGND VGND VPWR VPWR sky130_fd_sc_hd__decap_4
X_39_ net12 net4 VGND VGND VPWR VPWR _00_ sky130_fd_sc_hd__nor2_1
Xinput11 b[2] VGND VGND VPWR VPWR net11 sky130_fd_sc_hd__buf_1
XFILLER_10_19 VGND VGND VPWR VPWR sky130_fd_sc_hd__decap_8
Xinput9 b[0] VGND VGND VPWR VPWR net9 sky130_fd_sc_hd__clkbuf_1
X_72_ net11 net3 _02_ _01_ VGND VGND VPWR VPWR _29_ sky130_fd_sc_hd__o31ai_2
XFILLER_5_30 VPWR VGND VPWR VGND sky130_ef_sc_hd__decap_12
XFILLER_5_63 VGND VGND VPWR VPWR sky130_fd_sc_hd__fill_1
XPHY_EDGE_ROW_10_Right_10 VGND VGND VPWR VPWR sky130_fd_sc_hd__decap_3
X_55_ _03_ _15_ VGND VGND VPWR VPWR net22 sky130_fd_sc_hd__xnor2_1
XFILLER_2_64 VGND VGND VPWR VPWR sky130_fd_sc_hd__fill_1
Xinput12 b[3] VGND VGND VPWR VPWR net12 sky130_fd_sc_hd__clkbuf_1
XPHY_EDGE_ROW_8_Right_8 VGND VGND VPWR VPWR sky130_fd_sc_hd__decap_3
XFILLER_5_42 VPWR VGND VPWR VGND sky130_ef_sc_hd__decap_12
X_54_ _05_ _14_ _04_ VGND VGND VPWR VPWR _15_ sky130_fd_sc_hd__o21ba_1
X_71_ _11_ _13_ _27_ VGND VGND VPWR VPWR _28_ sky130_fd_sc_hd__a21oi_1
Xinput13 b[4] VGND VGND VPWR VPWR net13 sky130_fd_sc_hd__clkbuf_1
X_70_ _01_ _04_ _07_ _02_ VGND VGND VPWR VPWR _27_ sky130_fd_sc_hd__a211o_1
XFILLER_5_54 VGND VGND VPWR VPWR sky130_fd_sc_hd__fill_2
XFILLER_11_42 VGND VGND VPWR VPWR sky130_fd_sc_hd__decap_3
Xinput14 b[5] VGND VGND VPWR VPWR net14 sky130_fd_sc_hd__clkbuf_1
XTAP_TAPCELL_ROW_7_32 VGND VPWR sky130_fd_sc_hd__tapvpwrvgnd_1
X_53_ _11_ _13_ _07_ VGND VGND VPWR VPWR _14_ sky130_fd_sc_hd__a21oi_1
XPHY_EDGE_ROW_6_Left_18 VGND VGND VPWR VPWR sky130_fd_sc_hd__decap_3
XPHY_EDGE_ROW_9_Left_21 VGND VGND VPWR VPWR sky130_fd_sc_hd__decap_3
X_52_ _07_ _12_ VGND VGND VPWR VPWR _13_ sky130_fd_sc_hd__nor2_1
Xinput15 b[6] VGND VGND VPWR VPWR net15 sky130_fd_sc_hd__clkbuf_1
XFILLER_8_66 VGND VGND VPWR VPWR sky130_fd_sc_hd__fill_2
XFILLER_11_55 VGND VGND VPWR VPWR sky130_fd_sc_hd__fill_1
X_51_ net10 net2 VGND VGND VPWR VPWR _12_ sky130_fd_sc_hd__nor2_1
XFILLER_8_45 VGND VGND VPWR VPWR sky130_fd_sc_hd__fill_1
Xinput16 b[7] VGND VGND VPWR VPWR net16 sky130_fd_sc_hd__clkbuf_1
XFILLER_0_3 VPWR VGND VPWR VGND sky130_ef_sc_hd__decap_12
XFILLER_5_57 VGND VGND VPWR VPWR sky130_fd_sc_hd__decap_6
XFILLER_11_34 VGND VGND VPWR VPWR sky130_fd_sc_hd__decap_4
XFILLER_11_23 VGND VGND VPWR VPWR sky130_fd_sc_hd__fill_1
X_50_ net17 _09_ _08_ VGND VGND VPWR VPWR _11_ sky130_fd_sc_hd__a21bo_1
Xinput17 cin VGND VGND VPWR VPWR net17 sky130_fd_sc_hd__buf_1
XFILLER_8_35 VGND VGND VPWR VPWR sky130_fd_sc_hd__decap_4
XFILLER_8_24 VGND VGND VPWR VPWR sky130_fd_sc_hd__decap_4
XTAP_TAPCELL_ROW_1_26 VGND VPWR sky130_fd_sc_hd__tapvpwrvgnd_1
XPHY_EDGE_ROW_3_Right_3 VGND VGND VPWR VPWR sky130_fd_sc_hd__decap_3
XFILLER_11_57 VGND VGND VPWR VPWR sky130_fd_sc_hd__decap_3
XFILLER_2_26 VGND VGND VPWR VPWR sky130_fd_sc_hd__fill_2
XFILLER_10_7 VPWR VGND VPWR VGND sky130_ef_sc_hd__decap_12
XTAP_TAPCELL_ROW_11_36 VGND VPWR sky130_fd_sc_hd__tapvpwrvgnd_1
XPHY_EDGE_ROW_1_Left_13 VGND VGND VPWR VPWR sky130_fd_sc_hd__decap_3
XTAP_TAPCELL_ROW_11_37 VGND VPWR sky130_fd_sc_hd__tapvpwrvgnd_1
XFILLER_11_48 VGND VGND VPWR VPWR sky130_fd_sc_hd__decap_4
XFILLER_11_15 VGND VGND VPWR VPWR sky130_fd_sc_hd__decap_8
XPHY_EDGE_ROW_7_Right_7 VGND VGND VPWR VPWR sky130_fd_sc_hd__decap_3
XFILLER_11_27 VGND VGND VPWR VPWR sky130_fd_sc_hd__fill_1
XFILLER_2_29 VGND VGND VPWR VPWR sky130_fd_sc_hd__decap_3
XFILLER_8_39 VGND VGND VPWR VPWR sky130_fd_sc_hd__fill_1
XTAP_TAPCELL_ROW_4_29 VGND VPWR sky130_fd_sc_hd__tapvpwrvgnd_1
XFILLER_5_18 VPWR VGND VPWR VGND sky130_ef_sc_hd__decap_12
XFILLER_6_61 VGND VGND VPWR VPWR sky130_fd_sc_hd__decap_3
XPHY_EDGE_ROW_5_Left_17 VGND VGND VPWR VPWR sky130_fd_sc_hd__decap_3
XFILLER_8_29 VGND VGND VPWR VPWR sky130_fd_sc_hd__fill_1
XFILLER_0_41 VGND VGND VPWR VPWR sky130_fd_sc_hd__decap_4
XPHY_EDGE_ROW_8_Left_20 VGND VGND VPWR VPWR sky130_fd_sc_hd__decap_3
XFILLER_11_29 VGND VGND VPWR VPWR sky130_fd_sc_hd__fill_2
XFILLER_9_6 VPWR VGND VPWR VGND sky130_ef_sc_hd__decap_12
XTAP_TAPCELL_ROW_5_30 VGND VPWR sky130_fd_sc_hd__tapvpwrvgnd_1
XFILLER_6_41 VPWR VGND VPWR VGND sky130_ef_sc_hd__decap_12
X_86_ _16_ _20_ _37_ _38_ _18_ VGND VGND VPWR VPWR net18 sky130_fd_sc_hd__o221a_1
X_69_ _24_ _25_ VGND VGND VPWR VPWR _26_ sky130_fd_sc_hd__nand2_1
XFILLER_0_65 VGND VGND VPWR VPWR sky130_fd_sc_hd__decap_3
XFILLER_6_53 VGND VGND VPWR VPWR sky130_fd_sc_hd__decap_8
X_85_ _17_ _21_ VGND VGND VPWR VPWR _38_ sky130_fd_sc_hd__nand2_1
XFILLER_3_65 VGND VGND VPWR VPWR sky130_fd_sc_hd__decap_3
X_68_ net13 net5 VGND VGND VPWR VPWR _25_ sky130_fd_sc_hd__or2_1
XPHY_EDGE_ROW_2_Right_2 VGND VGND VPWR VPWR sky130_fd_sc_hd__decap_3
X_84_ _26_ _30_ VGND VGND VPWR VPWR net23 sky130_fd_sc_hd__xnor2_1
XFILLER_7_6 VGND VGND VPWR VPWR sky130_fd_sc_hd__decap_6
X_67_ net13 net5 VGND VGND VPWR VPWR _24_ sky130_fd_sc_hd__nand2_1
XFILLER_0_23 VGND VGND VPWR VPWR sky130_fd_sc_hd__fill_1
.ends
